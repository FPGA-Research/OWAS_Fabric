* NGSPICE file created from NPU_CTRL_CFG.ext - technology: ihp-sg13cmos5l

* Black-box entry subcircuit for sg13cmos5l_antennanp abstract view
.subckt sg13cmos5l_antennanp A VDD VSS
.ends

* Black-box entry subcircuit for sg13cmos5l_decap_8 abstract view
.subckt sg13cmos5l_decap_8 VDD VSS
.ends

* Black-box entry subcircuit for sg13cmos5l_decap_4 abstract view
.subckt sg13cmos5l_decap_4 VDD VSS
.ends

* Black-box entry subcircuit for sg13cmos5l_buf_1 abstract view
.subckt sg13cmos5l_buf_1 X A VDD VSS
.ends

* Black-box entry subcircuit for sg13cmos5l_fill_2 abstract view
.subckt sg13cmos5l_fill_2 VDD VSS
.ends

* Black-box entry subcircuit for latch abstract view
.subckt latch Q D VSS VDD GATE
.ends

* Black-box entry subcircuit for sg13cmos5l_dfrbpq_1 abstract view
.subckt sg13cmos5l_dfrbpq_1 Q CLK D RESET_B VDD VSS
.ends

* Black-box entry subcircuit for sg13cmos5l_fill_1 abstract view
.subckt sg13cmos5l_fill_1 VDD VSS
.ends

* Black-box entry subcircuit for sg13cmos5l_tiehi abstract view
.subckt sg13cmos5l_tiehi L_HI VDD VSS
.ends

* Black-box entry subcircuit for sg13cmos5l_mux4_1 abstract view
.subckt sg13cmos5l_mux4_1 X A0 A1 A2 A3 S0 S1 VDD VSS
.ends

* Black-box entry subcircuit for sg13cmos5l_or2_1 abstract view
.subckt sg13cmos5l_or2_1 X A B VDD VSS
.ends

.subckt NPU_CTRL_CFG NPU_ARRAY_EN NPU_COMPUTE_BANK_SWAP NPU_PSUM_LUT_EN NPU_PSUM_SKEW_EN
+ NPU_PSUM_SYSTOLIC_EN NPU_QUANT_SHIFT_EN NPU_QUANT_SHIFT_IN0 NPU_QUANT_SHIFT_IN1
+ NPU_QUANT_SHIFT_IN10 NPU_QUANT_SHIFT_IN11 NPU_QUANT_SHIFT_IN12 NPU_QUANT_SHIFT_IN13
+ NPU_QUANT_SHIFT_IN14 NPU_QUANT_SHIFT_IN15 NPU_QUANT_SHIFT_IN16 NPU_QUANT_SHIFT_IN17
+ NPU_QUANT_SHIFT_IN18 NPU_QUANT_SHIFT_IN19 NPU_QUANT_SHIFT_IN2 NPU_QUANT_SHIFT_IN20
+ NPU_QUANT_SHIFT_IN21 NPU_QUANT_SHIFT_IN22 NPU_QUANT_SHIFT_IN23 NPU_QUANT_SHIFT_IN24
+ NPU_QUANT_SHIFT_IN25 NPU_QUANT_SHIFT_IN26 NPU_QUANT_SHIFT_IN27 NPU_QUANT_SHIFT_IN28
+ NPU_QUANT_SHIFT_IN29 NPU_QUANT_SHIFT_IN3 NPU_QUANT_SHIFT_IN4 NPU_QUANT_SHIFT_IN5
+ NPU_QUANT_SHIFT_IN6 NPU_QUANT_SHIFT_IN7 NPU_QUANT_SHIFT_IN8 NPU_QUANT_SHIFT_IN9
+ NPU_SWAP_WEIGHTS Tile_X0Y0_Ci Tile_X0Y0_FrameData[0] Tile_X0Y0_FrameData[10] Tile_X0Y0_FrameData[11]
+ Tile_X0Y0_FrameData[12] Tile_X0Y0_FrameData[13] Tile_X0Y0_FrameData[14] Tile_X0Y0_FrameData[15]
+ Tile_X0Y0_FrameData[16] Tile_X0Y0_FrameData[17] Tile_X0Y0_FrameData[18] Tile_X0Y0_FrameData[19]
+ Tile_X0Y0_FrameData[1] Tile_X0Y0_FrameData[20] Tile_X0Y0_FrameData[21] Tile_X0Y0_FrameData[22]
+ Tile_X0Y0_FrameData[23] Tile_X0Y0_FrameData[24] Tile_X0Y0_FrameData[25] Tile_X0Y0_FrameData[26]
+ Tile_X0Y0_FrameData[27] Tile_X0Y0_FrameData[28] Tile_X0Y0_FrameData[29] Tile_X0Y0_FrameData[2]
+ Tile_X0Y0_FrameData[30] Tile_X0Y0_FrameData[31] Tile_X0Y0_FrameData[3] Tile_X0Y0_FrameData[4]
+ Tile_X0Y0_FrameData[5] Tile_X0Y0_FrameData[6] Tile_X0Y0_FrameData[7] Tile_X0Y0_FrameData[8]
+ Tile_X0Y0_FrameData[9] Tile_X0Y0_FrameStrobe[0] Tile_X0Y0_FrameStrobe[10] Tile_X0Y0_FrameStrobe[11]
+ Tile_X0Y0_FrameStrobe[12] Tile_X0Y0_FrameStrobe[13] Tile_X0Y0_FrameStrobe[14] Tile_X0Y0_FrameStrobe[15]
+ Tile_X0Y0_FrameStrobe[16] Tile_X0Y0_FrameStrobe[17] Tile_X0Y0_FrameStrobe[18] Tile_X0Y0_FrameStrobe[19]
+ Tile_X0Y0_FrameStrobe[1] Tile_X0Y0_FrameStrobe[2] Tile_X0Y0_FrameStrobe[3] Tile_X0Y0_FrameStrobe[4]
+ Tile_X0Y0_FrameStrobe[5] Tile_X0Y0_FrameStrobe[6] Tile_X0Y0_FrameStrobe[7] Tile_X0Y0_FrameStrobe[8]
+ Tile_X0Y0_FrameStrobe[9] Tile_X0Y0_FrameStrobe_O[0] Tile_X0Y0_FrameStrobe_O[10]
+ Tile_X0Y0_FrameStrobe_O[11] Tile_X0Y0_FrameStrobe_O[12] Tile_X0Y0_FrameStrobe_O[13]
+ Tile_X0Y0_FrameStrobe_O[14] Tile_X0Y0_FrameStrobe_O[15] Tile_X0Y0_FrameStrobe_O[16]
+ Tile_X0Y0_FrameStrobe_O[17] Tile_X0Y0_FrameStrobe_O[18] Tile_X0Y0_FrameStrobe_O[19]
+ Tile_X0Y0_FrameStrobe_O[1] Tile_X0Y0_FrameStrobe_O[2] Tile_X0Y0_FrameStrobe_O[3]
+ Tile_X0Y0_FrameStrobe_O[4] Tile_X0Y0_FrameStrobe_O[5] Tile_X0Y0_FrameStrobe_O[6]
+ Tile_X0Y0_FrameStrobe_O[7] Tile_X0Y0_FrameStrobe_O[8] Tile_X0Y0_FrameStrobe_O[9]
+ Tile_X0Y0_N1END[0] Tile_X0Y0_N1END[1] Tile_X0Y0_N1END[2] Tile_X0Y0_N1END[3] Tile_X0Y0_N2END[0]
+ Tile_X0Y0_N2END[1] Tile_X0Y0_N2END[2] Tile_X0Y0_N2END[3] Tile_X0Y0_N2END[4] Tile_X0Y0_N2END[5]
+ Tile_X0Y0_N2END[6] Tile_X0Y0_N2END[7] Tile_X0Y0_N2MID[0] Tile_X0Y0_N2MID[1] Tile_X0Y0_N2MID[2]
+ Tile_X0Y0_N2MID[3] Tile_X0Y0_N2MID[4] Tile_X0Y0_N2MID[5] Tile_X0Y0_N2MID[6] Tile_X0Y0_N2MID[7]
+ Tile_X0Y0_N4END[0] Tile_X0Y0_N4END[10] Tile_X0Y0_N4END[11] Tile_X0Y0_N4END[12] Tile_X0Y0_N4END[13]
+ Tile_X0Y0_N4END[14] Tile_X0Y0_N4END[15] Tile_X0Y0_N4END[1] Tile_X0Y0_N4END[2] Tile_X0Y0_N4END[3]
+ Tile_X0Y0_N4END[4] Tile_X0Y0_N4END[5] Tile_X0Y0_N4END[6] Tile_X0Y0_N4END[7] Tile_X0Y0_N4END[8]
+ Tile_X0Y0_N4END[9] Tile_X0Y0_NN4END[0] Tile_X0Y0_NN4END[10] Tile_X0Y0_NN4END[11]
+ Tile_X0Y0_NN4END[12] Tile_X0Y0_NN4END[13] Tile_X0Y0_NN4END[14] Tile_X0Y0_NN4END[15]
+ Tile_X0Y0_NN4END[1] Tile_X0Y0_NN4END[2] Tile_X0Y0_NN4END[3] Tile_X0Y0_NN4END[4]
+ Tile_X0Y0_NN4END[5] Tile_X0Y0_NN4END[6] Tile_X0Y0_NN4END[7] Tile_X0Y0_NN4END[8]
+ Tile_X0Y0_NN4END[9] Tile_X0Y0_S1BEG[0] Tile_X0Y0_S1BEG[1] Tile_X0Y0_S1BEG[2] Tile_X0Y0_S1BEG[3]
+ Tile_X0Y0_S2BEG[0] Tile_X0Y0_S2BEG[1] Tile_X0Y0_S2BEG[2] Tile_X0Y0_S2BEG[3] Tile_X0Y0_S2BEG[4]
+ Tile_X0Y0_S2BEG[5] Tile_X0Y0_S2BEG[6] Tile_X0Y0_S2BEG[7] Tile_X0Y0_S2BEGb[0] Tile_X0Y0_S2BEGb[1]
+ Tile_X0Y0_S2BEGb[2] Tile_X0Y0_S2BEGb[3] Tile_X0Y0_S2BEGb[4] Tile_X0Y0_S2BEGb[5]
+ Tile_X0Y0_S2BEGb[6] Tile_X0Y0_S2BEGb[7] Tile_X0Y0_S4BEG[0] Tile_X0Y0_S4BEG[10] Tile_X0Y0_S4BEG[11]
+ Tile_X0Y0_S4BEG[12] Tile_X0Y0_S4BEG[13] Tile_X0Y0_S4BEG[14] Tile_X0Y0_S4BEG[15]
+ Tile_X0Y0_S4BEG[1] Tile_X0Y0_S4BEG[2] Tile_X0Y0_S4BEG[3] Tile_X0Y0_S4BEG[4] Tile_X0Y0_S4BEG[5]
+ Tile_X0Y0_S4BEG[6] Tile_X0Y0_S4BEG[7] Tile_X0Y0_S4BEG[8] Tile_X0Y0_S4BEG[9] Tile_X0Y0_SS4BEG[0]
+ Tile_X0Y0_SS4BEG[10] Tile_X0Y0_SS4BEG[11] Tile_X0Y0_SS4BEG[12] Tile_X0Y0_SS4BEG[13]
+ Tile_X0Y0_SS4BEG[14] Tile_X0Y0_SS4BEG[15] Tile_X0Y0_SS4BEG[1] Tile_X0Y0_SS4BEG[2]
+ Tile_X0Y0_SS4BEG[3] Tile_X0Y0_SS4BEG[4] Tile_X0Y0_SS4BEG[5] Tile_X0Y0_SS4BEG[6]
+ Tile_X0Y0_SS4BEG[7] Tile_X0Y0_SS4BEG[8] Tile_X0Y0_SS4BEG[9] Tile_X0Y0_UserCLK Tile_X1Y0_Ci
+ Tile_X1Y0_FrameData_O[0] Tile_X1Y0_FrameData_O[10] Tile_X1Y0_FrameData_O[11] Tile_X1Y0_FrameData_O[12]
+ Tile_X1Y0_FrameData_O[13] Tile_X1Y0_FrameData_O[14] Tile_X1Y0_FrameData_O[15] Tile_X1Y0_FrameData_O[16]
+ Tile_X1Y0_FrameData_O[17] Tile_X1Y0_FrameData_O[18] Tile_X1Y0_FrameData_O[19] Tile_X1Y0_FrameData_O[1]
+ Tile_X1Y0_FrameData_O[20] Tile_X1Y0_FrameData_O[21] Tile_X1Y0_FrameData_O[22] Tile_X1Y0_FrameData_O[23]
+ Tile_X1Y0_FrameData_O[24] Tile_X1Y0_FrameData_O[25] Tile_X1Y0_FrameData_O[26] Tile_X1Y0_FrameData_O[27]
+ Tile_X1Y0_FrameData_O[28] Tile_X1Y0_FrameData_O[29] Tile_X1Y0_FrameData_O[2] Tile_X1Y0_FrameData_O[30]
+ Tile_X1Y0_FrameData_O[31] Tile_X1Y0_FrameData_O[3] Tile_X1Y0_FrameData_O[4] Tile_X1Y0_FrameData_O[5]
+ Tile_X1Y0_FrameData_O[6] Tile_X1Y0_FrameData_O[7] Tile_X1Y0_FrameData_O[8] Tile_X1Y0_FrameData_O[9]
+ Tile_X1Y0_FrameStrobe[0] Tile_X1Y0_FrameStrobe[10] Tile_X1Y0_FrameStrobe[11] Tile_X1Y0_FrameStrobe[12]
+ Tile_X1Y0_FrameStrobe[13] Tile_X1Y0_FrameStrobe[14] Tile_X1Y0_FrameStrobe[15] Tile_X1Y0_FrameStrobe[16]
+ Tile_X1Y0_FrameStrobe[17] Tile_X1Y0_FrameStrobe[18] Tile_X1Y0_FrameStrobe[19] Tile_X1Y0_FrameStrobe[1]
+ Tile_X1Y0_FrameStrobe[2] Tile_X1Y0_FrameStrobe[3] Tile_X1Y0_FrameStrobe[4] Tile_X1Y0_FrameStrobe[5]
+ Tile_X1Y0_FrameStrobe[6] Tile_X1Y0_FrameStrobe[7] Tile_X1Y0_FrameStrobe[8] Tile_X1Y0_FrameStrobe[9]
+ Tile_X1Y0_FrameStrobe_O[0] Tile_X1Y0_FrameStrobe_O[10] Tile_X1Y0_FrameStrobe_O[11]
+ Tile_X1Y0_FrameStrobe_O[12] Tile_X1Y0_FrameStrobe_O[13] Tile_X1Y0_FrameStrobe_O[14]
+ Tile_X1Y0_FrameStrobe_O[15] Tile_X1Y0_FrameStrobe_O[16] Tile_X1Y0_FrameStrobe_O[17]
+ Tile_X1Y0_FrameStrobe_O[18] Tile_X1Y0_FrameStrobe_O[19] Tile_X1Y0_FrameStrobe_O[1]
+ Tile_X1Y0_FrameStrobe_O[2] Tile_X1Y0_FrameStrobe_O[3] Tile_X1Y0_FrameStrobe_O[4]
+ Tile_X1Y0_FrameStrobe_O[5] Tile_X1Y0_FrameStrobe_O[6] Tile_X1Y0_FrameStrobe_O[7]
+ Tile_X1Y0_FrameStrobe_O[8] Tile_X1Y0_FrameStrobe_O[9] Tile_X1Y0_N1END[0] Tile_X1Y0_N1END[1]
+ Tile_X1Y0_N1END[2] Tile_X1Y0_N1END[3] Tile_X1Y0_N2END[0] Tile_X1Y0_N2END[1] Tile_X1Y0_N2END[2]
+ Tile_X1Y0_N2END[3] Tile_X1Y0_N2END[4] Tile_X1Y0_N2END[5] Tile_X1Y0_N2END[6] Tile_X1Y0_N2END[7]
+ Tile_X1Y0_N2MID[0] Tile_X1Y0_N2MID[1] Tile_X1Y0_N2MID[2] Tile_X1Y0_N2MID[3] Tile_X1Y0_N2MID[4]
+ Tile_X1Y0_N2MID[5] Tile_X1Y0_N2MID[6] Tile_X1Y0_N2MID[7] Tile_X1Y0_N4END[0] Tile_X1Y0_N4END[10]
+ Tile_X1Y0_N4END[11] Tile_X1Y0_N4END[12] Tile_X1Y0_N4END[13] Tile_X1Y0_N4END[14]
+ Tile_X1Y0_N4END[15] Tile_X1Y0_N4END[1] Tile_X1Y0_N4END[2] Tile_X1Y0_N4END[3] Tile_X1Y0_N4END[4]
+ Tile_X1Y0_N4END[5] Tile_X1Y0_N4END[6] Tile_X1Y0_N4END[7] Tile_X1Y0_N4END[8] Tile_X1Y0_N4END[9]
+ Tile_X1Y0_NN4END[0] Tile_X1Y0_NN4END[10] Tile_X1Y0_NN4END[11] Tile_X1Y0_NN4END[12]
+ Tile_X1Y0_NN4END[13] Tile_X1Y0_NN4END[14] Tile_X1Y0_NN4END[15] Tile_X1Y0_NN4END[1]
+ Tile_X1Y0_NN4END[2] Tile_X1Y0_NN4END[3] Tile_X1Y0_NN4END[4] Tile_X1Y0_NN4END[5]
+ Tile_X1Y0_NN4END[6] Tile_X1Y0_NN4END[7] Tile_X1Y0_NN4END[8] Tile_X1Y0_NN4END[9]
+ Tile_X1Y0_S1BEG[0] Tile_X1Y0_S1BEG[1] Tile_X1Y0_S1BEG[2] Tile_X1Y0_S1BEG[3] Tile_X1Y0_S2BEG[0]
+ Tile_X1Y0_S2BEG[1] Tile_X1Y0_S2BEG[2] Tile_X1Y0_S2BEG[3] Tile_X1Y0_S2BEG[4] Tile_X1Y0_S2BEG[5]
+ Tile_X1Y0_S2BEG[6] Tile_X1Y0_S2BEG[7] Tile_X1Y0_S2BEGb[0] Tile_X1Y0_S2BEGb[1] Tile_X1Y0_S2BEGb[2]
+ Tile_X1Y0_S2BEGb[3] Tile_X1Y0_S2BEGb[4] Tile_X1Y0_S2BEGb[5] Tile_X1Y0_S2BEGb[6]
+ Tile_X1Y0_S2BEGb[7] Tile_X1Y0_S4BEG[0] Tile_X1Y0_S4BEG[10] Tile_X1Y0_S4BEG[11] Tile_X1Y0_S4BEG[12]
+ Tile_X1Y0_S4BEG[13] Tile_X1Y0_S4BEG[14] Tile_X1Y0_S4BEG[15] Tile_X1Y0_S4BEG[1] Tile_X1Y0_S4BEG[2]
+ Tile_X1Y0_S4BEG[3] Tile_X1Y0_S4BEG[4] Tile_X1Y0_S4BEG[5] Tile_X1Y0_S4BEG[6] Tile_X1Y0_S4BEG[7]
+ Tile_X1Y0_S4BEG[8] Tile_X1Y0_S4BEG[9] Tile_X1Y0_SS4BEG[0] Tile_X1Y0_SS4BEG[10] Tile_X1Y0_SS4BEG[11]
+ Tile_X1Y0_SS4BEG[12] Tile_X1Y0_SS4BEG[13] Tile_X1Y0_SS4BEG[14] Tile_X1Y0_SS4BEG[15]
+ Tile_X1Y0_SS4BEG[1] Tile_X1Y0_SS4BEG[2] Tile_X1Y0_SS4BEG[3] Tile_X1Y0_SS4BEG[4]
+ Tile_X1Y0_SS4BEG[5] Tile_X1Y0_SS4BEG[6] Tile_X1Y0_SS4BEG[7] Tile_X1Y0_SS4BEG[8]
+ Tile_X1Y0_SS4BEG[9] Tile_X1Y0_UserCLKo VGND VPWR
XANTENNA__308__X Tile_X1Y0_FrameData_O[4] VPWR VGND sg13cmos5l_antennanp
XANTENNA__103__GATE Tile_X1Y0_FrameStrobe[0] VPWR VGND sg13cmos5l_antennanp
XFILLER_11_1042 VPWR VGND sg13cmos5l_decap_8
XANTENNA__218__X Tile_X1Y0_S2BEG[7] VPWR VGND sg13cmos5l_antennanp
XFILLER_14_634 VPWR VGND sg13cmos5l_decap_8
XFILLER_10_884 VPWR VGND sg13cmos5l_decap_4
XFILLER_13_155 VPWR VGND sg13cmos5l_decap_8
X_294_ Tile_X0Y0_SS4BEG[10] Tile_X0Y0_NN4END[5] VPWR VGND sg13cmos5l_buf_1
X_363_ Tile_X1Y0_FrameStrobe_O[7] Tile_X1Y0_FrameStrobe[7] VPWR VGND sg13cmos5l_buf_1
XFILLER_9_137 VPWR VGND sg13cmos5l_decap_8
XANTENNA__140__CLK Tile_X0Y0_UserCLK VPWR VGND sg13cmos5l_antennanp
XFILLER_3_1029 VPWR VGND sg13cmos5l_decap_8
XANTENNA__304__A Tile_X0Y0_FrameData[0] VPWR VGND sg13cmos5l_antennanp
XFILLER_10_158 VPWR VGND sg13cmos5l_decap_8
XANTENNA__042__GATE Tile_X0Y0_FrameStrobe[0] VPWR VGND sg13cmos5l_antennanp
XANTENNA__214__A Tile_X1Y0_N2MID[4] VPWR VGND sg13cmos5l_antennanp
XFILLER_12_98 VPWR VGND sg13cmos5l_decap_8
XFILLER_3_836 VPWR VGND sg13cmos5l_fill_2
XFILLER_2_324 VPWR VGND sg13cmos5l_decap_8
XANTENNA__057__GATE Tile_X0Y0_FrameStrobe[0] VPWR VGND sg13cmos5l_antennanp
XFILLER_14_420 VPWR VGND sg13cmos5l_decap_8
X_346_ Tile_X0Y0_FrameStrobe_O[10] Tile_X0Y0_FrameStrobe[10] VPWR VGND sg13cmos5l_buf_1
X_277_ Tile_X0Y0_S4BEG[9] Tile_X0Y0_N4END[6] VPWR VGND sg13cmos5l_buf_1
XANTENNA__321__X Tile_X1Y0_FrameData_O[17] VPWR VGND sg13cmos5l_antennanp
XFILLER_9_490 VPWR VGND sg13cmos5l_decap_8
XANTENNA__209__A Tile_X1Y0_N1END[1] VPWR VGND sg13cmos5l_antennanp
XANTENNA__401__A0 Tile_X0Y0_N1END[0] VPWR VGND sg13cmos5l_antennanp
XFILLER_12_924 VPWR VGND sg13cmos5l_fill_2
XFILLER_15_239 VPWR VGND sg13cmos5l_decap_8
X_200_ Tile_X0Y0_S2BEG[1] Tile_X0Y0_N2MID[6] VPWR VGND sg13cmos5l_buf_1
XFILLER_11_467 VPWR VGND sg13cmos5l_decap_8
X_062_ _062_/Q Tile_X0Y0_FrameData[8] VGND VPWR Tile_X0Y0_FrameStrobe[0] latch
X_131_ NPU_QUANT_SHIFT_IN16 Tile_X0Y0_UserCLK _381_/X _153_/L_HI VPWR VGND sg13cmos5l_dfrbpq_1
XANTENNA__231__X Tile_X1Y0_S4BEG[4] VPWR VGND sg13cmos5l_antennanp
XFILLER_3_622 VPWR VGND sg13cmos5l_decap_8
XFILLER_2_165 VPWR VGND sg13cmos5l_decap_8
XFILLER_2_143 VPWR VGND sg13cmos5l_decap_8
XFILLER_2_110 VPWR VGND sg13cmos5l_decap_8
XFILLER_14_283 VPWR VGND sg13cmos5l_decap_8
XFILLER_9_88 VPWR VGND sg13cmos5l_decap_8
X_329_ Tile_X1Y0_FrameData_O[25] Tile_X0Y0_FrameData[25] VPWR VGND sg13cmos5l_buf_1
XFILLER_7_994 VPWR VGND sg13cmos5l_fill_2
XFILLER_7_983 VPWR VGND sg13cmos5l_decap_8
XFILLER_6_482 VPWR VGND sg13cmos5l_decap_8
XFILLER_9_1057 VPWR VGND sg13cmos5l_decap_8
XANTENNA__316__X Tile_X1Y0_FrameData_O[12] VPWR VGND sg13cmos5l_antennanp
XFILLER_0_614 VPWR VGND sg13cmos5l_fill_2
XFILLER_0_636 VPWR VGND sg13cmos5l_fill_1
XFILLER_16_526 VPWR VGND sg13cmos5l_decap_8
XANTENNA__226__X Tile_X1Y0_S2BEGb[7] VPWR VGND sg13cmos5l_antennanp
XFILLER_11_231 VPWR VGND sg13cmos5l_decap_8
XFILLER_12_721 VPWR VGND sg13cmos5l_decap_8
XFILLER_12_798 VPWR VGND sg13cmos5l_decap_8
XFILLER_15_1018 VPWR VGND sg13cmos5l_decap_8
XFILLER_16_559 VPWR VGND sg13cmos5l_decap_8
X_045_ _045_/Q Tile_X0Y0_FrameData[25] VGND VPWR Tile_X0Y0_FrameStrobe[0] latch
X_114_ _114_/Q Tile_X0Y0_FrameData[25] VGND VPWR Tile_X1Y0_FrameStrobe[1] latch
XFILLER_8_769 VPWR VGND sg13cmos5l_decap_4
XFILLER_7_279 VPWR VGND sg13cmos5l_decap_8
XFILLER_4_964 VPWR VGND sg13cmos5l_decap_8
XFILLER_15_570 VPWR VGND sg13cmos5l_decap_8
XANTENNA__392__A2 Tile_X1Y0_NN4END[12] VPWR VGND sg13cmos5l_antennanp
XANTENNA__312__A Tile_X0Y0_FrameData[8] VPWR VGND sg13cmos5l_antennanp
XANTENNA__383__A2 Tile_X1Y0_NN4END[1] VPWR VGND sg13cmos5l_antennanp
XFILLER_14_1040 VPWR VGND sg13cmos5l_decap_8
XANTENNA__222__A Tile_X1Y0_N2END[4] VPWR VGND sg13cmos5l_antennanp
XFILLER_0_488 VPWR VGND sg13cmos5l_fill_1
XANTENNA__374__A2 Tile_X0Y0_NN4END[9] VPWR VGND sg13cmos5l_antennanp
XFILLER_12_595 VPWR VGND sg13cmos5l_decap_8
XFILLER_8_588 VPWR VGND sg13cmos5l_decap_8
XFILLER_8_511 VPWR VGND sg13cmos5l_decap_8
XFILLER_3_282 VPWR VGND sg13cmos5l_decap_4
XFILLER_6_1038 VPWR VGND sg13cmos5l_decap_8
XANTENNA__307__A Tile_X0Y0_FrameData[3] VPWR VGND sg13cmos5l_antennanp
XANTENNA__365__A2 Tile_X0Y0_NN4END[0] VPWR VGND sg13cmos5l_antennanp
XFILLER_1_208 VPWR VGND sg13cmos5l_fill_1
XFILLER_1_219 VPWR VGND sg13cmos5l_decap_4
XFILLER_14_849 VPWR VGND sg13cmos5l_decap_8
XANTENNA__217__A Tile_X1Y0_N2MID[1] VPWR VGND sg13cmos5l_antennanp
XFILLER_13_337 VPWR VGND sg13cmos5l_decap_8
XFILLER_9_319 VPWR VGND sg13cmos5l_decap_8
XFILLER_5_514 VPWR VGND sg13cmos5l_decap_8
XFILLER_1_731 VPWR VGND sg13cmos5l_decap_8
XANTENNA__102__D Tile_X0Y0_FrameData[4] VPWR VGND sg13cmos5l_antennanp
XFILLER_1_797 VPWR VGND sg13cmos5l_decap_4
XFILLER_16_153 VPWR VGND sg13cmos5l_decap_4
XFILLER_12_392 VPWR VGND sg13cmos5l_decap_8
XFILLER_9_831 VPWR VGND sg13cmos5l_decap_8
XFILLER_9_886 VPWR VGND sg13cmos5l_decap_8
XFILLER_8_330 VPWR VGND sg13cmos5l_decap_8
XFILLER_11_0 VPWR VGND sg13cmos5l_fill_2
XANTENNA__324__X Tile_X1Y0_FrameData_O[20] VPWR VGND sg13cmos5l_antennanp
XFILLER_11_1021 VPWR VGND sg13cmos5l_decap_8
XFILLER_11_1098 VPWR VGND sg13cmos5l_decap_8
XFILLER_2_539 VPWR VGND sg13cmos5l_decap_8
XFILLER_13_134 VPWR VGND sg13cmos5l_decap_8
XFILLER_14_613 VPWR VGND sg13cmos5l_decap_8
XFILLER_14_646 VPWR VGND sg13cmos5l_decap_4
X_362_ Tile_X1Y0_FrameStrobe_O[6] Tile_X1Y0_FrameStrobe[6] VPWR VGND sg13cmos5l_buf_1
XFILLER_9_116 VPWR VGND sg13cmos5l_decap_8
XANTENNA__234__X Tile_X1Y0_S4BEG[7] VPWR VGND sg13cmos5l_antennanp
XFILLER_10_874 VPWR VGND sg13cmos5l_decap_8
X_293_ Tile_X0Y0_SS4BEG[9] Tile_X0Y0_NN4END[6] VPWR VGND sg13cmos5l_buf_1
XFILLER_6_856 VPWR VGND sg13cmos5l_fill_1
XFILLER_5_355 VPWR VGND sg13cmos5l_decap_8
XFILLER_5_300 VPWR VGND sg13cmos5l_decap_8
XFILLER_5_366 VPWR VGND sg13cmos5l_fill_1
XFILLER_3_35 VPWR VGND sg13cmos5l_decap_8
XFILLER_1_594 VPWR VGND sg13cmos5l_decap_8
XFILLER_3_1008 VPWR VGND sg13cmos5l_decap_8
XANTENNA__320__A Tile_X0Y0_FrameData[16] VPWR VGND sg13cmos5l_antennanp
XANTENNA__319__X Tile_X1Y0_FrameData_O[15] VPWR VGND sg13cmos5l_antennanp
XFILLER_10_137 VPWR VGND sg13cmos5l_decap_8
XFILLER_11_649 VPWR VGND sg13cmos5l_decap_8
XFILLER_12_22 VPWR VGND sg13cmos5l_fill_1
XFILLER_12_77 VPWR VGND sg13cmos5l_decap_8
XFILLER_13_1105 VPWR VGND sg13cmos5l_decap_8
XFILLER_7_609 VPWR VGND sg13cmos5l_fill_2
XFILLER_6_119 VPWR VGND sg13cmos5l_decap_8
XANTENNA__230__A Tile_X1Y0_N4END[12] VPWR VGND sg13cmos5l_antennanp
XFILLER_3_848 VPWR VGND sg13cmos5l_decap_8
XFILLER_2_369 VPWR VGND sg13cmos5l_fill_2
XFILLER_2_303 VPWR VGND sg13cmos5l_decap_8
XANTENNA__229__X Tile_X1Y0_S4BEG[2] VPWR VGND sg13cmos5l_antennanp
XFILLER_14_487 VPWR VGND sg13cmos5l_decap_8
XFILLER_15_933 VPWR VGND sg13cmos5l_fill_2
X_276_ Tile_X0Y0_S4BEG[8] Tile_X0Y0_N4END[7] VPWR VGND sg13cmos5l_buf_1
X_345_ Tile_X0Y0_FrameStrobe_O[9] Tile_X0Y0_FrameStrobe[9] VPWR VGND sg13cmos5l_buf_1
XFILLER_2_1085 VPWR VGND sg13cmos5l_decap_8
XFILLER_6_697 VPWR VGND sg13cmos5l_fill_2
XFILLER_6_686 VPWR VGND sg13cmos5l_decap_8
XANTENNA__102__GATE Tile_X1Y0_FrameStrobe[0] VPWR VGND sg13cmos5l_antennanp
XANTENNA__315__A Tile_X0Y0_FrameData[11] VPWR VGND sg13cmos5l_antennanp
XFILLER_16_708 VPWR VGND sg13cmos5l_decap_4
XANTENNA__130__CLK Tile_X0Y0_UserCLK VPWR VGND sg13cmos5l_antennanp
XANTENNA__401__A1 Tile_X0Y0_N2MID[0] VPWR VGND sg13cmos5l_antennanp
XFILLER_11_446 VPWR VGND sg13cmos5l_decap_8
XFILLER_12_903 VPWR VGND sg13cmos5l_decap_8
XFILLER_12_914 VPWR VGND sg13cmos5l_fill_1
XFILLER_12_936 VPWR VGND sg13cmos5l_decap_4
XFILLER_15_218 VPWR VGND sg13cmos5l_decap_8
X_130_ NPU_QUANT_SHIFT_IN15 Tile_X0Y0_UserCLK _380_/X _154_/L_HI VPWR VGND sg13cmos5l_dfrbpq_1
XFILLER_8_918 VPWR VGND sg13cmos5l_fill_1
XANTENNA__225__A Tile_X1Y0_N2END[1] VPWR VGND sg13cmos5l_antennanp
X_061_ _061_/Q Tile_X0Y0_FrameData[9] VGND VPWR Tile_X0Y0_FrameStrobe[0] latch
XFILLER_7_439 VPWR VGND sg13cmos5l_fill_1
XFILLER_3_601 VPWR VGND sg13cmos5l_decap_8
XANTENNA__110__D Tile_X0Y0_FrameData[28] VPWR VGND sg13cmos5l_antennanp
XFILLER_3_656 VPWR VGND sg13cmos5l_fill_2
XFILLER_14_262 VPWR VGND sg13cmos5l_decap_8
XFILLER_15_785 VPWR VGND sg13cmos5l_decap_8
X_259_ Tile_X1Y0_UserCLKo Tile_X0Y0_UserCLK VPWR VGND sg13cmos5l_buf_1
X_328_ Tile_X1Y0_FrameData_O[24] Tile_X0Y0_FrameData[24] VPWR VGND sg13cmos5l_buf_1
XFILLER_9_67 VPWR VGND sg13cmos5l_fill_1
XFILLER_9_56 VPWR VGND sg13cmos5l_decap_8
XFILLER_7_940 VPWR VGND sg13cmos5l_fill_1
XFILLER_10_490 VPWR VGND sg13cmos5l_decap_8
XFILLER_9_1036 VPWR VGND sg13cmos5l_decap_8
XANTENNA__041__GATE Tile_X0Y0_FrameStrobe[0] VPWR VGND sg13cmos5l_antennanp
XANTENNA__056__GATE Tile_X0Y0_FrameStrobe[0] VPWR VGND sg13cmos5l_antennanp
XANTENNA__395__A0 Tile_X1Y0_N1END[3] VPWR VGND sg13cmos5l_antennanp
XANTENNA__332__X Tile_X1Y0_FrameData_O[28] VPWR VGND sg13cmos5l_antennanp
XFILLER_10_1119 VPWR VGND sg13cmos5l_fill_1
XFILLER_16_505 VPWR VGND sg13cmos5l_decap_8
XANTENNA__386__A0 Tile_X1Y0_N4END[6] VPWR VGND sg13cmos5l_antennanp
XFILLER_11_210 VPWR VGND sg13cmos5l_decap_8
XFILLER_11_287 VPWR VGND sg13cmos5l_decap_8
XFILLER_12_700 VPWR VGND sg13cmos5l_decap_8
XFILLER_12_777 VPWR VGND sg13cmos5l_decap_8
X_113_ _113_/Q Tile_X0Y0_FrameData[31] VGND VPWR Tile_X1Y0_FrameStrobe[0] latch
XFILLER_8_748 VPWR VGND sg13cmos5l_decap_8
XANTENNA__105__D Tile_X0Y0_FrameData[1] VPWR VGND sg13cmos5l_antennanp
XANTENNA__242__X Tile_X1Y0_S4BEG[15] VPWR VGND sg13cmos5l_antennanp
X_044_ _044_/Q Tile_X0Y0_FrameData[26] VGND VPWR Tile_X0Y0_FrameStrobe[0] latch
XFILLER_7_258 VPWR VGND sg13cmos5l_decap_8
XFILLER_4_910 VPWR VGND sg13cmos5l_fill_1
XANTENNA__377__A0 Tile_X0Y0_N4END[12] VPWR VGND sg13cmos5l_antennanp
XANTENNA__392__A3 Tile_X1Y0_NN4END[14] VPWR VGND sg13cmos5l_antennanp
XFILLER_6_291 VPWR VGND sg13cmos5l_decap_8
XANTENNA__327__X Tile_X1Y0_FrameData_O[23] VPWR VGND sg13cmos5l_antennanp
XANTENNA__368__A0 Tile_X0Y0_N4END[0] VPWR VGND sg13cmos5l_antennanp
XANTENNA__383__A3 Tile_X1Y0_NN4END[3] VPWR VGND sg13cmos5l_antennanp
XFILLER_14_1096 VPWR VGND sg13cmos5l_decap_8
XFILLER_5_707 VPWR VGND sg13cmos5l_decap_8
XFILLER_1_902 VPWR VGND sg13cmos5l_fill_1
XFILLER_0_467 VPWR VGND sg13cmos5l_fill_2
XFILLER_1_979 VPWR VGND sg13cmos5l_fill_1
XFILLER_1_957 VPWR VGND sg13cmos5l_fill_2
XANTENNA__237__X Tile_X1Y0_S4BEG[10] VPWR VGND sg13cmos5l_antennanp
XFILLER_16_335 VPWR VGND sg13cmos5l_decap_8
XANTENNA__374__A3 Tile_X0Y0_NN4END[11] VPWR VGND sg13cmos5l_antennanp
XFILLER_12_574 VPWR VGND sg13cmos5l_decap_8
XFILLER_8_567 VPWR VGND sg13cmos5l_decap_8
XFILLER_6_35 VPWR VGND sg13cmos5l_decap_8
XFILLER_6_1017 VPWR VGND sg13cmos5l_decap_8
XFILLER_4_773 VPWR VGND sg13cmos5l_decap_4
XFILLER_3_294 VPWR VGND sg13cmos5l_fill_1
XFILLER_3_261 VPWR VGND sg13cmos5l_fill_2
XANTENNA__365__A3 Tile_X0Y0_NN4END[2] VPWR VGND sg13cmos5l_antennanp
XFILLER_16_880 VPWR VGND sg13cmos5l_fill_2
XFILLER_16_891 VPWR VGND sg13cmos5l_decap_8
XANTENNA__323__A Tile_X0Y0_FrameData[19] VPWR VGND sg13cmos5l_antennanp
XFILLER_13_316 VPWR VGND sg13cmos5l_decap_8
XFILLER_15_99 VPWR VGND sg13cmos5l_decap_8
XANTENNA__233__A Tile_X1Y0_N4END[9] VPWR VGND sg13cmos5l_antennanp
XFILLER_1_765 VPWR VGND sg13cmos5l_fill_2
XFILLER_1_721 VPWR VGND sg13cmos5l_decap_8
XFILLER_16_132 VPWR VGND sg13cmos5l_decap_8
XFILLER_5_1083 VPWR VGND sg13cmos5l_decap_8
XFILLER_12_371 VPWR VGND sg13cmos5l_decap_8
XFILLER_9_810 VPWR VGND sg13cmos5l_decap_8
XFILLER_8_375 VPWR VGND sg13cmos5l_decap_4
XANTENNA__318__A Tile_X0Y0_FrameData[14] VPWR VGND sg13cmos5l_antennanp
XFILLER_10_319 VPWR VGND sg13cmos5l_decap_8
XFILLER_11_1000 VPWR VGND sg13cmos5l_decap_8
XANTENNA__340__X Tile_X0Y0_FrameStrobe_O[4] VPWR VGND sg13cmos5l_antennanp
XFILLER_11_1077 VPWR VGND sg13cmos5l_decap_8
XFILLER_2_518 VPWR VGND sg13cmos5l_decap_8
XANTENNA__228__A Tile_X1Y0_N4END[14] VPWR VGND sg13cmos5l_antennanp
XFILLER_13_113 VPWR VGND sg13cmos5l_decap_8
XFILLER_14_669 VPWR VGND sg13cmos5l_decap_4
X_292_ Tile_X0Y0_SS4BEG[8] Tile_X0Y0_NN4END[7] VPWR VGND sg13cmos5l_buf_1
X_361_ Tile_X1Y0_FrameStrobe_O[5] Tile_X1Y0_FrameStrobe[5] VPWR VGND sg13cmos5l_buf_1
XFILLER_10_853 VPWR VGND sg13cmos5l_decap_8
XANTENNA__113__D Tile_X0Y0_FrameData[31] VPWR VGND sg13cmos5l_antennanp
XANTENNA__250__X Tile_X1Y0_SS4BEG[7] VPWR VGND sg13cmos5l_antennanp
XFILLER_3_58 VPWR VGND sg13cmos5l_decap_8
XFILLER_1_573 VPWR VGND sg13cmos5l_decap_8
XFILLER_9_684 VPWR VGND sg13cmos5l_decap_8
XFILLER_8_183 VPWR VGND sg13cmos5l_decap_8
XFILLER_10_116 VPWR VGND sg13cmos5l_decap_8
XFILLER_11_628 VPWR VGND sg13cmos5l_decap_8
XANTENNA__335__X Tile_X1Y0_FrameData_O[31] VPWR VGND sg13cmos5l_antennanp
XFILLER_12_56 VPWR VGND sg13cmos5l_decap_8
XFILLER_3_816 VPWR VGND sg13cmos5l_decap_8
XFILLER_2_359 VPWR VGND sg13cmos5l_fill_1
XFILLER_2_1064 VPWR VGND sg13cmos5l_decap_8
XANTENNA__108__D Tile_X0Y0_FrameData[30] VPWR VGND sg13cmos5l_antennanp
XANTENNA__245__X Tile_X1Y0_SS4BEG[2] VPWR VGND sg13cmos5l_antennanp
XFILLER_14_466 VPWR VGND sg13cmos5l_decap_8
X_275_ Tile_X0Y0_S4BEG[7] Tile_X0Y0_N4END[8] VPWR VGND sg13cmos5l_buf_1
X_344_ Tile_X0Y0_FrameStrobe_O[8] Tile_X0Y0_FrameStrobe[8] VPWR VGND sg13cmos5l_buf_1
XFILLER_6_610 VPWR VGND sg13cmos5l_decap_4
XFILLER_10_683 VPWR VGND sg13cmos5l_decap_8
XFILLER_6_632 VPWR VGND sg13cmos5l_decap_8
XFILLER_5_186 VPWR VGND sg13cmos5l_fill_1
XFILLER_5_175 VPWR VGND sg13cmos5l_decap_8
XFILLER_2_860 VPWR VGND sg13cmos5l_fill_1
XANTENNA__331__A Tile_X0Y0_FrameData[27] VPWR VGND sg13cmos5l_antennanp
XFILLER_4_90 VPWR VGND sg13cmos5l_decap_8
XANTENNA__401__A2 Tile_X0Y0_N2MID[7] VPWR VGND sg13cmos5l_antennanp
XFILLER_11_425 VPWR VGND sg13cmos5l_decap_8
XFILLER_12_959 VPWR VGND sg13cmos5l_decap_4
XFILLER_7_407 VPWR VGND sg13cmos5l_decap_4
XANTENNA__241__A Tile_X1Y0_N4END[1] VPWR VGND sg13cmos5l_antennanp
X_060_ _060_/Q Tile_X0Y0_FrameData[10] VGND VPWR Tile_X0Y0_FrameStrobe[0] latch
XFILLER_14_241 VPWR VGND sg13cmos5l_decap_8
XFILLER_15_764 VPWR VGND sg13cmos5l_decap_8
XFILLER_9_24 VPWR VGND sg13cmos5l_fill_1
X_189_ Tile_X1Y0_FrameStrobe_O[10] Tile_X1Y0_FrameStrobe[10] VPWR VGND sg13cmos5l_buf_1
X_258_ Tile_X1Y0_SS4BEG[15] Tile_X1Y0_NN4END[0] VPWR VGND sg13cmos5l_buf_1
X_327_ Tile_X1Y0_FrameData_O[23] Tile_X0Y0_FrameData[23] VPWR VGND sg13cmos5l_buf_1
XFILLER_6_462 VPWR VGND sg13cmos5l_fill_2
XFILLER_9_1015 VPWR VGND sg13cmos5l_decap_8
XANTENNA__326__A Tile_X0Y0_FrameData[22] VPWR VGND sg13cmos5l_antennanp
XANTENNA__395__A1 Tile_X1Y0_N2MID[3] VPWR VGND sg13cmos5l_antennanp
XANTENNA__386__A1 Tile_X1Y0_N4END[7] VPWR VGND sg13cmos5l_antennanp
XANTENNA__236__A Tile_X1Y0_N4END[6] VPWR VGND sg13cmos5l_antennanp
XFILLER_11_266 VPWR VGND sg13cmos5l_decap_8
XFILLER_12_756 VPWR VGND sg13cmos5l_decap_8
X_043_ _043_/Q Tile_X0Y0_FrameData[27] VGND VPWR Tile_X0Y0_FrameStrobe[0] latch
X_112_ _112_/Q Tile_X0Y0_FrameData[26] VGND VPWR Tile_X1Y0_FrameStrobe[1] latch
XFILLER_8_727 VPWR VGND sg13cmos5l_decap_8
XFILLER_7_237 VPWR VGND sg13cmos5l_decap_8
XANTENNA__101__GATE Tile_X1Y0_FrameStrobe[0] VPWR VGND sg13cmos5l_antennanp
XFILLER_1_0 VPWR VGND sg13cmos5l_fill_2
XANTENNA__377__A1 Tile_X0Y0_N4END[13] VPWR VGND sg13cmos5l_antennanp
XFILLER_6_270 VPWR VGND sg13cmos5l_decap_8
XANTENNA__120__CLK Tile_X0Y0_UserCLK VPWR VGND sg13cmos5l_antennanp
XANTENNA__368__A1 Tile_X0Y0_N4END[3] VPWR VGND sg13cmos5l_antennanp
XANTENNA__343__X Tile_X0Y0_FrameStrobe_O[7] VPWR VGND sg13cmos5l_antennanp
XFILLER_14_1020 VPWR VGND sg13cmos5l_fill_2
XFILLER_14_1075 VPWR VGND sg13cmos5l_decap_8
XFILLER_4_229 VPWR VGND sg13cmos5l_decap_8
XFILLER_16_314 VPWR VGND sg13cmos5l_decap_8
XFILLER_12_553 VPWR VGND sg13cmos5l_decap_8
XFILLER_16_369 VPWR VGND sg13cmos5l_decap_8
XANTENNA__040__GATE Tile_X0Y0_FrameStrobe[0] VPWR VGND sg13cmos5l_antennanp
XANTENNA__143__CLK Tile_X0Y0_UserCLK VPWR VGND sg13cmos5l_antennanp
XANTENNA__253__X Tile_X1Y0_SS4BEG[10] VPWR VGND sg13cmos5l_antennanp
XFILLER_8_546 VPWR VGND sg13cmos5l_decap_8
XFILLER_6_14 VPWR VGND sg13cmos5l_decap_8
XANTENNA__055__GATE Tile_X0Y0_FrameStrobe[0] VPWR VGND sg13cmos5l_antennanp
XFILLER_15_380 VPWR VGND sg13cmos5l_fill_1
XFILLER_7_590 VPWR VGND sg13cmos5l_decap_8
XANTENNA__338__X Tile_X0Y0_FrameStrobe_O[2] VPWR VGND sg13cmos5l_antennanp
XFILLER_15_45 VPWR VGND sg13cmos5l_fill_2
XFILLER_15_78 VPWR VGND sg13cmos5l_decap_8
XFILLER_16_1115 VPWR VGND sg13cmos5l_decap_4
XFILLER_5_549 VPWR VGND sg13cmos5l_decap_8
XFILLER_0_232 VPWR VGND sg13cmos5l_decap_8
XFILLER_0_243 VPWR VGND sg13cmos5l_fill_1
XFILLER_0_254 VPWR VGND sg13cmos5l_decap_8
XFILLER_0_265 VPWR VGND sg13cmos5l_fill_2
XFILLER_0_287 VPWR VGND sg13cmos5l_fill_2
XFILLER_1_744 VPWR VGND sg13cmos5l_decap_8
XANTENNA__248__X Tile_X1Y0_SS4BEG[5] VPWR VGND sg13cmos5l_antennanp
XFILLER_16_111 VPWR VGND sg13cmos5l_decap_8
XFILLER_5_1062 VPWR VGND sg13cmos5l_decap_8
XFILLER_12_350 VPWR VGND sg13cmos5l_decap_8
XFILLER_13_840 VPWR VGND sg13cmos5l_decap_8
XFILLER_13_851 VPWR VGND sg13cmos5l_fill_1
XFILLER_13_884 VPWR VGND sg13cmos5l_fill_2
XANTENNA__039__CLK Tile_X0Y0_UserCLK VPWR VGND sg13cmos5l_antennanp
XANTENNA__334__A Tile_X0Y0_FrameData[30] VPWR VGND sg13cmos5l_antennanp
XFILLER_11_1056 VPWR VGND sg13cmos5l_decap_8
XFILLER_10_832 VPWR VGND sg13cmos5l_decap_8
XFILLER_13_169 VPWR VGND sg13cmos5l_decap_8
X_291_ Tile_X0Y0_SS4BEG[7] Tile_X0Y0_NN4END[8] VPWR VGND sg13cmos5l_buf_1
X_360_ Tile_X1Y0_FrameStrobe_O[4] Tile_X1Y0_FrameStrobe[4] VPWR VGND sg13cmos5l_buf_1
XFILLER_6_803 VPWR VGND sg13cmos5l_decap_8
XANTENNA__244__A Tile_X1Y0_NN4END[14] VPWR VGND sg13cmos5l_antennanp
XFILLER_10_898 VPWR VGND sg13cmos5l_decap_4
XFILLER_7_1113 VPWR VGND sg13cmos5l_decap_8
XFILLER_1_552 VPWR VGND sg13cmos5l_decap_8
XFILLER_9_663 VPWR VGND sg13cmos5l_decap_8
XFILLER_8_162 VPWR VGND sg13cmos5l_decap_8
XANTENNA__329__A Tile_X0Y0_FrameData[25] VPWR VGND sg13cmos5l_antennanp
XFILLER_11_607 VPWR VGND sg13cmos5l_decap_8
XANTENNA__351__X Tile_X0Y0_FrameStrobe_O[15] VPWR VGND sg13cmos5l_antennanp
XFILLER_12_35 VPWR VGND sg13cmos5l_decap_8
XFILLER_2_338 VPWR VGND sg13cmos5l_decap_8
XANTENNA__239__A Tile_X1Y0_N4END[3] VPWR VGND sg13cmos5l_antennanp
XFILLER_14_434 VPWR VGND sg13cmos5l_decap_8
XFILLER_14_445 VPWR VGND sg13cmos5l_decap_8
XFILLER_2_1043 VPWR VGND sg13cmos5l_decap_8
XFILLER_10_662 VPWR VGND sg13cmos5l_decap_8
X_274_ Tile_X0Y0_S4BEG[6] Tile_X0Y0_N4END[9] VPWR VGND sg13cmos5l_buf_1
X_343_ Tile_X0Y0_FrameStrobe_O[7] Tile_X0Y0_FrameStrobe[7] VPWR VGND sg13cmos5l_buf_1
XFILLER_5_121 VPWR VGND sg13cmos5l_fill_2
XANTENNA__261__X Tile_X0Y0_S2BEGb[1] VPWR VGND sg13cmos5l_antennanp
XFILLER_5_154 VPWR VGND sg13cmos5l_decap_8
XFILLER_5_132 VPWR VGND sg13cmos5l_decap_8
XANTENNA__120__Q NPU_QUANT_SHIFT_IN5 VPWR VGND sg13cmos5l_antennanp
XFILLER_0_809 VPWR VGND sg13cmos5l_decap_8
XANTENNA__401__A3 Tile_X0Y0_N2END[7] VPWR VGND sg13cmos5l_antennanp
XANTENNA__346__X Tile_X0Y0_FrameStrobe_O[10] VPWR VGND sg13cmos5l_antennanp
XFILLER_11_404 VPWR VGND sg13cmos5l_decap_8
XFILLER_8_909 VPWR VGND sg13cmos5l_decap_8
XFILLER_3_658 VPWR VGND sg13cmos5l_fill_1
XFILLER_2_179 VPWR VGND sg13cmos5l_decap_8
XFILLER_2_157 VPWR VGND sg13cmos5l_decap_4
XFILLER_2_124 VPWR VGND sg13cmos5l_decap_8
XANTENNA__256__X Tile_X1Y0_SS4BEG[13] VPWR VGND sg13cmos5l_antennanp
XFILLER_14_220 VPWR VGND sg13cmos5l_decap_8
XFILLER_14_297 VPWR VGND sg13cmos5l_decap_8
XFILLER_15_721 VPWR VGND sg13cmos5l_decap_4
X_326_ Tile_X1Y0_FrameData_O[22] Tile_X0Y0_FrameData[22] VPWR VGND sg13cmos5l_buf_1
XFILLER_11_993 VPWR VGND sg13cmos5l_decap_8
X_188_ Tile_X1Y0_FrameStrobe_O[9] Tile_X1Y0_FrameStrobe[9] VPWR VGND sg13cmos5l_buf_1
X_257_ Tile_X1Y0_SS4BEG[14] Tile_X1Y0_NN4END[1] VPWR VGND sg13cmos5l_buf_1
XFILLER_6_496 VPWR VGND sg13cmos5l_decap_8
XANTENNA__395__A2 Tile_X1Y0_N2MID[4] VPWR VGND sg13cmos5l_antennanp
XANTENNA__115__Q NPU_QUANT_SHIFT_IN0 VPWR VGND sg13cmos5l_antennanp
XANTENNA__342__A Tile_X0Y0_FrameStrobe[6] VPWR VGND sg13cmos5l_antennanp
XANTENNA__386__A2 Tile_X1Y0_NN4END[4] VPWR VGND sg13cmos5l_antennanp
XFILLER_12_735 VPWR VGND sg13cmos5l_decap_8
XANTENNA__252__A Tile_X1Y0_NN4END[6] VPWR VGND sg13cmos5l_antennanp
XFILLER_11_245 VPWR VGND sg13cmos5l_decap_8
X_042_ _042_/Q Tile_X0Y0_FrameData[28] VGND VPWR Tile_X0Y0_FrameStrobe[0] latch
X_111_ _111_/Q Tile_X0Y0_FrameData[27] VGND VPWR Tile_X1Y0_FrameStrobe[1] latch
XFILLER_8_706 VPWR VGND sg13cmos5l_decap_8
XFILLER_7_216 VPWR VGND sg13cmos5l_decap_8
XFILLER_4_989 VPWR VGND sg13cmos5l_decap_8
XFILLER_4_978 VPWR VGND sg13cmos5l_fill_1
XFILLER_8_1082 VPWR VGND sg13cmos5l_decap_8
XANTENNA__377__A2 Tile_X0Y0_NN4END[12] VPWR VGND sg13cmos5l_antennanp
XFILLER_15_584 VPWR VGND sg13cmos5l_decap_8
X_309_ Tile_X1Y0_FrameData_O[5] Tile_X0Y0_FrameData[5] VPWR VGND sg13cmos5l_buf_1
XFILLER_7_783 VPWR VGND sg13cmos5l_decap_8
XANTENNA__337__A Tile_X0Y0_FrameStrobe[1] VPWR VGND sg13cmos5l_antennanp
XANTENNA__368__A2 Tile_X0Y0_NN4END[1] VPWR VGND sg13cmos5l_antennanp
XFILLER_14_1054 VPWR VGND sg13cmos5l_decap_8
XFILLER_4_208 VPWR VGND sg13cmos5l_decap_8
XFILLER_1_1119 VPWR VGND sg13cmos5l_fill_1
XANTENNA__247__A Tile_X1Y0_NN4END[11] VPWR VGND sg13cmos5l_antennanp
XFILLER_12_532 VPWR VGND sg13cmos5l_decap_8
XFILLER_8_525 VPWR VGND sg13cmos5l_decap_8
XFILLER_3_263 VPWR VGND sg13cmos5l_fill_1
XANTENNA__042__D Tile_X0Y0_FrameData[28] VPWR VGND sg13cmos5l_antennanp
XANTENNA__100__GATE Tile_X1Y0_FrameStrobe[0] VPWR VGND sg13cmos5l_antennanp
XANTENNA__354__X Tile_X0Y0_FrameStrobe_O[18] VPWR VGND sg13cmos5l_antennanp
XFILLER_15_57 VPWR VGND sg13cmos5l_decap_8
XFILLER_5_528 VPWR VGND sg13cmos5l_decap_8
XFILLER_0_211 VPWR VGND sg13cmos5l_decap_8
XFILLER_5_1041 VPWR VGND sg13cmos5l_decap_8
XFILLER_1_767 VPWR VGND sg13cmos5l_fill_1
XFILLER_16_167 VPWR VGND sg13cmos5l_decap_8
XFILLER_16_189 VPWR VGND sg13cmos5l_decap_8
XANTENNA__264__X Tile_X0Y0_S2BEGb[4] VPWR VGND sg13cmos5l_antennanp
XFILLER_13_863 VPWR VGND sg13cmos5l_decap_8
XFILLER_9_845 VPWR VGND sg13cmos5l_decap_8
XFILLER_8_388 VPWR VGND sg13cmos5l_decap_8
XFILLER_8_355 VPWR VGND sg13cmos5l_decap_4
XFILLER_4_583 VPWR VGND sg13cmos5l_decap_8
XANTENNA__123__Q NPU_QUANT_SHIFT_IN8 VPWR VGND sg13cmos5l_antennanp
XFILLER_11_1035 VPWR VGND sg13cmos5l_decap_8
XANTENNA__350__A Tile_X0Y0_FrameStrobe[14] VPWR VGND sg13cmos5l_antennanp
XANTENNA__133__CLK Tile_X0Y0_UserCLK VPWR VGND sg13cmos5l_antennanp
XANTENNA__349__X Tile_X0Y0_FrameStrobe_O[13] VPWR VGND sg13cmos5l_antennanp
XFILLER_14_627 VPWR VGND sg13cmos5l_decap_8
XANTENNA__054__GATE Tile_X0Y0_FrameStrobe[0] VPWR VGND sg13cmos5l_antennanp
XFILLER_10_888 VPWR VGND sg13cmos5l_fill_1
XFILLER_13_148 VPWR VGND sg13cmos5l_decap_8
X_290_ Tile_X0Y0_SS4BEG[6] Tile_X0Y0_NN4END[9] VPWR VGND sg13cmos5l_buf_1
XANTENNA__069__GATE Tile_X0Y0_FrameStrobe[0] VPWR VGND sg13cmos5l_antennanp
XANTENNA__260__A Tile_X0Y0_N2END[7] VPWR VGND sg13cmos5l_antennanp
XFILLER_5_314 VPWR VGND sg13cmos5l_decap_4
XFILLER_1_531 VPWR VGND sg13cmos5l_decap_8
XANTENNA__259__X Tile_X1Y0_UserCLKo VPWR VGND sg13cmos5l_antennanp
XFILLER_3_49 VPWR VGND sg13cmos5l_decap_4
XFILLER_13_693 VPWR VGND sg13cmos5l_decap_8
XFILLER_9_642 VPWR VGND sg13cmos5l_decap_8
XFILLER_8_141 VPWR VGND sg13cmos5l_decap_8
XANTENNA__118__Q NPU_QUANT_SHIFT_IN3 VPWR VGND sg13cmos5l_antennanp
XANTENNA__345__A Tile_X0Y0_FrameStrobe[9] VPWR VGND sg13cmos5l_antennanp
XFILLER_12_14 VPWR VGND sg13cmos5l_fill_2
XFILLER_13_1119 VPWR VGND sg13cmos5l_fill_1
XFILLER_2_317 VPWR VGND sg13cmos5l_decap_8
XFILLER_2_1022 VPWR VGND sg13cmos5l_decap_8
XFILLER_14_413 VPWR VGND sg13cmos5l_decap_8
X_342_ Tile_X0Y0_FrameStrobe_O[6] Tile_X0Y0_FrameStrobe[6] VPWR VGND sg13cmos5l_buf_1
XFILLER_2_1099 VPWR VGND sg13cmos5l_decap_4
XANTENNA__255__A Tile_X1Y0_NN4END[3] VPWR VGND sg13cmos5l_antennanp
XFILLER_10_641 VPWR VGND sg13cmos5l_decap_8
X_273_ Tile_X0Y0_S4BEG[5] Tile_X0Y0_N4END[10] VPWR VGND sg13cmos5l_buf_1
XFILLER_6_656 VPWR VGND sg13cmos5l_decap_4
XFILLER_5_199 VPWR VGND sg13cmos5l_fill_1
XFILLER_2_884 VPWR VGND sg13cmos5l_decap_4
XFILLER_9_483 VPWR VGND sg13cmos5l_decap_8
XANTENNA__050__D Tile_X0Y0_FrameData[20] VPWR VGND sg13cmos5l_antennanp
XANTENNA__398__A0 Tile_X1Y0_N1END[0] VPWR VGND sg13cmos5l_antennanp
XANTENNA__362__X Tile_X1Y0_FrameStrobe_O[6] VPWR VGND sg13cmos5l_antennanp
XFILLER_3_615 VPWR VGND sg13cmos5l_decap_8
XFILLER_2_136 VPWR VGND sg13cmos5l_decap_8
XFILLER_2_103 VPWR VGND sg13cmos5l_decap_8
XANTENNA__389__A0 Tile_X1Y0_N4END[9] VPWR VGND sg13cmos5l_antennanp
XFILLER_14_276 VPWR VGND sg13cmos5l_decap_8
XFILLER_15_799 VPWR VGND sg13cmos5l_decap_8
X_325_ Tile_X1Y0_FrameData_O[21] Tile_X0Y0_FrameData[21] VPWR VGND sg13cmos5l_buf_1
XFILLER_9_48 VPWR VGND sg13cmos5l_decap_4
XANTENNA__272__X Tile_X0Y0_S4BEG[4] VPWR VGND sg13cmos5l_antennanp
XFILLER_11_972 VPWR VGND sg13cmos5l_decap_8
X_187_ _187_/L_HI VPWR VGND sg13cmos5l_tiehi
X_256_ Tile_X1Y0_SS4BEG[13] Tile_X1Y0_NN4END[2] VPWR VGND sg13cmos5l_buf_1
XFILLER_7_976 VPWR VGND sg13cmos5l_decap_8
XFILLER_6_475 VPWR VGND sg13cmos5l_decap_8
XFILLER_1_191 VPWR VGND sg13cmos5l_fill_1
XFILLER_2_692 VPWR VGND sg13cmos5l_decap_4
XANTENNA__395__A3 Tile_X1Y0_N2END[4] VPWR VGND sg13cmos5l_antennanp
XANTENNA__045__D Tile_X0Y0_FrameData[25] VPWR VGND sg13cmos5l_antennanp
XFILLER_9_291 VPWR VGND sg13cmos5l_decap_8
XANTENNA__131__Q NPU_QUANT_SHIFT_IN16 VPWR VGND sg13cmos5l_antennanp
XANTENNA__357__X Tile_X1Y0_FrameStrobe_O[1] VPWR VGND sg13cmos5l_antennanp
XANTENNA__386__A3 Tile_X1Y0_NN4END[6] VPWR VGND sg13cmos5l_antennanp
XFILLER_11_224 VPWR VGND sg13cmos5l_decap_8
XFILLER_12_714 VPWR VGND sg13cmos5l_decap_8
X_110_ _110_/Q Tile_X0Y0_FrameData[28] VGND VPWR Tile_X1Y0_FrameStrobe[1] latch
X_041_ _041_/Q Tile_X0Y0_FrameData[29] VGND VPWR Tile_X0Y0_FrameStrobe[0] latch
XFILLER_4_957 VPWR VGND sg13cmos5l_fill_1
XFILLER_4_946 VPWR VGND sg13cmos5l_decap_4
XFILLER_8_1061 VPWR VGND sg13cmos5l_decap_8
XFILLER_3_489 VPWR VGND sg13cmos5l_fill_1
XFILLER_3_456 VPWR VGND sg13cmos5l_decap_4
XANTENNA__267__X Tile_X0Y0_S2BEGb[7] VPWR VGND sg13cmos5l_antennanp
XANTENNA__377__A3 Tile_X0Y0_NN4END[14] VPWR VGND sg13cmos5l_antennanp
XFILLER_15_530 VPWR VGND sg13cmos5l_fill_1
XFILLER_15_563 VPWR VGND sg13cmos5l_decap_8
X_239_ Tile_X1Y0_S4BEG[12] Tile_X1Y0_N4END[3] VPWR VGND sg13cmos5l_buf_1
X_308_ Tile_X1Y0_FrameData_O[4] Tile_X0Y0_FrameData[4] VPWR VGND sg13cmos5l_buf_1
XFILLER_1_71 VPWR VGND sg13cmos5l_fill_1
XFILLER_1_60 VPWR VGND sg13cmos5l_decap_8
XANTENNA__368__A3 Tile_X0Y0_NN4END[3] VPWR VGND sg13cmos5l_antennanp
XFILLER_1_93 VPWR VGND sg13cmos5l_fill_2
XANTENNA__126__Q NPU_QUANT_SHIFT_IN11 VPWR VGND sg13cmos5l_antennanp
XANTENNA__353__A Tile_X0Y0_FrameStrobe[17] VPWR VGND sg13cmos5l_antennanp
XFILLER_14_1022 VPWR VGND sg13cmos5l_fill_1
XFILLER_14_1033 VPWR VGND sg13cmos5l_decap_8
XFILLER_1_938 VPWR VGND sg13cmos5l_fill_2
XFILLER_1_927 VPWR VGND sg13cmos5l_decap_4
XFILLER_16_349 VPWR VGND sg13cmos5l_fill_2
XANTENNA__263__A Tile_X0Y0_N2END[4] VPWR VGND sg13cmos5l_antennanp
XFILLER_12_511 VPWR VGND sg13cmos5l_decap_8
XFILLER_12_588 VPWR VGND sg13cmos5l_decap_4
XFILLER_8_504 VPWR VGND sg13cmos5l_decap_8
XFILLER_6_49 VPWR VGND sg13cmos5l_fill_2
XFILLER_4_743 VPWR VGND sg13cmos5l_fill_2
XFILLER_3_286 VPWR VGND sg13cmos5l_fill_2
XFILLER_3_275 VPWR VGND sg13cmos5l_decap_8
XFILLER_3_231 VPWR VGND sg13cmos5l_fill_2
XFILLER_3_220 VPWR VGND sg13cmos5l_fill_1
XANTENNA__348__A Tile_X0Y0_FrameStrobe[12] VPWR VGND sg13cmos5l_antennanp
XFILLER_5_507 VPWR VGND sg13cmos5l_decap_8
XFILLER_0_267 VPWR VGND sg13cmos5l_fill_1
XFILLER_0_278 VPWR VGND sg13cmos5l_decap_4
XFILLER_5_1020 VPWR VGND sg13cmos5l_decap_8
XFILLER_1_779 VPWR VGND sg13cmos5l_fill_2
XANTENNA__258__A Tile_X1Y0_NN4END[0] VPWR VGND sg13cmos5l_antennanp
XFILLER_16_146 VPWR VGND sg13cmos5l_decap_8
XFILLER_5_1097 VPWR VGND sg13cmos5l_decap_8
XFILLER_12_385 VPWR VGND sg13cmos5l_decap_8
XFILLER_13_886 VPWR VGND sg13cmos5l_fill_1
XFILLER_9_879 VPWR VGND sg13cmos5l_decap_8
XFILLER_9_824 VPWR VGND sg13cmos5l_decap_8
XFILLER_8_323 VPWR VGND sg13cmos5l_decap_8
XANTENNA__280__X Tile_X0Y0_S4BEG[12] VPWR VGND sg13cmos5l_antennanp
XFILLER_4_562 VPWR VGND sg13cmos5l_decap_8
XFILLER_15_190 VPWR VGND sg13cmos5l_decap_8
XFILLER_16_680 VPWR VGND sg13cmos5l_fill_1
XANTENNA__053__D Tile_X0Y0_FrameData[17] VPWR VGND sg13cmos5l_antennanp
XANTENNA__190__X Tile_X1Y0_FrameStrobe_O[11] VPWR VGND sg13cmos5l_antennanp
XFILLER_11_1014 VPWR VGND sg13cmos5l_decap_8
XFILLER_13_127 VPWR VGND sg13cmos5l_decap_8
XFILLER_14_606 VPWR VGND sg13cmos5l_decap_8
XFILLER_10_867 VPWR VGND sg13cmos5l_decap_8
XFILLER_9_109 VPWR VGND sg13cmos5l_decap_8
XFILLER_6_849 VPWR VGND sg13cmos5l_decap_8
XFILLER_1_587 VPWR VGND sg13cmos5l_decap_8
XANTENNA__275__X Tile_X0Y0_S4BEG[7] VPWR VGND sg13cmos5l_antennanp
XFILLER_13_672 VPWR VGND sg13cmos5l_decap_8
XFILLER_16_90 VPWR VGND sg13cmos5l_decap_8
XFILLER_9_621 VPWR VGND sg13cmos5l_decap_8
XFILLER_8_120 VPWR VGND sg13cmos5l_decap_8
XFILLER_12_182 VPWR VGND sg13cmos5l_decap_8
XFILLER_9_698 VPWR VGND sg13cmos5l_decap_8
XFILLER_8_197 VPWR VGND sg13cmos5l_decap_4
XANTENNA__048__D Tile_X0Y0_FrameData[22] VPWR VGND sg13cmos5l_antennanp
XANTENNA__114__GATE Tile_X1Y0_FrameStrobe[1] VPWR VGND sg13cmos5l_antennanp
XANTENNA__134__Q NPU_QUANT_SHIFT_IN19 VPWR VGND sg13cmos5l_antennanp
XANTENNA__361__A Tile_X1Y0_FrameStrobe[5] VPWR VGND sg13cmos5l_antennanp
XFILLER_10_620 VPWR VGND sg13cmos5l_decap_8
X_272_ Tile_X0Y0_S4BEG[4] Tile_X0Y0_N4END[11] VPWR VGND sg13cmos5l_buf_1
X_341_ Tile_X0Y0_FrameStrobe_O[5] Tile_X0Y0_FrameStrobe[5] VPWR VGND sg13cmos5l_buf_1
XFILLER_2_1078 VPWR VGND sg13cmos5l_decap_8
XANTENNA__271__A Tile_X0Y0_N4END[12] VPWR VGND sg13cmos5l_antennanp
XFILLER_10_697 VPWR VGND sg13cmos5l_decap_8
XFILLER_6_679 VPWR VGND sg13cmos5l_decap_8
XFILLER_6_646 VPWR VGND sg13cmos5l_decap_4
XFILLER_1_340 VPWR VGND sg13cmos5l_fill_1
XFILLER_14_981 VPWR VGND sg13cmos5l_fill_1
XFILLER_14_992 VPWR VGND sg13cmos5l_decap_8
XFILLER_9_462 VPWR VGND sg13cmos5l_decap_8
XANTENNA__123__CLK Tile_X0Y0_UserCLK VPWR VGND sg13cmos5l_antennanp
XANTENNA__053__GATE Tile_X0Y0_FrameStrobe[0] VPWR VGND sg13cmos5l_antennanp
XANTENNA__068__GATE Tile_X0Y0_FrameStrobe[0] VPWR VGND sg13cmos5l_antennanp
XANTENNA__129__Q NPU_QUANT_SHIFT_IN14 VPWR VGND sg13cmos5l_antennanp
XANTENNA__356__A Tile_X1Y0_FrameStrobe[0] VPWR VGND sg13cmos5l_antennanp
XANTENNA__398__A1 Tile_X1Y0_N2MID[0] VPWR VGND sg13cmos5l_antennanp
XFILLER_11_439 VPWR VGND sg13cmos5l_decap_8
XFILLER_12_929 VPWR VGND sg13cmos5l_decap_8
XFILLER_3_649 VPWR VGND sg13cmos5l_fill_1
XANTENNA__039__Q NPU_PSUM_SKEW_EN VPWR VGND sg13cmos5l_antennanp
XANTENNA__266__A Tile_X0Y0_N2END[1] VPWR VGND sg13cmos5l_antennanp
XANTENNA__389__A1 Tile_X1Y0_N4END[10] VPWR VGND sg13cmos5l_antennanp
XFILLER_15_745 VPWR VGND sg13cmos5l_fill_2
XFILLER_4_1118 VPWR VGND sg13cmos5l_fill_2
XANTENNA__146__CLK Tile_X0Y0_UserCLK VPWR VGND sg13cmos5l_antennanp
XFILLER_14_255 VPWR VGND sg13cmos5l_decap_8
XFILLER_15_778 VPWR VGND sg13cmos5l_decap_8
X_255_ Tile_X1Y0_SS4BEG[12] Tile_X1Y0_NN4END[3] VPWR VGND sg13cmos5l_buf_1
X_324_ Tile_X1Y0_FrameData_O[20] Tile_X0Y0_FrameData[20] VPWR VGND sg13cmos5l_buf_1
XFILLER_9_38 VPWR VGND sg13cmos5l_fill_1
XFILLER_10_483 VPWR VGND sg13cmos5l_decap_8
X_186_ _186_/L_HI VPWR VGND sg13cmos5l_tiehi
XFILLER_9_1029 VPWR VGND sg13cmos5l_decap_8
XFILLER_7_999 VPWR VGND sg13cmos5l_decap_8
XFILLER_6_421 VPWR VGND sg13cmos5l_decap_4
XFILLER_2_671 VPWR VGND sg13cmos5l_decap_8
XFILLER_9_270 VPWR VGND sg13cmos5l_decap_8
XANTENNA__061__D Tile_X0Y0_FrameData[9] VPWR VGND sg13cmos5l_antennanp
XFILLER_11_203 VPWR VGND sg13cmos5l_decap_8
X_040_ _040_/Q Tile_X0Y0_FrameData[30] VGND VPWR Tile_X0Y0_FrameStrobe[0] latch
XFILLER_3_424 VPWR VGND sg13cmos5l_decap_4
XFILLER_8_1040 VPWR VGND sg13cmos5l_decap_8
XFILLER_15_542 VPWR VGND sg13cmos5l_fill_2
XANTENNA__283__X Tile_X0Y0_S4BEG[15] VPWR VGND sg13cmos5l_antennanp
XFILLER_10_291 VPWR VGND sg13cmos5l_decap_8
X_169_ _169_/L_HI VPWR VGND sg13cmos5l_tiehi
X_238_ Tile_X1Y0_S4BEG[11] Tile_X1Y0_N4END[4] VPWR VGND sg13cmos5l_buf_1
X_307_ Tile_X1Y0_FrameData_O[3] Tile_X0Y0_FrameData[3] VPWR VGND sg13cmos5l_buf_1
XFILLER_6_284 VPWR VGND sg13cmos5l_decap_8
XFILLER_3_980 VPWR VGND sg13cmos5l_decap_8
XANTENNA__056__D Tile_X0Y0_FrameData[14] VPWR VGND sg13cmos5l_antennanp
XANTENNA__193__X Tile_X1Y0_FrameStrobe_O[14] VPWR VGND sg13cmos5l_antennanp
XANTENNA__142__Q NPU_QUANT_SHIFT_IN27 VPWR VGND sg13cmos5l_antennanp
XFILLER_14_1089 VPWR VGND sg13cmos5l_decap_8
XFILLER_1_906 VPWR VGND sg13cmos5l_fill_1
XFILLER_0_427 VPWR VGND sg13cmos5l_fill_1
XFILLER_16_328 VPWR VGND sg13cmos5l_decap_8
XFILLER_12_567 VPWR VGND sg13cmos5l_decap_8
XFILLER_6_28 VPWR VGND sg13cmos5l_decap_8
XFILLER_10_81 VPWR VGND sg13cmos5l_decap_8
XFILLER_4_766 VPWR VGND sg13cmos5l_decap_8
XFILLER_4_755 VPWR VGND sg13cmos5l_decap_4
XFILLER_4_722 VPWR VGND sg13cmos5l_decap_8
XFILLER_3_298 VPWR VGND sg13cmos5l_decap_4
XFILLER_3_254 VPWR VGND sg13cmos5l_decap_8
XANTENNA__278__X Tile_X0Y0_S4BEG[10] VPWR VGND sg13cmos5l_antennanp
XFILLER_0_961 VPWR VGND sg13cmos5l_fill_1
XFILLER_16_873 VPWR VGND sg13cmos5l_decap_8
XANTENNA__188__X Tile_X1Y0_FrameStrobe_O[9] VPWR VGND sg13cmos5l_antennanp
XFILLER_0_1110 VPWR VGND sg13cmos5l_decap_8
XFILLER_13_309 VPWR VGND sg13cmos5l_decap_8
XANTENNA__137__Q NPU_QUANT_SHIFT_IN22 VPWR VGND sg13cmos5l_antennanp
XANTENNA__364__A Tile_X1Y0_FrameStrobe[8] VPWR VGND sg13cmos5l_antennanp
XFILLER_1_758 VPWR VGND sg13cmos5l_decap_8
XFILLER_1_714 VPWR VGND sg13cmos5l_fill_2
XFILLER_5_1076 VPWR VGND sg13cmos5l_decap_8
XANTENNA__274__A Tile_X0Y0_N4END[9] VPWR VGND sg13cmos5l_antennanp
XFILLER_16_125 VPWR VGND sg13cmos5l_decap_4
XFILLER_9_803 VPWR VGND sg13cmos5l_decap_8
XFILLER_8_302 VPWR VGND sg13cmos5l_decap_8
XFILLER_12_364 VPWR VGND sg13cmos5l_decap_8
XFILLER_8_379 VPWR VGND sg13cmos5l_fill_2
XFILLER_16_692 VPWR VGND sg13cmos5l_decap_4
XFILLER_7_93 VPWR VGND sg13cmos5l_decap_8
XANTENNA__359__A Tile_X1Y0_FrameStrobe[3] VPWR VGND sg13cmos5l_antennanp
XFILLER_10_802 VPWR VGND sg13cmos5l_decap_8
XFILLER_13_106 VPWR VGND sg13cmos5l_decap_8
XFILLER_10_813 VPWR VGND sg13cmos5l_fill_2
XFILLER_10_846 VPWR VGND sg13cmos5l_decap_8
XFILLER_1_566 VPWR VGND sg13cmos5l_decap_8
XANTENNA__269__A Tile_X0Y0_N4END[14] VPWR VGND sg13cmos5l_antennanp
XANTENNA__291__X Tile_X0Y0_SS4BEG[7] VPWR VGND sg13cmos5l_antennanp
XFILLER_12_161 VPWR VGND sg13cmos5l_decap_8
XFILLER_13_640 VPWR VGND sg13cmos5l_fill_1
XFILLER_9_677 VPWR VGND sg13cmos5l_decap_8
XFILLER_8_176 VPWR VGND sg13cmos5l_decap_8
XFILLER_5_861 VPWR VGND sg13cmos5l_fill_2
XANTENNA__064__D Tile_X0Y0_FrameData[6] VPWR VGND sg13cmos5l_antennanp
XFILLER_10_109 VPWR VGND sg13cmos5l_decap_8
XFILLER_12_49 VPWR VGND sg13cmos5l_decap_8
XFILLER_3_809 VPWR VGND sg13cmos5l_decap_8
XANTENNA__150__Q NPU_QUANT_SHIFT_EN VPWR VGND sg13cmos5l_antennanp
XFILLER_2_1057 VPWR VGND sg13cmos5l_decap_8
XFILLER_14_459 VPWR VGND sg13cmos5l_decap_8
X_271_ Tile_X0Y0_S4BEG[3] Tile_X0Y0_N4END[12] VPWR VGND sg13cmos5l_buf_1
X_340_ Tile_X0Y0_FrameStrobe_O[4] Tile_X0Y0_FrameStrobe[4] VPWR VGND sg13cmos5l_buf_1
XFILLER_10_676 VPWR VGND sg13cmos5l_decap_8
XFILLER_6_625 VPWR VGND sg13cmos5l_decap_8
XFILLER_6_614 VPWR VGND sg13cmos5l_fill_1
XFILLER_5_168 VPWR VGND sg13cmos5l_decap_8
XFILLER_2_897 VPWR VGND sg13cmos5l_decap_8
XFILLER_2_875 VPWR VGND sg13cmos5l_fill_2
XFILLER_2_853 VPWR VGND sg13cmos5l_decap_8
XFILLER_1_363 VPWR VGND sg13cmos5l_fill_2
XANTENNA__286__X Tile_X0Y0_SS4BEG[2] VPWR VGND sg13cmos5l_antennanp
XFILLER_9_441 VPWR VGND sg13cmos5l_decap_8
XFILLER_4_83 VPWR VGND sg13cmos5l_decap_8
XFILLER_4_50 VPWR VGND sg13cmos5l_fill_1
XANTENNA__059__D Tile_X0Y0_FrameData[11] VPWR VGND sg13cmos5l_antennanp
XANTENNA__196__X Tile_X1Y0_FrameStrobe_O[17] VPWR VGND sg13cmos5l_antennanp
XANTENNA__398__A2 Tile_X1Y0_N2MID[7] VPWR VGND sg13cmos5l_antennanp
XANTENNA__145__Q NPU_COMPUTE_BANK_SWAP VPWR VGND sg13cmos5l_antennanp
XFILLER_11_418 VPWR VGND sg13cmos5l_decap_8
XFILLER_12_919 VPWR VGND sg13cmos5l_fill_1
XFILLER_1_1090 VPWR VGND sg13cmos5l_decap_8
XANTENNA__389__A2 Tile_X1Y0_NN4END[9] VPWR VGND sg13cmos5l_antennanp
XFILLER_14_234 VPWR VGND sg13cmos5l_decap_8
XFILLER_15_713 VPWR VGND sg13cmos5l_decap_4
XFILLER_15_757 VPWR VGND sg13cmos5l_decap_8
XFILLER_9_17 VPWR VGND sg13cmos5l_decap_8
XANTENNA__282__A Tile_X0Y0_N4END[1] VPWR VGND sg13cmos5l_antennanp
XFILLER_10_462 VPWR VGND sg13cmos5l_decap_8
XFILLER_13_92 VPWR VGND sg13cmos5l_decap_8
X_185_ _185_/L_HI VPWR VGND sg13cmos5l_tiehi
X_254_ Tile_X1Y0_SS4BEG[11] Tile_X1Y0_NN4END[4] VPWR VGND sg13cmos5l_buf_1
X_323_ Tile_X1Y0_FrameData_O[19] Tile_X0Y0_FrameData[19] VPWR VGND sg13cmos5l_buf_1
XANTENNA__113__GATE Tile_X1Y0_FrameStrobe[0] VPWR VGND sg13cmos5l_antennanp
XFILLER_9_1008 VPWR VGND sg13cmos5l_decap_8
XFILLER_2_650 VPWR VGND sg13cmos5l_decap_8
XFILLER_14_790 VPWR VGND sg13cmos5l_decap_8
XANTENNA__192__A Tile_X1Y0_FrameStrobe[13] VPWR VGND sg13cmos5l_antennanp
XFILLER_11_259 VPWR VGND sg13cmos5l_decap_8
XFILLER_12_749 VPWR VGND sg13cmos5l_decap_8
XANTENNA__277__A Tile_X0Y0_N4END[6] VPWR VGND sg13cmos5l_antennanp
XFILLER_8_1096 VPWR VGND sg13cmos5l_decap_8
XFILLER_15_598 VPWR VGND sg13cmos5l_decap_8
X_306_ Tile_X1Y0_FrameData_O[2] Tile_X0Y0_FrameData[2] VPWR VGND sg13cmos5l_buf_1
XANTENNA__052__GATE Tile_X0Y0_FrameStrobe[0] VPWR VGND sg13cmos5l_antennanp
XFILLER_10_270 VPWR VGND sg13cmos5l_decap_8
XFILLER_11_782 VPWR VGND sg13cmos5l_decap_8
X_168_ _168_/L_HI VPWR VGND sg13cmos5l_tiehi
X_237_ Tile_X1Y0_S4BEG[10] Tile_X1Y0_N4END[5] VPWR VGND sg13cmos5l_buf_1
XFILLER_7_797 VPWR VGND sg13cmos5l_decap_8
XFILLER_7_753 VPWR VGND sg13cmos5l_decap_4
XFILLER_6_263 VPWR VGND sg13cmos5l_decap_8
XFILLER_6_230 VPWR VGND sg13cmos5l_decap_4
XANTENNA__067__GATE Tile_X0Y0_FrameStrobe[0] VPWR VGND sg13cmos5l_antennanp
X_099_ _099_/Q Tile_X0Y0_FrameData[7] VGND VPWR Tile_X1Y0_FrameStrobe[0] latch
XFILLER_2_491 VPWR VGND sg13cmos5l_fill_2
XFILLER_1_95 VPWR VGND sg13cmos5l_fill_1
XFILLER_1_84 VPWR VGND sg13cmos5l_fill_2
XFILLER_14_1013 VPWR VGND sg13cmos5l_decap_8
XANTENNA__072__D Tile_X0Y0_FrameData[30] VPWR VGND sg13cmos5l_antennanp
XFILLER_14_1068 VPWR VGND sg13cmos5l_decap_8
XANTENNA__136__CLK Tile_X0Y0_UserCLK VPWR VGND sg13cmos5l_antennanp
XFILLER_12_546 VPWR VGND sg13cmos5l_decap_8
XFILLER_16_307 VPWR VGND sg13cmos5l_decap_8
XFILLER_8_539 VPWR VGND sg13cmos5l_decap_8
XFILLER_0_951 VPWR VGND sg13cmos5l_fill_2
XFILLER_10_60 VPWR VGND sg13cmos5l_decap_8
XFILLER_4_745 VPWR VGND sg13cmos5l_fill_1
XFILLER_16_852 VPWR VGND sg13cmos5l_decap_8
XANTENNA__294__X Tile_X0Y0_SS4BEG[10] VPWR VGND sg13cmos5l_antennanp
XFILLER_15_351 VPWR VGND sg13cmos5l_fill_2
XFILLER_15_362 VPWR VGND sg13cmos5l_decap_8
XFILLER_7_583 VPWR VGND sg13cmos5l_decap_8
XANTENNA__067__D Tile_X0Y0_FrameData[3] VPWR VGND sg13cmos5l_antennanp
XFILLER_15_38 VPWR VGND sg13cmos5l_decap_8
XFILLER_16_1108 VPWR VGND sg13cmos5l_decap_8
XFILLER_16_1119 VPWR VGND sg13cmos5l_fill_1
XFILLER_0_225 VPWR VGND sg13cmos5l_decap_8
XFILLER_0_247 VPWR VGND sg13cmos5l_decap_8
XFILLER_16_104 VPWR VGND sg13cmos5l_decap_8
XFILLER_5_1055 VPWR VGND sg13cmos5l_decap_8
XFILLER_12_343 VPWR VGND sg13cmos5l_decap_8
XFILLER_13_833 VPWR VGND sg13cmos5l_decap_8
XFILLER_13_877 VPWR VGND sg13cmos5l_decap_8
XANTENNA__290__A Tile_X0Y0_NN4END[9] VPWR VGND sg13cmos5l_antennanp
XANTENNA__370__A0 Tile_X0Y0_N4END[5] VPWR VGND sg13cmos5l_antennanp
XFILLER_8_347 VPWR VGND sg13cmos5l_fill_1
XANTENNA__289__X Tile_X0Y0_SS4BEG[5] VPWR VGND sg13cmos5l_antennanp
XFILLER_0_781 VPWR VGND sg13cmos5l_decap_8
XFILLER_4_597 VPWR VGND sg13cmos5l_decap_8
XFILLER_16_660 VPWR VGND sg13cmos5l_decap_4
XFILLER_8_881 VPWR VGND sg13cmos5l_decap_8
XFILLER_7_72 VPWR VGND sg13cmos5l_decap_8
XANTENNA__199__X Tile_X0Y0_S2BEG[0] VPWR VGND sg13cmos5l_antennanp
XFILLER_11_1049 VPWR VGND sg13cmos5l_decap_8
XANTENNA__148__Q NPU_PSUM_SYSTOLIC_EN VPWR VGND sg13cmos5l_antennanp
XFILLER_10_825 VPWR VGND sg13cmos5l_decap_8
XFILLER_6_818 VPWR VGND sg13cmos5l_fill_2
XFILLER_7_1106 VPWR VGND sg13cmos5l_decap_8
XFILLER_3_19 VPWR VGND sg13cmos5l_fill_1
XFILLER_1_545 VPWR VGND sg13cmos5l_decap_8
XANTENNA__285__A Tile_X0Y0_NN4END[14] VPWR VGND sg13cmos5l_antennanp
XFILLER_12_140 VPWR VGND sg13cmos5l_decap_8
XFILLER_9_656 VPWR VGND sg13cmos5l_decap_8
XFILLER_8_155 VPWR VGND sg13cmos5l_decap_8
XFILLER_10_1082 VPWR VGND sg13cmos5l_decap_8
XFILLER_5_884 VPWR VGND sg13cmos5l_decap_8
XFILLER_4_361 VPWR VGND sg13cmos5l_decap_8
XANTENNA__195__A Tile_X1Y0_FrameStrobe[16] VPWR VGND sg13cmos5l_antennanp
XANTENNA__080__D Tile_X0Y0_FrameData[26] VPWR VGND sg13cmos5l_antennanp
XFILLER_14_427 VPWR VGND sg13cmos5l_decap_8
XFILLER_2_1036 VPWR VGND sg13cmos5l_decap_8
XFILLER_10_655 VPWR VGND sg13cmos5l_decap_8
X_270_ Tile_X0Y0_S4BEG[2] Tile_X0Y0_N4END[13] VPWR VGND sg13cmos5l_buf_1
XFILLER_13_482 VPWR VGND sg13cmos5l_decap_8
X_399_ _399_/X Tile_X0Y0_N1END[2] Tile_X0Y0_N2MID[2] Tile_X0Y0_N2MID[5] Tile_X0Y0_N2END[5]
+ _040_/Q _075_/Q VPWR VGND sg13cmos5l_mux4_1
XFILLER_9_497 VPWR VGND sg13cmos5l_decap_8
XFILLER_9_420 VPWR VGND sg13cmos5l_decap_8
XFILLER_5_670 VPWR VGND sg13cmos5l_fill_1
XFILLER_4_62 VPWR VGND sg13cmos5l_decap_8
XANTENNA__398__A3 Tile_X1Y0_N2END[7] VPWR VGND sg13cmos5l_antennanp
XANTENNA__075__D Tile_X0Y0_FrameData[31] VPWR VGND sg13cmos5l_antennanp
XFILLER_3_629 VPWR VGND sg13cmos5l_decap_4
XFILLER_2_117 VPWR VGND sg13cmos5l_decap_8
XANTENNA__389__A3 Tile_X1Y0_NN4END[11] VPWR VGND sg13cmos5l_antennanp
XFILLER_14_213 VPWR VGND sg13cmos5l_decap_8
X_322_ Tile_X1Y0_FrameData_O[18] Tile_X0Y0_FrameData[18] VPWR VGND sg13cmos5l_buf_1
XFILLER_10_441 VPWR VGND sg13cmos5l_decap_8
XFILLER_11_986 VPWR VGND sg13cmos5l_decap_8
XFILLER_13_71 VPWR VGND sg13cmos5l_decap_8
X_184_ _184_/L_HI VPWR VGND sg13cmos5l_tiehi
X_253_ Tile_X1Y0_SS4BEG[10] Tile_X1Y0_NN4END[5] VPWR VGND sg13cmos5l_buf_1
XFILLER_1_161 VPWR VGND sg13cmos5l_decap_8
XFILLER_6_489 VPWR VGND sg13cmos5l_decap_8
XANTENNA__297__X Tile_X0Y0_SS4BEG[13] VPWR VGND sg13cmos5l_antennanp
XFILLER_12_728 VPWR VGND sg13cmos5l_decap_8
XFILLER_11_238 VPWR VGND sg13cmos5l_decap_8
XFILLER_8_1075 VPWR VGND sg13cmos5l_decap_8
XANTENNA__293__A Tile_X0Y0_NN4END[6] VPWR VGND sg13cmos5l_antennanp
XFILLER_11_761 VPWR VGND sg13cmos5l_decap_8
XFILLER_15_544 VPWR VGND sg13cmos5l_fill_1
XFILLER_15_577 VPWR VGND sg13cmos5l_decap_8
X_305_ Tile_X1Y0_FrameData_O[1] Tile_X0Y0_FrameData[1] VPWR VGND sg13cmos5l_buf_1
X_098_ _098_/Q Tile_X0Y0_FrameData[8] VGND VPWR Tile_X1Y0_FrameStrobe[0] latch
X_167_ _167_/L_HI VPWR VGND sg13cmos5l_tiehi
X_236_ Tile_X1Y0_S4BEG[9] Tile_X1Y0_N4END[6] VPWR VGND sg13cmos5l_buf_1
XFILLER_7_732 VPWR VGND sg13cmos5l_decap_8
XFILLER_2_470 VPWR VGND sg13cmos5l_decap_8
XFILLER_14_1047 VPWR VGND sg13cmos5l_decap_8
XANTENNA__112__GATE Tile_X1Y0_FrameStrobe[1] VPWR VGND sg13cmos5l_antennanp
XFILLER_12_525 VPWR VGND sg13cmos5l_decap_8
XFILLER_8_518 VPWR VGND sg13cmos5l_decap_8
XANTENNA__288__A Tile_X0Y0_NN4END[11] VPWR VGND sg13cmos5l_antennanp
XFILLER_0_930 VPWR VGND sg13cmos5l_fill_1
XFILLER_15_330 VPWR VGND sg13cmos5l_decap_8
XFILLER_16_831 VPWR VGND sg13cmos5l_decap_8
XFILLER_16_886 VPWR VGND sg13cmos5l_fill_2
X_219_ Tile_X1Y0_S2BEGb[0] Tile_X1Y0_N2END[7] VPWR VGND sg13cmos5l_buf_1
XFILLER_13_1091 VPWR VGND sg13cmos5l_decap_8
XFILLER_7_562 VPWR VGND sg13cmos5l_decap_8
XANTENNA__198__A Tile_X1Y0_FrameStrobe[19] VPWR VGND sg13cmos5l_antennanp
XFILLER_15_17 VPWR VGND sg13cmos5l_fill_2
XANTENNA__083__D Tile_X0Y0_FrameData[23] VPWR VGND sg13cmos5l_antennanp
XFILLER_0_204 VPWR VGND sg13cmos5l_decap_8
XFILLER_1_738 VPWR VGND sg13cmos5l_fill_2
XFILLER_1_716 VPWR VGND sg13cmos5l_fill_1
XANTENNA__051__GATE Tile_X0Y0_FrameStrobe[0] VPWR VGND sg13cmos5l_antennanp
XFILLER_5_1034 VPWR VGND sg13cmos5l_decap_8
XANTENNA__066__GATE Tile_X0Y0_FrameStrobe[0] VPWR VGND sg13cmos5l_antennanp
XFILLER_12_322 VPWR VGND sg13cmos5l_decap_8
XFILLER_12_399 VPWR VGND sg13cmos5l_decap_8
XFILLER_13_812 VPWR VGND sg13cmos5l_decap_8
XFILLER_13_856 VPWR VGND sg13cmos5l_decap_8
XFILLER_9_838 VPWR VGND sg13cmos5l_decap_8
XFILLER_8_359 VPWR VGND sg13cmos5l_fill_2
XFILLER_8_337 VPWR VGND sg13cmos5l_fill_2
XANTENNA__370__A1 Tile_X0Y0_N4END[6] VPWR VGND sg13cmos5l_antennanp
XFILLER_4_576 VPWR VGND sg13cmos5l_decap_8
XFILLER_0_760 VPWR VGND sg13cmos5l_decap_8
XFILLER_16_672 VPWR VGND sg13cmos5l_fill_1
XANTENNA__126__CLK Tile_X0Y0_UserCLK VPWR VGND sg13cmos5l_antennanp
XFILLER_11_1028 VPWR VGND sg13cmos5l_decap_8
XFILLER_8_860 VPWR VGND sg13cmos5l_decap_8
XFILLER_7_51 VPWR VGND sg13cmos5l_fill_2
XFILLER_7_40 VPWR VGND sg13cmos5l_decap_8
XANTENNA__078__D Tile_X0Y0_FrameData[28] VPWR VGND sg13cmos5l_antennanp
XFILLER_5_318 VPWR VGND sg13cmos5l_fill_2
XFILLER_5_307 VPWR VGND sg13cmos5l_decap_8
XFILLER_1_524 VPWR VGND sg13cmos5l_decap_8
XANTENNA__149__CLK Tile_X0Y0_UserCLK VPWR VGND sg13cmos5l_antennanp
XFILLER_12_196 VPWR VGND sg13cmos5l_decap_8
XFILLER_13_686 VPWR VGND sg13cmos5l_decap_8
XFILLER_9_635 VPWR VGND sg13cmos5l_decap_8
XFILLER_8_134 VPWR VGND sg13cmos5l_decap_8
XFILLER_10_1061 VPWR VGND sg13cmos5l_decap_8
XFILLER_14_406 VPWR VGND sg13cmos5l_decap_8
XFILLER_2_1015 VPWR VGND sg13cmos5l_decap_8
XFILLER_10_634 VPWR VGND sg13cmos5l_decap_8
XFILLER_2_888 VPWR VGND sg13cmos5l_fill_2
XFILLER_2_811 VPWR VGND sg13cmos5l_decap_8
XANTENNA__296__A Tile_X0Y0_NN4END[3] VPWR VGND sg13cmos5l_antennanp
XFILLER_13_461 VPWR VGND sg13cmos5l_decap_8
X_398_ _398_/X Tile_X1Y0_N1END[0] Tile_X1Y0_N2MID[0] Tile_X1Y0_N2MID[7] Tile_X1Y0_N2END[7]
+ _082_/Q _081_/Q VPWR VGND sg13cmos5l_mux4_1
XFILLER_9_476 VPWR VGND sg13cmos5l_decap_8
XFILLER_5_693 VPWR VGND sg13cmos5l_decap_8
XANTENNA__091__D Tile_X0Y0_FrameData[15] VPWR VGND sg13cmos5l_antennanp
XFILLER_3_608 VPWR VGND sg13cmos5l_decap_8
XFILLER_10_420 VPWR VGND sg13cmos5l_decap_8
XFILLER_14_269 VPWR VGND sg13cmos5l_decap_8
XFILLER_15_737 VPWR VGND sg13cmos5l_fill_1
X_252_ Tile_X1Y0_SS4BEG[9] Tile_X1Y0_NN4END[6] VPWR VGND sg13cmos5l_buf_1
X_321_ Tile_X1Y0_FrameData_O[17] Tile_X0Y0_FrameData[17] VPWR VGND sg13cmos5l_buf_1
XFILLER_10_497 VPWR VGND sg13cmos5l_decap_8
XFILLER_13_50 VPWR VGND sg13cmos5l_decap_8
X_183_ _183_/L_HI VPWR VGND sg13cmos5l_tiehi
XFILLER_6_468 VPWR VGND sg13cmos5l_decap_8
XFILLER_1_184 VPWR VGND sg13cmos5l_decap_8
XFILLER_2_696 VPWR VGND sg13cmos5l_fill_1
XFILLER_2_685 VPWR VGND sg13cmos5l_decap_8
XFILLER_9_284 VPWR VGND sg13cmos5l_decap_8
XANTENNA__086__D Tile_X0Y0_FrameData[20] VPWR VGND sg13cmos5l_antennanp
XFILLER_11_217 VPWR VGND sg13cmos5l_decap_8
XFILLER_12_707 VPWR VGND sg13cmos5l_decap_8
XFILLER_8_1054 VPWR VGND sg13cmos5l_decap_8
XFILLER_8_1021 VPWR VGND sg13cmos5l_fill_2
XFILLER_15_512 VPWR VGND sg13cmos5l_decap_8
XFILLER_11_740 VPWR VGND sg13cmos5l_decap_8
XFILLER_15_556 VPWR VGND sg13cmos5l_decap_8
X_235_ Tile_X1Y0_S4BEG[8] Tile_X1Y0_N4END[7] VPWR VGND sg13cmos5l_buf_1
X_304_ Tile_X1Y0_FrameData_O[0] Tile_X0Y0_FrameData[0] VPWR VGND sg13cmos5l_buf_1
XFILLER_7_711 VPWR VGND sg13cmos5l_decap_4
X_097_ _097_/Q Tile_X0Y0_FrameData[9] VGND VPWR Tile_X1Y0_FrameStrobe[0] latch
X_166_ _166_/L_HI VPWR VGND sg13cmos5l_tiehi
XFILLER_6_298 VPWR VGND sg13cmos5l_decap_8
XFILLER_1_31 VPWR VGND sg13cmos5l_fill_1
XFILLER_3_994 VPWR VGND sg13cmos5l_decap_8
XFILLER_1_53 VPWR VGND sg13cmos5l_fill_1
XFILLER_1_86 VPWR VGND sg13cmos5l_fill_1
XFILLER_1_75 VPWR VGND sg13cmos5l_decap_4
XFILLER_14_1026 VPWR VGND sg13cmos5l_decap_8
XFILLER_12_504 VPWR VGND sg13cmos5l_decap_8
XFILLER_4_736 VPWR VGND sg13cmos5l_decap_8
XFILLER_3_268 VPWR VGND sg13cmos5l_decap_8
XFILLER_3_202 VPWR VGND sg13cmos5l_decap_8
XFILLER_10_95 VPWR VGND sg13cmos5l_decap_8
XFILLER_15_353 VPWR VGND sg13cmos5l_fill_1
XFILLER_16_810 VPWR VGND sg13cmos5l_decap_8
XFILLER_16_898 VPWR VGND sg13cmos5l_fill_2
XFILLER_13_1070 VPWR VGND sg13cmos5l_decap_8
X_149_ NPU_ARRAY_EN Tile_X0Y0_UserCLK _400_/X _164_/L_HI VPWR VGND sg13cmos5l_dfrbpq_1
X_218_ Tile_X1Y0_S2BEG[7] Tile_X1Y0_N2MID[0] VPWR VGND sg13cmos5l_buf_1
XFILLER_7_541 VPWR VGND sg13cmos5l_decap_8
XFILLER_3_791 VPWR VGND sg13cmos5l_decap_4
XFILLER_5_1013 VPWR VGND sg13cmos5l_decap_8
XFILLER_12_301 VPWR VGND sg13cmos5l_decap_8
XFILLER_16_139 VPWR VGND sg13cmos5l_decap_8
XFILLER_12_378 VPWR VGND sg13cmos5l_decap_8
XFILLER_9_817 VPWR VGND sg13cmos5l_decap_8
XFILLER_8_316 VPWR VGND sg13cmos5l_decap_8
XANTENNA__299__A Tile_X0Y0_NN4END[0] VPWR VGND sg13cmos5l_antennanp
XANTENNA__370__A2 Tile_X0Y0_NN4END[5] VPWR VGND sg13cmos5l_antennanp
XFILLER_0_750 VPWR VGND sg13cmos5l_fill_1
XFILLER_4_555 VPWR VGND sg13cmos5l_decap_8
XFILLER_4_522 VPWR VGND sg13cmos5l_fill_2
XFILLER_15_183 VPWR VGND sg13cmos5l_decap_8
XFILLER_16_640 VPWR VGND sg13cmos5l_fill_1
XFILLER_16_684 VPWR VGND sg13cmos5l_decap_4
XFILLER_11_1007 VPWR VGND sg13cmos5l_decap_8
XFILLER_7_63 VPWR VGND sg13cmos5l_decap_4
XANTENNA__111__GATE Tile_X1Y0_FrameStrobe[1] VPWR VGND sg13cmos5l_antennanp
XANTENNA__094__D Tile_X0Y0_FrameData[12] VPWR VGND sg13cmos5l_antennanp
XFILLER_16_83 VPWR VGND sg13cmos5l_decap_8
XFILLER_9_614 VPWR VGND sg13cmos5l_decap_8
XFILLER_9_603 VPWR VGND sg13cmos5l_fill_1
XFILLER_10_1040 VPWR VGND sg13cmos5l_decap_8
XFILLER_12_175 VPWR VGND sg13cmos5l_decap_8
XFILLER_8_113 VPWR VGND sg13cmos5l_decap_8
XFILLER_4_385 VPWR VGND sg13cmos5l_decap_8
XFILLER_16_481 VPWR VGND sg13cmos5l_decap_4
XANTENNA__050__GATE Tile_X0Y0_FrameStrobe[0] VPWR VGND sg13cmos5l_antennanp
XANTENNA__065__GATE Tile_X0Y0_FrameStrobe[0] VPWR VGND sg13cmos5l_antennanp
XANTENNA__089__D Tile_X0Y0_FrameData[17] VPWR VGND sg13cmos5l_antennanp
XFILLER_10_613 VPWR VGND sg13cmos5l_decap_8
XFILLER_6_639 VPWR VGND sg13cmos5l_decap_8
XFILLER_1_300 VPWR VGND sg13cmos5l_fill_1
XFILLER_1_322 VPWR VGND sg13cmos5l_decap_4
XANTENNA__116__CLK Tile_X0Y0_UserCLK VPWR VGND sg13cmos5l_antennanp
XFILLER_13_440 VPWR VGND sg13cmos5l_decap_8
XFILLER_14_985 VPWR VGND sg13cmos5l_decap_8
X_397_ _397_/X Tile_X1Y0_N1END[1] Tile_X1Y0_N2MID[1] Tile_X1Y0_N2MID[6] Tile_X1Y0_N2END[6]
+ _080_/Q _079_/Q VPWR VGND sg13cmos5l_mux4_1
XFILLER_9_455 VPWR VGND sg13cmos5l_decap_8
XFILLER_12_1113 VPWR VGND sg13cmos5l_decap_8
XFILLER_4_97 VPWR VGND sg13cmos5l_decap_8
XANTENNA__139__CLK Tile_X0Y0_UserCLK VPWR VGND sg13cmos5l_antennanp
XFILLER_15_705 VPWR VGND sg13cmos5l_decap_4
XFILLER_14_248 VPWR VGND sg13cmos5l_decap_8
X_182_ _182_/L_HI VPWR VGND sg13cmos5l_tiehi
X_251_ Tile_X1Y0_SS4BEG[8] Tile_X1Y0_NN4END[7] VPWR VGND sg13cmos5l_buf_1
X_320_ Tile_X1Y0_FrameData_O[16] Tile_X0Y0_FrameData[16] VPWR VGND sg13cmos5l_buf_1
XFILLER_10_476 VPWR VGND sg13cmos5l_decap_8
XFILLER_8_0 VPWR VGND sg13cmos5l_fill_2
XFILLER_6_425 VPWR VGND sg13cmos5l_fill_2
XFILLER_1_196 VPWR VGND sg13cmos5l_decap_4
XFILLER_2_664 VPWR VGND sg13cmos5l_decap_8
XFILLER_13_281 VPWR VGND sg13cmos5l_decap_8
XFILLER_9_263 VPWR VGND sg13cmos5l_decap_8
XFILLER_8_1033 VPWR VGND sg13cmos5l_decap_8
XFILLER_15_535 VPWR VGND sg13cmos5l_decap_8
XFILLER_10_284 VPWR VGND sg13cmos5l_decap_8
XFILLER_11_796 VPWR VGND sg13cmos5l_decap_8
X_165_ _165_/L_HI VPWR VGND sg13cmos5l_tiehi
X_234_ Tile_X1Y0_S4BEG[7] Tile_X1Y0_N4END[8] VPWR VGND sg13cmos5l_buf_1
X_303_ Tile_X0Y0_S1BEG[3] Tile_X0Y0_N1END[0] VPWR VGND sg13cmos5l_buf_1
X_096_ _096_/Q Tile_X0Y0_FrameData[10] VGND VPWR Tile_X1Y0_FrameStrobe[0] latch
XFILLER_6_277 VPWR VGND sg13cmos5l_decap_8
XFILLER_3_973 VPWR VGND sg13cmos5l_decap_8
XANTENNA__391__A0 Tile_X1Y0_N4END[8] VPWR VGND sg13cmos5l_antennanp
XANTENNA__097__D Tile_X0Y0_FrameData[9] VPWR VGND sg13cmos5l_antennanp
XANTENNA__382__A0 Tile_X1Y0_N4END[2] VPWR VGND sg13cmos5l_antennanp
XFILLER_0_910 VPWR VGND sg13cmos5l_fill_1
XFILLER_10_74 VPWR VGND sg13cmos5l_decap_8
XFILLER_4_759 VPWR VGND sg13cmos5l_fill_1
XANTENNA__202__X Tile_X0Y0_S2BEG[3] VPWR VGND sg13cmos5l_antennanp
XFILLER_15_376 VPWR VGND sg13cmos5l_decap_4
XFILLER_16_866 VPWR VGND sg13cmos5l_decap_8
XANTENNA__373__A0 Tile_X0Y0_N4END[8] VPWR VGND sg13cmos5l_antennanp
XFILLER_11_593 VPWR VGND sg13cmos5l_fill_2
X_148_ NPU_PSUM_SYSTOLIC_EN Tile_X0Y0_UserCLK _399_/X _168_/L_HI VPWR VGND sg13cmos5l_dfrbpq_1
X_217_ Tile_X1Y0_S2BEG[6] Tile_X1Y0_N2MID[1] VPWR VGND sg13cmos5l_buf_1
XFILLER_7_597 VPWR VGND sg13cmos5l_fill_2
XFILLER_7_520 VPWR VGND sg13cmos5l_decap_8
X_079_ _079_/Q Tile_X0Y0_FrameData[27] VGND VPWR Tile_X1Y0_FrameStrobe[0] latch
XFILLER_3_770 VPWR VGND sg13cmos5l_decap_8
XFILLER_0_1103 VPWR VGND sg13cmos5l_decap_8
XFILLER_1_707 VPWR VGND sg13cmos5l_decap_8
XFILLER_5_1069 VPWR VGND sg13cmos5l_decap_8
XFILLER_13_847 VPWR VGND sg13cmos5l_decap_4
XFILLER_16_118 VPWR VGND sg13cmos5l_decap_8
XANTENNA__370__A3 Tile_X0Y0_NN4END[7] VPWR VGND sg13cmos5l_antennanp
XFILLER_12_357 VPWR VGND sg13cmos5l_decap_8
XFILLER_8_339 VPWR VGND sg13cmos5l_fill_1
XFILLER_4_501 VPWR VGND sg13cmos5l_decap_8
XFILLER_0_795 VPWR VGND sg13cmos5l_decap_8
XFILLER_16_652 VPWR VGND sg13cmos5l_decap_4
XFILLER_15_162 VPWR VGND sg13cmos5l_decap_8
XFILLER_16_696 VPWR VGND sg13cmos5l_fill_1
XFILLER_11_390 VPWR VGND sg13cmos5l_decap_8
XFILLER_8_895 VPWR VGND sg13cmos5l_decap_8
XFILLER_7_86 VPWR VGND sg13cmos5l_decap_8
XFILLER_4_1080 VPWR VGND sg13cmos5l_decap_8
XFILLER_10_839 VPWR VGND sg13cmos5l_decap_8
XFILLER_1_559 VPWR VGND sg13cmos5l_decap_8
XFILLER_12_154 VPWR VGND sg13cmos5l_decap_8
XFILLER_13_622 VPWR VGND sg13cmos5l_decap_8
XFILLER_16_62 VPWR VGND sg13cmos5l_decap_8
XFILLER_8_169 VPWR VGND sg13cmos5l_decap_8
XFILLER_5_854 VPWR VGND sg13cmos5l_decap_8
XFILLER_5_821 VPWR VGND sg13cmos5l_decap_8
XFILLER_4_375 VPWR VGND sg13cmos5l_decap_4
XFILLER_0_592 VPWR VGND sg13cmos5l_fill_2
XFILLER_10_1096 VPWR VGND sg13cmos5l_decap_8
XFILLER_16_460 VPWR VGND sg13cmos5l_fill_1
XANTENNA__300__X Tile_X0Y0_S1BEG[0] VPWR VGND sg13cmos5l_antennanp
XFILLER_10_669 VPWR VGND sg13cmos5l_decap_8
XFILLER_6_618 VPWR VGND sg13cmos5l_decap_8
XANTENNA__210__X Tile_X1Y0_S1BEG[3] VPWR VGND sg13cmos5l_antennanp
XFILLER_2_868 VPWR VGND sg13cmos5l_decap_8
XFILLER_2_846 VPWR VGND sg13cmos5l_decap_8
XFILLER_2_835 VPWR VGND sg13cmos5l_decap_8
XANTENNA__110__GATE Tile_X1Y0_FrameStrobe[1] VPWR VGND sg13cmos5l_antennanp
XFILLER_13_496 VPWR VGND sg13cmos5l_decap_8
X_396_ _396_/X Tile_X1Y0_N1END[2] Tile_X1Y0_N2MID[2] Tile_X1Y0_N2MID[5] Tile_X1Y0_N2END[5]
+ _078_/Q _077_/Q VPWR VGND sg13cmos5l_mux4_1
XFILLER_9_434 VPWR VGND sg13cmos5l_decap_8
XFILLER_4_76 VPWR VGND sg13cmos5l_decap_8
XFILLER_4_54 VPWR VGND sg13cmos5l_fill_2
XFILLER_4_43 VPWR VGND sg13cmos5l_decap_8
XFILLER_1_1083 VPWR VGND sg13cmos5l_decap_8
XFILLER_14_227 VPWR VGND sg13cmos5l_decap_8
XFILLER_10_455 VPWR VGND sg13cmos5l_decap_8
XFILLER_11_901 VPWR VGND sg13cmos5l_decap_8
X_181_ _181_/L_HI VPWR VGND sg13cmos5l_tiehi
X_250_ Tile_X1Y0_SS4BEG[7] Tile_X1Y0_NN4END[8] VPWR VGND sg13cmos5l_buf_1
XANTENNA__205__X Tile_X0Y0_S2BEG[6] VPWR VGND sg13cmos5l_antennanp
XFILLER_13_85 VPWR VGND sg13cmos5l_decap_8
XFILLER_2_643 VPWR VGND sg13cmos5l_decap_8
XFILLER_2_621 VPWR VGND sg13cmos5l_decap_8
XFILLER_1_175 VPWR VGND sg13cmos5l_decap_4
XFILLER_13_260 VPWR VGND sg13cmos5l_decap_8
XFILLER_14_783 VPWR VGND sg13cmos5l_decap_8
XANTENNA__064__GATE Tile_X0Y0_FrameStrobe[0] VPWR VGND sg13cmos5l_antennanp
XFILLER_16_1080 VPWR VGND sg13cmos5l_decap_8
X_379_ _379_/X Tile_X0Y0_N4END[14] Tile_X0Y0_N4END[15] Tile_X0Y0_NN4END[12] Tile_X0Y0_NN4END[14]
+ _046_/Q _045_/Q VPWR VGND sg13cmos5l_mux4_1
XFILLER_9_242 VPWR VGND sg13cmos5l_decap_8
XANTENNA__079__GATE Tile_X1Y0_FrameStrobe[0] VPWR VGND sg13cmos5l_antennanp
XANTENNA__201__A Tile_X0Y0_N2MID[5] VPWR VGND sg13cmos5l_antennanp
XFILLER_8_1089 VPWR VGND sg13cmos5l_decap_8
X_302_ Tile_X0Y0_S1BEG[2] Tile_X0Y0_N1END[1] VPWR VGND sg13cmos5l_buf_1
XFILLER_10_263 VPWR VGND sg13cmos5l_decap_8
XFILLER_11_775 VPWR VGND sg13cmos5l_decap_8
X_095_ _095_/Q Tile_X0Y0_FrameData[11] VGND VPWR Tile_X1Y0_FrameStrobe[0] latch
X_164_ _164_/L_HI VPWR VGND sg13cmos5l_tiehi
X_233_ Tile_X1Y0_S4BEG[6] Tile_X1Y0_N4END[9] VPWR VGND sg13cmos5l_buf_1
XFILLER_7_757 VPWR VGND sg13cmos5l_fill_2
XFILLER_7_746 VPWR VGND sg13cmos5l_decap_8
XFILLER_6_256 VPWR VGND sg13cmos5l_decap_8
XFILLER_6_245 VPWR VGND sg13cmos5l_fill_1
XFILLER_6_223 VPWR VGND sg13cmos5l_decap_8
XFILLER_3_952 VPWR VGND sg13cmos5l_decap_8
XFILLER_2_484 VPWR VGND sg13cmos5l_decap_8
XFILLER_1_99 VPWR VGND sg13cmos5l_decap_8
XANTENNA__129__CLK Tile_X0Y0_UserCLK VPWR VGND sg13cmos5l_antennanp
XANTENNA__391__A1 Tile_X1Y0_N4END[11] VPWR VGND sg13cmos5l_antennanp
XFILLER_14_1006 VPWR VGND sg13cmos5l_decap_8
XANTENNA__382__A1 Tile_X1Y0_N4END[3] VPWR VGND sg13cmos5l_antennanp
XFILLER_12_539 VPWR VGND sg13cmos5l_decap_8
XFILLER_0_900 VPWR VGND sg13cmos5l_fill_1
XFILLER_0_922 VPWR VGND sg13cmos5l_fill_1
XFILLER_10_20 VPWR VGND sg13cmos5l_fill_1
XFILLER_10_31 VPWR VGND sg13cmos5l_decap_4
XFILLER_10_53 VPWR VGND sg13cmos5l_decap_8
XANTENNA__373__A1 Tile_X0Y0_N4END[9] VPWR VGND sg13cmos5l_antennanp
XFILLER_15_344 VPWR VGND sg13cmos5l_decap_8
XFILLER_16_845 VPWR VGND sg13cmos5l_decap_8
XFILLER_11_572 VPWR VGND sg13cmos5l_decap_8
X_078_ _078_/Q Tile_X0Y0_FrameData[28] VGND VPWR Tile_X1Y0_FrameStrobe[0] latch
X_147_ NPU_PSUM_LUT_EN Tile_X0Y0_UserCLK _398_/X _169_/L_HI VPWR VGND sg13cmos5l_dfrbpq_1
X_216_ Tile_X1Y0_S2BEG[5] Tile_X1Y0_N2MID[2] VPWR VGND sg13cmos5l_buf_1
XFILLER_7_576 VPWR VGND sg13cmos5l_decap_8
XFILLER_2_292 VPWR VGND sg13cmos5l_fill_1
XFILLER_2_281 VPWR VGND sg13cmos5l_decap_8
XANTENNA__303__X Tile_X0Y0_S1BEG[3] VPWR VGND sg13cmos5l_antennanp
XFILLER_0_218 VPWR VGND sg13cmos5l_decap_8
XFILLER_5_1048 VPWR VGND sg13cmos5l_decap_8
XFILLER_12_336 VPWR VGND sg13cmos5l_decap_8
XFILLER_13_826 VPWR VGND sg13cmos5l_decap_8
XANTENNA__213__X Tile_X1Y0_S2BEG[2] VPWR VGND sg13cmos5l_antennanp
XFILLER_0_774 VPWR VGND sg13cmos5l_decap_8
XFILLER_15_141 VPWR VGND sg13cmos5l_decap_8
XFILLER_16_620 VPWR VGND sg13cmos5l_decap_4
XFILLER_16_664 VPWR VGND sg13cmos5l_fill_1
XFILLER_12_870 VPWR VGND sg13cmos5l_decap_4
XFILLER_8_874 VPWR VGND sg13cmos5l_decap_8
XFILLER_8_852 VPWR VGND sg13cmos5l_decap_4
XFILLER_16_0 VPWR VGND sg13cmos5l_fill_1
XFILLER_10_818 VPWR VGND sg13cmos5l_decap_8
XFILLER_1_538 VPWR VGND sg13cmos5l_decap_8
XFILLER_13_601 VPWR VGND sg13cmos5l_decap_8
XANTENNA__208__X Tile_X1Y0_S1BEG[1] VPWR VGND sg13cmos5l_antennanp
XFILLER_12_133 VPWR VGND sg13cmos5l_decap_8
XFILLER_9_649 VPWR VGND sg13cmos5l_decap_8
XFILLER_8_148 VPWR VGND sg13cmos5l_decap_8
XFILLER_10_1075 VPWR VGND sg13cmos5l_decap_8
XFILLER_5_800 VPWR VGND sg13cmos5l_decap_8
XFILLER_4_354 VPWR VGND sg13cmos5l_decap_8
XFILLER_16_494 VPWR VGND sg13cmos5l_decap_8
XFILLER_8_682 VPWR VGND sg13cmos5l_decap_8
XFILLER_8_671 VPWR VGND sg13cmos5l_fill_1
XFILLER_7_192 VPWR VGND sg13cmos5l_fill_2
XFILLER_7_181 VPWR VGND sg13cmos5l_decap_8
XFILLER_2_1029 VPWR VGND sg13cmos5l_decap_8
XFILLER_10_648 VPWR VGND sg13cmos5l_decap_8
XANTENNA__204__A Tile_X0Y0_N2MID[2] VPWR VGND sg13cmos5l_antennanp
XFILLER_13_475 VPWR VGND sg13cmos5l_decap_8
X_395_ _395_/X Tile_X1Y0_N1END[3] Tile_X1Y0_N2MID[3] Tile_X1Y0_N2MID[4] Tile_X1Y0_N2END[4]
+ _076_/Q _113_/Q VPWR VGND sg13cmos5l_mux4_1
XFILLER_9_413 VPWR VGND sg13cmos5l_decap_8
XFILLER_5_652 VPWR VGND sg13cmos5l_decap_8
XFILLER_4_162 VPWR VGND sg13cmos5l_decap_8
XFILLER_4_11 VPWR VGND sg13cmos5l_fill_2
XFILLER_1_891 VPWR VGND sg13cmos5l_decap_8
XFILLER_1_1062 VPWR VGND sg13cmos5l_decap_8
XFILLER_9_980 VPWR VGND sg13cmos5l_decap_8
XFILLER_8_490 VPWR VGND sg13cmos5l_decap_8
XANTENNA__311__X Tile_X1Y0_FrameData_O[7] VPWR VGND sg13cmos5l_antennanp
XFILLER_14_206 VPWR VGND sg13cmos5l_decap_8
XFILLER_15_729 VPWR VGND sg13cmos5l_decap_4
XANTENNA__400__A0 Tile_X0Y0_N1END[1] VPWR VGND sg13cmos5l_antennanp
XFILLER_10_434 VPWR VGND sg13cmos5l_decap_8
XFILLER_11_979 VPWR VGND sg13cmos5l_decap_8
XFILLER_13_64 VPWR VGND sg13cmos5l_decap_8
X_180_ _180_/L_HI VPWR VGND sg13cmos5l_tiehi
XANTENNA__221__X Tile_X1Y0_S2BEGb[2] VPWR VGND sg13cmos5l_antennanp
XFILLER_1_154 VPWR VGND sg13cmos5l_decap_8
XFILLER_14_762 VPWR VGND sg13cmos5l_decap_8
X_378_ _378_/X Tile_X0Y0_N4END[13] Tile_X0Y0_N4END[14] Tile_X0Y0_NN4END[13] Tile_X0Y0_NN4END[15]
+ _048_/Q _047_/Q VPWR VGND sg13cmos5l_mux4_1
XFILLER_9_221 VPWR VGND sg13cmos5l_decap_8
XFILLER_9_298 VPWR VGND sg13cmos5l_decap_8
XFILLER_6_950 VPWR VGND sg13cmos5l_fill_2
XFILLER_5_493 VPWR VGND sg13cmos5l_decap_8
XANTENNA__306__X Tile_X1Y0_FrameData_O[2] VPWR VGND sg13cmos5l_antennanp
XFILLER_8_1068 VPWR VGND sg13cmos5l_decap_8
XFILLER_15_526 VPWR VGND sg13cmos5l_decap_4
X_232_ Tile_X1Y0_S4BEG[5] Tile_X1Y0_N4END[10] VPWR VGND sg13cmos5l_buf_1
X_301_ Tile_X0Y0_S1BEG[1] Tile_X0Y0_N1END[2] VPWR VGND sg13cmos5l_buf_1
XANTENNA__216__X Tile_X1Y0_S2BEG[5] VPWR VGND sg13cmos5l_antennanp
XFILLER_10_242 VPWR VGND sg13cmos5l_decap_8
XFILLER_11_754 VPWR VGND sg13cmos5l_decap_8
X_094_ _094_/Q Tile_X0Y0_FrameData[12] VGND VPWR Tile_X1Y0_FrameStrobe[0] latch
X_163_ _163_/L_HI VPWR VGND sg13cmos5l_tiehi
XFILLER_7_725 VPWR VGND sg13cmos5l_decap_8
XFILLER_1_23 VPWR VGND sg13cmos5l_fill_2
XFILLER_1_67 VPWR VGND sg13cmos5l_decap_4
XANTENNA__391__A2 Tile_X1Y0_NN4END[9] VPWR VGND sg13cmos5l_antennanp
XFILLER_14_592 VPWR VGND sg13cmos5l_decap_8
XANTENNA__302__A Tile_X0Y0_N1END[1] VPWR VGND sg13cmos5l_antennanp
XFILLER_12_518 VPWR VGND sg13cmos5l_decap_8
XANTENNA__382__A2 Tile_X1Y0_NN4END[0] VPWR VGND sg13cmos5l_antennanp
XFILLER_3_216 VPWR VGND sg13cmos5l_decap_4
XANTENNA__212__A Tile_X1Y0_N2MID[6] VPWR VGND sg13cmos5l_antennanp
XANTENNA__063__GATE Tile_X0Y0_FrameStrobe[0] VPWR VGND sg13cmos5l_antennanp
XANTENNA__078__GATE Tile_X1Y0_FrameStrobe[0] VPWR VGND sg13cmos5l_antennanp
XFILLER_15_323 VPWR VGND sg13cmos5l_decap_8
XFILLER_16_824 VPWR VGND sg13cmos5l_decap_8
XANTENNA__373__A2 Tile_X0Y0_NN4END[8] VPWR VGND sg13cmos5l_antennanp
XFILLER_11_551 VPWR VGND sg13cmos5l_decap_8
X_215_ Tile_X1Y0_S2BEG[4] Tile_X1Y0_N2MID[3] VPWR VGND sg13cmos5l_buf_1
XFILLER_11_595 VPWR VGND sg13cmos5l_fill_1
XFILLER_13_1084 VPWR VGND sg13cmos5l_decap_8
X_077_ _077_/Q Tile_X0Y0_FrameData[29] VGND VPWR Tile_X1Y0_FrameStrobe[0] latch
X_146_ NPU_SWAP_WEIGHTS Tile_X0Y0_UserCLK _397_/X _170_/L_HI VPWR VGND sg13cmos5l_dfrbpq_1
XFILLER_7_555 VPWR VGND sg13cmos5l_decap_8
XFILLER_5_1027 VPWR VGND sg13cmos5l_decap_8
XANTENNA__207__A Tile_X1Y0_N1END[3] VPWR VGND sg13cmos5l_antennanp
XFILLER_12_315 VPWR VGND sg13cmos5l_decap_8
XFILLER_13_805 VPWR VGND sg13cmos5l_decap_8
XFILLER_4_569 VPWR VGND sg13cmos5l_decap_8
XANTENNA__119__CLK Tile_X0Y0_UserCLK VPWR VGND sg13cmos5l_antennanp
XFILLER_15_120 VPWR VGND sg13cmos5l_decap_8
XFILLER_16_632 VPWR VGND sg13cmos5l_fill_1
XFILLER_16_676 VPWR VGND sg13cmos5l_decap_4
XFILLER_15_1102 VPWR VGND sg13cmos5l_decap_8
XFILLER_15_197 VPWR VGND sg13cmos5l_decap_8
XFILLER_8_831 VPWR VGND sg13cmos5l_decap_8
XFILLER_7_33 VPWR VGND sg13cmos5l_decap_8
X_129_ NPU_QUANT_SHIFT_IN14 Tile_X0Y0_UserCLK _379_/X _155_/L_HI VPWR VGND sg13cmos5l_dfrbpq_1
XANTENNA__314__X Tile_X1Y0_FrameData_O[10] VPWR VGND sg13cmos5l_antennanp
XFILLER_1_517 VPWR VGND sg13cmos5l_decap_8
XFILLER_1_506 VPWR VGND sg13cmos5l_decap_8
XFILLER_16_42 VPWR VGND sg13cmos5l_fill_2
XANTENNA__224__X Tile_X1Y0_S2BEGb[5] VPWR VGND sg13cmos5l_antennanp
XFILLER_12_112 VPWR VGND sg13cmos5l_decap_8
XFILLER_12_189 VPWR VGND sg13cmos5l_decap_8
XFILLER_13_679 VPWR VGND sg13cmos5l_decap_8
XFILLER_16_97 VPWR VGND sg13cmos5l_decap_4
XFILLER_9_628 VPWR VGND sg13cmos5l_decap_8
XFILLER_8_127 VPWR VGND sg13cmos5l_decap_8
XFILLER_10_1054 VPWR VGND sg13cmos5l_decap_8
XFILLER_4_322 VPWR VGND sg13cmos5l_decap_4
XFILLER_0_583 VPWR VGND sg13cmos5l_fill_2
XFILLER_7_160 VPWR VGND sg13cmos5l_decap_8
XANTENNA__310__A Tile_X0Y0_FrameData[6] VPWR VGND sg13cmos5l_antennanp
XANTENNA__309__X Tile_X1Y0_FrameData_O[5] VPWR VGND sg13cmos5l_antennanp
XFILLER_2_1008 VPWR VGND sg13cmos5l_decap_8
XFILLER_10_627 VPWR VGND sg13cmos5l_decap_8
XFILLER_2_804 VPWR VGND sg13cmos5l_decap_8
XANTENNA__220__A Tile_X1Y0_N2END[6] VPWR VGND sg13cmos5l_antennanp
XANTENNA__219__X Tile_X1Y0_S2BEGb[0] VPWR VGND sg13cmos5l_antennanp
XFILLER_13_454 VPWR VGND sg13cmos5l_decap_8
XFILLER_14_999 VPWR VGND sg13cmos5l_decap_8
X_394_ _394_/X Tile_X1Y0_N4END[14] Tile_X1Y0_N4END[15] Tile_X1Y0_NN4END[12] Tile_X1Y0_NN4END[14]
+ _084_/Q _083_/Q VPWR VGND sg13cmos5l_mux4_1
XFILLER_9_469 VPWR VGND sg13cmos5l_decap_8
XFILLER_5_631 VPWR VGND sg13cmos5l_decap_8
XFILLER_4_141 VPWR VGND sg13cmos5l_decap_4
XFILLER_5_686 VPWR VGND sg13cmos5l_decap_8
XFILLER_1_870 VPWR VGND sg13cmos5l_decap_8
XFILLER_1_1041 VPWR VGND sg13cmos5l_decap_8
XFILLER_16_292 VPWR VGND sg13cmos5l_decap_4
XANTENNA__305__A Tile_X0Y0_FrameData[1] VPWR VGND sg13cmos5l_antennanp
XANTENNA__400__A1 Tile_X0Y0_N2MID[1] VPWR VGND sg13cmos5l_antennanp
XANTENNA__215__A Tile_X1Y0_N2MID[3] VPWR VGND sg13cmos5l_antennanp
XFILLER_10_413 VPWR VGND sg13cmos5l_decap_8
XFILLER_13_43 VPWR VGND sg13cmos5l_decap_8
XFILLER_6_406 VPWR VGND sg13cmos5l_fill_1
XFILLER_1_122 VPWR VGND sg13cmos5l_decap_8
XFILLER_2_678 VPWR VGND sg13cmos5l_decap_8
XFILLER_2_601 VPWR VGND sg13cmos5l_decap_8
XANTENNA__100__D Tile_X0Y0_FrameData[6] VPWR VGND sg13cmos5l_antennanp
XFILLER_13_295 VPWR VGND sg13cmos5l_decap_8
XFILLER_14_730 VPWR VGND sg13cmos5l_fill_1
XFILLER_14_741 VPWR VGND sg13cmos5l_decap_8
X_377_ _377_/X Tile_X0Y0_N4END[12] Tile_X0Y0_N4END[13] Tile_X0Y0_NN4END[12] Tile_X0Y0_NN4END[14]
+ _050_/Q _049_/Q VPWR VGND sg13cmos5l_mux4_1
XFILLER_9_277 VPWR VGND sg13cmos5l_decap_8
XFILLER_9_200 VPWR VGND sg13cmos5l_decap_8
XFILLER_10_991 VPWR VGND sg13cmos5l_decap_8
XANTENNA__394__A0 Tile_X1Y0_N4END[14] VPWR VGND sg13cmos5l_antennanp
XANTENNA__322__X Tile_X1Y0_FrameData_O[18] VPWR VGND sg13cmos5l_antennanp
XFILLER_8_1047 VPWR VGND sg13cmos5l_decap_8
XANTENNA__385__A0 Tile_X1Y0_N4END[5] VPWR VGND sg13cmos5l_antennanp
XFILLER_10_221 VPWR VGND sg13cmos5l_decap_8
XFILLER_11_733 VPWR VGND sg13cmos5l_decap_8
XFILLER_15_549 VPWR VGND sg13cmos5l_decap_8
X_162_ _162_/L_HI VPWR VGND sg13cmos5l_tiehi
X_231_ Tile_X1Y0_S4BEG[4] Tile_X1Y0_N4END[11] VPWR VGND sg13cmos5l_buf_1
X_300_ Tile_X0Y0_S1BEG[0] Tile_X0Y0_N1END[3] VPWR VGND sg13cmos5l_buf_1
XANTENNA__232__X Tile_X1Y0_S4BEG[5] VPWR VGND sg13cmos5l_antennanp
XFILLER_10_298 VPWR VGND sg13cmos5l_decap_8
X_093_ _093_/Q Tile_X0Y0_FrameData[13] VGND VPWR Tile_X1Y0_FrameStrobe[0] latch
XFILLER_6_0 VPWR VGND sg13cmos5l_fill_2
XFILLER_3_987 VPWR VGND sg13cmos5l_decap_8
XFILLER_2_497 VPWR VGND sg13cmos5l_decap_8
XFILLER_2_464 VPWR VGND sg13cmos5l_fill_2
XANTENNA__376__A0 Tile_X0Y0_N4END[8] VPWR VGND sg13cmos5l_antennanp
XFILLER_1_79 VPWR VGND sg13cmos5l_fill_2
XANTENNA__391__A3 Tile_X1Y0_NN4END[11] VPWR VGND sg13cmos5l_antennanp
XFILLER_14_571 VPWR VGND sg13cmos5l_decap_8
XANTENNA__317__X Tile_X1Y0_FrameData_O[13] VPWR VGND sg13cmos5l_antennanp
XANTENNA__367__A0 Tile_X0Y0_N4END[2] VPWR VGND sg13cmos5l_antennanp
XANTENNA__382__A3 Tile_X1Y0_NN4END[2] VPWR VGND sg13cmos5l_antennanp
XFILLER_4_729 VPWR VGND sg13cmos5l_decap_8
XFILLER_10_88 VPWR VGND sg13cmos5l_decap_8
XFILLER_15_302 VPWR VGND sg13cmos5l_decap_8
XFILLER_16_803 VPWR VGND sg13cmos5l_decap_8
XANTENNA__227__X Tile_X1Y0_S4BEG[0] VPWR VGND sg13cmos5l_antennanp
XANTENNA__373__A3 Tile_X0Y0_NN4END[10] VPWR VGND sg13cmos5l_antennanp
XFILLER_11_530 VPWR VGND sg13cmos5l_decap_8
X_145_ NPU_COMPUTE_BANK_SWAP Tile_X0Y0_UserCLK _395_/X _171_/L_HI VPWR VGND sg13cmos5l_dfrbpq_1
X_214_ Tile_X1Y0_S2BEG[3] Tile_X1Y0_N2MID[4] VPWR VGND sg13cmos5l_buf_1
XFILLER_7_534 VPWR VGND sg13cmos5l_decap_8
XFILLER_13_1063 VPWR VGND sg13cmos5l_decap_8
X_076_ _076_/Q Tile_X0Y0_FrameData[30] VGND VPWR Tile_X1Y0_FrameStrobe[0] latch
XFILLER_3_784 VPWR VGND sg13cmos5l_decap_8
XFILLER_0_1117 VPWR VGND sg13cmos5l_fill_2
XANTENNA__313__A Tile_X0Y0_FrameData[9] VPWR VGND sg13cmos5l_antennanp
XFILLER_5_1006 VPWR VGND sg13cmos5l_decap_8
XFILLER_8_309 VPWR VGND sg13cmos5l_decap_8
XANTENNA__223__A Tile_X1Y0_N2END[3] VPWR VGND sg13cmos5l_antennanp
XFILLER_4_515 VPWR VGND sg13cmos5l_decap_8
XFILLER_0_743 VPWR VGND sg13cmos5l_decap_8
XFILLER_15_176 VPWR VGND sg13cmos5l_decap_8
XFILLER_16_611 VPWR VGND sg13cmos5l_decap_4
XFILLER_16_644 VPWR VGND sg13cmos5l_decap_4
XFILLER_16_688 VPWR VGND sg13cmos5l_fill_1
XFILLER_11_371 VPWR VGND sg13cmos5l_decap_8
X_128_ NPU_QUANT_SHIFT_IN13 Tile_X0Y0_UserCLK _378_/X _162_/L_HI VPWR VGND sg13cmos5l_dfrbpq_1
XFILLER_8_810 VPWR VGND sg13cmos5l_decap_8
XFILLER_7_67 VPWR VGND sg13cmos5l_fill_2
XFILLER_7_56 VPWR VGND sg13cmos5l_decap_8
X_059_ _059_/Q Tile_X0Y0_FrameData[11] VGND VPWR Tile_X0Y0_FrameStrobe[0] latch
XFILLER_4_1094 VPWR VGND sg13cmos5l_decap_8
XANTENNA__062__GATE Tile_X0Y0_FrameStrobe[0] VPWR VGND sg13cmos5l_antennanp
XANTENNA__308__A Tile_X0Y0_FrameData[4] VPWR VGND sg13cmos5l_antennanp
XFILLER_10_809 VPWR VGND sg13cmos5l_decap_4
XANTENNA__077__GATE Tile_X1Y0_FrameStrobe[0] VPWR VGND sg13cmos5l_antennanp
XANTENNA__330__X Tile_X1Y0_FrameData_O[26] VPWR VGND sg13cmos5l_antennanp
XANTENNA__218__A Tile_X1Y0_N2MID[0] VPWR VGND sg13cmos5l_antennanp
XFILLER_13_636 VPWR VGND sg13cmos5l_decap_4
XFILLER_16_76 VPWR VGND sg13cmos5l_decap_8
XFILLER_9_607 VPWR VGND sg13cmos5l_decap_8
XFILLER_10_1033 VPWR VGND sg13cmos5l_decap_8
XFILLER_12_168 VPWR VGND sg13cmos5l_decap_8
XFILLER_8_106 VPWR VGND sg13cmos5l_decap_8
XFILLER_5_835 VPWR VGND sg13cmos5l_decap_4
XFILLER_4_301 VPWR VGND sg13cmos5l_decap_8
XANTENNA__103__D Tile_X0Y0_FrameData[3] VPWR VGND sg13cmos5l_antennanp
XANTENNA__240__X Tile_X1Y0_S4BEG[13] VPWR VGND sg13cmos5l_antennanp
XFILLER_0_551 VPWR VGND sg13cmos5l_fill_2
XFILLER_16_474 VPWR VGND sg13cmos5l_decap_8
XFILLER_6_1101 VPWR VGND sg13cmos5l_decap_8
XANTENNA__325__X Tile_X1Y0_FrameData_O[21] VPWR VGND sg13cmos5l_antennanp
XFILLER_1_304 VPWR VGND sg13cmos5l_decap_4
XFILLER_1_315 VPWR VGND sg13cmos5l_decap_8
XANTENNA__235__X Tile_X1Y0_S4BEG[8] VPWR VGND sg13cmos5l_antennanp
X_393_ _393_/X Tile_X1Y0_N4END[13] Tile_X1Y0_N4END[14] Tile_X1Y0_NN4END[13] Tile_X1Y0_NN4END[15]
+ _086_/Q _085_/Q VPWR VGND sg13cmos5l_mux4_1
XFILLER_9_448 VPWR VGND sg13cmos5l_decap_8
XFILLER_12_1106 VPWR VGND sg13cmos5l_decap_8
XFILLER_5_610 VPWR VGND sg13cmos5l_fill_1
XFILLER_1_1020 VPWR VGND sg13cmos5l_decap_8
XFILLER_1_1097 VPWR VGND sg13cmos5l_decap_8
XANTENNA__321__A Tile_X0Y0_FrameData[17] VPWR VGND sg13cmos5l_antennanp
XANTENNA__400__A2 Tile_X0Y0_N2MID[6] VPWR VGND sg13cmos5l_antennanp
XFILLER_13_22 VPWR VGND sg13cmos5l_fill_2
XFILLER_10_469 VPWR VGND sg13cmos5l_decap_8
XFILLER_13_99 VPWR VGND sg13cmos5l_decap_8
XANTENNA__231__A Tile_X1Y0_N4END[11] VPWR VGND sg13cmos5l_antennanp
XFILLER_2_657 VPWR VGND sg13cmos5l_decap_8
XFILLER_2_635 VPWR VGND sg13cmos5l_decap_4
XFILLER_13_274 VPWR VGND sg13cmos5l_decap_8
XFILLER_14_797 VPWR VGND sg13cmos5l_decap_8
XFILLER_16_1094 VPWR VGND sg13cmos5l_decap_8
X_376_ _376_/X Tile_X0Y0_N4END[8] Tile_X0Y0_N4END[11] Tile_X0Y0_NN4END[9] Tile_X0Y0_NN4END[11]
+ _052_/Q _051_/Q VPWR VGND sg13cmos5l_mux4_1
XFILLER_9_256 VPWR VGND sg13cmos5l_decap_8
XANTENNA__394__A1 Tile_X1Y0_N4END[15] VPWR VGND sg13cmos5l_antennanp
XANTENNA__316__A Tile_X0Y0_FrameData[12] VPWR VGND sg13cmos5l_antennanp
XFILLER_8_1026 VPWR VGND sg13cmos5l_decap_8
XANTENNA__226__A Tile_X1Y0_N2END[0] VPWR VGND sg13cmos5l_antennanp
XANTENNA__385__A1 Tile_X1Y0_N4END[6] VPWR VGND sg13cmos5l_antennanp
XFILLER_10_200 VPWR VGND sg13cmos5l_decap_8
XFILLER_10_277 VPWR VGND sg13cmos5l_decap_8
XFILLER_11_712 VPWR VGND sg13cmos5l_decap_8
XFILLER_11_789 VPWR VGND sg13cmos5l_decap_8
X_161_ _161_/L_HI VPWR VGND sg13cmos5l_tiehi
X_230_ Tile_X1Y0_S4BEG[3] Tile_X1Y0_N4END[12] VPWR VGND sg13cmos5l_buf_1
X_092_ _092_/Q Tile_X0Y0_FrameData[14] VGND VPWR Tile_X1Y0_FrameStrobe[0] latch
XFILLER_3_966 VPWR VGND sg13cmos5l_decap_8
XANTENNA__111__D Tile_X0Y0_FrameData[27] VPWR VGND sg13cmos5l_antennanp
XANTENNA__376__A1 Tile_X0Y0_N4END[11] VPWR VGND sg13cmos5l_antennanp
XFILLER_14_550 VPWR VGND sg13cmos5l_decap_8
X_359_ Tile_X1Y0_FrameStrobe_O[3] Tile_X1Y0_FrameStrobe[3] VPWR VGND sg13cmos5l_buf_1
XFILLER_7_1092 VPWR VGND sg13cmos5l_decap_8
XANTENNA__367__A1 Tile_X0Y0_N4END[3] VPWR VGND sg13cmos5l_antennanp
XANTENNA__333__X Tile_X1Y0_FrameData_O[29] VPWR VGND sg13cmos5l_antennanp
XFILLER_10_67 VPWR VGND sg13cmos5l_decap_8
XFILLER_4_708 VPWR VGND sg13cmos5l_fill_2
XFILLER_15_369 VPWR VGND sg13cmos5l_decap_8
XFILLER_16_859 VPWR VGND sg13cmos5l_decap_8
XANTENNA__106__D Tile_X0Y0_FrameData[0] VPWR VGND sg13cmos5l_antennanp
XANTENNA__243__X Tile_X1Y0_SS4BEG[0] VPWR VGND sg13cmos5l_antennanp
XFILLER_11_586 VPWR VGND sg13cmos5l_decap_8
XFILLER_13_1042 VPWR VGND sg13cmos5l_decap_8
X_075_ _075_/Q Tile_X0Y0_FrameData[31] VGND VPWR Tile_X0Y0_FrameStrobe[0] latch
X_144_ NPU_QUANT_SHIFT_IN29 Tile_X0Y0_UserCLK _394_/X _172_/L_HI VPWR VGND sg13cmos5l_dfrbpq_1
X_213_ Tile_X1Y0_S2BEG[2] Tile_X1Y0_N2MID[5] VPWR VGND sg13cmos5l_buf_1
XFILLER_7_513 VPWR VGND sg13cmos5l_decap_8
XFILLER_3_763 VPWR VGND sg13cmos5l_decap_8
XFILLER_2_251 VPWR VGND sg13cmos5l_decap_8
XANTENNA__142__CLK Tile_X0Y0_UserCLK VPWR VGND sg13cmos5l_antennanp
XFILLER_9_1110 VPWR VGND sg13cmos5l_fill_2
XANTENNA__328__X Tile_X1Y0_FrameData_O[24] VPWR VGND sg13cmos5l_antennanp
XFILLER_0_722 VPWR VGND sg13cmos5l_decap_8
XFILLER_0_788 VPWR VGND sg13cmos5l_decap_8
XANTENNA__238__X Tile_X1Y0_S4BEG[11] VPWR VGND sg13cmos5l_antennanp
XFILLER_11_350 VPWR VGND sg13cmos5l_decap_8
XFILLER_15_155 VPWR VGND sg13cmos5l_decap_8
XFILLER_16_656 VPWR VGND sg13cmos5l_fill_1
XFILLER_11_383 VPWR VGND sg13cmos5l_decap_8
X_058_ _058_/Q Tile_X0Y0_FrameData[12] VGND VPWR Tile_X0Y0_FrameStrobe[0] latch
X_127_ NPU_QUANT_SHIFT_IN12 Tile_X0Y0_UserCLK _377_/X _178_/L_HI VPWR VGND sg13cmos5l_dfrbpq_1
XFILLER_8_888 VPWR VGND sg13cmos5l_decap_8
XFILLER_7_79 VPWR VGND sg13cmos5l_decap_8
XFILLER_7_321 VPWR VGND sg13cmos5l_fill_1
XFILLER_3_593 VPWR VGND sg13cmos5l_fill_2
XFILLER_3_582 VPWR VGND sg13cmos5l_decap_8
XFILLER_4_1073 VPWR VGND sg13cmos5l_decap_8
XANTENNA__324__A Tile_X0Y0_FrameData[20] VPWR VGND sg13cmos5l_antennanp
XFILLER_12_147 VPWR VGND sg13cmos5l_decap_8
XFILLER_13_615 VPWR VGND sg13cmos5l_decap_8
XFILLER_16_44 VPWR VGND sg13cmos5l_fill_1
XFILLER_16_55 VPWR VGND sg13cmos5l_decap_8
XANTENNA__234__A Tile_X1Y0_N4END[8] VPWR VGND sg13cmos5l_antennanp
XFILLER_10_1012 VPWR VGND sg13cmos5l_decap_8
XFILLER_5_847 VPWR VGND sg13cmos5l_decap_8
XFILLER_5_814 VPWR VGND sg13cmos5l_decap_8
XFILLER_0_585 VPWR VGND sg13cmos5l_fill_1
XFILLER_10_1089 VPWR VGND sg13cmos5l_decap_8
XFILLER_4_368 VPWR VGND sg13cmos5l_decap_8
XFILLER_16_453 VPWR VGND sg13cmos5l_fill_1
XFILLER_8_641 VPWR VGND sg13cmos5l_decap_4
XFILLER_8_696 VPWR VGND sg13cmos5l_fill_2
XFILLER_14_0 VPWR VGND sg13cmos5l_fill_1
XANTENNA__319__A Tile_X0Y0_FrameData[15] VPWR VGND sg13cmos5l_antennanp
XANTENNA__341__X Tile_X0Y0_FrameStrobe_O[5] VPWR VGND sg13cmos5l_antennanp
XFILLER_1_338 VPWR VGND sg13cmos5l_fill_2
XFILLER_2_828 VPWR VGND sg13cmos5l_decap_8
XANTENNA__229__A Tile_X1Y0_N4END[13] VPWR VGND sg13cmos5l_antennanp
XFILLER_13_489 VPWR VGND sg13cmos5l_decap_8
XFILLER_14_979 VPWR VGND sg13cmos5l_fill_2
X_392_ _392_/X Tile_X1Y0_N4END[12] Tile_X1Y0_N4END[13] Tile_X1Y0_NN4END[12] Tile_X1Y0_NN4END[14]
+ _088_/Q _087_/Q VPWR VGND sg13cmos5l_mux4_1
XFILLER_9_427 VPWR VGND sg13cmos5l_decap_8
XANTENNA__114__D Tile_X0Y0_FrameData[25] VPWR VGND sg13cmos5l_antennanp
XANTENNA__251__X Tile_X1Y0_SS4BEG[8] VPWR VGND sg13cmos5l_antennanp
XFILLER_5_666 VPWR VGND sg13cmos5l_decap_4
XFILLER_4_36 VPWR VGND sg13cmos5l_decap_8
XANTENNA__061__GATE Tile_X0Y0_FrameStrobe[0] VPWR VGND sg13cmos5l_antennanp
XFILLER_4_69 VPWR VGND sg13cmos5l_decap_8
XANTENNA__076__GATE Tile_X1Y0_FrameStrobe[0] VPWR VGND sg13cmos5l_antennanp
XFILLER_16_272 VPWR VGND sg13cmos5l_decap_8
XFILLER_1_1076 VPWR VGND sg13cmos5l_decap_8
XFILLER_9_961 VPWR VGND sg13cmos5l_fill_1
XFILLER_9_994 VPWR VGND sg13cmos5l_decap_8
XANTENNA__336__X Tile_X0Y0_FrameStrobe_O[0] VPWR VGND sg13cmos5l_antennanp
XANTENNA__400__A3 Tile_X0Y0_N2END[6] VPWR VGND sg13cmos5l_antennanp
XFILLER_10_448 VPWR VGND sg13cmos5l_decap_8
XFILLER_13_78 VPWR VGND sg13cmos5l_decap_8
XFILLER_1_113 VPWR VGND sg13cmos5l_fill_2
XFILLER_2_614 VPWR VGND sg13cmos5l_decap_8
XFILLER_1_168 VPWR VGND sg13cmos5l_decap_8
XFILLER_1_179 VPWR VGND sg13cmos5l_fill_1
XANTENNA__109__D Tile_X0Y0_FrameData[29] VPWR VGND sg13cmos5l_antennanp
XANTENNA__246__X Tile_X1Y0_SS4BEG[3] VPWR VGND sg13cmos5l_antennanp
XFILLER_14_710 VPWR VGND sg13cmos5l_decap_4
XFILLER_10_960 VPWR VGND sg13cmos5l_decap_8
XFILLER_13_253 VPWR VGND sg13cmos5l_decap_8
XFILLER_14_776 VPWR VGND sg13cmos5l_decap_8
XFILLER_16_1073 VPWR VGND sg13cmos5l_decap_8
X_375_ _375_/X Tile_X0Y0_N4END[10] Tile_X0Y0_N4END[11] Tile_X0Y0_NN4END[8] Tile_X0Y0_NN4END[10]
+ _054_/Q _053_/Q VPWR VGND sg13cmos5l_mux4_1
XFILLER_9_235 VPWR VGND sg13cmos5l_decap_8
XFILLER_0_190 VPWR VGND sg13cmos5l_decap_8
XANTENNA__394__A2 Tile_X1Y0_NN4END[12] VPWR VGND sg13cmos5l_antennanp
XANTENNA__332__A Tile_X0Y0_FrameData[28] VPWR VGND sg13cmos5l_antennanp
XFILLER_8_1016 VPWR VGND sg13cmos5l_fill_1
XANTENNA__385__A2 Tile_X1Y0_NN4END[5] VPWR VGND sg13cmos5l_antennanp
XFILLER_10_256 VPWR VGND sg13cmos5l_decap_8
XFILLER_11_768 VPWR VGND sg13cmos5l_decap_8
X_091_ _091_/Q Tile_X0Y0_FrameData[15] VGND VPWR Tile_X1Y0_FrameStrobe[0] latch
X_160_ _160_/L_HI VPWR VGND sg13cmos5l_tiehi
XFILLER_7_739 VPWR VGND sg13cmos5l_decap_8
XFILLER_6_249 VPWR VGND sg13cmos5l_decap_8
XFILLER_6_238 VPWR VGND sg13cmos5l_decap_8
XFILLER_6_216 VPWR VGND sg13cmos5l_decap_8
XANTENNA__242__A Tile_X1Y0_N4END[0] VPWR VGND sg13cmos5l_antennanp
XFILLER_3_923 VPWR VGND sg13cmos5l_fill_1
XFILLER_2_477 VPWR VGND sg13cmos5l_decap_8
XANTENNA__376__A2 Tile_X0Y0_NN4END[9] VPWR VGND sg13cmos5l_antennanp
X_358_ Tile_X1Y0_FrameStrobe_O[2] Tile_X1Y0_FrameStrobe[2] VPWR VGND sg13cmos5l_buf_1
X_289_ Tile_X0Y0_SS4BEG[5] Tile_X0Y0_NN4END[10] VPWR VGND sg13cmos5l_buf_1
XFILLER_6_761 VPWR VGND sg13cmos5l_decap_4
XFILLER_7_1071 VPWR VGND sg13cmos5l_decap_8
XFILLER_5_293 VPWR VGND sg13cmos5l_decap_8
XANTENNA__327__A Tile_X0Y0_FrameData[23] VPWR VGND sg13cmos5l_antennanp
XANTENNA__367__A2 Tile_X0Y0_NN4END[0] VPWR VGND sg13cmos5l_antennanp
XFILLER_10_24 VPWR VGND sg13cmos5l_decap_8
XFILLER_10_35 VPWR VGND sg13cmos5l_fill_1
XFILLER_10_46 VPWR VGND sg13cmos5l_decap_8
XANTENNA__237__A Tile_X1Y0_N4END[5] VPWR VGND sg13cmos5l_antennanp
XFILLER_15_337 VPWR VGND sg13cmos5l_decap_8
XFILLER_16_838 VPWR VGND sg13cmos5l_decap_8
X_212_ Tile_X1Y0_S2BEG[1] Tile_X1Y0_N2MID[6] VPWR VGND sg13cmos5l_buf_1
XFILLER_11_565 VPWR VGND sg13cmos5l_decap_8
XFILLER_13_1021 VPWR VGND sg13cmos5l_decap_8
XFILLER_13_1098 VPWR VGND sg13cmos5l_decap_8
X_074_ _074_/Q Tile_X0Y0_FrameData[28] VGND VPWR Tile_X0Y0_FrameStrobe[1] latch
X_143_ NPU_QUANT_SHIFT_IN28 Tile_X0Y0_UserCLK _393_/X _173_/L_HI VPWR VGND sg13cmos5l_dfrbpq_1
XFILLER_7_569 VPWR VGND sg13cmos5l_decap_8
XFILLER_3_742 VPWR VGND sg13cmos5l_decap_8
XFILLER_2_296 VPWR VGND sg13cmos5l_decap_8
XFILLER_2_274 VPWR VGND sg13cmos5l_decap_8
XFILLER_2_230 VPWR VGND sg13cmos5l_decap_8
XFILLER_0_1119 VPWR VGND sg13cmos5l_fill_1
XFILLER_14_392 VPWR VGND sg13cmos5l_decap_8
XFILLER_15_860 VPWR VGND sg13cmos5l_decap_8
XFILLER_15_871 VPWR VGND sg13cmos5l_fill_1
XFILLER_6_580 VPWR VGND sg13cmos5l_decap_8
XFILLER_12_329 VPWR VGND sg13cmos5l_decap_8
XFILLER_13_819 VPWR VGND sg13cmos5l_decap_8
XANTENNA__344__X Tile_X0Y0_FrameStrobe_O[8] VPWR VGND sg13cmos5l_antennanp
XFILLER_0_701 VPWR VGND sg13cmos5l_decap_8
XFILLER_0_767 VPWR VGND sg13cmos5l_decap_8
XFILLER_15_134 VPWR VGND sg13cmos5l_decap_8
XFILLER_16_624 VPWR VGND sg13cmos5l_fill_1
XFILLER_16_668 VPWR VGND sg13cmos5l_decap_4
XANTENNA__254__X Tile_X1Y0_SS4BEG[11] VPWR VGND sg13cmos5l_antennanp
XFILLER_12_863 VPWR VGND sg13cmos5l_decap_8
XFILLER_12_874 VPWR VGND sg13cmos5l_fill_1
XFILLER_12_896 VPWR VGND sg13cmos5l_decap_8
XFILLER_15_1116 VPWR VGND sg13cmos5l_decap_4
XFILLER_8_845 VPWR VGND sg13cmos5l_decap_8
XFILLER_7_300 VPWR VGND sg13cmos5l_decap_8
X_057_ _057_/Q Tile_X0Y0_FrameData[13] VGND VPWR Tile_X0Y0_FrameStrobe[0] latch
X_126_ NPU_QUANT_SHIFT_IN11 Tile_X0Y0_UserCLK _376_/X _151_/L_HI VPWR VGND sg13cmos5l_dfrbpq_1
XFILLER_8_867 VPWR VGND sg13cmos5l_decap_8
XFILLER_7_47 VPWR VGND sg13cmos5l_decap_4
XFILLER_7_377 VPWR VGND sg13cmos5l_fill_2
XFILLER_7_344 VPWR VGND sg13cmos5l_decap_4
XFILLER_4_1052 VPWR VGND sg13cmos5l_decap_8
XANTENNA__340__A Tile_X0Y0_FrameStrobe[4] VPWR VGND sg13cmos5l_antennanp
XANTENNA__339__X Tile_X0Y0_FrameStrobe_O[3] VPWR VGND sg13cmos5l_antennanp
XFILLER_12_126 VPWR VGND sg13cmos5l_decap_8
XFILLER_10_1068 VPWR VGND sg13cmos5l_decap_8
XFILLER_4_347 VPWR VGND sg13cmos5l_decap_8
XANTENNA__250__A Tile_X1Y0_NN4END[8] VPWR VGND sg13cmos5l_antennanp
XFILLER_0_531 VPWR VGND sg13cmos5l_fill_1
XFILLER_0_553 VPWR VGND sg13cmos5l_fill_1
XFILLER_0_564 VPWR VGND sg13cmos5l_fill_1
XANTENNA__132__CLK Tile_X0Y0_UserCLK VPWR VGND sg13cmos5l_antennanp
XANTENNA__249__X Tile_X1Y0_SS4BEG[6] VPWR VGND sg13cmos5l_antennanp
XFILLER_16_432 VPWR VGND sg13cmos5l_decap_4
XFILLER_12_693 VPWR VGND sg13cmos5l_decap_8
XFILLER_8_675 VPWR VGND sg13cmos5l_decap_8
XFILLER_8_664 VPWR VGND sg13cmos5l_decap_4
XFILLER_7_174 VPWR VGND sg13cmos5l_decap_8
X_109_ _109_/Q Tile_X0Y0_FrameData[29] VGND VPWR Tile_X1Y0_FrameStrobe[1] latch
XFILLER_4_870 VPWR VGND sg13cmos5l_decap_4
XANTENNA__335__A Tile_X0Y0_FrameData[31] VPWR VGND sg13cmos5l_antennanp
XFILLER_2_818 VPWR VGND sg13cmos5l_decap_8
XFILLER_14_947 VPWR VGND sg13cmos5l_fill_1
X_391_ _391_/X Tile_X1Y0_N4END[8] Tile_X1Y0_N4END[11] Tile_X1Y0_NN4END[9] Tile_X1Y0_NN4END[11]
+ _090_/Q _089_/Q VPWR VGND sg13cmos5l_mux4_1
XANTENNA__245__A Tile_X1Y0_NN4END[13] VPWR VGND sg13cmos5l_antennanp
XFILLER_13_468 VPWR VGND sg13cmos5l_decap_8
XFILLER_9_406 VPWR VGND sg13cmos5l_decap_8
XFILLER_5_645 VPWR VGND sg13cmos5l_fill_1
XFILLER_4_111 VPWR VGND sg13cmos5l_decap_8
XFILLER_1_1011 VPWR VGND sg13cmos5l_fill_2
XFILLER_1_884 VPWR VGND sg13cmos5l_decap_8
XFILLER_16_240 VPWR VGND sg13cmos5l_fill_1
XFILLER_16_251 VPWR VGND sg13cmos5l_decap_8
XFILLER_1_1055 VPWR VGND sg13cmos5l_decap_8
XFILLER_12_490 VPWR VGND sg13cmos5l_decap_8
XFILLER_9_940 VPWR VGND sg13cmos5l_decap_4
XFILLER_9_973 VPWR VGND sg13cmos5l_decap_8
XFILLER_8_483 VPWR VGND sg13cmos5l_decap_8
XANTENNA__040__D Tile_X0Y0_FrameData[30] VPWR VGND sg13cmos5l_antennanp
XANTENNA__397__A0 Tile_X1Y0_N1END[1] VPWR VGND sg13cmos5l_antennanp
XFILLER_10_427 VPWR VGND sg13cmos5l_decap_8
XFILLER_11_939 VPWR VGND sg13cmos5l_fill_2
XFILLER_13_24 VPWR VGND sg13cmos5l_fill_1
XFILLER_13_35 VPWR VGND sg13cmos5l_decap_4
XFILLER_13_57 VPWR VGND sg13cmos5l_decap_8
XANTENNA__352__X Tile_X0Y0_FrameStrobe_O[16] VPWR VGND sg13cmos5l_antennanp
XANTENNA__388__A0 Tile_X1Y0_N4END[8] VPWR VGND sg13cmos5l_antennanp
XFILLER_13_232 VPWR VGND sg13cmos5l_decap_8
XFILLER_14_722 VPWR VGND sg13cmos5l_fill_1
XFILLER_14_755 VPWR VGND sg13cmos5l_decap_8
X_374_ _374_/X Tile_X0Y0_N4END[9] Tile_X0Y0_N4END[10] Tile_X0Y0_NN4END[9] Tile_X0Y0_NN4END[11]
+ _056_/Q _055_/Q VPWR VGND sg13cmos5l_mux4_1
XFILLER_9_214 VPWR VGND sg13cmos5l_decap_8
XANTENNA__262__X Tile_X0Y0_S2BEGb[2] VPWR VGND sg13cmos5l_antennanp
XFILLER_16_1052 VPWR VGND sg13cmos5l_decap_8
XFILLER_5_453 VPWR VGND sg13cmos5l_decap_4
XFILLER_5_486 VPWR VGND sg13cmos5l_decap_8
XANTENNA__379__A0 Tile_X0Y0_N4END[14] VPWR VGND sg13cmos5l_antennanp
XANTENNA__394__A3 Tile_X1Y0_NN4END[14] VPWR VGND sg13cmos5l_antennanp
XANTENNA__121__Q NPU_QUANT_SHIFT_IN6 VPWR VGND sg13cmos5l_antennanp
XANTENNA__347__X Tile_X0Y0_FrameStrobe_O[11] VPWR VGND sg13cmos5l_antennanp
XANTENNA__385__A3 Tile_X1Y0_NN4END[7] VPWR VGND sg13cmos5l_antennanp
XFILLER_15_519 VPWR VGND sg13cmos5l_decap_8
XANTENNA__060__GATE Tile_X0Y0_FrameStrobe[0] VPWR VGND sg13cmos5l_antennanp
XFILLER_10_235 VPWR VGND sg13cmos5l_decap_8
XFILLER_11_747 VPWR VGND sg13cmos5l_decap_8
X_090_ _090_/Q Tile_X0Y0_FrameData[16] VGND VPWR Tile_X1Y0_FrameStrobe[0] latch
XFILLER_7_718 VPWR VGND sg13cmos5l_decap_8
XANTENNA__075__GATE Tile_X0Y0_FrameStrobe[0] VPWR VGND sg13cmos5l_antennanp
XANTENNA__257__X Tile_X1Y0_SS4BEG[14] VPWR VGND sg13cmos5l_antennanp
XANTENNA__376__A3 Tile_X0Y0_NN4END[11] VPWR VGND sg13cmos5l_antennanp
XFILLER_14_585 VPWR VGND sg13cmos5l_decap_8
X_357_ Tile_X1Y0_FrameStrobe_O[1] Tile_X1Y0_FrameStrobe[1] VPWR VGND sg13cmos5l_buf_1
X_288_ Tile_X0Y0_SS4BEG[4] Tile_X0Y0_NN4END[11] VPWR VGND sg13cmos5l_buf_1
XFILLER_5_272 VPWR VGND sg13cmos5l_decap_8
XANTENNA__367__A3 Tile_X0Y0_NN4END[2] VPWR VGND sg13cmos5l_antennanp
XANTENNA__116__Q NPU_QUANT_SHIFT_IN1 VPWR VGND sg13cmos5l_antennanp
XANTENNA__343__A Tile_X0Y0_FrameStrobe[7] VPWR VGND sg13cmos5l_antennanp
XFILLER_3_209 VPWR VGND sg13cmos5l_decap_8
XFILLER_0_905 VPWR VGND sg13cmos5l_fill_1
XFILLER_15_316 VPWR VGND sg13cmos5l_decap_8
XFILLER_16_817 VPWR VGND sg13cmos5l_decap_8
XFILLER_11_544 VPWR VGND sg13cmos5l_decap_8
XFILLER_13_1000 VPWR VGND sg13cmos5l_decap_8
X_142_ NPU_QUANT_SHIFT_IN27 Tile_X0Y0_UserCLK _392_/X _174_/L_HI VPWR VGND sg13cmos5l_dfrbpq_1
X_211_ Tile_X1Y0_S2BEG[0] Tile_X1Y0_N2MID[7] VPWR VGND sg13cmos5l_buf_1
XANTENNA__253__A Tile_X1Y0_NN4END[5] VPWR VGND sg13cmos5l_antennanp
XFILLER_13_1077 VPWR VGND sg13cmos5l_decap_8
X_073_ _073_/Q Tile_X0Y0_FrameData[29] VGND VPWR Tile_X0Y0_FrameStrobe[1] latch
XFILLER_7_548 VPWR VGND sg13cmos5l_decap_8
XFILLER_4_0 VPWR VGND sg13cmos5l_fill_2
XFILLER_14_382 VPWR VGND sg13cmos5l_decap_4
XANTENNA__338__A Tile_X0Y0_FrameStrobe[2] VPWR VGND sg13cmos5l_antennanp
XFILLER_12_308 VPWR VGND sg13cmos5l_decap_8
XANTENNA__360__X Tile_X1Y0_FrameStrobe_O[4] VPWR VGND sg13cmos5l_antennanp
XANTENNA__248__A Tile_X1Y0_NN4END[10] VPWR VGND sg13cmos5l_antennanp
XFILLER_15_113 VPWR VGND sg13cmos5l_decap_8
XFILLER_16_636 VPWR VGND sg13cmos5l_decap_4
XFILLER_12_842 VPWR VGND sg13cmos5l_decap_8
X_125_ NPU_QUANT_SHIFT_IN10 Tile_X0Y0_UserCLK _375_/X _159_/L_HI VPWR VGND sg13cmos5l_dfrbpq_1
XFILLER_8_824 VPWR VGND sg13cmos5l_decap_8
XFILLER_7_26 VPWR VGND sg13cmos5l_decap_8
XANTENNA__270__X Tile_X0Y0_S4BEG[2] VPWR VGND sg13cmos5l_antennanp
X_056_ _056_/Q Tile_X0Y0_FrameData[14] VGND VPWR Tile_X0Y0_FrameStrobe[0] latch
XFILLER_3_573 VPWR VGND sg13cmos5l_fill_2
XFILLER_4_1031 VPWR VGND sg13cmos5l_decap_8
XANTENNA__043__D Tile_X0Y0_FrameData[27] VPWR VGND sg13cmos5l_antennanp
XFILLER_16_35 VPWR VGND sg13cmos5l_decap_8
XANTENNA__355__X Tile_X0Y0_FrameStrobe_O[19] VPWR VGND sg13cmos5l_antennanp
XFILLER_12_105 VPWR VGND sg13cmos5l_decap_8
XFILLER_10_1047 VPWR VGND sg13cmos5l_decap_8
XFILLER_4_315 VPWR VGND sg13cmos5l_decap_8
XANTENNA__265__X Tile_X0Y0_S2BEGb[5] VPWR VGND sg13cmos5l_antennanp
XFILLER_16_411 VPWR VGND sg13cmos5l_decap_8
XFILLER_11_182 VPWR VGND sg13cmos5l_decap_8
XFILLER_12_672 VPWR VGND sg13cmos5l_decap_8
X_108_ _108_/Q Tile_X0Y0_FrameData[30] VGND VPWR Tile_X1Y0_FrameStrobe[1] latch
XFILLER_8_698 VPWR VGND sg13cmos5l_fill_1
XFILLER_8_610 VPWR VGND sg13cmos5l_decap_8
XFILLER_7_153 VPWR VGND sg13cmos5l_decap_8
X_039_ NPU_PSUM_SKEW_EN Tile_X0Y0_UserCLK _039_/D _161_/L_HI VPWR VGND sg13cmos5l_dfrbpq_1
XFILLER_6_1115 VPWR VGND sg13cmos5l_decap_4
XANTENNA__124__Q NPU_QUANT_SHIFT_IN9 VPWR VGND sg13cmos5l_antennanp
XANTENNA__351__A Tile_X0Y0_FrameStrobe[15] VPWR VGND sg13cmos5l_antennanp
XFILLER_13_447 VPWR VGND sg13cmos5l_decap_8
X_390_ _390_/X Tile_X1Y0_N4END[10] Tile_X1Y0_N4END[11] Tile_X1Y0_NN4END[8] Tile_X1Y0_NN4END[10]
+ _092_/Q _091_/Q VPWR VGND sg13cmos5l_mux4_1
XFILLER_5_624 VPWR VGND sg13cmos5l_decap_8
XANTENNA__261__A Tile_X0Y0_N2END[6] VPWR VGND sg13cmos5l_antennanp
XFILLER_4_145 VPWR VGND sg13cmos5l_fill_2
XFILLER_4_134 VPWR VGND sg13cmos5l_decap_8
XFILLER_1_863 VPWR VGND sg13cmos5l_decap_8
XFILLER_16_230 VPWR VGND sg13cmos5l_fill_2
XFILLER_1_1034 VPWR VGND sg13cmos5l_decap_8
XFILLER_16_296 VPWR VGND sg13cmos5l_fill_1
XFILLER_8_462 VPWR VGND sg13cmos5l_decap_8
XANTENNA__119__Q NPU_QUANT_SHIFT_IN4 VPWR VGND sg13cmos5l_antennanp
XANTENNA__346__A Tile_X0Y0_FrameStrobe[10] VPWR VGND sg13cmos5l_antennanp
XANTENNA__397__A1 Tile_X1Y0_N2MID[1] VPWR VGND sg13cmos5l_antennanp
XFILLER_10_406 VPWR VGND sg13cmos5l_decap_8
XFILLER_13_14 VPWR VGND sg13cmos5l_fill_2
XANTENNA__122__CLK Tile_X0Y0_UserCLK VPWR VGND sg13cmos5l_antennanp
XANTENNA__256__A Tile_X1Y0_NN4END[2] VPWR VGND sg13cmos5l_antennanp
XANTENNA__388__A1 Tile_X1Y0_N4END[9] VPWR VGND sg13cmos5l_antennanp
XFILLER_13_211 VPWR VGND sg13cmos5l_decap_8
XFILLER_13_288 VPWR VGND sg13cmos5l_decap_8
XFILLER_14_734 VPWR VGND sg13cmos5l_decap_8
XFILLER_16_1031 VPWR VGND sg13cmos5l_decap_8
X_373_ _373_/X Tile_X0Y0_N4END[8] Tile_X0Y0_N4END[9] Tile_X0Y0_NN4END[8] Tile_X0Y0_NN4END[10]
+ _058_/Q _057_/Q VPWR VGND sg13cmos5l_mux4_1
XFILLER_10_984 VPWR VGND sg13cmos5l_decap_8
XFILLER_3_1118 VPWR VGND sg13cmos5l_fill_2
XANTENNA__379__A1 Tile_X0Y0_N4END[15] VPWR VGND sg13cmos5l_antennanp
XANTENNA__145__CLK Tile_X0Y0_UserCLK VPWR VGND sg13cmos5l_antennanp
XFILLER_9_782 VPWR VGND sg13cmos5l_decap_8
XFILLER_8_281 VPWR VGND sg13cmos5l_decap_8
XANTENNA__051__D Tile_X0Y0_FrameData[19] VPWR VGND sg13cmos5l_antennanp
XFILLER_5_92 VPWR VGND sg13cmos5l_decap_8
XFILLER_10_214 VPWR VGND sg13cmos5l_decap_8
XFILLER_11_726 VPWR VGND sg13cmos5l_decap_8
XANTENNA__363__X Tile_X1Y0_FrameStrobe_O[7] VPWR VGND sg13cmos5l_antennanp
XANTENNA__273__X Tile_X0Y0_S4BEG[5] VPWR VGND sg13cmos5l_antennanp
XFILLER_10_781 VPWR VGND sg13cmos5l_decap_8
XFILLER_14_564 VPWR VGND sg13cmos5l_decap_8
X_287_ Tile_X0Y0_SS4BEG[3] Tile_X0Y0_NN4END[12] VPWR VGND sg13cmos5l_buf_1
X_356_ Tile_X1Y0_FrameStrobe_O[0] Tile_X1Y0_FrameStrobe[0] VPWR VGND sg13cmos5l_buf_1
XFILLER_6_796 VPWR VGND sg13cmos5l_decap_8
XFILLER_5_251 VPWR VGND sg13cmos5l_decap_8
XFILLER_7_1040 VPWR VGND sg13cmos5l_decap_8
XANTENNA__046__D Tile_X0Y0_FrameData[24] VPWR VGND sg13cmos5l_antennanp
XANTENNA__132__Q NPU_QUANT_SHIFT_IN17 VPWR VGND sg13cmos5l_antennanp
XANTENNA__358__X Tile_X1Y0_FrameStrobe_O[2] VPWR VGND sg13cmos5l_antennanp
XFILLER_11_523 VPWR VGND sg13cmos5l_decap_8
X_141_ NPU_QUANT_SHIFT_IN26 Tile_X0Y0_UserCLK _391_/X _175_/L_HI VPWR VGND sg13cmos5l_dfrbpq_1
X_210_ Tile_X1Y0_S1BEG[3] Tile_X1Y0_N1END[0] VPWR VGND sg13cmos5l_buf_1
XFILLER_7_527 VPWR VGND sg13cmos5l_decap_8
XFILLER_13_1056 VPWR VGND sg13cmos5l_decap_8
X_072_ _072_/Q Tile_X0Y0_FrameData[30] VGND VPWR Tile_X0Y0_FrameStrobe[1] latch
XFILLER_3_777 VPWR VGND sg13cmos5l_decap_8
XFILLER_3_711 VPWR VGND sg13cmos5l_decap_8
XFILLER_2_265 VPWR VGND sg13cmos5l_decap_4
XANTENNA__268__X Tile_X0Y0_S4BEG[0] VPWR VGND sg13cmos5l_antennanp
X_339_ Tile_X0Y0_FrameStrobe_O[3] Tile_X0Y0_FrameStrobe[3] VPWR VGND sg13cmos5l_buf_1
XFILLER_2_82 VPWR VGND sg13cmos5l_decap_8
XANTENNA__074__GATE Tile_X0Y0_FrameStrobe[1] VPWR VGND sg13cmos5l_antennanp
XANTENNA__127__Q NPU_QUANT_SHIFT_IN12 VPWR VGND sg13cmos5l_antennanp
XANTENNA__354__A Tile_X0Y0_FrameStrobe[18] VPWR VGND sg13cmos5l_antennanp
XANTENNA__089__GATE Tile_X1Y0_FrameStrobe[0] VPWR VGND sg13cmos5l_antennanp
XFILLER_4_508 VPWR VGND sg13cmos5l_decap_8
XFILLER_0_736 VPWR VGND sg13cmos5l_decap_8
XFILLER_15_169 VPWR VGND sg13cmos5l_decap_8
XFILLER_16_604 VPWR VGND sg13cmos5l_decap_4
XFILLER_16_615 VPWR VGND sg13cmos5l_fill_2
XFILLER_16_648 VPWR VGND sg13cmos5l_fill_1
XANTENNA__264__A Tile_X0Y0_N2END[3] VPWR VGND sg13cmos5l_antennanp
XFILLER_11_364 VPWR VGND sg13cmos5l_decap_8
XFILLER_11_397 VPWR VGND sg13cmos5l_decap_8
X_055_ _055_/Q Tile_X0Y0_FrameData[15] VGND VPWR Tile_X0Y0_FrameStrobe[0] latch
X_124_ NPU_QUANT_SHIFT_IN9 Tile_X0Y0_UserCLK _374_/X _187_/L_HI VPWR VGND sg13cmos5l_dfrbpq_1
XFILLER_8_803 VPWR VGND sg13cmos5l_decap_8
XFILLER_11_91 VPWR VGND sg13cmos5l_decap_8
XFILLER_3_552 VPWR VGND sg13cmos5l_decap_8
XFILLER_4_1087 VPWR VGND sg13cmos5l_decap_8
XFILLER_4_1010 VPWR VGND sg13cmos5l_decap_8
XFILLER_15_681 VPWR VGND sg13cmos5l_fill_1
XANTENNA__349__A Tile_X0Y0_FrameStrobe[13] VPWR VGND sg13cmos5l_antennanp
XFILLER_13_629 VPWR VGND sg13cmos5l_decap_8
XFILLER_16_69 VPWR VGND sg13cmos5l_decap_4
XFILLER_5_839 VPWR VGND sg13cmos5l_fill_1
XFILLER_5_828 VPWR VGND sg13cmos5l_decap_8
XFILLER_0_500 VPWR VGND sg13cmos5l_fill_1
XFILLER_0_544 VPWR VGND sg13cmos5l_decap_8
XFILLER_10_1026 VPWR VGND sg13cmos5l_decap_8
XANTENNA__259__A Tile_X0Y0_UserCLK VPWR VGND sg13cmos5l_antennanp
XFILLER_12_651 VPWR VGND sg13cmos5l_decap_8
XFILLER_16_467 VPWR VGND sg13cmos5l_decap_8
XANTENNA__281__X Tile_X0Y0_S4BEG[13] VPWR VGND sg13cmos5l_antennanp
XFILLER_11_161 VPWR VGND sg13cmos5l_decap_8
X_038_ _039_/D _396_/X _114_/Q VPWR VGND sg13cmos5l_or2_1
X_107_ _107_/Q Tile_X0Y0_FrameData[31] VGND VPWR Tile_X1Y0_FrameStrobe[1] latch
XFILLER_7_121 VPWR VGND sg13cmos5l_fill_1
XANTENNA__054__D Tile_X0Y0_FrameData[16] VPWR VGND sg13cmos5l_antennanp
XANTENNA__191__X Tile_X1Y0_FrameStrobe_O[12] VPWR VGND sg13cmos5l_antennanp
XFILLER_8_92 VPWR VGND sg13cmos5l_decap_8
XFILLER_1_308 VPWR VGND sg13cmos5l_fill_1
XANTENNA__140__Q NPU_QUANT_SHIFT_IN25 VPWR VGND sg13cmos5l_antennanp
XFILLER_13_404 VPWR VGND sg13cmos5l_decap_4
XFILLER_1_853 VPWR VGND sg13cmos5l_fill_2
XFILLER_1_831 VPWR VGND sg13cmos5l_fill_1
XANTENNA__276__X Tile_X0Y0_S4BEG[8] VPWR VGND sg13cmos5l_antennanp
XFILLER_13_993 VPWR VGND sg13cmos5l_decap_8
XFILLER_16_286 VPWR VGND sg13cmos5l_fill_2
XFILLER_12_0 VPWR VGND sg13cmos5l_fill_2
XANTENNA__049__D Tile_X0Y0_FrameData[21] VPWR VGND sg13cmos5l_antennanp
XANTENNA__397__A2 Tile_X1Y0_N2MID[6] VPWR VGND sg13cmos5l_antennanp
XFILLER_11_908 VPWR VGND sg13cmos5l_fill_1
XANTENNA__135__Q NPU_QUANT_SHIFT_IN20 VPWR VGND sg13cmos5l_antennanp
XANTENNA__362__A Tile_X1Y0_FrameStrobe[6] VPWR VGND sg13cmos5l_antennanp
XFILLER_2_639 VPWR VGND sg13cmos5l_fill_1
XFILLER_2_628 VPWR VGND sg13cmos5l_decap_8
XANTENNA__388__A2 Tile_X1Y0_NN4END[8] VPWR VGND sg13cmos5l_antennanp
XFILLER_13_267 VPWR VGND sg13cmos5l_decap_8
XFILLER_16_1010 VPWR VGND sg13cmos5l_decap_8
XFILLER_16_1087 VPWR VGND sg13cmos5l_decap_8
X_372_ _372_/X Tile_X0Y0_N4END[4] Tile_X0Y0_N4END[7] Tile_X0Y0_NN4END[5] Tile_X0Y0_NN4END[7]
+ _060_/Q _059_/Q VPWR VGND sg13cmos5l_mux4_1
XFILLER_9_249 VPWR VGND sg13cmos5l_decap_8
XANTENNA__272__A Tile_X0Y0_N4END[11] VPWR VGND sg13cmos5l_antennanp
XFILLER_0_171 VPWR VGND sg13cmos5l_decap_8
XANTENNA__379__A2 Tile_X0Y0_NN4END[12] VPWR VGND sg13cmos5l_antennanp
XFILLER_9_761 VPWR VGND sg13cmos5l_decap_8
XFILLER_8_260 VPWR VGND sg13cmos5l_decap_8
XFILLER_5_71 VPWR VGND sg13cmos5l_decap_8
XANTENNA__357__A Tile_X1Y0_FrameStrobe[1] VPWR VGND sg13cmos5l_antennanp
XFILLER_11_705 VPWR VGND sg13cmos5l_decap_8
XFILLER_6_208 VPWR VGND sg13cmos5l_fill_2
XFILLER_3_959 VPWR VGND sg13cmos5l_decap_8
XANTENNA__267__A Tile_X0Y0_N2END[0] VPWR VGND sg13cmos5l_antennanp
XFILLER_14_543 VPWR VGND sg13cmos5l_decap_8
XFILLER_10_760 VPWR VGND sg13cmos5l_decap_8
XFILLER_14_80 VPWR VGND sg13cmos5l_decap_8
X_286_ Tile_X0Y0_SS4BEG[2] Tile_X0Y0_NN4END[13] VPWR VGND sg13cmos5l_buf_1
X_355_ Tile_X0Y0_FrameStrobe_O[19] Tile_X0Y0_FrameStrobe[19] VPWR VGND sg13cmos5l_buf_1
XFILLER_5_230 VPWR VGND sg13cmos5l_decap_8
XFILLER_6_786 VPWR VGND sg13cmos5l_fill_1
XFILLER_2_981 VPWR VGND sg13cmos5l_decap_8
XFILLER_7_1085 VPWR VGND sg13cmos5l_decap_8
XFILLER_7_1052 VPWR VGND sg13cmos5l_fill_2
XANTENNA__062__D Tile_X0Y0_FrameData[8] VPWR VGND sg13cmos5l_antennanp
XFILLER_11_502 VPWR VGND sg13cmos5l_decap_8
XFILLER_11_579 VPWR VGND sg13cmos5l_decap_8
XFILLER_13_1035 VPWR VGND sg13cmos5l_decap_8
X_071_ _071_/Q Tile_X0Y0_FrameData[31] VGND VPWR Tile_X0Y0_FrameStrobe[1] latch
X_140_ NPU_QUANT_SHIFT_IN25 Tile_X0Y0_UserCLK _390_/X _165_/L_HI VPWR VGND sg13cmos5l_dfrbpq_1
XFILLER_7_506 VPWR VGND sg13cmos5l_decap_8
XFILLER_3_756 VPWR VGND sg13cmos5l_decap_8
XFILLER_2_288 VPWR VGND sg13cmos5l_decap_4
XFILLER_2_244 VPWR VGND sg13cmos5l_decap_8
XFILLER_2_211 VPWR VGND sg13cmos5l_fill_2
XFILLER_2_200 VPWR VGND sg13cmos5l_decap_8
XANTENNA__135__CLK Tile_X0Y0_UserCLK VPWR VGND sg13cmos5l_antennanp
XANTENNA__284__X Tile_X0Y0_SS4BEG[0] VPWR VGND sg13cmos5l_antennanp
X_338_ Tile_X0Y0_FrameStrobe_O[2] Tile_X0Y0_FrameStrobe[2] VPWR VGND sg13cmos5l_buf_1
X_269_ Tile_X0Y0_S4BEG[1] Tile_X0Y0_N4END[14] VPWR VGND sg13cmos5l_buf_1
XFILLER_6_594 VPWR VGND sg13cmos5l_decap_4
XFILLER_2_61 VPWR VGND sg13cmos5l_decap_8
XANTENNA__057__D Tile_X0Y0_FrameData[13] VPWR VGND sg13cmos5l_antennanp
XANTENNA__194__X Tile_X1Y0_FrameStrobe_O[15] VPWR VGND sg13cmos5l_antennanp
XANTENNA__143__Q NPU_QUANT_SHIFT_IN28 VPWR VGND sg13cmos5l_antennanp
XFILLER_0_715 VPWR VGND sg13cmos5l_decap_8
XFILLER_15_148 VPWR VGND sg13cmos5l_decap_8
XANTENNA__280__A Tile_X0Y0_N4END[3] VPWR VGND sg13cmos5l_antennanp
XFILLER_11_343 VPWR VGND sg13cmos5l_decap_8
X_054_ _054_/Q Tile_X0Y0_FrameData[16] VGND VPWR Tile_X0Y0_FrameStrobe[0] latch
X_123_ NPU_QUANT_SHIFT_IN8 Tile_X0Y0_UserCLK _373_/X _186_/L_HI VPWR VGND sg13cmos5l_dfrbpq_1
XFILLER_7_336 VPWR VGND sg13cmos5l_fill_1
XFILLER_7_314 VPWR VGND sg13cmos5l_decap_8
XANTENNA__279__X Tile_X0Y0_S4BEG[11] VPWR VGND sg13cmos5l_antennanp
XFILLER_11_70 VPWR VGND sg13cmos5l_decap_8
XFILLER_3_575 VPWR VGND sg13cmos5l_fill_1
XFILLER_3_531 VPWR VGND sg13cmos5l_decap_8
XFILLER_4_1066 VPWR VGND sg13cmos5l_decap_8
XFILLER_14_192 VPWR VGND sg13cmos5l_decap_8
XANTENNA__190__A Tile_X1Y0_FrameStrobe[11] VPWR VGND sg13cmos5l_antennanp
XFILLER_7_870 VPWR VGND sg13cmos5l_fill_2
XANTENNA__189__X Tile_X1Y0_FrameStrobe_O[10] VPWR VGND sg13cmos5l_antennanp
XANTENNA__138__Q NPU_QUANT_SHIFT_IN23 VPWR VGND sg13cmos5l_antennanp
XFILLER_13_608 VPWR VGND sg13cmos5l_decap_8
XFILLER_16_48 VPWR VGND sg13cmos5l_decap_8
XFILLER_10_1005 VPWR VGND sg13cmos5l_decap_8
XFILLER_5_807 VPWR VGND sg13cmos5l_decap_8
XFILLER_0_512 VPWR VGND sg13cmos5l_fill_1
XFILLER_0_523 VPWR VGND sg13cmos5l_fill_1
XFILLER_16_446 VPWR VGND sg13cmos5l_decap_8
XANTENNA__275__A Tile_X0Y0_N4END[8] VPWR VGND sg13cmos5l_antennanp
XFILLER_11_140 VPWR VGND sg13cmos5l_decap_8
XFILLER_12_630 VPWR VGND sg13cmos5l_decap_8
XFILLER_8_634 VPWR VGND sg13cmos5l_decap_8
XFILLER_7_100 VPWR VGND sg13cmos5l_decap_8
X_106_ _106_/Q Tile_X0Y0_FrameData[0] VGND VPWR Tile_X1Y0_FrameStrobe[0] latch
XFILLER_8_689 VPWR VGND sg13cmos5l_decap_8
XFILLER_7_188 VPWR VGND sg13cmos5l_decap_4
XFILLER_4_840 VPWR VGND sg13cmos5l_fill_2
XFILLER_3_361 VPWR VGND sg13cmos5l_decap_4
XANTENNA__073__GATE Tile_X0Y0_FrameStrobe[1] VPWR VGND sg13cmos5l_antennanp
XFILLER_3_383 VPWR VGND sg13cmos5l_fill_1
XANTENNA__088__GATE Tile_X1Y0_FrameStrobe[0] VPWR VGND sg13cmos5l_antennanp
XANTENNA__070__D Tile_X0Y0_FrameData[0] VPWR VGND sg13cmos5l_antennanp
XFILLER_5_659 VPWR VGND sg13cmos5l_decap_8
XFILLER_4_169 VPWR VGND sg13cmos5l_decap_4
XFILLER_1_898 VPWR VGND sg13cmos5l_decap_4
XFILLER_16_210 VPWR VGND sg13cmos5l_fill_2
XFILLER_16_232 VPWR VGND sg13cmos5l_fill_1
XFILLER_16_265 VPWR VGND sg13cmos5l_decap_4
XFILLER_1_1003 VPWR VGND sg13cmos5l_fill_1
XFILLER_1_1069 VPWR VGND sg13cmos5l_decap_8
XANTENNA__292__X Tile_X0Y0_SS4BEG[8] VPWR VGND sg13cmos5l_antennanp
XFILLER_13_972 VPWR VGND sg13cmos5l_decap_8
XFILLER_9_987 VPWR VGND sg13cmos5l_decap_8
XFILLER_8_497 VPWR VGND sg13cmos5l_decap_8
XFILLER_4_670 VPWR VGND sg13cmos5l_decap_8
XANTENNA__065__D Tile_X0Y0_FrameData[5] VPWR VGND sg13cmos5l_antennanp
XANTENNA__397__A3 Tile_X1Y0_N2END[6] VPWR VGND sg13cmos5l_antennanp
XFILLER_1_106 VPWR VGND sg13cmos5l_decap_8
XANTENNA__388__A3 Tile_X1Y0_NN4END[10] VPWR VGND sg13cmos5l_antennanp
XFILLER_14_714 VPWR VGND sg13cmos5l_fill_1
X_371_ _371_/X Tile_X0Y0_N4END[6] Tile_X0Y0_N4END[7] Tile_X0Y0_NN4END[4] Tile_X0Y0_NN4END[6]
+ _062_/Q _061_/Q VPWR VGND sg13cmos5l_mux4_1
XFILLER_13_246 VPWR VGND sg13cmos5l_decap_8
XFILLER_14_769 VPWR VGND sg13cmos5l_decap_8
XFILLER_16_1066 VPWR VGND sg13cmos5l_decap_8
XFILLER_9_228 VPWR VGND sg13cmos5l_decap_8
XFILLER_6_946 VPWR VGND sg13cmos5l_decap_4
XFILLER_6_979 VPWR VGND sg13cmos5l_decap_8
XANTENNA__287__X Tile_X0Y0_SS4BEG[3] VPWR VGND sg13cmos5l_antennanp
XANTENNA__379__A3 Tile_X0Y0_NN4END[14] VPWR VGND sg13cmos5l_antennanp
XFILLER_13_791 VPWR VGND sg13cmos5l_decap_8
XFILLER_9_740 VPWR VGND sg13cmos5l_decap_8
XFILLER_8_1009 VPWR VGND sg13cmos5l_decap_8
XFILLER_5_50 VPWR VGND sg13cmos5l_decap_4
XANTENNA__197__X Tile_X1Y0_FrameStrobe_O[18] VPWR VGND sg13cmos5l_antennanp
XANTENNA__146__Q NPU_SWAP_WEIGHTS VPWR VGND sg13cmos5l_antennanp
XFILLER_10_249 VPWR VGND sg13cmos5l_decap_8
XFILLER_3_916 VPWR VGND sg13cmos5l_decap_8
XFILLER_14_522 VPWR VGND sg13cmos5l_decap_8
XFILLER_14_599 VPWR VGND sg13cmos5l_decap_8
X_354_ Tile_X0Y0_FrameStrobe_O[18] Tile_X0Y0_FrameStrobe[18] VPWR VGND sg13cmos5l_buf_1
XANTENNA__283__A Tile_X0Y0_N4END[0] VPWR VGND sg13cmos5l_antennanp
X_285_ Tile_X0Y0_SS4BEG[1] Tile_X0Y0_NN4END[14] VPWR VGND sg13cmos5l_buf_1
XFILLER_6_776 VPWR VGND sg13cmos5l_fill_1
XFILLER_6_765 VPWR VGND sg13cmos5l_fill_1
XFILLER_5_286 VPWR VGND sg13cmos5l_decap_8
XFILLER_2_960 VPWR VGND sg13cmos5l_decap_8
XFILLER_1_492 VPWR VGND sg13cmos5l_decap_8
XFILLER_7_1064 VPWR VGND sg13cmos5l_decap_8
XANTENNA__193__A Tile_X1Y0_FrameStrobe[14] VPWR VGND sg13cmos5l_antennanp
XFILLER_10_39 VPWR VGND sg13cmos5l_decap_8
XFILLER_9_581 VPWR VGND sg13cmos5l_decap_8
XFILLER_11_558 VPWR VGND sg13cmos5l_decap_8
XFILLER_13_1014 VPWR VGND sg13cmos5l_decap_8
X_070_ _070_/Q Tile_X0Y0_FrameData[0] VGND VPWR Tile_X0Y0_FrameStrobe[0] latch
XFILLER_3_735 VPWR VGND sg13cmos5l_decap_8
XFILLER_2_223 VPWR VGND sg13cmos5l_decap_8
XANTENNA__278__A Tile_X0Y0_N4END[5] VPWR VGND sg13cmos5l_antennanp
XFILLER_15_820 VPWR VGND sg13cmos5l_decap_8
XFILLER_15_853 VPWR VGND sg13cmos5l_decap_8
X_337_ Tile_X0Y0_FrameStrobe_O[1] Tile_X0Y0_FrameStrobe[1] VPWR VGND sg13cmos5l_buf_1
X_199_ Tile_X0Y0_S2BEG[0] Tile_X0Y0_N2MID[7] VPWR VGND sg13cmos5l_buf_1
X_268_ Tile_X0Y0_S4BEG[0] Tile_X0Y0_N4END[15] VPWR VGND sg13cmos5l_buf_1
XFILLER_6_573 VPWR VGND sg13cmos5l_decap_8
XANTENNA__188__A Tile_X1Y0_FrameStrobe[9] VPWR VGND sg13cmos5l_antennanp
XFILLER_9_1115 VPWR VGND sg13cmos5l_decap_4
XFILLER_2_790 VPWR VGND sg13cmos5l_decap_8
XANTENNA__073__D Tile_X0Y0_FrameData[29] VPWR VGND sg13cmos5l_antennanp
XFILLER_16_628 VPWR VGND sg13cmos5l_decap_4
XFILLER_11_322 VPWR VGND sg13cmos5l_decap_8
XFILLER_12_812 VPWR VGND sg13cmos5l_decap_8
XFILLER_12_856 VPWR VGND sg13cmos5l_decap_8
XFILLER_12_878 VPWR VGND sg13cmos5l_decap_8
XFILLER_15_1109 VPWR VGND sg13cmos5l_decap_8
XFILLER_15_127 VPWR VGND sg13cmos5l_decap_8
XFILLER_8_838 VPWR VGND sg13cmos5l_decap_8
X_053_ _053_/Q Tile_X0Y0_FrameData[17] VGND VPWR Tile_X0Y0_FrameStrobe[0] latch
X_122_ NPU_QUANT_SHIFT_IN7 Tile_X0Y0_UserCLK _372_/X _185_/L_HI VPWR VGND sg13cmos5l_dfrbpq_1
XFILLER_7_348 VPWR VGND sg13cmos5l_fill_1
XFILLER_2_0 VPWR VGND sg13cmos5l_fill_2
XANTENNA__295__X Tile_X0Y0_SS4BEG[11] VPWR VGND sg13cmos5l_antennanp
XFILLER_15_650 VPWR VGND sg13cmos5l_fill_2
XFILLER_4_1045 VPWR VGND sg13cmos5l_decap_8
XFILLER_14_171 VPWR VGND sg13cmos5l_decap_8
XFILLER_7_860 VPWR VGND sg13cmos5l_fill_2
XFILLER_6_381 VPWR VGND sg13cmos5l_decap_4
XANTENNA__068__D Tile_X0Y0_FrameData[2] VPWR VGND sg13cmos5l_antennanp
XFILLER_12_119 VPWR VGND sg13cmos5l_decap_8
XANTENNA__125__CLK Tile_X0Y0_UserCLK VPWR VGND sg13cmos5l_antennanp
XFILLER_0_557 VPWR VGND sg13cmos5l_decap_8
XFILLER_16_425 VPWR VGND sg13cmos5l_decap_8
XANTENNA__291__A Tile_X0Y0_NN4END[8] VPWR VGND sg13cmos5l_antennanp
XFILLER_11_196 VPWR VGND sg13cmos5l_decap_8
XFILLER_12_686 VPWR VGND sg13cmos5l_decap_8
X_105_ _105_/Q Tile_X0Y0_FrameData[1] VGND VPWR Tile_X1Y0_FrameStrobe[0] latch
XFILLER_8_657 VPWR VGND sg13cmos5l_decap_8
XFILLER_7_167 VPWR VGND sg13cmos5l_decap_8
XFILLER_4_874 VPWR VGND sg13cmos5l_fill_1
XFILLER_3_351 VPWR VGND sg13cmos5l_decap_4
XFILLER_16_992 VPWR VGND sg13cmos5l_fill_1
XANTENNA__148__CLK Tile_X0Y0_UserCLK VPWR VGND sg13cmos5l_antennanp
XFILLER_8_61 VPWR VGND sg13cmos5l_fill_2
XANTENNA__149__Q NPU_ARRAY_EN VPWR VGND sg13cmos5l_antennanp
XFILLER_5_638 VPWR VGND sg13cmos5l_decap_8
XFILLER_4_19 VPWR VGND sg13cmos5l_fill_2
XFILLER_4_104 VPWR VGND sg13cmos5l_decap_8
XFILLER_1_822 VPWR VGND sg13cmos5l_decap_8
XFILLER_1_811 VPWR VGND sg13cmos5l_fill_1
XFILLER_1_877 VPWR VGND sg13cmos5l_decap_8
XANTENNA__286__A Tile_X0Y0_NN4END[13] VPWR VGND sg13cmos5l_antennanp
XFILLER_16_244 VPWR VGND sg13cmos5l_decap_8
XFILLER_16_288 VPWR VGND sg13cmos5l_fill_1
XFILLER_1_1048 VPWR VGND sg13cmos5l_decap_8
XFILLER_9_900 VPWR VGND sg13cmos5l_decap_8
XFILLER_12_483 VPWR VGND sg13cmos5l_decap_8
XFILLER_9_933 VPWR VGND sg13cmos5l_decap_8
XFILLER_9_944 VPWR VGND sg13cmos5l_fill_2
XFILLER_8_476 VPWR VGND sg13cmos5l_decap_8
XFILLER_8_410 VPWR VGND sg13cmos5l_decap_4
XFILLER_3_181 VPWR VGND sg13cmos5l_decap_8
XANTENNA__196__A Tile_X1Y0_FrameStrobe[17] VPWR VGND sg13cmos5l_antennanp
XFILLER_13_28 VPWR VGND sg13cmos5l_decap_8
XFILLER_13_39 VPWR VGND sg13cmos5l_fill_1
XANTENNA__081__D Tile_X0Y0_FrameData[25] VPWR VGND sg13cmos5l_antennanp
XFILLER_11_1112 VPWR VGND sg13cmos5l_decap_8
XFILLER_1_129 VPWR VGND sg13cmos5l_decap_4
XFILLER_13_225 VPWR VGND sg13cmos5l_decap_8
XFILLER_14_704 VPWR VGND sg13cmos5l_fill_2
XFILLER_14_726 VPWR VGND sg13cmos5l_decap_4
XFILLER_14_748 VPWR VGND sg13cmos5l_decap_8
X_370_ _370_/X Tile_X0Y0_N4END[5] Tile_X0Y0_N4END[6] Tile_X0Y0_NN4END[5] Tile_X0Y0_NN4END[7]
+ _064_/Q _063_/Q VPWR VGND sg13cmos5l_mux4_1
XFILLER_9_207 VPWR VGND sg13cmos5l_decap_8
XANTENNA__072__GATE Tile_X0Y0_FrameStrobe[1] VPWR VGND sg13cmos5l_antennanp
XFILLER_10_921 VPWR VGND sg13cmos5l_fill_2
XFILLER_10_998 VPWR VGND sg13cmos5l_decap_8
XFILLER_16_1045 VPWR VGND sg13cmos5l_decap_8
XANTENNA__087__GATE Tile_X1Y0_FrameStrobe[0] VPWR VGND sg13cmos5l_antennanp
XFILLER_5_457 VPWR VGND sg13cmos5l_fill_2
XFILLER_12_280 VPWR VGND sg13cmos5l_decap_8
XFILLER_13_770 VPWR VGND sg13cmos5l_decap_8
XFILLER_9_796 VPWR VGND sg13cmos5l_decap_8
XFILLER_8_295 VPWR VGND sg13cmos5l_decap_8
XANTENNA__076__D Tile_X0Y0_FrameData[30] VPWR VGND sg13cmos5l_antennanp
XFILLER_10_228 VPWR VGND sg13cmos5l_decap_8
XFILLER_2_416 VPWR VGND sg13cmos5l_fill_2
XFILLER_14_501 VPWR VGND sg13cmos5l_decap_8
XFILLER_14_578 VPWR VGND sg13cmos5l_decap_8
X_284_ Tile_X0Y0_SS4BEG[0] Tile_X0Y0_NN4END[15] VPWR VGND sg13cmos5l_buf_1
X_353_ Tile_X0Y0_FrameStrobe_O[17] Tile_X0Y0_FrameStrobe[17] VPWR VGND sg13cmos5l_buf_1
XFILLER_10_795 VPWR VGND sg13cmos5l_decap_8
XFILLER_5_265 VPWR VGND sg13cmos5l_decap_8
XANTENNA__298__X Tile_X0Y0_SS4BEG[14] VPWR VGND sg13cmos5l_antennanp
XFILLER_1_460 VPWR VGND sg13cmos5l_decap_8
XFILLER_9_560 VPWR VGND sg13cmos5l_decap_8
XFILLER_10_18 VPWR VGND sg13cmos5l_fill_2
XFILLER_11_537 VPWR VGND sg13cmos5l_decap_8
XFILLER_15_309 VPWR VGND sg13cmos5l_decap_8
XFILLER_3_725 VPWR VGND sg13cmos5l_fill_1
XANTENNA__294__A Tile_X0Y0_NN4END[5] VPWR VGND sg13cmos5l_antennanp
XFILLER_10_581 VPWR VGND sg13cmos5l_decap_8
XFILLER_14_386 VPWR VGND sg13cmos5l_fill_2
X_267_ Tile_X0Y0_S2BEGb[7] Tile_X0Y0_N2END[0] VPWR VGND sg13cmos5l_buf_1
X_336_ Tile_X0Y0_FrameStrobe_O[0] Tile_X0Y0_FrameStrobe[0] VPWR VGND sg13cmos5l_buf_1
X_198_ Tile_X1Y0_FrameStrobe_O[19] Tile_X1Y0_FrameStrobe[19] VPWR VGND sg13cmos5l_buf_1
XFILLER_6_552 VPWR VGND sg13cmos5l_decap_8
XFILLER_2_96 VPWR VGND sg13cmos5l_decap_8
XFILLER_12_1092 VPWR VGND sg13cmos5l_decap_8
XFILLER_15_106 VPWR VGND sg13cmos5l_decap_8
XFILLER_11_301 VPWR VGND sg13cmos5l_decap_8
XFILLER_11_378 VPWR VGND sg13cmos5l_fill_2
X_121_ NPU_QUANT_SHIFT_IN6 Tile_X0Y0_UserCLK _371_/X _184_/L_HI VPWR VGND sg13cmos5l_dfrbpq_1
XFILLER_8_817 VPWR VGND sg13cmos5l_decap_8
XFILLER_7_19 VPWR VGND sg13cmos5l_decap_8
X_052_ _052_/Q Tile_X0Y0_FrameData[18] VGND VPWR Tile_X0Y0_FrameStrobe[0] latch
XFILLER_3_566 VPWR VGND sg13cmos5l_decap_8
XANTENNA__289__A Tile_X0Y0_NN4END[10] VPWR VGND sg13cmos5l_antennanp
XFILLER_4_1024 VPWR VGND sg13cmos5l_decap_8
XFILLER_14_150 VPWR VGND sg13cmos5l_decap_8
XFILLER_15_673 VPWR VGND sg13cmos5l_fill_1
X_319_ Tile_X1Y0_FrameData_O[15] Tile_X0Y0_FrameData[15] VPWR VGND sg13cmos5l_buf_1
XFILLER_7_872 VPWR VGND sg13cmos5l_fill_1
XANTENNA__199__A Tile_X0Y0_N2MID[7] VPWR VGND sg13cmos5l_antennanp
XFILLER_16_28 VPWR VGND sg13cmos5l_decap_8
XANTENNA__084__D Tile_X0Y0_FrameData[22] VPWR VGND sg13cmos5l_antennanp
XFILLER_14_1110 VPWR VGND sg13cmos5l_decap_8
XFILLER_4_308 VPWR VGND sg13cmos5l_decap_8
XFILLER_16_404 VPWR VGND sg13cmos5l_fill_1
XFILLER_11_175 VPWR VGND sg13cmos5l_decap_8
XFILLER_12_665 VPWR VGND sg13cmos5l_decap_8
X_104_ _104_/Q Tile_X0Y0_FrameData[2] VGND VPWR Tile_X1Y0_FrameStrobe[0] latch
XFILLER_7_146 VPWR VGND sg13cmos5l_decap_8
XFILLER_6_1119 VPWR VGND sg13cmos5l_fill_1
XFILLER_16_971 VPWR VGND sg13cmos5l_fill_1
XANTENNA__079__D Tile_X0Y0_FrameData[27] VPWR VGND sg13cmos5l_antennanp
XFILLER_14_919 VPWR VGND sg13cmos5l_fill_1
XFILLER_5_617 VPWR VGND sg13cmos5l_decap_8
XFILLER_5_606 VPWR VGND sg13cmos5l_decap_4
XFILLER_4_127 VPWR VGND sg13cmos5l_decap_8
XFILLER_16_212 VPWR VGND sg13cmos5l_fill_1
XFILLER_16_223 VPWR VGND sg13cmos5l_decap_8
XFILLER_1_1016 VPWR VGND sg13cmos5l_fill_1
XFILLER_1_1027 VPWR VGND sg13cmos5l_decap_8
XFILLER_12_462 VPWR VGND sg13cmos5l_decap_8
XFILLER_8_455 VPWR VGND sg13cmos5l_decap_8
XFILLER_4_694 VPWR VGND sg13cmos5l_decap_4
XFILLER_3_160 VPWR VGND sg13cmos5l_decap_8
XANTENNA__115__CLK Tile_X0Y0_UserCLK VPWR VGND sg13cmos5l_antennanp
XFILLER_0_1082 VPWR VGND sg13cmos5l_decap_8
XFILLER_13_204 VPWR VGND sg13cmos5l_decap_8
XFILLER_16_1024 VPWR VGND sg13cmos5l_decap_8
XFILLER_10_955 VPWR VGND sg13cmos5l_fill_2
XFILLER_10_977 VPWR VGND sg13cmos5l_decap_8
XANTENNA__138__CLK Tile_X0Y0_UserCLK VPWR VGND sg13cmos5l_antennanp
XFILLER_0_163 VPWR VGND sg13cmos5l_decap_4
XFILLER_0_185 VPWR VGND sg13cmos5l_fill_2
XANTENNA__297__A Tile_X0Y0_NN4END[2] VPWR VGND sg13cmos5l_antennanp
XFILLER_9_775 VPWR VGND sg13cmos5l_decap_8
XFILLER_8_274 VPWR VGND sg13cmos5l_decap_8
XFILLER_5_992 VPWR VGND sg13cmos5l_decap_8
XFILLER_5_85 VPWR VGND sg13cmos5l_decap_8
XFILLER_10_0 VPWR VGND sg13cmos5l_fill_2
XFILLER_10_207 VPWR VGND sg13cmos5l_decap_8
XFILLER_11_719 VPWR VGND sg13cmos5l_decap_8
XANTENNA__092__D Tile_X0Y0_FrameData[14] VPWR VGND sg13cmos5l_antennanp
XFILLER_2_1111 VPWR VGND sg13cmos5l_fill_1
XFILLER_14_557 VPWR VGND sg13cmos5l_decap_8
XFILLER_14_94 VPWR VGND sg13cmos5l_decap_8
X_283_ Tile_X0Y0_S4BEG[15] Tile_X0Y0_N4END[0] VPWR VGND sg13cmos5l_buf_1
X_352_ Tile_X0Y0_FrameStrobe_O[16] Tile_X0Y0_FrameStrobe[16] VPWR VGND sg13cmos5l_buf_1
XFILLER_10_774 VPWR VGND sg13cmos5l_decap_8
XFILLER_6_745 VPWR VGND sg13cmos5l_decap_8
XFILLER_6_734 VPWR VGND sg13cmos5l_decap_4
XFILLER_5_244 VPWR VGND sg13cmos5l_decap_8
XFILLER_7_1099 VPWR VGND sg13cmos5l_decap_8
XFILLER_7_1033 VPWR VGND sg13cmos5l_decap_8
XFILLER_2_995 VPWR VGND sg13cmos5l_decap_4
XANTENNA__390__A0 Tile_X1Y0_N4END[10] VPWR VGND sg13cmos5l_antennanp
XANTENNA__071__GATE Tile_X0Y0_FrameStrobe[1] VPWR VGND sg13cmos5l_antennanp
XANTENNA__087__D Tile_X0Y0_FrameData[19] VPWR VGND sg13cmos5l_antennanp
XANTENNA__086__GATE Tile_X1Y0_FrameStrobe[0] VPWR VGND sg13cmos5l_antennanp
XFILLER_11_516 VPWR VGND sg13cmos5l_decap_8
XANTENNA__381__A0 Tile_X1Y0_N4END[1] VPWR VGND sg13cmos5l_antennanp
XFILLER_13_1049 VPWR VGND sg13cmos5l_decap_8
XFILLER_3_704 VPWR VGND sg13cmos5l_decap_8
XFILLER_2_269 VPWR VGND sg13cmos5l_fill_2
XFILLER_2_258 VPWR VGND sg13cmos5l_decap_8
XFILLER_14_332 VPWR VGND sg13cmos5l_decap_8
XANTENNA__372__A0 Tile_X0Y0_N4END[4] VPWR VGND sg13cmos5l_antennanp
XFILLER_10_560 VPWR VGND sg13cmos5l_decap_8
X_197_ Tile_X1Y0_FrameStrobe_O[18] Tile_X1Y0_FrameStrobe[18] VPWR VGND sg13cmos5l_buf_1
X_266_ Tile_X0Y0_S2BEGb[6] Tile_X0Y0_N2END[1] VPWR VGND sg13cmos5l_buf_1
X_335_ Tile_X1Y0_FrameData_O[31] Tile_X0Y0_FrameData[31] VPWR VGND sg13cmos5l_buf_1
XFILLER_6_531 VPWR VGND sg13cmos5l_decap_8
XFILLER_9_1106 VPWR VGND sg13cmos5l_decap_4
XFILLER_2_75 VPWR VGND sg13cmos5l_decap_8
XFILLER_12_1071 VPWR VGND sg13cmos5l_decap_8
XFILLER_0_729 VPWR VGND sg13cmos5l_decap_8
XFILLER_11_357 VPWR VGND sg13cmos5l_decap_8
X_051_ _051_/Q Tile_X0Y0_FrameData[19] VGND VPWR Tile_X0Y0_FrameStrobe[0] latch
X_120_ NPU_QUANT_SHIFT_IN5 Tile_X0Y0_UserCLK _370_/X _156_/L_HI VPWR VGND sg13cmos5l_dfrbpq_1
XFILLER_11_84 VPWR VGND sg13cmos5l_decap_8
XFILLER_3_589 VPWR VGND sg13cmos5l_decap_4
XFILLER_3_545 VPWR VGND sg13cmos5l_decap_8
XFILLER_4_1003 VPWR VGND sg13cmos5l_decap_8
XFILLER_15_641 VPWR VGND sg13cmos5l_decap_4
XFILLER_15_652 VPWR VGND sg13cmos5l_fill_1
X_249_ Tile_X1Y0_SS4BEG[6] Tile_X1Y0_NN4END[9] VPWR VGND sg13cmos5l_buf_1
X_318_ Tile_X1Y0_FrameData_O[14] Tile_X0Y0_FrameData[14] VPWR VGND sg13cmos5l_buf_1
XFILLER_7_862 VPWR VGND sg13cmos5l_fill_1
XFILLER_0_504 VPWR VGND sg13cmos5l_fill_1
XFILLER_10_1019 VPWR VGND sg13cmos5l_decap_8
XFILLER_12_644 VPWR VGND sg13cmos5l_decap_8
XFILLER_11_154 VPWR VGND sg13cmos5l_decap_8
X_103_ _103_/Q Tile_X0Y0_FrameData[3] VGND VPWR Tile_X1Y0_FrameStrobe[0] latch
XFILLER_7_114 VPWR VGND sg13cmos5l_decap_8
XFILLER_8_85 VPWR VGND sg13cmos5l_decap_8
XANTENNA__095__D Tile_X0Y0_FrameData[11] VPWR VGND sg13cmos5l_antennanp
XFILLER_13_408 VPWR VGND sg13cmos5l_fill_1
XANTENNA__200__X Tile_X0Y0_S2BEG[1] VPWR VGND sg13cmos5l_antennanp
XFILLER_12_441 VPWR VGND sg13cmos5l_decap_8
XFILLER_13_986 VPWR VGND sg13cmos5l_decap_8
XFILLER_16_279 VPWR VGND sg13cmos5l_decap_8
XFILLER_9_957 VPWR VGND sg13cmos5l_fill_1
XFILLER_8_423 VPWR VGND sg13cmos5l_fill_1
XFILLER_4_684 VPWR VGND sg13cmos5l_decap_4
XFILLER_14_706 VPWR VGND sg13cmos5l_fill_1
XFILLER_0_1061 VPWR VGND sg13cmos5l_decap_8
XFILLER_10_923 VPWR VGND sg13cmos5l_fill_1
XFILLER_16_1003 VPWR VGND sg13cmos5l_decap_8
XFILLER_10_967 VPWR VGND sg13cmos5l_decap_8
XFILLER_6_916 VPWR VGND sg13cmos5l_fill_2
XFILLER_1_610 VPWR VGND sg13cmos5l_fill_1
XFILLER_0_153 VPWR VGND sg13cmos5l_decap_4
XFILLER_0_197 VPWR VGND sg13cmos5l_decap_8
XFILLER_1_676 VPWR VGND sg13cmos5l_fill_2
XFILLER_1_632 VPWR VGND sg13cmos5l_fill_2
XFILLER_9_754 VPWR VGND sg13cmos5l_decap_8
XFILLER_8_253 VPWR VGND sg13cmos5l_decap_8
XFILLER_5_971 VPWR VGND sg13cmos5l_decap_8
XFILLER_5_64 VPWR VGND sg13cmos5l_decap_8
XFILLER_2_418 VPWR VGND sg13cmos5l_fill_1
XFILLER_14_536 VPWR VGND sg13cmos5l_decap_8
X_351_ Tile_X0Y0_FrameStrobe_O[15] Tile_X0Y0_FrameStrobe[15] VPWR VGND sg13cmos5l_buf_1
XFILLER_10_753 VPWR VGND sg13cmos5l_decap_8
XFILLER_14_73 VPWR VGND sg13cmos5l_decap_8
X_282_ Tile_X0Y0_S4BEG[14] Tile_X0Y0_N4END[1] VPWR VGND sg13cmos5l_buf_1
XFILLER_6_702 VPWR VGND sg13cmos5l_fill_1
XFILLER_5_223 VPWR VGND sg13cmos5l_decap_8
XFILLER_2_974 VPWR VGND sg13cmos5l_decap_8
XFILLER_2_941 VPWR VGND sg13cmos5l_decap_4
XFILLER_7_1078 VPWR VGND sg13cmos5l_decap_8
XFILLER_13_580 VPWR VGND sg13cmos5l_decap_8
XANTENNA__390__A1 Tile_X1Y0_N4END[11] VPWR VGND sg13cmos5l_antennanp
XANTENNA__128__CLK Tile_X0Y0_UserCLK VPWR VGND sg13cmos5l_antennanp
XANTENNA__381__A1 Tile_X1Y0_N4END[2] VPWR VGND sg13cmos5l_antennanp
XFILLER_13_1028 VPWR VGND sg13cmos5l_decap_8
XFILLER_3_749 VPWR VGND sg13cmos5l_decap_8
XFILLER_2_237 VPWR VGND sg13cmos5l_decap_8
XFILLER_14_311 VPWR VGND sg13cmos5l_decap_8
XFILLER_14_377 VPWR VGND sg13cmos5l_fill_2
XFILLER_14_399 VPWR VGND sg13cmos5l_decap_8
XFILLER_15_834 VPWR VGND sg13cmos5l_fill_2
XFILLER_15_867 VPWR VGND sg13cmos5l_decap_4
X_334_ Tile_X1Y0_FrameData_O[30] Tile_X0Y0_FrameData[30] VPWR VGND sg13cmos5l_buf_1
XANTENNA__372__A1 Tile_X0Y0_N4END[7] VPWR VGND sg13cmos5l_antennanp
X_196_ Tile_X1Y0_FrameStrobe_O[17] Tile_X1Y0_FrameStrobe[17] VPWR VGND sg13cmos5l_buf_1
X_265_ Tile_X0Y0_S2BEGb[5] Tile_X0Y0_N2END[2] VPWR VGND sg13cmos5l_buf_1
XFILLER_6_587 VPWR VGND sg13cmos5l_decap_8
XFILLER_6_510 VPWR VGND sg13cmos5l_decap_8
XFILLER_1_270 VPWR VGND sg13cmos5l_decap_8
XFILLER_1_281 VPWR VGND sg13cmos5l_fill_2
XFILLER_2_54 VPWR VGND sg13cmos5l_decap_8
XFILLER_0_708 VPWR VGND sg13cmos5l_decap_8
XFILLER_12_1050 VPWR VGND sg13cmos5l_decap_8
XANTENNA__098__D Tile_X0Y0_FrameData[8] VPWR VGND sg13cmos5l_antennanp
XFILLER_12_826 VPWR VGND sg13cmos5l_decap_8
XFILLER_12_837 VPWR VGND sg13cmos5l_fill_2
XFILLER_11_336 VPWR VGND sg13cmos5l_decap_8
X_050_ _050_/Q Tile_X0Y0_FrameData[20] VGND VPWR Tile_X0Y0_FrameStrobe[0] latch
XFILLER_7_329 VPWR VGND sg13cmos5l_decap_8
XFILLER_7_307 VPWR VGND sg13cmos5l_decap_8
XANTENNA__203__X Tile_X0Y0_S2BEG[4] VPWR VGND sg13cmos5l_antennanp
XFILLER_11_63 VPWR VGND sg13cmos5l_decap_8
XFILLER_3_524 VPWR VGND sg13cmos5l_decap_8
XFILLER_4_1059 VPWR VGND sg13cmos5l_decap_8
XFILLER_14_185 VPWR VGND sg13cmos5l_decap_8
XFILLER_15_697 VPWR VGND sg13cmos5l_fill_1
X_317_ Tile_X1Y0_FrameData_O[13] Tile_X0Y0_FrameData[13] VPWR VGND sg13cmos5l_buf_1
XANTENNA__070__GATE Tile_X0Y0_FrameStrobe[0] VPWR VGND sg13cmos5l_antennanp
XANTENNA__085__GATE Tile_X1Y0_FrameStrobe[0] VPWR VGND sg13cmos5l_antennanp
X_179_ _179_/L_HI VPWR VGND sg13cmos5l_tiehi
X_248_ Tile_X1Y0_SS4BEG[5] Tile_X1Y0_NN4END[10] VPWR VGND sg13cmos5l_buf_1
XFILLER_0_516 VPWR VGND sg13cmos5l_fill_1
XFILLER_0_527 VPWR VGND sg13cmos5l_fill_1
XFILLER_16_439 VPWR VGND sg13cmos5l_decap_8
XFILLER_11_133 VPWR VGND sg13cmos5l_decap_8
XFILLER_12_623 VPWR VGND sg13cmos5l_decap_8
XFILLER_8_627 VPWR VGND sg13cmos5l_decap_8
XFILLER_8_605 VPWR VGND sg13cmos5l_fill_2
XFILLER_3_1092 VPWR VGND sg13cmos5l_decap_8
X_102_ _102_/Q Tile_X0Y0_FrameData[4] VGND VPWR Tile_X1Y0_FrameStrobe[0] latch
XFILLER_4_833 VPWR VGND sg13cmos5l_decap_8
XFILLER_0_0 VPWR VGND sg13cmos5l_fill_1
XFILLER_3_387 VPWR VGND sg13cmos5l_fill_2
XFILLER_15_450 VPWR VGND sg13cmos5l_decap_8
XFILLER_16_962 VPWR VGND sg13cmos5l_decap_8
XFILLER_6_192 VPWR VGND sg13cmos5l_decap_8
XFILLER_1_858 VPWR VGND sg13cmos5l_fill_1
XFILLER_16_203 VPWR VGND sg13cmos5l_decap_8
XFILLER_16_236 VPWR VGND sg13cmos5l_decap_4
XFILLER_16_258 VPWR VGND sg13cmos5l_decap_8
XFILLER_1_1007 VPWR VGND sg13cmos5l_fill_1
XFILLER_12_420 VPWR VGND sg13cmos5l_decap_8
XFILLER_12_497 VPWR VGND sg13cmos5l_decap_8
XFILLER_4_663 VPWR VGND sg13cmos5l_decap_8
XFILLER_3_195 VPWR VGND sg13cmos5l_decap_8
XANTENNA__301__X Tile_X0Y0_S1BEG[1] VPWR VGND sg13cmos5l_antennanp
XFILLER_0_1040 VPWR VGND sg13cmos5l_decap_8
XFILLER_14_718 VPWR VGND sg13cmos5l_decap_4
XFILLER_10_902 VPWR VGND sg13cmos5l_fill_2
XFILLER_13_239 VPWR VGND sg13cmos5l_decap_8
XFILLER_16_1059 VPWR VGND sg13cmos5l_decap_8
XFILLER_6_906 VPWR VGND sg13cmos5l_fill_2
XANTENNA__211__X Tile_X1Y0_S2BEG[0] VPWR VGND sg13cmos5l_antennanp
XFILLER_0_132 VPWR VGND sg13cmos5l_decap_8
XFILLER_12_294 VPWR VGND sg13cmos5l_decap_8
XFILLER_13_784 VPWR VGND sg13cmos5l_decap_8
XFILLER_9_733 VPWR VGND sg13cmos5l_decap_8
XFILLER_8_232 VPWR VGND sg13cmos5l_decap_8
XFILLER_5_21 VPWR VGND sg13cmos5l_fill_2
XFILLER_5_43 VPWR VGND sg13cmos5l_decap_8
XFILLER_15_1081 VPWR VGND sg13cmos5l_decap_8
XFILLER_14_515 VPWR VGND sg13cmos5l_decap_8
X_350_ Tile_X0Y0_FrameStrobe_O[14] Tile_X0Y0_FrameStrobe[14] VPWR VGND sg13cmos5l_buf_1
XANTENNA__206__X Tile_X0Y0_S2BEG[7] VPWR VGND sg13cmos5l_antennanp
XFILLER_10_732 VPWR VGND sg13cmos5l_decap_8
XFILLER_14_52 VPWR VGND sg13cmos5l_decap_8
X_281_ Tile_X0Y0_S4BEG[13] Tile_X0Y0_N4END[2] VPWR VGND sg13cmos5l_buf_1
XFILLER_6_769 VPWR VGND sg13cmos5l_fill_1
XFILLER_7_1013 VPWR VGND sg13cmos5l_fill_2
XFILLER_5_279 VPWR VGND sg13cmos5l_decap_8
XFILLER_2_953 VPWR VGND sg13cmos5l_decap_8
XFILLER_1_485 VPWR VGND sg13cmos5l_decap_8
XFILLER_1_474 VPWR VGND sg13cmos5l_fill_1
XFILLER_7_1057 VPWR VGND sg13cmos5l_decap_8
XANTENNA__390__A2 Tile_X1Y0_NN4END[8] VPWR VGND sg13cmos5l_antennanp
XFILLER_9_596 VPWR VGND sg13cmos5l_decap_8
XFILLER_9_574 VPWR VGND sg13cmos5l_decap_8
XANTENNA__381__A2 Tile_X1Y0_NN4END[1] VPWR VGND sg13cmos5l_antennanp
XFILLER_13_1007 VPWR VGND sg13cmos5l_decap_8
XANTENNA__202__A Tile_X0Y0_N2MID[4] VPWR VGND sg13cmos5l_antennanp
XFILLER_2_216 VPWR VGND sg13cmos5l_decap_8
XFILLER_15_813 VPWR VGND sg13cmos5l_decap_8
XFILLER_15_846 VPWR VGND sg13cmos5l_decap_8
X_264_ Tile_X0Y0_S2BEGb[4] Tile_X0Y0_N2END[3] VPWR VGND sg13cmos5l_buf_1
X_333_ Tile_X1Y0_FrameData_O[29] Tile_X0Y0_FrameData[29] VPWR VGND sg13cmos5l_buf_1
XANTENNA__372__A2 Tile_X0Y0_NN4END[5] VPWR VGND sg13cmos5l_antennanp
X_195_ Tile_X1Y0_FrameStrobe_O[16] Tile_X1Y0_FrameStrobe[16] VPWR VGND sg13cmos5l_buf_1
XFILLER_6_566 VPWR VGND sg13cmos5l_decap_8
XFILLER_1_260 VPWR VGND sg13cmos5l_decap_4
XFILLER_1_293 VPWR VGND sg13cmos5l_decap_8
XFILLER_9_1119 VPWR VGND sg13cmos5l_fill_1
XFILLER_2_783 VPWR VGND sg13cmos5l_decap_8
XFILLER_11_315 VPWR VGND sg13cmos5l_decap_8
XFILLER_12_805 VPWR VGND sg13cmos5l_decap_8
XFILLER_12_849 VPWR VGND sg13cmos5l_decap_8
XFILLER_11_42 VPWR VGND sg13cmos5l_decap_8
XFILLER_4_1038 VPWR VGND sg13cmos5l_decap_8
XFILLER_14_164 VPWR VGND sg13cmos5l_decap_8
XFILLER_15_665 VPWR VGND sg13cmos5l_decap_4
X_247_ Tile_X1Y0_SS4BEG[4] Tile_X1Y0_NN4END[11] VPWR VGND sg13cmos5l_buf_1
X_316_ Tile_X1Y0_FrameData_O[12] Tile_X0Y0_FrameData[12] VPWR VGND sg13cmos5l_buf_1
XFILLER_10_392 VPWR VGND sg13cmos5l_decap_8
X_178_ _178_/L_HI VPWR VGND sg13cmos5l_tiehi
XFILLER_7_853 VPWR VGND sg13cmos5l_decap_8
XFILLER_6_374 VPWR VGND sg13cmos5l_decap_8
XFILLER_6_352 VPWR VGND sg13cmos5l_fill_1
XANTENNA__118__CLK Tile_X0Y0_UserCLK VPWR VGND sg13cmos5l_antennanp
XANTENNA__304__X Tile_X1Y0_FrameData_O[0] VPWR VGND sg13cmos5l_antennanp
XFILLER_16_418 VPWR VGND sg13cmos5l_decap_8
XFILLER_3_1071 VPWR VGND sg13cmos5l_decap_8
XFILLER_11_112 VPWR VGND sg13cmos5l_decap_8
XFILLER_11_189 VPWR VGND sg13cmos5l_decap_8
XFILLER_12_602 VPWR VGND sg13cmos5l_decap_8
XFILLER_12_679 VPWR VGND sg13cmos5l_decap_8
X_101_ _101_/Q Tile_X0Y0_FrameData[5] VGND VPWR Tile_X1Y0_FrameStrobe[0] latch
XFILLER_8_617 VPWR VGND sg13cmos5l_decap_8
XANTENNA__214__X Tile_X1Y0_S2BEG[3] VPWR VGND sg13cmos5l_antennanp
XFILLER_4_812 VPWR VGND sg13cmos5l_decap_8
XFILLER_3_344 VPWR VGND sg13cmos5l_decap_8
XFILLER_3_333 VPWR VGND sg13cmos5l_fill_1
XFILLER_3_322 VPWR VGND sg13cmos5l_decap_8
XFILLER_16_985 VPWR VGND sg13cmos5l_decap_8
XFILLER_16_996 VPWR VGND sg13cmos5l_decap_4
XFILLER_7_683 VPWR VGND sg13cmos5l_decap_4
XANTENNA__300__A Tile_X0Y0_N1END[3] VPWR VGND sg13cmos5l_antennanp
XFILLER_1_804 VPWR VGND sg13cmos5l_decap_8
XANTENNA__210__A Tile_X1Y0_N1END[0] VPWR VGND sg13cmos5l_antennanp
XANTENNA__084__GATE Tile_X1Y0_FrameStrobe[0] VPWR VGND sg13cmos5l_antennanp
XANTENNA__209__X Tile_X1Y0_S1BEG[2] VPWR VGND sg13cmos5l_antennanp
XANTENNA__099__GATE Tile_X1Y0_FrameStrobe[0] VPWR VGND sg13cmos5l_antennanp
XFILLER_12_476 VPWR VGND sg13cmos5l_decap_8
XFILLER_9_926 VPWR VGND sg13cmos5l_decap_8
XFILLER_8_469 VPWR VGND sg13cmos5l_decap_8
XFILLER_8_414 VPWR VGND sg13cmos5l_fill_1
XFILLER_4_642 VPWR VGND sg13cmos5l_decap_8
XFILLER_4_620 VPWR VGND sg13cmos5l_fill_1
XFILLER_3_174 VPWR VGND sg13cmos5l_decap_8
XFILLER_15_281 VPWR VGND sg13cmos5l_decap_8
XFILLER_16_782 VPWR VGND sg13cmos5l_decap_8
XFILLER_11_1105 VPWR VGND sg13cmos5l_decap_8
XFILLER_0_1096 VPWR VGND sg13cmos5l_decap_8
XFILLER_13_218 VPWR VGND sg13cmos5l_decap_8
XFILLER_16_1038 VPWR VGND sg13cmos5l_decap_8
XANTENNA__205__A Tile_X0Y0_N2MID[1] VPWR VGND sg13cmos5l_antennanp
XFILLER_1_678 VPWR VGND sg13cmos5l_fill_1
XFILLER_1_656 VPWR VGND sg13cmos5l_fill_2
XFILLER_1_634 VPWR VGND sg13cmos5l_fill_1
XFILLER_1_601 VPWR VGND sg13cmos5l_decap_4
XFILLER_13_763 VPWR VGND sg13cmos5l_decap_8
XFILLER_9_712 VPWR VGND sg13cmos5l_decap_8
XFILLER_12_273 VPWR VGND sg13cmos5l_decap_8
XFILLER_9_789 VPWR VGND sg13cmos5l_decap_8
XFILLER_8_288 VPWR VGND sg13cmos5l_decap_8
XFILLER_5_951 VPWR VGND sg13cmos5l_fill_2
XFILLER_5_99 VPWR VGND sg13cmos5l_decap_8
XANTENNA__393__A0 Tile_X1Y0_N4END[13] VPWR VGND sg13cmos5l_antennanp
XFILLER_15_1060 VPWR VGND sg13cmos5l_decap_8
XFILLER_16_590 VPWR VGND sg13cmos5l_decap_8
XANTENNA__312__X Tile_X1Y0_FrameData_O[8] VPWR VGND sg13cmos5l_antennanp
XFILLER_2_1103 VPWR VGND sg13cmos5l_fill_1
XANTENNA__384__A0 Tile_X1Y0_N4END[4] VPWR VGND sg13cmos5l_antennanp
XFILLER_10_711 VPWR VGND sg13cmos5l_decap_8
X_280_ Tile_X0Y0_S4BEG[12] Tile_X0Y0_N4END[3] VPWR VGND sg13cmos5l_buf_1
XFILLER_10_788 VPWR VGND sg13cmos5l_decap_8
XFILLER_5_258 VPWR VGND sg13cmos5l_decap_8
XANTENNA__222__X Tile_X1Y0_S2BEGb[3] VPWR VGND sg13cmos5l_antennanp
XFILLER_7_1047 VPWR VGND sg13cmos5l_fill_1
XFILLER_1_453 VPWR VGND sg13cmos5l_decap_8
XFILLER_1_420 VPWR VGND sg13cmos5l_fill_2
XANTENNA__375__A0 Tile_X0Y0_N4END[10] VPWR VGND sg13cmos5l_antennanp
XANTENNA__390__A3 Tile_X1Y0_NN4END[10] VPWR VGND sg13cmos5l_antennanp
XFILLER_9_553 VPWR VGND sg13cmos5l_decap_8
XANTENNA__366__A0 Tile_X0Y0_N4END[1] VPWR VGND sg13cmos5l_antennanp
XANTENNA__307__X Tile_X1Y0_FrameData_O[3] VPWR VGND sg13cmos5l_antennanp
XANTENNA__381__A3 Tile_X1Y0_NN4END[3] VPWR VGND sg13cmos5l_antennanp
XFILLER_3_718 VPWR VGND sg13cmos5l_decap_8
X_401_ _401_/X Tile_X0Y0_N1END[0] Tile_X0Y0_N2MID[0] Tile_X0Y0_N2MID[7] Tile_X0Y0_N2END[7]
+ _044_/Q _043_/Q VPWR VGND sg13cmos5l_mux4_1
XFILLER_6_1080 VPWR VGND sg13cmos5l_decap_8
XANTENNA__217__X Tile_X1Y0_S2BEG[6] VPWR VGND sg13cmos5l_antennanp
XANTENNA__372__A3 Tile_X0Y0_NN4END[7] VPWR VGND sg13cmos5l_antennanp
XFILLER_14_346 VPWR VGND sg13cmos5l_decap_4
X_263_ Tile_X0Y0_S2BEGb[3] Tile_X0Y0_N2END[4] VPWR VGND sg13cmos5l_buf_1
X_332_ Tile_X1Y0_FrameData_O[28] Tile_X0Y0_FrameData[28] VPWR VGND sg13cmos5l_buf_1
XFILLER_10_574 VPWR VGND sg13cmos5l_decap_8
X_194_ Tile_X1Y0_FrameStrobe_O[15] Tile_X1Y0_FrameStrobe[15] VPWR VGND sg13cmos5l_buf_1
XFILLER_6_545 VPWR VGND sg13cmos5l_decap_8
XFILLER_1_250 VPWR VGND sg13cmos5l_decap_4
XFILLER_2_89 VPWR VGND sg13cmos5l_decap_8
XFILLER_2_762 VPWR VGND sg13cmos5l_decap_8
XFILLER_2_45 VPWR VGND sg13cmos5l_fill_2
XFILLER_2_23 VPWR VGND sg13cmos5l_fill_1
XFILLER_13_390 VPWR VGND sg13cmos5l_decap_8
XFILLER_14_891 VPWR VGND sg13cmos5l_fill_1
XANTENNA__303__A Tile_X0Y0_N1END[0] VPWR VGND sg13cmos5l_antennanp
XFILLER_12_1085 VPWR VGND sg13cmos5l_decap_8
XANTENNA__213__A Tile_X1Y0_N2MID[5] VPWR VGND sg13cmos5l_antennanp
XFILLER_11_21 VPWR VGND sg13cmos5l_decap_8
XFILLER_11_98 VPWR VGND sg13cmos5l_decap_8
XFILLER_3_559 VPWR VGND sg13cmos5l_decap_8
XFILLER_4_1017 VPWR VGND sg13cmos5l_decap_8
XFILLER_14_143 VPWR VGND sg13cmos5l_decap_8
XFILLER_15_633 VPWR VGND sg13cmos5l_fill_1
XFILLER_11_883 VPWR VGND sg13cmos5l_fill_1
XFILLER_11_894 VPWR VGND sg13cmos5l_decap_8
X_177_ _177_/L_HI VPWR VGND sg13cmos5l_tiehi
X_246_ Tile_X1Y0_SS4BEG[3] Tile_X1Y0_NN4END[12] VPWR VGND sg13cmos5l_buf_1
X_315_ Tile_X1Y0_FrameData_O[11] Tile_X0Y0_FrameData[11] VPWR VGND sg13cmos5l_buf_1
XFILLER_7_832 VPWR VGND sg13cmos5l_decap_8
XFILLER_2_592 VPWR VGND sg13cmos5l_decap_4
XFILLER_2_581 VPWR VGND sg13cmos5l_fill_1
XFILLER_14_1103 VPWR VGND sg13cmos5l_decap_8
XANTENNA__320__X Tile_X1Y0_FrameData_O[16] VPWR VGND sg13cmos5l_antennanp
XFILLER_3_1050 VPWR VGND sg13cmos5l_decap_8
XANTENNA__208__A Tile_X1Y0_N1END[2] VPWR VGND sg13cmos5l_antennanp
XFILLER_11_168 VPWR VGND sg13cmos5l_decap_8
XFILLER_12_658 VPWR VGND sg13cmos5l_decap_8
X_100_ _100_/Q Tile_X0Y0_FrameData[6] VGND VPWR Tile_X1Y0_FrameStrobe[0] latch
XANTENNA__230__X Tile_X1Y0_S4BEG[3] VPWR VGND sg13cmos5l_antennanp
XFILLER_11_691 VPWR VGND sg13cmos5l_decap_8
X_229_ Tile_X1Y0_S4BEG[2] Tile_X1Y0_N4END[13] VPWR VGND sg13cmos5l_buf_1
XFILLER_8_99 VPWR VGND sg13cmos5l_decap_8
XFILLER_7_651 VPWR VGND sg13cmos5l_decap_8
XANTENNA__315__X Tile_X1Y0_FrameData_O[11] VPWR VGND sg13cmos5l_antennanp
XFILLER_1_816 VPWR VGND sg13cmos5l_fill_2
XFILLER_12_455 VPWR VGND sg13cmos5l_decap_8
XFILLER_16_216 VPWR VGND sg13cmos5l_decap_8
XANTENNA__225__X Tile_X1Y0_S2BEGb[6] VPWR VGND sg13cmos5l_antennanp
XFILLER_4_698 VPWR VGND sg13cmos5l_fill_1
XFILLER_3_153 VPWR VGND sg13cmos5l_decap_8
XFILLER_3_131 VPWR VGND sg13cmos5l_decap_8
XFILLER_16_761 VPWR VGND sg13cmos5l_decap_8
XFILLER_15_260 VPWR VGND sg13cmos5l_decap_8
XFILLER_7_492 VPWR VGND sg13cmos5l_decap_8
XANTENNA__311__A Tile_X0Y0_FrameData[7] VPWR VGND sg13cmos5l_antennanp
XFILLER_0_1075 VPWR VGND sg13cmos5l_decap_8
XFILLER_16_1017 VPWR VGND sg13cmos5l_decap_8
XFILLER_10_915 VPWR VGND sg13cmos5l_fill_2
XFILLER_6_908 VPWR VGND sg13cmos5l_fill_1
XANTENNA__221__A Tile_X1Y0_N2END[5] VPWR VGND sg13cmos5l_antennanp
XFILLER_0_167 VPWR VGND sg13cmos5l_fill_1
XFILLER_0_178 VPWR VGND sg13cmos5l_decap_8
XFILLER_1_646 VPWR VGND sg13cmos5l_decap_8
XFILLER_12_252 VPWR VGND sg13cmos5l_decap_8
XFILLER_13_742 VPWR VGND sg13cmos5l_decap_8
XFILLER_9_768 VPWR VGND sg13cmos5l_decap_8
XFILLER_8_267 VPWR VGND sg13cmos5l_decap_8
XFILLER_5_985 VPWR VGND sg13cmos5l_decap_8
XFILLER_5_78 VPWR VGND sg13cmos5l_decap_8
XFILLER_16_580 VPWR VGND sg13cmos5l_decap_8
XANTENNA__306__A Tile_X0Y0_FrameData[2] VPWR VGND sg13cmos5l_antennanp
XANTENNA__393__A1 Tile_X1Y0_N4END[14] VPWR VGND sg13cmos5l_antennanp
XANTENNA__083__GATE Tile_X1Y0_FrameStrobe[0] VPWR VGND sg13cmos5l_antennanp
XANTENNA__098__GATE Tile_X1Y0_FrameStrobe[0] VPWR VGND sg13cmos5l_antennanp
XANTENNA__384__A1 Tile_X1Y0_N4END[5] VPWR VGND sg13cmos5l_antennanp
XFILLER_14_87 VPWR VGND sg13cmos5l_decap_8
XANTENNA__216__A Tile_X1Y0_N2MID[2] VPWR VGND sg13cmos5l_antennanp
XFILLER_10_767 VPWR VGND sg13cmos5l_decap_8
XFILLER_6_738 VPWR VGND sg13cmos5l_fill_1
XFILLER_6_727 VPWR VGND sg13cmos5l_decap_8
XFILLER_5_237 VPWR VGND sg13cmos5l_decap_8
XANTENNA__101__D Tile_X0Y0_FrameData[5] VPWR VGND sg13cmos5l_antennanp
XFILLER_7_1026 VPWR VGND sg13cmos5l_decap_8
XFILLER_7_1015 VPWR VGND sg13cmos5l_fill_1
XFILLER_2_988 VPWR VGND sg13cmos5l_decap_8
XANTENNA__375__A1 Tile_X0Y0_N4END[11] VPWR VGND sg13cmos5l_antennanp
XFILLER_13_594 VPWR VGND sg13cmos5l_decap_8
XFILLER_9_532 VPWR VGND sg13cmos5l_decap_8
XFILLER_5_793 VPWR VGND sg13cmos5l_decap_8
XANTENNA__366__A1 Tile_X0Y0_N4END[2] VPWR VGND sg13cmos5l_antennanp
XFILLER_11_509 VPWR VGND sg13cmos5l_decap_8
XANTENNA__323__X Tile_X1Y0_FrameData_O[19] VPWR VGND sg13cmos5l_antennanp
XFILLER_2_207 VPWR VGND sg13cmos5l_decap_4
XFILLER_14_325 VPWR VGND sg13cmos5l_decap_8
X_400_ _400_/X Tile_X0Y0_N1END[1] Tile_X0Y0_N2MID[1] Tile_X0Y0_N2MID[6] Tile_X0Y0_N2END[6]
+ _042_/Q _041_/Q VPWR VGND sg13cmos5l_mux4_1
X_331_ Tile_X1Y0_FrameData_O[27] Tile_X0Y0_FrameData[27] VPWR VGND sg13cmos5l_buf_1
XFILLER_10_553 VPWR VGND sg13cmos5l_decap_8
X_193_ Tile_X1Y0_FrameStrobe_O[14] Tile_X1Y0_FrameStrobe[14] VPWR VGND sg13cmos5l_buf_1
X_262_ Tile_X0Y0_S2BEGb[2] Tile_X0Y0_N2END[5] VPWR VGND sg13cmos5l_buf_1
XFILLER_6_524 VPWR VGND sg13cmos5l_decap_8
XANTENNA__233__X Tile_X1Y0_S4BEG[6] VPWR VGND sg13cmos5l_antennanp
XFILLER_1_240 VPWR VGND sg13cmos5l_fill_1
XFILLER_2_68 VPWR VGND sg13cmos5l_decap_8
XFILLER_12_1064 VPWR VGND sg13cmos5l_decap_8
XFILLER_9_373 VPWR VGND sg13cmos5l_fill_2
XFILLER_9_340 VPWR VGND sg13cmos5l_decap_8
XANTENNA__318__X Tile_X1Y0_FrameData_O[14] VPWR VGND sg13cmos5l_antennanp
XANTENNA__141__CLK Tile_X0Y0_UserCLK VPWR VGND sg13cmos5l_antennanp
XFILLER_11_77 VPWR VGND sg13cmos5l_decap_8
XFILLER_3_538 VPWR VGND sg13cmos5l_decap_8
XANTENNA__228__X Tile_X1Y0_S4BEG[1] VPWR VGND sg13cmos5l_antennanp
XFILLER_14_122 VPWR VGND sg13cmos5l_decap_8
XFILLER_15_612 VPWR VGND sg13cmos5l_decap_8
XFILLER_15_645 VPWR VGND sg13cmos5l_fill_1
XFILLER_15_689 VPWR VGND sg13cmos5l_fill_1
X_314_ Tile_X1Y0_FrameData_O[10] Tile_X0Y0_FrameData[10] VPWR VGND sg13cmos5l_buf_1
XFILLER_14_199 VPWR VGND sg13cmos5l_decap_8
X_176_ _176_/L_HI VPWR VGND sg13cmos5l_tiehi
X_245_ Tile_X1Y0_SS4BEG[2] Tile_X1Y0_NN4END[13] VPWR VGND sg13cmos5l_buf_1
XFILLER_7_811 VPWR VGND sg13cmos5l_decap_8
XFILLER_2_560 VPWR VGND sg13cmos5l_decap_8
XANTENNA__314__A Tile_X0Y0_FrameData[10] VPWR VGND sg13cmos5l_antennanp
XFILLER_0_508 VPWR VGND sg13cmos5l_fill_1
XFILLER_12_637 VPWR VGND sg13cmos5l_decap_8
XANTENNA__224__A Tile_X1Y0_N2END[2] VPWR VGND sg13cmos5l_antennanp
XFILLER_11_147 VPWR VGND sg13cmos5l_decap_8
XFILLER_7_107 VPWR VGND sg13cmos5l_decap_8
XFILLER_15_464 VPWR VGND sg13cmos5l_decap_4
XFILLER_11_670 VPWR VGND sg13cmos5l_decap_8
X_159_ _159_/L_HI VPWR VGND sg13cmos5l_tiehi
X_228_ Tile_X1Y0_S4BEG[1] Tile_X1Y0_N4END[14] VPWR VGND sg13cmos5l_buf_1
XFILLER_8_78 VPWR VGND sg13cmos5l_decap_8
XFILLER_7_674 VPWR VGND sg13cmos5l_fill_2
XANTENNA__309__A Tile_X0Y0_FrameData[5] VPWR VGND sg13cmos5l_antennanp
XANTENNA__331__X Tile_X1Y0_FrameData_O[27] VPWR VGND sg13cmos5l_antennanp
XFILLER_1_839 VPWR VGND sg13cmos5l_decap_8
XANTENNA__219__A Tile_X1Y0_N2END[7] VPWR VGND sg13cmos5l_antennanp
XFILLER_12_434 VPWR VGND sg13cmos5l_decap_8
XFILLER_13_979 VPWR VGND sg13cmos5l_decap_8
XANTENNA__104__D Tile_X0Y0_FrameData[2] VPWR VGND sg13cmos5l_antennanp
XFILLER_4_677 VPWR VGND sg13cmos5l_decap_8
XFILLER_4_611 VPWR VGND sg13cmos5l_fill_2
XFILLER_3_110 VPWR VGND sg13cmos5l_decap_8
XANTENNA__241__X Tile_X1Y0_S4BEG[14] VPWR VGND sg13cmos5l_antennanp
XFILLER_4_688 VPWR VGND sg13cmos5l_fill_2
XFILLER_16_740 VPWR VGND sg13cmos5l_decap_8
XFILLER_7_471 VPWR VGND sg13cmos5l_decap_8
XANTENNA__326__X Tile_X1Y0_FrameData_O[22] VPWR VGND sg13cmos5l_antennanp
XFILLER_0_1054 VPWR VGND sg13cmos5l_decap_8
XFILLER_0_146 VPWR VGND sg13cmos5l_decap_8
XFILLER_0_157 VPWR VGND sg13cmos5l_fill_2
XFILLER_1_625 VPWR VGND sg13cmos5l_fill_2
XANTENNA__236__X Tile_X1Y0_S4BEG[9] VPWR VGND sg13cmos5l_antennanp
XFILLER_12_231 VPWR VGND sg13cmos5l_decap_8
XFILLER_13_721 VPWR VGND sg13cmos5l_decap_8
XFILLER_13_798 VPWR VGND sg13cmos5l_decap_8
XFILLER_9_747 VPWR VGND sg13cmos5l_decap_8
XFILLER_8_246 VPWR VGND sg13cmos5l_decap_8
XFILLER_5_964 VPWR VGND sg13cmos5l_decap_8
XFILLER_5_57 VPWR VGND sg13cmos5l_decap_8
XFILLER_0_680 VPWR VGND sg13cmos5l_decap_8
XANTENNA__393__A2 Tile_X1Y0_NN4END[13] VPWR VGND sg13cmos5l_antennanp
XFILLER_15_1095 VPWR VGND sg13cmos5l_decap_8
XANTENNA__322__A Tile_X0Y0_FrameData[18] VPWR VGND sg13cmos5l_antennanp
XFILLER_14_529 VPWR VGND sg13cmos5l_decap_8
XANTENNA__384__A2 Tile_X1Y0_NN4END[4] VPWR VGND sg13cmos5l_antennanp
XFILLER_10_746 VPWR VGND sg13cmos5l_decap_8
XFILLER_14_66 VPWR VGND sg13cmos5l_decap_8
XANTENNA__232__A Tile_X1Y0_N4END[10] VPWR VGND sg13cmos5l_antennanp
XFILLER_5_216 VPWR VGND sg13cmos5l_decap_4
XFILLER_2_967 VPWR VGND sg13cmos5l_decap_8
XFILLER_2_945 VPWR VGND sg13cmos5l_fill_2
XFILLER_2_934 VPWR VGND sg13cmos5l_decap_8
XFILLER_1_499 VPWR VGND sg13cmos5l_decap_8
XANTENNA__375__A2 Tile_X0Y0_NN4END[8] VPWR VGND sg13cmos5l_antennanp
XFILLER_13_573 VPWR VGND sg13cmos5l_decap_8
XFILLER_9_588 VPWR VGND sg13cmos5l_decap_4
XFILLER_9_511 VPWR VGND sg13cmos5l_decap_8
XFILLER_5_772 VPWR VGND sg13cmos5l_decap_8
XANTENNA__317__A Tile_X0Y0_FrameData[13] VPWR VGND sg13cmos5l_antennanp
XANTENNA__366__A2 Tile_X0Y0_NN4END[1] VPWR VGND sg13cmos5l_antennanp
XANTENNA__227__A Tile_X1Y0_N4END[15] VPWR VGND sg13cmos5l_antennanp
XFILLER_14_304 VPWR VGND sg13cmos5l_decap_8
XFILLER_15_827 VPWR VGND sg13cmos5l_decap_8
X_330_ Tile_X1Y0_FrameData_O[26] Tile_X0Y0_FrameData[26] VPWR VGND sg13cmos5l_buf_1
XFILLER_10_532 VPWR VGND sg13cmos5l_decap_8
X_192_ Tile_X1Y0_FrameStrobe_O[13] Tile_X1Y0_FrameStrobe[13] VPWR VGND sg13cmos5l_buf_1
X_261_ Tile_X0Y0_S2BEGb[1] Tile_X0Y0_N2END[6] VPWR VGND sg13cmos5l_buf_1
XFILLER_6_503 VPWR VGND sg13cmos5l_decap_8
XANTENNA__112__D Tile_X0Y0_FrameData[26] VPWR VGND sg13cmos5l_antennanp
XFILLER_9_0 VPWR VGND sg13cmos5l_fill_2
XFILLER_2_797 VPWR VGND sg13cmos5l_decap_8
XFILLER_2_47 VPWR VGND sg13cmos5l_fill_1
XANTENNA__082__GATE Tile_X1Y0_FrameStrobe[0] VPWR VGND sg13cmos5l_antennanp
XFILLER_14_882 VPWR VGND sg13cmos5l_fill_1
XANTENNA__097__GATE Tile_X1Y0_FrameStrobe[0] VPWR VGND sg13cmos5l_antennanp
XFILLER_12_1043 VPWR VGND sg13cmos5l_decap_8
XFILLER_12_819 VPWR VGND sg13cmos5l_decap_8
XANTENNA__334__X Tile_X1Y0_FrameData_O[30] VPWR VGND sg13cmos5l_antennanp
XFILLER_11_329 VPWR VGND sg13cmos5l_decap_8
XFILLER_11_56 VPWR VGND sg13cmos5l_decap_8
XFILLER_3_517 VPWR VGND sg13cmos5l_decap_8
XFILLER_11_852 VPWR VGND sg13cmos5l_decap_8
XFILLER_14_101 VPWR VGND sg13cmos5l_decap_8
XFILLER_14_178 VPWR VGND sg13cmos5l_decap_8
XFILLER_15_657 VPWR VGND sg13cmos5l_decap_4
X_244_ Tile_X1Y0_SS4BEG[1] Tile_X1Y0_NN4END[14] VPWR VGND sg13cmos5l_buf_1
X_313_ Tile_X1Y0_FrameData_O[9] Tile_X0Y0_FrameData[9] VPWR VGND sg13cmos5l_buf_1
XANTENNA__107__D Tile_X0Y0_FrameData[31] VPWR VGND sg13cmos5l_antennanp
XANTENNA__244__X Tile_X1Y0_SS4BEG[1] VPWR VGND sg13cmos5l_antennanp
XFILLER_10_340 VPWR VGND sg13cmos5l_decap_8
X_175_ _175_/L_HI VPWR VGND sg13cmos5l_tiehi
XFILLER_14_690 VPWR VGND sg13cmos5l_decap_8
XFILLER_9_193 VPWR VGND sg13cmos5l_decap_8
XANTENNA__330__A Tile_X0Y0_FrameData[26] VPWR VGND sg13cmos5l_antennanp
XANTENNA__329__X Tile_X1Y0_FrameData_O[25] VPWR VGND sg13cmos5l_antennanp
XFILLER_11_126 VPWR VGND sg13cmos5l_decap_8
XFILLER_12_616 VPWR VGND sg13cmos5l_decap_8
XFILLER_3_1085 VPWR VGND sg13cmos5l_decap_8
XFILLER_4_826 VPWR VGND sg13cmos5l_decap_8
XANTENNA__240__A Tile_X1Y0_N4END[2] VPWR VGND sg13cmos5l_antennanp
XANTENNA__239__X Tile_X1Y0_S4BEG[12] VPWR VGND sg13cmos5l_antennanp
XFILLER_15_443 VPWR VGND sg13cmos5l_decap_8
XFILLER_16_922 VPWR VGND sg13cmos5l_decap_4
XFILLER_16_933 VPWR VGND sg13cmos5l_fill_2
X_227_ Tile_X1Y0_S4BEG[0] Tile_X1Y0_N4END[15] VPWR VGND sg13cmos5l_buf_1
XFILLER_7_620 VPWR VGND sg13cmos5l_decap_8
X_089_ _089_/Q Tile_X0Y0_FrameData[17] VGND VPWR Tile_X1Y0_FrameStrobe[0] latch
X_158_ _158_/L_HI VPWR VGND sg13cmos5l_tiehi
XFILLER_6_185 VPWR VGND sg13cmos5l_decap_8
XANTENNA__131__CLK Tile_X0Y0_UserCLK VPWR VGND sg13cmos5l_antennanp
XANTENNA__325__A Tile_X0Y0_FrameData[21] VPWR VGND sg13cmos5l_antennanp
XFILLER_0_317 VPWR VGND sg13cmos5l_fill_2
XFILLER_1_829 VPWR VGND sg13cmos5l_fill_2
XFILLER_1_818 VPWR VGND sg13cmos5l_fill_1
XANTENNA__235__A Tile_X1Y0_N4END[7] VPWR VGND sg13cmos5l_antennanp
XFILLER_12_413 VPWR VGND sg13cmos5l_decap_8
XFILLER_9_907 VPWR VGND sg13cmos5l_decap_8
XFILLER_4_656 VPWR VGND sg13cmos5l_decap_8
XFILLER_0_851 VPWR VGND sg13cmos5l_decap_8
XFILLER_3_188 VPWR VGND sg13cmos5l_decap_8
XFILLER_15_295 VPWR VGND sg13cmos5l_decap_8
XFILLER_16_796 VPWR VGND sg13cmos5l_decap_8
XFILLER_11_1119 VPWR VGND sg13cmos5l_fill_1
XFILLER_12_980 VPWR VGND sg13cmos5l_decap_8
XFILLER_7_450 VPWR VGND sg13cmos5l_decap_8
XANTENNA__396__A0 Tile_X1Y0_N1END[2] VPWR VGND sg13cmos5l_antennanp
XANTENNA__342__X Tile_X0Y0_FrameStrobe_O[6] VPWR VGND sg13cmos5l_antennanp
XFILLER_1_615 VPWR VGND sg13cmos5l_decap_8
XFILLER_0_114 VPWR VGND sg13cmos5l_fill_1
XFILLER_0_125 VPWR VGND sg13cmos5l_decap_8
XANTENNA__387__A0 Tile_X1Y0_N4END[4] VPWR VGND sg13cmos5l_antennanp
XFILLER_12_210 VPWR VGND sg13cmos5l_decap_8
XFILLER_13_700 VPWR VGND sg13cmos5l_decap_8
XANTENNA__252__X Tile_X1Y0_SS4BEG[9] VPWR VGND sg13cmos5l_antennanp
XFILLER_12_287 VPWR VGND sg13cmos5l_decap_8
XFILLER_13_777 VPWR VGND sg13cmos5l_decap_8
XFILLER_9_726 VPWR VGND sg13cmos5l_decap_8
XFILLER_5_36 VPWR VGND sg13cmos5l_decap_8
XFILLER_0_670 VPWR VGND sg13cmos5l_fill_1
XANTENNA__378__A0 Tile_X0Y0_N4END[13] VPWR VGND sg13cmos5l_antennanp
XANTENNA__393__A3 Tile_X1Y0_NN4END[15] VPWR VGND sg13cmos5l_antennanp
XFILLER_15_1074 VPWR VGND sg13cmos5l_decap_8
XANTENNA__337__X Tile_X0Y0_FrameStrobe_O[1] VPWR VGND sg13cmos5l_antennanp
XANTENNA__369__A0 Tile_X0Y0_N4END[4] VPWR VGND sg13cmos5l_antennanp
XFILLER_14_508 VPWR VGND sg13cmos5l_decap_8
XANTENNA__384__A3 Tile_X1Y0_NN4END[6] VPWR VGND sg13cmos5l_antennanp
XFILLER_10_725 VPWR VGND sg13cmos5l_decap_8
XFILLER_14_45 VPWR VGND sg13cmos5l_decap_8
XFILLER_7_1006 VPWR VGND sg13cmos5l_decap_8
XFILLER_1_467 VPWR VGND sg13cmos5l_decap_8
XFILLER_1_478 VPWR VGND sg13cmos5l_decap_8
XANTENNA__247__X Tile_X1Y0_SS4BEG[4] VPWR VGND sg13cmos5l_antennanp
XANTENNA__375__A3 Tile_X0Y0_NN4END[10] VPWR VGND sg13cmos5l_antennanp
XFILLER_13_552 VPWR VGND sg13cmos5l_decap_8
XFILLER_9_567 VPWR VGND sg13cmos5l_decap_8
XFILLER_5_751 VPWR VGND sg13cmos5l_decap_8
XFILLER_4_294 VPWR VGND sg13cmos5l_decap_8
XANTENNA__366__A3 Tile_X0Y0_NN4END[3] VPWR VGND sg13cmos5l_antennanp
XFILLER_16_390 VPWR VGND sg13cmos5l_decap_8
XANTENNA__333__A Tile_X0Y0_FrameData[29] VPWR VGND sg13cmos5l_antennanp
XFILLER_6_1094 VPWR VGND sg13cmos5l_decap_8
XFILLER_10_511 VPWR VGND sg13cmos5l_decap_8
XFILLER_15_806 VPWR VGND sg13cmos5l_decap_8
XFILLER_15_839 VPWR VGND sg13cmos5l_decap_8
X_260_ Tile_X0Y0_S2BEGb[0] Tile_X0Y0_N2END[7] VPWR VGND sg13cmos5l_buf_1
XANTENNA__243__A Tile_X1Y0_NN4END[15] VPWR VGND sg13cmos5l_antennanp
XFILLER_10_588 VPWR VGND sg13cmos5l_decap_8
X_191_ Tile_X1Y0_FrameStrobe_O[12] Tile_X1Y0_FrameStrobe[12] VPWR VGND sg13cmos5l_buf_1
XFILLER_6_559 VPWR VGND sg13cmos5l_decap_8
XFILLER_1_264 VPWR VGND sg13cmos5l_fill_2
XFILLER_1_286 VPWR VGND sg13cmos5l_decap_8
XFILLER_2_776 VPWR VGND sg13cmos5l_decap_8
XFILLER_2_732 VPWR VGND sg13cmos5l_decap_8
X_389_ _389_/X Tile_X1Y0_N4END[9] Tile_X1Y0_N4END[10] Tile_X1Y0_NN4END[9] Tile_X1Y0_NN4END[11]
+ _094_/Q _093_/Q VPWR VGND sg13cmos5l_mux4_1
XFILLER_12_1022 VPWR VGND sg13cmos5l_decap_8
XFILLER_12_1099 VPWR VGND sg13cmos5l_decap_8
XFILLER_5_581 VPWR VGND sg13cmos5l_fill_2
XFILLER_5_570 VPWR VGND sg13cmos5l_decap_8
XANTENNA__328__A Tile_X0Y0_FrameData[24] VPWR VGND sg13cmos5l_antennanp
XFILLER_11_308 VPWR VGND sg13cmos5l_decap_8
XFILLER_11_35 VPWR VGND sg13cmos5l_decap_8
XANTENNA__350__X Tile_X0Y0_FrameStrobe_O[14] VPWR VGND sg13cmos5l_antennanp
XFILLER_8_1112 VPWR VGND sg13cmos5l_decap_8
XANTENNA__238__A Tile_X1Y0_N4END[4] VPWR VGND sg13cmos5l_antennanp
XFILLER_15_625 VPWR VGND sg13cmos5l_fill_1
XFILLER_11_831 VPWR VGND sg13cmos5l_decap_8
XFILLER_14_157 VPWR VGND sg13cmos5l_decap_8
X_243_ Tile_X1Y0_SS4BEG[0] Tile_X1Y0_NN4END[15] VPWR VGND sg13cmos5l_buf_1
X_312_ Tile_X1Y0_FrameData_O[8] Tile_X0Y0_FrameData[8] VPWR VGND sg13cmos5l_buf_1
XANTENNA__260__X Tile_X0Y0_S2BEGb[0] VPWR VGND sg13cmos5l_antennanp
XFILLER_10_385 VPWR VGND sg13cmos5l_decap_8
X_174_ _174_/L_HI VPWR VGND sg13cmos5l_tiehi
XFILLER_7_846 VPWR VGND sg13cmos5l_decap_8
XFILLER_6_312 VPWR VGND sg13cmos5l_decap_8
XFILLER_13_190 VPWR VGND sg13cmos5l_decap_8
XFILLER_14_1117 VPWR VGND sg13cmos5l_fill_2
XFILLER_9_172 VPWR VGND sg13cmos5l_decap_8
XFILLER_3_1064 VPWR VGND sg13cmos5l_decap_8
XANTENNA__345__X Tile_X0Y0_FrameStrobe_O[9] VPWR VGND sg13cmos5l_antennanp
XFILLER_11_105 VPWR VGND sg13cmos5l_decap_8
XFILLER_4_805 VPWR VGND sg13cmos5l_decap_8
XFILLER_3_337 VPWR VGND sg13cmos5l_decap_8
XFILLER_3_315 VPWR VGND sg13cmos5l_decap_8
XANTENNA__081__GATE Tile_X1Y0_FrameStrobe[0] VPWR VGND sg13cmos5l_antennanp
XANTENNA__096__GATE Tile_X1Y0_FrameStrobe[0] VPWR VGND sg13cmos5l_antennanp
XFILLER_15_433 VPWR VGND sg13cmos5l_decap_4
XFILLER_16_956 VPWR VGND sg13cmos5l_fill_2
XFILLER_16_978 VPWR VGND sg13cmos5l_decap_8
XANTENNA__255__X Tile_X1Y0_SS4BEG[12] VPWR VGND sg13cmos5l_antennanp
XFILLER_10_193 VPWR VGND sg13cmos5l_decap_8
X_157_ _157_/L_HI VPWR VGND sg13cmos5l_tiehi
X_226_ Tile_X1Y0_S2BEGb[7] Tile_X1Y0_N2END[0] VPWR VGND sg13cmos5l_buf_1
XFILLER_8_14 VPWR VGND sg13cmos5l_decap_8
XFILLER_7_665 VPWR VGND sg13cmos5l_decap_4
XFILLER_6_153 VPWR VGND sg13cmos5l_fill_1
XFILLER_6_131 VPWR VGND sg13cmos5l_decap_4
XANTENNA__049__GATE Tile_X0Y0_FrameStrobe[0] VPWR VGND sg13cmos5l_antennanp
X_088_ _088_/Q Tile_X0Y0_FrameData[18] VGND VPWR Tile_X1Y0_FrameStrobe[0] latch
XFILLER_2_381 VPWR VGND sg13cmos5l_decap_4
XANTENNA__341__A Tile_X0Y0_FrameStrobe[5] VPWR VGND sg13cmos5l_antennanp
XFILLER_12_469 VPWR VGND sg13cmos5l_decap_8
XANTENNA__251__A Tile_X1Y0_NN4END[7] VPWR VGND sg13cmos5l_antennanp
XFILLER_0_830 VPWR VGND sg13cmos5l_decap_8
XFILLER_3_167 VPWR VGND sg13cmos5l_decap_8
XFILLER_3_145 VPWR VGND sg13cmos5l_fill_1
XFILLER_15_274 VPWR VGND sg13cmos5l_decap_8
XFILLER_16_720 VPWR VGND sg13cmos5l_fill_1
XFILLER_16_775 VPWR VGND sg13cmos5l_decap_8
X_209_ Tile_X1Y0_S1BEG[2] Tile_X1Y0_N1END[1] VPWR VGND sg13cmos5l_buf_1
XFILLER_3_690 VPWR VGND sg13cmos5l_decap_8
XANTENNA__396__A1 Tile_X1Y0_N2MID[2] VPWR VGND sg13cmos5l_antennanp
XANTENNA__336__A Tile_X0Y0_FrameStrobe[0] VPWR VGND sg13cmos5l_antennanp
XFILLER_0_1089 VPWR VGND sg13cmos5l_decap_8
XFILLER_1_638 VPWR VGND sg13cmos5l_fill_2
XFILLER_1_627 VPWR VGND sg13cmos5l_fill_1
XFILLER_1_605 VPWR VGND sg13cmos5l_fill_1
XFILLER_9_1092 VPWR VGND sg13cmos5l_decap_8
XANTENNA__246__A Tile_X1Y0_NN4END[12] VPWR VGND sg13cmos5l_antennanp
XANTENNA__387__A1 Tile_X1Y0_N4END[7] VPWR VGND sg13cmos5l_antennanp
XFILLER_13_756 VPWR VGND sg13cmos5l_decap_8
XFILLER_9_705 VPWR VGND sg13cmos5l_decap_8
XFILLER_12_266 VPWR VGND sg13cmos5l_decap_8
XANTENNA__121__CLK Tile_X0Y0_UserCLK VPWR VGND sg13cmos5l_antennanp
XFILLER_5_999 VPWR VGND sg13cmos5l_decap_8
XANTENNA__378__A1 Tile_X0Y0_N4END[14] VPWR VGND sg13cmos5l_antennanp
XFILLER_15_1053 VPWR VGND sg13cmos5l_decap_8
XANTENNA__041__D Tile_X0Y0_FrameData[29] VPWR VGND sg13cmos5l_antennanp
XFILLER_2_1118 VPWR VGND sg13cmos5l_fill_2
XANTENNA__369__A1 Tile_X0Y0_N4END[5] VPWR VGND sg13cmos5l_antennanp
XFILLER_14_13 VPWR VGND sg13cmos5l_fill_2
XANTENNA__144__CLK Tile_X0Y0_UserCLK VPWR VGND sg13cmos5l_antennanp
XANTENNA__353__X Tile_X0Y0_FrameStrobe_O[17] VPWR VGND sg13cmos5l_antennanp
XFILLER_10_704 VPWR VGND sg13cmos5l_decap_8
XFILLER_2_914 VPWR VGND sg13cmos5l_decap_4
XANTENNA__263__X Tile_X0Y0_S2BEGb[3] VPWR VGND sg13cmos5l_antennanp
XFILLER_13_531 VPWR VGND sg13cmos5l_decap_8
XFILLER_9_546 VPWR VGND sg13cmos5l_decap_8
XFILLER_5_730 VPWR VGND sg13cmos5l_decap_8
XFILLER_1_991 VPWR VGND sg13cmos5l_fill_1
XANTENNA__122__Q NPU_QUANT_SHIFT_IN7 VPWR VGND sg13cmos5l_antennanp
XFILLER_6_91 VPWR VGND sg13cmos5l_decap_8
XANTENNA__348__X Tile_X0Y0_FrameStrobe_O[12] VPWR VGND sg13cmos5l_antennanp
XFILLER_6_1073 VPWR VGND sg13cmos5l_decap_8
XFILLER_14_339 VPWR VGND sg13cmos5l_decap_8
X_190_ Tile_X1Y0_FrameStrobe_O[11] Tile_X1Y0_FrameStrobe[11] VPWR VGND sg13cmos5l_buf_1
XFILLER_10_567 VPWR VGND sg13cmos5l_decap_8
XFILLER_6_538 VPWR VGND sg13cmos5l_decap_8
XFILLER_2_711 VPWR VGND sg13cmos5l_decap_8
XFILLER_1_254 VPWR VGND sg13cmos5l_fill_2
XFILLER_2_38 VPWR VGND sg13cmos5l_fill_1
XFILLER_2_27 VPWR VGND sg13cmos5l_fill_2
XANTENNA__258__X Tile_X1Y0_SS4BEG[15] VPWR VGND sg13cmos5l_antennanp
XFILLER_12_1001 VPWR VGND sg13cmos5l_decap_8
XFILLER_13_383 VPWR VGND sg13cmos5l_decap_8
XFILLER_14_862 VPWR VGND sg13cmos5l_fill_2
XFILLER_14_873 VPWR VGND sg13cmos5l_fill_2
X_388_ _388_/X Tile_X1Y0_N4END[8] Tile_X1Y0_N4END[9] Tile_X1Y0_NN4END[8] Tile_X1Y0_NN4END[10]
+ _096_/Q _095_/Q VPWR VGND sg13cmos5l_mux4_1
XFILLER_9_354 VPWR VGND sg13cmos5l_fill_1
XFILLER_12_1078 VPWR VGND sg13cmos5l_decap_8
XANTENNA__117__Q NPU_QUANT_SHIFT_IN2 VPWR VGND sg13cmos5l_antennanp
XANTENNA__344__A Tile_X0Y0_FrameStrobe[8] VPWR VGND sg13cmos5l_antennanp
XFILLER_11_14 VPWR VGND sg13cmos5l_decap_8
XFILLER_14_136 VPWR VGND sg13cmos5l_decap_8
XANTENNA__254__A Tile_X1Y0_NN4END[4] VPWR VGND sg13cmos5l_antennanp
XFILLER_11_810 VPWR VGND sg13cmos5l_decap_8
XFILLER_11_876 VPWR VGND sg13cmos5l_fill_2
XFILLER_11_887 VPWR VGND sg13cmos5l_decap_8
X_173_ _173_/L_HI VPWR VGND sg13cmos5l_tiehi
X_242_ Tile_X1Y0_S4BEG[15] Tile_X1Y0_N4END[0] VPWR VGND sg13cmos5l_buf_1
X_311_ Tile_X1Y0_FrameData_O[7] Tile_X0Y0_FrameData[7] VPWR VGND sg13cmos5l_buf_1
XFILLER_7_825 VPWR VGND sg13cmos5l_decap_8
XFILLER_2_574 VPWR VGND sg13cmos5l_decap_8
XFILLER_2_596 VPWR VGND sg13cmos5l_fill_1
XFILLER_2_585 VPWR VGND sg13cmos5l_decap_8
XFILLER_9_151 VPWR VGND sg13cmos5l_decap_8
XFILLER_3_81 VPWR VGND sg13cmos5l_fill_1
XANTENNA__339__A Tile_X0Y0_FrameStrobe[3] VPWR VGND sg13cmos5l_antennanp
XFILLER_3_1043 VPWR VGND sg13cmos5l_decap_8
XANTENNA__361__X Tile_X1Y0_FrameStrobe_O[5] VPWR VGND sg13cmos5l_antennanp
XANTENNA__249__A Tile_X1Y0_NN4END[9] VPWR VGND sg13cmos5l_antennanp
XFILLER_16_935 VPWR VGND sg13cmos5l_fill_1
XANTENNA__271__X Tile_X0Y0_S4BEG[3] VPWR VGND sg13cmos5l_antennanp
XFILLER_10_172 VPWR VGND sg13cmos5l_decap_8
XFILLER_11_684 VPWR VGND sg13cmos5l_decap_8
X_087_ _087_/Q Tile_X0Y0_FrameData[19] VGND VPWR Tile_X1Y0_FrameStrobe[0] latch
X_156_ _156_/L_HI VPWR VGND sg13cmos5l_tiehi
X_225_ Tile_X1Y0_S2BEGb[6] Tile_X1Y0_N2END[1] VPWR VGND sg13cmos5l_buf_1
XFILLER_7_644 VPWR VGND sg13cmos5l_decap_8
XFILLER_7_611 VPWR VGND sg13cmos5l_fill_1
XFILLER_3_894 VPWR VGND sg13cmos5l_fill_1
XANTENNA__044__D Tile_X0Y0_FrameData[26] VPWR VGND sg13cmos5l_antennanp
XANTENNA__130__Q NPU_QUANT_SHIFT_IN15 VPWR VGND sg13cmos5l_antennanp
XANTENNA__356__X Tile_X1Y0_FrameStrobe_O[0] VPWR VGND sg13cmos5l_antennanp
XANTENNA__109__GATE Tile_X1Y0_FrameStrobe[1] VPWR VGND sg13cmos5l_antennanp
XFILLER_12_448 VPWR VGND sg13cmos5l_decap_8
XFILLER_8_419 VPWR VGND sg13cmos5l_decap_4
XFILLER_3_124 VPWR VGND sg13cmos5l_decap_8
XFILLER_16_732 VPWR VGND sg13cmos5l_decap_4
XANTENNA__266__X Tile_X0Y0_S2BEGb[6] VPWR VGND sg13cmos5l_antennanp
XFILLER_15_253 VPWR VGND sg13cmos5l_decap_8
XFILLER_16_754 VPWR VGND sg13cmos5l_decap_8
XFILLER_11_481 VPWR VGND sg13cmos5l_decap_8
X_139_ NPU_QUANT_SHIFT_IN24 Tile_X0Y0_UserCLK _389_/X _166_/L_HI VPWR VGND sg13cmos5l_dfrbpq_1
X_208_ Tile_X1Y0_S1BEG[1] Tile_X1Y0_N1END[2] VPWR VGND sg13cmos5l_buf_1
XFILLER_7_485 VPWR VGND sg13cmos5l_decap_8
XANTENNA__396__A2 Tile_X1Y0_N2MID[5] VPWR VGND sg13cmos5l_antennanp
XFILLER_0_1068 VPWR VGND sg13cmos5l_decap_8
XANTENNA__080__GATE Tile_X1Y0_FrameStrobe[0] VPWR VGND sg13cmos5l_antennanp
XANTENNA__125__Q NPU_QUANT_SHIFT_IN10 VPWR VGND sg13cmos5l_antennanp
XANTENNA__352__A Tile_X0Y0_FrameStrobe[16] VPWR VGND sg13cmos5l_antennanp
XFILLER_10_908 VPWR VGND sg13cmos5l_decap_8
XANTENNA__095__GATE Tile_X1Y0_FrameStrobe[0] VPWR VGND sg13cmos5l_antennanp
XFILLER_9_1071 VPWR VGND sg13cmos5l_decap_8
XANTENNA__048__GATE Tile_X0Y0_FrameStrobe[0] VPWR VGND sg13cmos5l_antennanp
XANTENNA__387__A2 Tile_X1Y0_NN4END[5] VPWR VGND sg13cmos5l_antennanp
XFILLER_12_245 VPWR VGND sg13cmos5l_decap_8
XFILLER_13_735 VPWR VGND sg13cmos5l_decap_8
XANTENNA__262__A Tile_X0Y0_N2END[5] VPWR VGND sg13cmos5l_antennanp
XFILLER_10_1110 VPWR VGND sg13cmos5l_decap_8
XFILLER_5_978 VPWR VGND sg13cmos5l_decap_8
XFILLER_0_661 VPWR VGND sg13cmos5l_fill_1
XFILLER_0_694 VPWR VGND sg13cmos5l_decap_8
XFILLER_10_8 VPWR VGND sg13cmos5l_fill_1
XANTENNA__378__A2 Tile_X0Y0_NN4END[13] VPWR VGND sg13cmos5l_antennanp
XFILLER_16_540 VPWR VGND sg13cmos5l_decap_8
XFILLER_16_551 VPWR VGND sg13cmos5l_decap_4
XFILLER_16_573 VPWR VGND sg13cmos5l_decap_8
XFILLER_15_1032 VPWR VGND sg13cmos5l_decap_8
XFILLER_8_783 VPWR VGND sg13cmos5l_fill_1
XFILLER_7_293 VPWR VGND sg13cmos5l_decap_8
XANTENNA__347__A Tile_X0Y0_FrameStrobe[11] VPWR VGND sg13cmos5l_antennanp
XANTENNA__369__A2 Tile_X0Y0_NN4END[4] VPWR VGND sg13cmos5l_antennanp
XFILLER_2_904 VPWR VGND sg13cmos5l_fill_2
XFILLER_7_1019 VPWR VGND sg13cmos5l_decap_8
XANTENNA__257__A Tile_X1Y0_NN4END[1] VPWR VGND sg13cmos5l_antennanp
XFILLER_13_510 VPWR VGND sg13cmos5l_decap_8
XFILLER_13_587 VPWR VGND sg13cmos5l_decap_8
XFILLER_9_525 VPWR VGND sg13cmos5l_decap_8
XFILLER_5_786 VPWR VGND sg13cmos5l_decap_8
XFILLER_4_252 VPWR VGND sg13cmos5l_decap_8
XFILLER_6_70 VPWR VGND sg13cmos5l_decap_8
XANTENNA__052__D Tile_X0Y0_FrameData[18] VPWR VGND sg13cmos5l_antennanp
XFILLER_14_318 VPWR VGND sg13cmos5l_decap_8
XFILLER_6_1052 VPWR VGND sg13cmos5l_decap_8
XANTENNA__364__X Tile_X1Y0_FrameStrobe_O[8] VPWR VGND sg13cmos5l_antennanp
XFILLER_10_546 VPWR VGND sg13cmos5l_decap_8
XFILLER_6_517 VPWR VGND sg13cmos5l_decap_8
XFILLER_1_200 VPWR VGND sg13cmos5l_fill_2
XFILLER_2_756 VPWR VGND sg13cmos5l_fill_2
XANTENNA__274__X Tile_X0Y0_S4BEG[6] VPWR VGND sg13cmos5l_antennanp
XFILLER_12_1057 VPWR VGND sg13cmos5l_decap_8
X_387_ _387_/X Tile_X1Y0_N4END[4] Tile_X1Y0_N4END[7] Tile_X1Y0_NN4END[5] Tile_X1Y0_NN4END[7]
+ _098_/Q _097_/Q VPWR VGND sg13cmos5l_mux4_1
XFILLER_9_366 VPWR VGND sg13cmos5l_decap_8
XFILLER_9_333 VPWR VGND sg13cmos5l_decap_8
XANTENNA__134__CLK Tile_X0Y0_UserCLK VPWR VGND sg13cmos5l_antennanp
XANTENNA__047__D Tile_X0Y0_FrameData[23] VPWR VGND sg13cmos5l_antennanp
XANTENNA__133__Q NPU_QUANT_SHIFT_IN18 VPWR VGND sg13cmos5l_antennanp
XANTENNA__360__A Tile_X1Y0_FrameStrobe[4] VPWR VGND sg13cmos5l_antennanp
XANTENNA__359__X Tile_X1Y0_FrameStrobe_O[3] VPWR VGND sg13cmos5l_antennanp
XFILLER_8_1103 VPWR VGND sg13cmos5l_decap_4
XFILLER_14_115 VPWR VGND sg13cmos5l_decap_8
XFILLER_15_605 VPWR VGND sg13cmos5l_decap_8
X_310_ Tile_X1Y0_FrameData_O[6] Tile_X0Y0_FrameData[6] VPWR VGND sg13cmos5l_buf_1
X_172_ _172_/L_HI VPWR VGND sg13cmos5l_tiehi
X_241_ Tile_X1Y0_S4BEG[14] Tile_X1Y0_N4END[1] VPWR VGND sg13cmos5l_buf_1
XFILLER_7_804 VPWR VGND sg13cmos5l_decap_8
XANTENNA__270__A Tile_X0Y0_N4END[13] VPWR VGND sg13cmos5l_antennanp
XFILLER_7_0 VPWR VGND sg13cmos5l_fill_1
XFILLER_2_553 VPWR VGND sg13cmos5l_decap_8
XANTENNA__269__X Tile_X0Y0_S4BEG[1] VPWR VGND sg13cmos5l_antennanp
XFILLER_14_1119 VPWR VGND sg13cmos5l_fill_1
XFILLER_9_130 VPWR VGND sg13cmos5l_decap_8
XANTENNA__128__Q NPU_QUANT_SHIFT_IN13 VPWR VGND sg13cmos5l_antennanp
XFILLER_3_1099 VPWR VGND sg13cmos5l_decap_4
XFILLER_3_1022 VPWR VGND sg13cmos5l_decap_8
XANTENNA__355__A Tile_X0Y0_FrameStrobe[19] VPWR VGND sg13cmos5l_antennanp
XFILLER_16_914 VPWR VGND sg13cmos5l_decap_4
XANTENNA__265__A Tile_X0Y0_N2END[2] VPWR VGND sg13cmos5l_antennanp
XFILLER_15_457 VPWR VGND sg13cmos5l_decap_8
XFILLER_16_958 VPWR VGND sg13cmos5l_fill_1
XFILLER_16_969 VPWR VGND sg13cmos5l_fill_2
X_224_ Tile_X1Y0_S2BEGb[5] Tile_X1Y0_N2END[2] VPWR VGND sg13cmos5l_buf_1
XFILLER_8_27 VPWR VGND sg13cmos5l_fill_2
XFILLER_10_151 VPWR VGND sg13cmos5l_decap_8
XFILLER_11_663 VPWR VGND sg13cmos5l_decap_8
XFILLER_12_91 VPWR VGND sg13cmos5l_decap_8
X_086_ _086_/Q Tile_X0Y0_FrameData[20] VGND VPWR Tile_X1Y0_FrameStrobe[0] latch
X_155_ _155_/L_HI VPWR VGND sg13cmos5l_tiehi
XANTENNA__060__D Tile_X0Y0_FrameData[10] VPWR VGND sg13cmos5l_antennanp
XANTENNA__399__A0 Tile_X0Y0_N1END[2] VPWR VGND sg13cmos5l_antennanp
XFILLER_12_427 VPWR VGND sg13cmos5l_decap_8
XFILLER_4_604 VPWR VGND sg13cmos5l_decap_8
XFILLER_0_865 VPWR VGND sg13cmos5l_decap_8
XFILLER_15_232 VPWR VGND sg13cmos5l_decap_8
XFILLER_16_700 VPWR VGND sg13cmos5l_decap_4
XANTENNA__282__X Tile_X0Y0_S4BEG[14] VPWR VGND sg13cmos5l_antennanp
XFILLER_11_460 VPWR VGND sg13cmos5l_decap_8
XFILLER_12_994 VPWR VGND sg13cmos5l_decap_8
X_207_ Tile_X1Y0_S1BEG[0] Tile_X1Y0_N1END[3] VPWR VGND sg13cmos5l_buf_1
X_069_ _069_/Q Tile_X0Y0_FrameData[1] VGND VPWR Tile_X0Y0_FrameStrobe[0] latch
X_138_ NPU_QUANT_SHIFT_IN23 Tile_X0Y0_UserCLK _388_/X _167_/L_HI VPWR VGND sg13cmos5l_dfrbpq_1
XFILLER_7_464 VPWR VGND sg13cmos5l_decap_8
XANTENNA__396__A3 Tile_X1Y0_N2END[5] VPWR VGND sg13cmos5l_antennanp
XFILLER_0_1025 VPWR VGND sg13cmos5l_decap_4
XFILLER_0_1047 VPWR VGND sg13cmos5l_decap_8
XFILLER_0_50 VPWR VGND sg13cmos5l_fill_1
XANTENNA__055__D Tile_X0Y0_FrameData[15] VPWR VGND sg13cmos5l_antennanp
XANTENNA__192__X Tile_X1Y0_FrameStrobe_O[13] VPWR VGND sg13cmos5l_antennanp
XFILLER_9_81 VPWR VGND sg13cmos5l_decap_8
XANTENNA__141__Q NPU_QUANT_SHIFT_IN26 VPWR VGND sg13cmos5l_antennanp
XFILLER_0_139 VPWR VGND sg13cmos5l_decap_8
XFILLER_9_1050 VPWR VGND sg13cmos5l_decap_8
XANTENNA__387__A3 Tile_X1Y0_NN4END[7] VPWR VGND sg13cmos5l_antennanp
XFILLER_12_224 VPWR VGND sg13cmos5l_decap_8
XFILLER_13_714 VPWR VGND sg13cmos5l_decap_8
XFILLER_8_239 VPWR VGND sg13cmos5l_decap_8
XFILLER_5_957 VPWR VGND sg13cmos5l_decap_8
XANTENNA__277__X Tile_X0Y0_S4BEG[9] VPWR VGND sg13cmos5l_antennanp
XANTENNA__378__A3 Tile_X0Y0_NN4END[15] VPWR VGND sg13cmos5l_antennanp
XFILLER_12_791 VPWR VGND sg13cmos5l_decap_8
XFILLER_15_1011 VPWR VGND sg13cmos5l_decap_8
XFILLER_15_1088 VPWR VGND sg13cmos5l_decap_8
XFILLER_8_795 VPWR VGND sg13cmos5l_decap_4
XFILLER_8_762 VPWR VGND sg13cmos5l_decap_8
XFILLER_7_272 VPWR VGND sg13cmos5l_decap_8
XANTENNA__108__GATE Tile_X1Y0_FrameStrobe[1] VPWR VGND sg13cmos5l_antennanp
XANTENNA__136__Q NPU_QUANT_SHIFT_IN21 VPWR VGND sg13cmos5l_antennanp
XANTENNA__363__A Tile_X1Y0_FrameStrobe[7] VPWR VGND sg13cmos5l_antennanp
XANTENNA__369__A3 Tile_X0Y0_NN4END[6] VPWR VGND sg13cmos5l_antennanp
XFILLER_10_739 VPWR VGND sg13cmos5l_decap_8
XFILLER_14_59 VPWR VGND sg13cmos5l_decap_8
XFILLER_5_209 VPWR VGND sg13cmos5l_decap_8
XANTENNA__273__A Tile_X0Y0_N4END[10] VPWR VGND sg13cmos5l_antennanp
XFILLER_13_566 VPWR VGND sg13cmos5l_decap_8
XFILLER_9_504 VPWR VGND sg13cmos5l_decap_8
XFILLER_5_721 VPWR VGND sg13cmos5l_decap_4
XFILLER_5_765 VPWR VGND sg13cmos5l_decap_8
XFILLER_1_971 VPWR VGND sg13cmos5l_fill_1
XFILLER_0_492 VPWR VGND sg13cmos5l_fill_1
XANTENNA__094__GATE Tile_X1Y0_FrameStrobe[0] VPWR VGND sg13cmos5l_antennanp
XFILLER_8_581 VPWR VGND sg13cmos5l_decap_8
XANTENNA__047__GATE Tile_X0Y0_FrameStrobe[0] VPWR VGND sg13cmos5l_antennanp
XFILLER_6_1031 VPWR VGND sg13cmos5l_decap_8
XANTENNA__358__A Tile_X1Y0_FrameStrobe[2] VPWR VGND sg13cmos5l_antennanp
XFILLER_10_525 VPWR VGND sg13cmos5l_decap_8
XFILLER_1_212 VPWR VGND sg13cmos5l_decap_8
XFILLER_1_245 VPWR VGND sg13cmos5l_fill_2
XANTENNA__268__A Tile_X0Y0_N4END[15] VPWR VGND sg13cmos5l_antennanp
XFILLER_13_330 VPWR VGND sg13cmos5l_decap_8
XFILLER_14_842 VPWR VGND sg13cmos5l_decap_8
XFILLER_14_864 VPWR VGND sg13cmos5l_fill_1
X_386_ _386_/X Tile_X1Y0_N4END[6] Tile_X1Y0_N4END[7] Tile_X1Y0_NN4END[4] Tile_X1Y0_NN4END[6]
+ _100_/Q _099_/Q VPWR VGND sg13cmos5l_mux4_1
XFILLER_9_312 VPWR VGND sg13cmos5l_decap_8
XANTENNA__290__X Tile_X0Y0_SS4BEG[6] VPWR VGND sg13cmos5l_antennanp
XFILLER_12_1036 VPWR VGND sg13cmos5l_decap_8
XANTENNA__063__D Tile_X0Y0_FrameData[7] VPWR VGND sg13cmos5l_antennanp
XFILLER_11_49 VPWR VGND sg13cmos5l_decap_8
X_240_ Tile_X1Y0_S4BEG[13] Tile_X1Y0_N4END[2] VPWR VGND sg13cmos5l_buf_1
XFILLER_10_333 VPWR VGND sg13cmos5l_decap_8
XFILLER_10_399 VPWR VGND sg13cmos5l_decap_8
XFILLER_11_845 VPWR VGND sg13cmos5l_decap_8
XFILLER_11_867 VPWR VGND sg13cmos5l_fill_2
XFILLER_11_878 VPWR VGND sg13cmos5l_fill_1
X_171_ _171_/L_HI VPWR VGND sg13cmos5l_tiehi
XFILLER_6_348 VPWR VGND sg13cmos5l_decap_4
XFILLER_11_1091 VPWR VGND sg13cmos5l_decap_8
XFILLER_2_532 VPWR VGND sg13cmos5l_decap_8
XANTENNA__285__X Tile_X0Y0_SS4BEG[1] VPWR VGND sg13cmos5l_antennanp
XFILLER_14_650 VPWR VGND sg13cmos5l_fill_2
XFILLER_14_683 VPWR VGND sg13cmos5l_decap_8
X_369_ _369_/X Tile_X0Y0_N4END[4] Tile_X0Y0_N4END[5] Tile_X0Y0_NN4END[4] Tile_X0Y0_NN4END[6]
+ _066_/Q _065_/Q VPWR VGND sg13cmos5l_mux4_1
XFILLER_9_186 VPWR VGND sg13cmos5l_decap_8
XFILLER_3_72 VPWR VGND sg13cmos5l_fill_2
XFILLER_3_1001 VPWR VGND sg13cmos5l_decap_8
XANTENNA__058__D Tile_X0Y0_FrameData[12] VPWR VGND sg13cmos5l_antennanp
XANTENNA__195__X Tile_X1Y0_FrameStrobe_O[16] VPWR VGND sg13cmos5l_antennanp
XFILLER_11_119 VPWR VGND sg13cmos5l_decap_8
XFILLER_12_609 VPWR VGND sg13cmos5l_decap_8
XFILLER_3_1078 VPWR VGND sg13cmos5l_decap_8
XANTENNA__144__Q NPU_QUANT_SHIFT_IN29 VPWR VGND sg13cmos5l_antennanp
XFILLER_4_819 VPWR VGND sg13cmos5l_decap_8
XFILLER_3_329 VPWR VGND sg13cmos5l_decap_4
XFILLER_10_130 VPWR VGND sg13cmos5l_decap_8
XFILLER_11_642 VPWR VGND sg13cmos5l_decap_8
X_223_ Tile_X1Y0_S2BEGb[4] Tile_X1Y0_N2END[3] VPWR VGND sg13cmos5l_buf_1
XFILLER_8_39 VPWR VGND sg13cmos5l_decap_4
XANTENNA__124__CLK Tile_X0Y0_UserCLK VPWR VGND sg13cmos5l_antennanp
XANTENNA__281__A Tile_X0Y0_N4END[2] VPWR VGND sg13cmos5l_antennanp
XFILLER_12_70 VPWR VGND sg13cmos5l_decap_8
X_085_ _085_/Q Tile_X0Y0_FrameData[21] VGND VPWR Tile_X1Y0_FrameStrobe[0] latch
X_154_ _154_/L_HI VPWR VGND sg13cmos5l_tiehi
XFILLER_7_679 VPWR VGND sg13cmos5l_fill_1
XFILLER_6_112 VPWR VGND sg13cmos5l_decap_8
XFILLER_3_841 VPWR VGND sg13cmos5l_decap_8
XFILLER_3_830 VPWR VGND sg13cmos5l_fill_2
XANTENNA__191__A Tile_X1Y0_FrameStrobe[12] VPWR VGND sg13cmos5l_antennanp
XFILLER_14_480 VPWR VGND sg13cmos5l_decap_8
XANTENNA__139__Q NPU_QUANT_SHIFT_IN24 VPWR VGND sg13cmos5l_antennanp
XANTENNA__399__A1 Tile_X0Y0_N2MID[2] VPWR VGND sg13cmos5l_antennanp
XANTENNA__147__CLK Tile_X0Y0_UserCLK VPWR VGND sg13cmos5l_antennanp
XFILLER_12_406 VPWR VGND sg13cmos5l_decap_8
XFILLER_4_649 VPWR VGND sg13cmos5l_decap_8
XFILLER_0_844 VPWR VGND sg13cmos5l_decap_8
XANTENNA__276__A Tile_X0Y0_N4END[7] VPWR VGND sg13cmos5l_antennanp
XFILLER_15_211 VPWR VGND sg13cmos5l_decap_8
XFILLER_16_712 VPWR VGND sg13cmos5l_fill_1
XFILLER_16_789 VPWR VGND sg13cmos5l_decap_8
XFILLER_12_940 VPWR VGND sg13cmos5l_fill_1
XFILLER_12_973 VPWR VGND sg13cmos5l_decap_8
XFILLER_15_288 VPWR VGND sg13cmos5l_decap_8
X_137_ NPU_QUANT_SHIFT_IN22 Tile_X0Y0_UserCLK _387_/X _152_/L_HI VPWR VGND sg13cmos5l_dfrbpq_1
X_206_ Tile_X0Y0_S2BEG[7] Tile_X0Y0_N2MID[0] VPWR VGND sg13cmos5l_buf_1
XFILLER_8_944 VPWR VGND sg13cmos5l_decap_4
XFILLER_7_443 VPWR VGND sg13cmos5l_decap_8
X_068_ _068_/Q Tile_X0Y0_FrameData[2] VGND VPWR Tile_X0Y0_FrameStrobe[0] latch
XANTENNA__071__D Tile_X0Y0_FrameData[31] VPWR VGND sg13cmos5l_antennanp
XFILLER_0_118 VPWR VGND sg13cmos5l_decap_8
XFILLER_12_203 VPWR VGND sg13cmos5l_decap_8
XFILLER_9_719 VPWR VGND sg13cmos5l_decap_8
XFILLER_5_29 VPWR VGND sg13cmos5l_decap_8
XANTENNA__293__X Tile_X0Y0_SS4BEG[9] VPWR VGND sg13cmos5l_antennanp
XFILLER_16_597 VPWR VGND sg13cmos5l_decap_4
XFILLER_11_280 VPWR VGND sg13cmos5l_decap_8
XFILLER_12_770 VPWR VGND sg13cmos5l_decap_8
XFILLER_15_1067 VPWR VGND sg13cmos5l_decap_8
XFILLER_8_741 VPWR VGND sg13cmos5l_decap_8
XFILLER_7_251 VPWR VGND sg13cmos5l_decap_8
XFILLER_15_0 VPWR VGND sg13cmos5l_fill_2
XANTENNA__066__D Tile_X0Y0_FrameData[4] VPWR VGND sg13cmos5l_antennanp
XFILLER_10_718 VPWR VGND sg13cmos5l_decap_8
XFILLER_2_906 VPWR VGND sg13cmos5l_fill_1
XFILLER_13_545 VPWR VGND sg13cmos5l_decap_8
XFILLER_5_744 VPWR VGND sg13cmos5l_decap_8
XFILLER_5_700 VPWR VGND sg13cmos5l_decap_8
XFILLER_4_287 VPWR VGND sg13cmos5l_decap_8
XFILLER_4_243 VPWR VGND sg13cmos5l_fill_2
XFILLER_1_983 VPWR VGND sg13cmos5l_fill_1
XFILLER_1_950 VPWR VGND sg13cmos5l_decap_8
XANTENNA__288__X Tile_X0Y0_SS4BEG[4] VPWR VGND sg13cmos5l_antennanp
XFILLER_16_383 VPWR VGND sg13cmos5l_decap_8
XFILLER_8_560 VPWR VGND sg13cmos5l_decap_8
XANTENNA__198__X Tile_X1Y0_FrameStrobe_O[19] VPWR VGND sg13cmos5l_antennanp
XFILLER_6_1087 VPWR VGND sg13cmos5l_decap_8
XANTENNA__147__Q NPU_PSUM_LUT_EN VPWR VGND sg13cmos5l_antennanp
XFILLER_10_504 VPWR VGND sg13cmos5l_decap_8
XFILLER_2_769 VPWR VGND sg13cmos5l_decap_8
XFILLER_2_758 VPWR VGND sg13cmos5l_fill_1
XFILLER_2_725 VPWR VGND sg13cmos5l_decap_8
XANTENNA__284__A Tile_X0Y0_NN4END[15] VPWR VGND sg13cmos5l_antennanp
XFILLER_13_397 VPWR VGND sg13cmos5l_decap_8
XFILLER_14_887 VPWR VGND sg13cmos5l_fill_1
XFILLER_15_92 VPWR VGND sg13cmos5l_decap_8
X_385_ _385_/X Tile_X1Y0_N4END[5] Tile_X1Y0_N4END[6] Tile_X1Y0_NN4END[5] Tile_X1Y0_NN4END[7]
+ _102_/Q _101_/Q VPWR VGND sg13cmos5l_mux4_1
XANTENNA__107__GATE Tile_X1Y0_FrameStrobe[1] VPWR VGND sg13cmos5l_antennanp
XFILLER_12_1015 VPWR VGND sg13cmos5l_decap_8
XFILLER_5_596 VPWR VGND sg13cmos5l_decap_8
XFILLER_5_563 VPWR VGND sg13cmos5l_decap_8
XFILLER_1_791 VPWR VGND sg13cmos5l_fill_2
XANTENNA__194__A Tile_X1Y0_FrameStrobe[15] VPWR VGND sg13cmos5l_antennanp
XFILLER_11_28 VPWR VGND sg13cmos5l_decap_8
XFILLER_10_312 VPWR VGND sg13cmos5l_decap_8
XFILLER_11_824 VPWR VGND sg13cmos5l_decap_8
X_170_ _170_/L_HI VPWR VGND sg13cmos5l_tiehi
XFILLER_10_378 VPWR VGND sg13cmos5l_decap_8
XFILLER_11_1070 VPWR VGND sg13cmos5l_decap_8
XFILLER_7_839 VPWR VGND sg13cmos5l_decap_8
XFILLER_6_305 VPWR VGND sg13cmos5l_decap_8
XFILLER_2_511 VPWR VGND sg13cmos5l_decap_8
XANTENNA__093__GATE Tile_X1Y0_FrameStrobe[0] VPWR VGND sg13cmos5l_antennanp
XANTENNA__279__A Tile_X0Y0_N4END[4] VPWR VGND sg13cmos5l_antennanp
XANTENNA__046__GATE Tile_X0Y0_FrameStrobe[0] VPWR VGND sg13cmos5l_antennanp
XFILLER_13_183 VPWR VGND sg13cmos5l_decap_8
XFILLER_14_662 VPWR VGND sg13cmos5l_decap_4
X_299_ Tile_X0Y0_SS4BEG[15] Tile_X0Y0_NN4END[0] VPWR VGND sg13cmos5l_buf_1
X_368_ _368_/X Tile_X0Y0_N4END[0] Tile_X0Y0_N4END[3] Tile_X0Y0_NN4END[1] Tile_X0Y0_NN4END[3]
+ _068_/Q _067_/Q VPWR VGND sg13cmos5l_mux4_1
XFILLER_9_165 VPWR VGND sg13cmos5l_decap_8
XANTENNA__189__A Tile_X1Y0_FrameStrobe[10] VPWR VGND sg13cmos5l_antennanp
XFILLER_3_1057 VPWR VGND sg13cmos5l_decap_8
XANTENNA__074__D Tile_X0Y0_FrameData[28] VPWR VGND sg13cmos5l_antennanp
XFILLER_3_308 VPWR VGND sg13cmos5l_decap_8
XFILLER_15_426 VPWR VGND sg13cmos5l_decap_8
XFILLER_15_437 VPWR VGND sg13cmos5l_fill_2
XFILLER_16_949 VPWR VGND sg13cmos5l_decap_8
XFILLER_10_186 VPWR VGND sg13cmos5l_decap_8
XFILLER_11_621 VPWR VGND sg13cmos5l_decap_8
XFILLER_11_698 VPWR VGND sg13cmos5l_decap_8
X_153_ _153_/L_HI VPWR VGND sg13cmos5l_tiehi
X_222_ Tile_X1Y0_S2BEGb[3] Tile_X1Y0_N2END[4] VPWR VGND sg13cmos5l_buf_1
XFILLER_8_29 VPWR VGND sg13cmos5l_fill_1
XFILLER_7_658 VPWR VGND sg13cmos5l_decap_8
XFILLER_6_135 VPWR VGND sg13cmos5l_fill_1
X_084_ _084_/Q Tile_X0Y0_FrameData[22] VGND VPWR Tile_X1Y0_FrameStrobe[0] latch
XFILLER_7_669 VPWR VGND sg13cmos5l_fill_2
XFILLER_6_146 VPWR VGND sg13cmos5l_decap_8
XFILLER_2_374 VPWR VGND sg13cmos5l_decap_8
XFILLER_2_352 VPWR VGND sg13cmos5l_decap_8
XANTENNA__296__X Tile_X0Y0_SS4BEG[12] VPWR VGND sg13cmos5l_antennanp
XFILLER_5_190 VPWR VGND sg13cmos5l_fill_2
XFILLER_5_1119 VPWR VGND sg13cmos5l_fill_1
XANTENNA__069__D Tile_X0Y0_FrameData[1] VPWR VGND sg13cmos5l_antennanp
XANTENNA__399__A2 Tile_X0Y0_N2MID[5] VPWR VGND sg13cmos5l_antennanp
XFILLER_0_823 VPWR VGND sg13cmos5l_decap_8
XFILLER_3_138 VPWR VGND sg13cmos5l_decap_8
XFILLER_15_267 VPWR VGND sg13cmos5l_decap_8
XFILLER_16_724 VPWR VGND sg13cmos5l_decap_4
XFILLER_16_768 VPWR VGND sg13cmos5l_decap_8
XANTENNA__292__A Tile_X0Y0_NN4END[7] VPWR VGND sg13cmos5l_antennanp
XFILLER_11_495 VPWR VGND sg13cmos5l_decap_8
XFILLER_12_952 VPWR VGND sg13cmos5l_decap_8
X_136_ NPU_QUANT_SHIFT_IN21 Tile_X0Y0_UserCLK _386_/X _183_/L_HI VPWR VGND sg13cmos5l_dfrbpq_1
X_205_ Tile_X0Y0_S2BEG[6] Tile_X0Y0_N2MID[1] VPWR VGND sg13cmos5l_buf_1
XFILLER_7_499 VPWR VGND sg13cmos5l_decap_8
XFILLER_7_411 VPWR VGND sg13cmos5l_fill_1
X_067_ _067_/Q Tile_X0Y0_FrameData[3] VGND VPWR Tile_X0Y0_FrameStrobe[0] latch
XFILLER_3_683 VPWR VGND sg13cmos5l_decap_8
XFILLER_2_193 VPWR VGND sg13cmos5l_decap_8
XFILLER_9_1085 VPWR VGND sg13cmos5l_decap_8
XFILLER_13_749 VPWR VGND sg13cmos5l_decap_8
XFILLER_12_259 VPWR VGND sg13cmos5l_decap_8
XFILLER_4_469 VPWR VGND sg13cmos5l_fill_1
XANTENNA__287__A Tile_X0Y0_NN4END[12] VPWR VGND sg13cmos5l_antennanp
XFILLER_15_1046 VPWR VGND sg13cmos5l_decap_8
XFILLER_8_720 VPWR VGND sg13cmos5l_decap_8
X_119_ NPU_QUANT_SHIFT_IN4 Tile_X0Y0_UserCLK _369_/X _157_/L_HI VPWR VGND sg13cmos5l_dfrbpq_1
XFILLER_7_230 VPWR VGND sg13cmos5l_decap_8
XANTENNA__137__CLK Tile_X0Y0_UserCLK VPWR VGND sg13cmos5l_antennanp
XANTENNA__197__A Tile_X1Y0_FrameStrobe[18] VPWR VGND sg13cmos5l_antennanp
XANTENNA__082__D Tile_X0Y0_FrameData[24] VPWR VGND sg13cmos5l_antennanp
XFILLER_2_918 VPWR VGND sg13cmos5l_fill_2
XFILLER_13_524 VPWR VGND sg13cmos5l_decap_8
XFILLER_9_539 VPWR VGND sg13cmos5l_decap_8
XFILLER_4_222 VPWR VGND sg13cmos5l_decap_8
XFILLER_1_995 VPWR VGND sg13cmos5l_fill_1
XFILLER_16_351 VPWR VGND sg13cmos5l_fill_1
XFILLER_16_362 VPWR VGND sg13cmos5l_decap_8
XFILLER_1_1111 VPWR VGND sg13cmos5l_fill_1
XFILLER_6_84 VPWR VGND sg13cmos5l_decap_8
XFILLER_6_1066 VPWR VGND sg13cmos5l_decap_8
XANTENNA__077__D Tile_X0Y0_FrameData[29] VPWR VGND sg13cmos5l_antennanp
XANTENNA__380__A0 Tile_X1Y0_N4END[0] VPWR VGND sg13cmos5l_antennanp
XFILLER_2_704 VPWR VGND sg13cmos5l_decap_8
XFILLER_1_236 VPWR VGND sg13cmos5l_decap_4
XFILLER_15_71 VPWR VGND sg13cmos5l_decap_8
X_384_ _384_/X Tile_X1Y0_N4END[4] Tile_X1Y0_N4END[5] Tile_X1Y0_NN4END[4] Tile_X1Y0_NN4END[6]
+ _104_/Q _103_/Q VPWR VGND sg13cmos5l_mux4_1
XFILLER_9_347 VPWR VGND sg13cmos5l_decap_8
XANTENNA__371__A0 Tile_X0Y0_N4END[6] VPWR VGND sg13cmos5l_antennanp
XFILLER_5_542 VPWR VGND sg13cmos5l_decap_8
XANTENNA__299__X Tile_X0Y0_SS4BEG[15] VPWR VGND sg13cmos5l_antennanp
XFILLER_16_181 VPWR VGND sg13cmos5l_fill_2
XFILLER_15_619 VPWR VGND sg13cmos5l_fill_2
XFILLER_11_803 VPWR VGND sg13cmos5l_decap_8
XFILLER_14_129 VPWR VGND sg13cmos5l_decap_8
XFILLER_7_818 VPWR VGND sg13cmos5l_decap_8
XFILLER_2_567 VPWR VGND sg13cmos5l_decap_8
XANTENNA__295__A Tile_X0Y0_NN4END[4] VPWR VGND sg13cmos5l_antennanp
XFILLER_14_641 VPWR VGND sg13cmos5l_fill_2
XFILLER_13_162 VPWR VGND sg13cmos5l_decap_8
X_298_ Tile_X0Y0_SS4BEG[14] Tile_X0Y0_NN4END[1] VPWR VGND sg13cmos5l_buf_1
X_367_ _367_/X Tile_X0Y0_N4END[2] Tile_X0Y0_N4END[3] Tile_X0Y0_NN4END[0] Tile_X0Y0_NN4END[2]
+ _070_/Q _069_/Q VPWR VGND sg13cmos5l_mux4_1
XFILLER_9_144 VPWR VGND sg13cmos5l_decap_8
XFILLER_5_383 VPWR VGND sg13cmos5l_decap_4
XFILLER_3_74 VPWR VGND sg13cmos5l_fill_1
XFILLER_3_1036 VPWR VGND sg13cmos5l_decap_8
XANTENNA__090__D Tile_X0Y0_FrameData[16] VPWR VGND sg13cmos5l_antennanp
XANTENNA__106__GATE Tile_X1Y0_FrameStrobe[0] VPWR VGND sg13cmos5l_antennanp
XFILLER_11_600 VPWR VGND sg13cmos5l_decap_4
XFILLER_10_165 VPWR VGND sg13cmos5l_decap_8
XFILLER_11_677 VPWR VGND sg13cmos5l_decap_8
X_083_ _083_/Q Tile_X0Y0_FrameData[23] VGND VPWR Tile_X1Y0_FrameStrobe[0] latch
X_152_ _152_/L_HI VPWR VGND sg13cmos5l_tiehi
X_221_ Tile_X1Y0_S2BEGb[2] Tile_X1Y0_N2END[5] VPWR VGND sg13cmos5l_buf_1
XFILLER_7_637 VPWR VGND sg13cmos5l_decap_8
XFILLER_7_615 VPWR VGND sg13cmos5l_fill_2
XFILLER_3_887 VPWR VGND sg13cmos5l_decap_8
XFILLER_2_331 VPWR VGND sg13cmos5l_decap_8
XANTENNA__092__GATE Tile_X1Y0_FrameStrobe[0] VPWR VGND sg13cmos5l_antennanp
XANTENNA__399__A3 Tile_X0Y0_N2END[5] VPWR VGND sg13cmos5l_antennanp
XANTENNA__085__D Tile_X0Y0_FrameData[21] VPWR VGND sg13cmos5l_antennanp
XFILLER_0_802 VPWR VGND sg13cmos5l_decap_8
XFILLER_3_117 VPWR VGND sg13cmos5l_decap_8
XANTENNA__045__GATE Tile_X0Y0_FrameStrobe[0] VPWR VGND sg13cmos5l_antennanp
XFILLER_15_246 VPWR VGND sg13cmos5l_decap_8
XFILLER_16_736 VPWR VGND sg13cmos5l_fill_1
XFILLER_16_747 VPWR VGND sg13cmos5l_decap_8
X_204_ Tile_X0Y0_S2BEG[5] Tile_X0Y0_N2MID[2] VPWR VGND sg13cmos5l_buf_1
XFILLER_8_902 VPWR VGND sg13cmos5l_decap_8
XFILLER_11_474 VPWR VGND sg13cmos5l_decap_8
X_066_ _066_/Q Tile_X0Y0_FrameData[4] VGND VPWR Tile_X0Y0_FrameStrobe[0] latch
X_135_ NPU_QUANT_SHIFT_IN20 Tile_X0Y0_UserCLK _385_/X _182_/L_HI VPWR VGND sg13cmos5l_dfrbpq_1
XFILLER_7_478 VPWR VGND sg13cmos5l_decap_8
XFILLER_2_172 VPWR VGND sg13cmos5l_decap_8
XFILLER_2_161 VPWR VGND sg13cmos5l_fill_1
XFILLER_2_150 VPWR VGND sg13cmos5l_decap_8
XFILLER_14_290 VPWR VGND sg13cmos5l_decap_8
XFILLER_9_95 VPWR VGND sg13cmos5l_decap_8
XFILLER_9_1064 VPWR VGND sg13cmos5l_decap_8
XFILLER_12_238 VPWR VGND sg13cmos5l_decap_8
XFILLER_13_728 VPWR VGND sg13cmos5l_decap_8
XFILLER_10_1103 VPWR VGND sg13cmos5l_decap_8
XFILLER_0_610 VPWR VGND sg13cmos5l_fill_1
XFILLER_0_654 VPWR VGND sg13cmos5l_decap_8
XFILLER_0_665 VPWR VGND sg13cmos5l_fill_2
XFILLER_0_687 VPWR VGND sg13cmos5l_decap_8
XFILLER_16_522 VPWR VGND sg13cmos5l_fill_1
XFILLER_16_533 VPWR VGND sg13cmos5l_decap_8
XFILLER_16_555 VPWR VGND sg13cmos5l_fill_1
XFILLER_16_566 VPWR VGND sg13cmos5l_decap_8
XFILLER_15_1025 VPWR VGND sg13cmos5l_decap_8
X_049_ _049_/Q Tile_X0Y0_FrameData[21] VGND VPWR Tile_X0Y0_FrameStrobe[0] latch
X_118_ NPU_QUANT_SHIFT_IN3 Tile_X0Y0_UserCLK _368_/X _158_/L_HI VPWR VGND sg13cmos5l_dfrbpq_1
XFILLER_8_776 VPWR VGND sg13cmos5l_decap_8
XFILLER_7_286 VPWR VGND sg13cmos5l_decap_8
XFILLER_4_982 VPWR VGND sg13cmos5l_decap_8
XFILLER_4_971 VPWR VGND sg13cmos5l_decap_8
XFILLER_1_407 VPWR VGND sg13cmos5l_fill_1
XFILLER_13_503 VPWR VGND sg13cmos5l_decap_8
XFILLER_9_518 VPWR VGND sg13cmos5l_decap_8
XFILLER_5_779 VPWR VGND sg13cmos5l_decap_8
XFILLER_4_201 VPWR VGND sg13cmos5l_decap_8
XANTENNA__298__A Tile_X0Y0_NN4END[1] VPWR VGND sg13cmos5l_antennanp
XFILLER_0_484 VPWR VGND sg13cmos5l_fill_1
XANTENNA_1 Tile_X0Y0_FrameData[26] VPWR VGND sg13cmos5l_antennanp
XFILLER_8_595 VPWR VGND sg13cmos5l_decap_8
XFILLER_6_63 VPWR VGND sg13cmos5l_decap_8
XFILLER_6_1045 VPWR VGND sg13cmos5l_decap_8
XANTENNA__093__D Tile_X0Y0_FrameData[13] VPWR VGND sg13cmos5l_antennanp
XFILLER_10_539 VPWR VGND sg13cmos5l_decap_8
XANTENNA__380__A1 Tile_X1Y0_N4END[1] VPWR VGND sg13cmos5l_antennanp
XFILLER_2_749 VPWR VGND sg13cmos5l_decap_8
XFILLER_14_856 VPWR VGND sg13cmos5l_fill_2
XFILLER_15_50 VPWR VGND sg13cmos5l_decap_8
X_383_ _383_/X Tile_X1Y0_N4END[0] Tile_X1Y0_N4END[3] Tile_X1Y0_NN4END[1] Tile_X1Y0_NN4END[3]
+ _106_/Q _105_/Q VPWR VGND sg13cmos5l_mux4_1
XANTENNA__127__CLK Tile_X0Y0_UserCLK VPWR VGND sg13cmos5l_antennanp
XANTENNA__371__A1 Tile_X0Y0_N4END[7] VPWR VGND sg13cmos5l_antennanp
XFILLER_13_344 VPWR VGND sg13cmos5l_decap_4
XFILLER_14_878 VPWR VGND sg13cmos5l_decap_4
XFILLER_9_359 VPWR VGND sg13cmos5l_decap_8
XFILLER_9_326 VPWR VGND sg13cmos5l_decap_8
XFILLER_5_521 VPWR VGND sg13cmos5l_decap_8
XFILLER_16_160 VPWR VGND sg13cmos5l_decap_8
XFILLER_9_893 VPWR VGND sg13cmos5l_decap_8
XFILLER_8_1107 VPWR VGND sg13cmos5l_fill_1
XANTENNA__088__D Tile_X0Y0_FrameData[18] VPWR VGND sg13cmos5l_antennanp
XFILLER_14_108 VPWR VGND sg13cmos5l_decap_8
XFILLER_10_347 VPWR VGND sg13cmos5l_decap_4
XFILLER_11_859 VPWR VGND sg13cmos5l_decap_4
XFILLER_2_546 VPWR VGND sg13cmos5l_decap_8
XFILLER_13_141 VPWR VGND sg13cmos5l_decap_8
XFILLER_14_620 VPWR VGND sg13cmos5l_decap_8
XFILLER_14_697 VPWR VGND sg13cmos5l_decap_8
X_366_ _366_/X Tile_X0Y0_N4END[1] Tile_X0Y0_N4END[2] Tile_X0Y0_NN4END[1] Tile_X0Y0_NN4END[3]
+ _072_/Q _071_/Q VPWR VGND sg13cmos5l_mux4_1
XFILLER_9_123 VPWR VGND sg13cmos5l_decap_8
X_297_ Tile_X0Y0_SS4BEG[13] Tile_X0Y0_NN4END[2] VPWR VGND sg13cmos5l_buf_1
XFILLER_6_896 VPWR VGND sg13cmos5l_fill_2
XFILLER_5_373 VPWR VGND sg13cmos5l_decap_4
XFILLER_5_362 VPWR VGND sg13cmos5l_decap_4
XFILLER_3_53 VPWR VGND sg13cmos5l_fill_2
XFILLER_3_42 VPWR VGND sg13cmos5l_decap_8
XFILLER_3_1015 VPWR VGND sg13cmos5l_decap_8
XFILLER_16_918 VPWR VGND sg13cmos5l_fill_1
X_220_ Tile_X1Y0_S2BEGb[1] Tile_X1Y0_N2END[6] VPWR VGND sg13cmos5l_buf_1
XFILLER_10_144 VPWR VGND sg13cmos5l_decap_8
XFILLER_11_656 VPWR VGND sg13cmos5l_decap_8
XFILLER_12_84 VPWR VGND sg13cmos5l_decap_8
XFILLER_13_1112 VPWR VGND sg13cmos5l_decap_8
X_082_ _082_/Q Tile_X0Y0_FrameData[24] VGND VPWR Tile_X1Y0_FrameStrobe[0] latch
X_151_ _151_/L_HI VPWR VGND sg13cmos5l_tiehi
XFILLER_7_627 VPWR VGND sg13cmos5l_decap_8
XFILLER_7_605 VPWR VGND sg13cmos5l_fill_1
XFILLER_6_126 VPWR VGND sg13cmos5l_fill_2
XFILLER_3_855 VPWR VGND sg13cmos5l_decap_4
XFILLER_2_310 VPWR VGND sg13cmos5l_decap_8
XFILLER_2_1092 VPWR VGND sg13cmos5l_decap_8
XFILLER_14_494 VPWR VGND sg13cmos5l_decap_8
XFILLER_15_962 VPWR VGND sg13cmos5l_decap_4
X_349_ Tile_X0Y0_FrameStrobe_O[13] Tile_X0Y0_FrameStrobe[13] VPWR VGND sg13cmos5l_buf_1
XFILLER_6_693 VPWR VGND sg13cmos5l_decap_4
XFILLER_0_858 VPWR VGND sg13cmos5l_decap_4
XFILLER_15_225 VPWR VGND sg13cmos5l_decap_8
XFILLER_16_704 VPWR VGND sg13cmos5l_fill_1
XFILLER_11_453 VPWR VGND sg13cmos5l_decap_8
XFILLER_12_910 VPWR VGND sg13cmos5l_decap_4
XFILLER_12_987 VPWR VGND sg13cmos5l_decap_8
X_203_ Tile_X0Y0_S2BEG[4] Tile_X0Y0_N2MID[3] VPWR VGND sg13cmos5l_buf_1
X_065_ _065_/Q Tile_X0Y0_FrameData[5] VGND VPWR Tile_X0Y0_FrameStrobe[0] latch
X_134_ NPU_QUANT_SHIFT_IN19 Tile_X0Y0_UserCLK _384_/X _177_/L_HI VPWR VGND sg13cmos5l_dfrbpq_1
XFILLER_7_457 VPWR VGND sg13cmos5l_decap_8
XFILLER_3_663 VPWR VGND sg13cmos5l_decap_8
XFILLER_0_1029 VPWR VGND sg13cmos5l_fill_2
XFILLER_15_792 VPWR VGND sg13cmos5l_decap_8
XFILLER_9_74 VPWR VGND sg13cmos5l_decap_8
XFILLER_9_63 VPWR VGND sg13cmos5l_decap_4
XFILLER_9_52 VPWR VGND sg13cmos5l_fill_1
XANTENNA__105__GATE Tile_X1Y0_FrameStrobe[0] VPWR VGND sg13cmos5l_antennanp
XFILLER_9_1043 VPWR VGND sg13cmos5l_decap_8
XANTENNA__096__D Tile_X0Y0_FrameData[10] VPWR VGND sg13cmos5l_antennanp
XFILLER_12_217 VPWR VGND sg13cmos5l_decap_8
XFILLER_13_707 VPWR VGND sg13cmos5l_decap_8
XANTENNA__201__X Tile_X0Y0_S2BEG[2] VPWR VGND sg13cmos5l_antennanp
XFILLER_0_600 VPWR VGND sg13cmos5l_decap_4
XFILLER_16_501 VPWR VGND sg13cmos5l_fill_1
XFILLER_16_512 VPWR VGND sg13cmos5l_decap_8
XFILLER_11_294 VPWR VGND sg13cmos5l_decap_8
XFILLER_12_784 VPWR VGND sg13cmos5l_decap_8
XFILLER_15_1004 VPWR VGND sg13cmos5l_decap_8
X_117_ NPU_QUANT_SHIFT_IN2 Tile_X0Y0_UserCLK _367_/X _160_/L_HI VPWR VGND sg13cmos5l_dfrbpq_1
XFILLER_8_799 VPWR VGND sg13cmos5l_fill_1
XFILLER_8_788 VPWR VGND sg13cmos5l_decap_8
XFILLER_8_755 VPWR VGND sg13cmos5l_decap_8
XFILLER_7_265 VPWR VGND sg13cmos5l_decap_8
XANTENNA__091__GATE Tile_X1Y0_FrameStrobe[0] VPWR VGND sg13cmos5l_antennanp
X_048_ _048_/Q Tile_X0Y0_FrameData[22] VGND VPWR Tile_X0Y0_FrameStrobe[0] latch
XFILLER_3_460 VPWR VGND sg13cmos5l_fill_2
XANTENNA__044__GATE Tile_X0Y0_FrameStrobe[0] VPWR VGND sg13cmos5l_antennanp
XANTENNA__059__GATE Tile_X0Y0_FrameStrobe[0] VPWR VGND sg13cmos5l_antennanp
XFILLER_13_559 VPWR VGND sg13cmos5l_decap_8
XFILLER_5_714 VPWR VGND sg13cmos5l_fill_1
XFILLER_5_758 VPWR VGND sg13cmos5l_decap_8
XFILLER_5_725 VPWR VGND sg13cmos5l_fill_2
XFILLER_1_931 VPWR VGND sg13cmos5l_fill_1
XFILLER_1_920 VPWR VGND sg13cmos5l_decap_8
XFILLER_0_463 VPWR VGND sg13cmos5l_decap_4
XFILLER_0_496 VPWR VGND sg13cmos5l_fill_1
XFILLER_1_975 VPWR VGND sg13cmos5l_fill_1
XFILLER_16_342 VPWR VGND sg13cmos5l_decap_8
XFILLER_16_397 VPWR VGND sg13cmos5l_decap_8
XFILLER_12_581 VPWR VGND sg13cmos5l_decap_8
XFILLER_8_574 VPWR VGND sg13cmos5l_decap_8
XFILLER_6_42 VPWR VGND sg13cmos5l_decap_8
XFILLER_6_1024 VPWR VGND sg13cmos5l_decap_8
XFILLER_13_0 VPWR VGND sg13cmos5l_fill_2
XFILLER_10_518 VPWR VGND sg13cmos5l_decap_8
XANTENNA__380__A2 Tile_X1Y0_NN4END[0] VPWR VGND sg13cmos5l_antennanp
XFILLER_2_739 VPWR VGND sg13cmos5l_decap_4
XFILLER_13_323 VPWR VGND sg13cmos5l_decap_8
XFILLER_14_835 VPWR VGND sg13cmos5l_decap_8
X_382_ _382_/X Tile_X1Y0_N4END[2] Tile_X1Y0_N4END[3] Tile_X1Y0_NN4END[0] Tile_X1Y0_NN4END[2]
+ _108_/Q _107_/Q VPWR VGND sg13cmos5l_mux4_1
XFILLER_9_305 VPWR VGND sg13cmos5l_decap_8
XANTENNA__371__A2 Tile_X0Y0_NN4END[4] VPWR VGND sg13cmos5l_antennanp
XFILLER_12_1029 VPWR VGND sg13cmos5l_decap_8
XFILLER_5_500 VPWR VGND sg13cmos5l_decap_8
XFILLER_0_271 VPWR VGND sg13cmos5l_decap_8
XFILLER_0_282 VPWR VGND sg13cmos5l_fill_1
XFILLER_5_577 VPWR VGND sg13cmos5l_decap_4
XFILLER_1_772 VPWR VGND sg13cmos5l_decap_8
XFILLER_5_1090 VPWR VGND sg13cmos5l_decap_8
XFILLER_8_1119 VPWR VGND sg13cmos5l_fill_1
XFILLER_10_326 VPWR VGND sg13cmos5l_decap_8
XFILLER_11_838 VPWR VGND sg13cmos5l_decap_8
XFILLER_6_319 VPWR VGND sg13cmos5l_fill_1
XFILLER_11_1084 VPWR VGND sg13cmos5l_decap_8
XFILLER_2_525 VPWR VGND sg13cmos5l_decap_8
XFILLER_13_120 VPWR VGND sg13cmos5l_decap_8
XFILLER_13_197 VPWR VGND sg13cmos5l_decap_8
XFILLER_14_676 VPWR VGND sg13cmos5l_decap_8
X_296_ Tile_X0Y0_SS4BEG[12] Tile_X0Y0_NN4END[3] VPWR VGND sg13cmos5l_buf_1
X_365_ _365_/X Tile_X0Y0_N4END[0] Tile_X0Y0_N4END[1] Tile_X0Y0_NN4END[0] Tile_X0Y0_NN4END[2]
+ _074_/Q _073_/Q VPWR VGND sg13cmos5l_mux4_1
XFILLER_9_102 VPWR VGND sg13cmos5l_decap_8
XFILLER_10_860 VPWR VGND sg13cmos5l_decap_8
XFILLER_10_893 VPWR VGND sg13cmos5l_fill_2
XFILLER_9_179 VPWR VGND sg13cmos5l_decap_8
XFILLER_6_864 VPWR VGND sg13cmos5l_decap_4
XFILLER_6_820 VPWR VGND sg13cmos5l_fill_1
XFILLER_3_65 VPWR VGND sg13cmos5l_decap_8
XFILLER_1_580 VPWR VGND sg13cmos5l_decap_8
XFILLER_9_691 VPWR VGND sg13cmos5l_decap_8
XFILLER_8_190 VPWR VGND sg13cmos5l_decap_8
XANTENNA__099__D Tile_X0Y0_FrameData[7] VPWR VGND sg13cmos5l_antennanp
XANTENNA__117__CLK Tile_X0Y0_UserCLK VPWR VGND sg13cmos5l_antennanp
XFILLER_10_123 VPWR VGND sg13cmos5l_decap_8
XFILLER_11_635 VPWR VGND sg13cmos5l_decap_8
X_150_ NPU_QUANT_SHIFT_EN Tile_X0Y0_UserCLK _401_/X _163_/L_HI VPWR VGND sg13cmos5l_dfrbpq_1
XANTENNA__204__X Tile_X0Y0_S2BEG[5] VPWR VGND sg13cmos5l_antennanp
XFILLER_12_63 VPWR VGND sg13cmos5l_decap_8
X_081_ _081_/Q Tile_X0Y0_FrameData[25] VGND VPWR Tile_X1Y0_FrameStrobe[0] latch
XFILLER_6_105 VPWR VGND sg13cmos5l_decap_8
XFILLER_3_823 VPWR VGND sg13cmos5l_decap_8
XFILLER_2_388 VPWR VGND sg13cmos5l_fill_1
XFILLER_2_1071 VPWR VGND sg13cmos5l_decap_8
XFILLER_10_690 VPWR VGND sg13cmos5l_decap_8
XFILLER_14_473 VPWR VGND sg13cmos5l_decap_8
X_279_ Tile_X0Y0_S4BEG[11] Tile_X0Y0_N4END[4] VPWR VGND sg13cmos5l_buf_1
X_348_ Tile_X0Y0_FrameStrobe_O[12] Tile_X0Y0_FrameStrobe[12] VPWR VGND sg13cmos5l_buf_1
XFILLER_6_672 VPWR VGND sg13cmos5l_decap_8
XFILLER_5_182 VPWR VGND sg13cmos5l_decap_4
XFILLER_0_837 VPWR VGND sg13cmos5l_decap_8
XANTENNA__200__A Tile_X0Y0_N2MID[6] VPWR VGND sg13cmos5l_antennanp
XFILLER_15_204 VPWR VGND sg13cmos5l_decap_8
XFILLER_16_716 VPWR VGND sg13cmos5l_decap_4
XFILLER_11_432 VPWR VGND sg13cmos5l_decap_8
XFILLER_12_966 VPWR VGND sg13cmos5l_decap_8
X_133_ NPU_QUANT_SHIFT_IN18 Tile_X0Y0_UserCLK _383_/X _179_/L_HI VPWR VGND sg13cmos5l_dfrbpq_1
X_202_ Tile_X0Y0_S2BEG[3] Tile_X0Y0_N2MID[4] VPWR VGND sg13cmos5l_buf_1
XFILLER_8_948 VPWR VGND sg13cmos5l_fill_2
XFILLER_8_926 VPWR VGND sg13cmos5l_decap_4
X_064_ _064_/Q Tile_X0Y0_FrameData[6] VGND VPWR Tile_X0Y0_FrameStrobe[0] latch
XFILLER_3_697 VPWR VGND sg13cmos5l_decap_8
XFILLER_15_771 VPWR VGND sg13cmos5l_decap_8
XFILLER_9_42 VPWR VGND sg13cmos5l_fill_2
XFILLER_9_31 VPWR VGND sg13cmos5l_decap_8
XFILLER_9_1022 VPWR VGND sg13cmos5l_decap_8
XFILLER_9_1099 VPWR VGND sg13cmos5l_decap_8
XFILLER_11_273 VPWR VGND sg13cmos5l_decap_8
XFILLER_12_763 VPWR VGND sg13cmos5l_decap_8
X_116_ NPU_QUANT_SHIFT_IN1 Tile_X0Y0_UserCLK _366_/X _176_/L_HI VPWR VGND sg13cmos5l_dfrbpq_1
XFILLER_8_734 VPWR VGND sg13cmos5l_decap_8
XFILLER_7_244 VPWR VGND sg13cmos5l_decap_8
X_047_ _047_/Q Tile_X0Y0_FrameData[23] VGND VPWR Tile_X0Y0_FrameStrobe[0] latch
XANTENNA__392__A0 Tile_X1Y0_N4END[12] VPWR VGND sg13cmos5l_antennanp
XANTENNA__302__X Tile_X0Y0_S1BEG[2] VPWR VGND sg13cmos5l_antennanp
XFILLER_13_538 VPWR VGND sg13cmos5l_decap_8
XANTENNA__383__A0 Tile_X1Y0_N4END[0] VPWR VGND sg13cmos5l_antennanp
XFILLER_14_1082 VPWR VGND sg13cmos5l_decap_8
XFILLER_5_737 VPWR VGND sg13cmos5l_decap_4
XANTENNA__212__X Tile_X1Y0_S2BEG[1] VPWR VGND sg13cmos5l_antennanp
XFILLER_0_453 VPWR VGND sg13cmos5l_fill_1
XFILLER_4_236 VPWR VGND sg13cmos5l_decap_8
XFILLER_1_987 VPWR VGND sg13cmos5l_fill_1
XFILLER_1_943 VPWR VGND sg13cmos5l_fill_1
XFILLER_1_910 VPWR VGND sg13cmos5l_decap_8
XANTENNA__104__GATE Tile_X1Y0_FrameStrobe[0] VPWR VGND sg13cmos5l_antennanp
XFILLER_16_321 VPWR VGND sg13cmos5l_decap_4
XANTENNA__374__A0 Tile_X0Y0_N4END[9] VPWR VGND sg13cmos5l_antennanp
XFILLER_12_560 VPWR VGND sg13cmos5l_decap_8
XFILLER_16_376 VPWR VGND sg13cmos5l_decap_4
XFILLER_8_553 VPWR VGND sg13cmos5l_decap_8
XFILLER_6_98 VPWR VGND sg13cmos5l_decap_8
XFILLER_6_21 VPWR VGND sg13cmos5l_decap_8
XANTENNA__150__CLK Tile_X0Y0_UserCLK VPWR VGND sg13cmos5l_antennanp
XANTENNA__365__A0 Tile_X0Y0_N4END[0] VPWR VGND sg13cmos5l_antennanp
XANTENNA__380__A3 Tile_X1Y0_NN4END[2] VPWR VGND sg13cmos5l_antennanp
XFILLER_1_206 VPWR VGND sg13cmos5l_fill_2
XFILLER_2_718 VPWR VGND sg13cmos5l_decap_8
XANTENNA__090__GATE Tile_X1Y0_FrameStrobe[0] VPWR VGND sg13cmos5l_antennanp
XANTENNA__207__X Tile_X1Y0_S1BEG[0] VPWR VGND sg13cmos5l_antennanp
XFILLER_13_302 VPWR VGND sg13cmos5l_decap_8
XFILLER_13_379 VPWR VGND sg13cmos5l_fill_1
XFILLER_14_858 VPWR VGND sg13cmos5l_fill_1
XFILLER_15_85 VPWR VGND sg13cmos5l_decap_8
X_381_ _381_/X Tile_X1Y0_N4END[1] Tile_X1Y0_N4END[2] Tile_X1Y0_NN4END[1] Tile_X1Y0_NN4END[3]
+ _110_/Q _109_/Q VPWR VGND sg13cmos5l_mux4_1
XANTENNA__371__A3 Tile_X0Y0_NN4END[6] VPWR VGND sg13cmos5l_antennanp
XFILLER_12_1008 VPWR VGND sg13cmos5l_decap_8
XFILLER_5_589 VPWR VGND sg13cmos5l_decap_8
XFILLER_5_556 VPWR VGND sg13cmos5l_decap_8
XFILLER_0_261 VPWR VGND sg13cmos5l_fill_1
XFILLER_1_784 VPWR VGND sg13cmos5l_decap_8
XFILLER_1_751 VPWR VGND sg13cmos5l_decap_8
XANTENNA__043__GATE Tile_X0Y0_FrameStrobe[0] VPWR VGND sg13cmos5l_antennanp
XANTENNA__058__GATE Tile_X0Y0_FrameStrobe[0] VPWR VGND sg13cmos5l_antennanp
XFILLER_10_305 VPWR VGND sg13cmos5l_decap_8
XFILLER_11_817 VPWR VGND sg13cmos5l_decap_8
XFILLER_11_1063 VPWR VGND sg13cmos5l_decap_8
XFILLER_2_504 VPWR VGND sg13cmos5l_decap_8
XANTENNA__203__A Tile_X0Y0_N2MID[3] VPWR VGND sg13cmos5l_antennanp
XFILLER_13_176 VPWR VGND sg13cmos5l_decap_8
XFILLER_14_655 VPWR VGND sg13cmos5l_decap_4
X_295_ Tile_X0Y0_SS4BEG[11] Tile_X0Y0_NN4END[4] VPWR VGND sg13cmos5l_buf_1
X_364_ Tile_X1Y0_FrameStrobe_O[8] Tile_X1Y0_FrameStrobe[8] VPWR VGND sg13cmos5l_buf_1
XFILLER_9_158 VPWR VGND sg13cmos5l_decap_8
XFILLER_6_810 VPWR VGND sg13cmos5l_decap_4
XFILLER_6_898 VPWR VGND sg13cmos5l_fill_1
XFILLER_3_11 VPWR VGND sg13cmos5l_fill_2
XFILLER_3_88 VPWR VGND sg13cmos5l_decap_8
XFILLER_9_670 VPWR VGND sg13cmos5l_decap_8
XANTENNA__310__X Tile_X1Y0_FrameData_O[6] VPWR VGND sg13cmos5l_antennanp
XFILLER_15_419 VPWR VGND sg13cmos5l_decap_8
XFILLER_10_102 VPWR VGND sg13cmos5l_decap_8
XFILLER_11_614 VPWR VGND sg13cmos5l_decap_8
X_080_ _080_/Q Tile_X0Y0_FrameData[26] VGND VPWR Tile_X1Y0_FrameStrobe[0] latch
XFILLER_10_179 VPWR VGND sg13cmos5l_decap_8
XFILLER_12_42 VPWR VGND sg13cmos5l_decap_8
XFILLER_6_139 VPWR VGND sg13cmos5l_decap_8
XFILLER_3_802 VPWR VGND sg13cmos5l_decap_8
XFILLER_2_345 VPWR VGND sg13cmos5l_decap_8
XANTENNA__220__X Tile_X1Y0_S2BEGb[1] VPWR VGND sg13cmos5l_antennanp
XFILLER_14_441 VPWR VGND sg13cmos5l_fill_1
XFILLER_14_452 VPWR VGND sg13cmos5l_decap_8
XFILLER_15_997 VPWR VGND sg13cmos5l_decap_8
XFILLER_2_1050 VPWR VGND sg13cmos5l_decap_8
X_278_ Tile_X0Y0_S4BEG[10] Tile_X0Y0_N4END[5] VPWR VGND sg13cmos5l_buf_1
X_347_ Tile_X0Y0_FrameStrobe_O[11] Tile_X0Y0_FrameStrobe[11] VPWR VGND sg13cmos5l_buf_1
XFILLER_5_161 VPWR VGND sg13cmos5l_decap_8
XANTENNA__305__X Tile_X1Y0_FrameData_O[1] VPWR VGND sg13cmos5l_antennanp
XFILLER_0_816 VPWR VGND sg13cmos5l_decap_8
XFILLER_16_728 VPWR VGND sg13cmos5l_fill_1
XANTENNA__215__X Tile_X1Y0_S2BEG[4] VPWR VGND sg13cmos5l_antennanp
XFILLER_11_411 VPWR VGND sg13cmos5l_decap_8
XFILLER_11_488 VPWR VGND sg13cmos5l_decap_8
XFILLER_12_945 VPWR VGND sg13cmos5l_decap_8
X_063_ _063_/Q Tile_X0Y0_FrameData[7] VGND VPWR Tile_X0Y0_FrameStrobe[0] latch
X_132_ NPU_QUANT_SHIFT_IN17 Tile_X0Y0_UserCLK _382_/X _181_/L_HI VPWR VGND sg13cmos5l_dfrbpq_1
X_201_ Tile_X0Y0_S2BEG[2] Tile_X0Y0_N2MID[5] VPWR VGND sg13cmos5l_buf_1
XFILLER_8_916 VPWR VGND sg13cmos5l_fill_2
XFILLER_3_676 VPWR VGND sg13cmos5l_decap_8
XFILLER_3_0 VPWR VGND sg13cmos5l_fill_2
XFILLER_2_186 VPWR VGND sg13cmos5l_decap_8
XFILLER_2_131 VPWR VGND sg13cmos5l_fill_1
XFILLER_0_23 VPWR VGND sg13cmos5l_fill_2
XFILLER_0_45 VPWR VGND sg13cmos5l_fill_2
XFILLER_15_750 VPWR VGND sg13cmos5l_decap_8
XANTENNA__301__A Tile_X0Y0_N1END[2] VPWR VGND sg13cmos5l_antennanp
XFILLER_9_1078 VPWR VGND sg13cmos5l_decap_8
XFILLER_9_1001 VPWR VGND sg13cmos5l_decap_8
XFILLER_5_919 VPWR VGND sg13cmos5l_fill_1
XFILLER_10_1117 VPWR VGND sg13cmos5l_fill_2
XANTENNA__211__A Tile_X1Y0_N2MID[7] VPWR VGND sg13cmos5l_antennanp
XFILLER_12_742 VPWR VGND sg13cmos5l_decap_8
XFILLER_16_547 VPWR VGND sg13cmos5l_fill_1
XFILLER_8_713 VPWR VGND sg13cmos5l_decap_8
XFILLER_8_702 VPWR VGND sg13cmos5l_fill_1
XFILLER_11_252 VPWR VGND sg13cmos5l_decap_8
XFILLER_15_1039 VPWR VGND sg13cmos5l_decap_8
X_046_ _046_/Q Tile_X0Y0_FrameData[24] VGND VPWR Tile_X0Y0_FrameStrobe[0] latch
X_115_ NPU_QUANT_SHIFT_IN0 Tile_X0Y0_UserCLK _365_/X _180_/L_HI VPWR VGND sg13cmos5l_dfrbpq_1
XFILLER_7_223 VPWR VGND sg13cmos5l_decap_8
XFILLER_7_212 VPWR VGND sg13cmos5l_fill_1
XFILLER_4_996 VPWR VGND sg13cmos5l_decap_8
XANTENNA__392__A1 Tile_X1Y0_N4END[13] VPWR VGND sg13cmos5l_antennanp
XFILLER_15_591 VPWR VGND sg13cmos5l_decap_8
XFILLER_7_790 VPWR VGND sg13cmos5l_decap_8
XFILLER_13_517 VPWR VGND sg13cmos5l_decap_8
XANTENNA__206__A Tile_X0Y0_N2MID[0] VPWR VGND sg13cmos5l_antennanp
XANTENNA__383__A1 Tile_X1Y0_N4END[3] VPWR VGND sg13cmos5l_antennanp
XFILLER_14_1061 VPWR VGND sg13cmos5l_decap_8
XFILLER_4_215 VPWR VGND sg13cmos5l_decap_8
XFILLER_4_259 VPWR VGND sg13cmos5l_fill_1
XFILLER_1_999 VPWR VGND sg13cmos5l_fill_1
XFILLER_16_300 VPWR VGND sg13cmos5l_decap_8
XFILLER_16_355 VPWR VGND sg13cmos5l_decap_8
XFILLER_1_1104 VPWR VGND sg13cmos5l_decap_8
XFILLER_1_1115 VPWR VGND sg13cmos5l_decap_4
XANTENNA__374__A1 Tile_X0Y0_N4END[10] VPWR VGND sg13cmos5l_antennanp
XFILLER_8_532 VPWR VGND sg13cmos5l_decap_8
XFILLER_6_77 VPWR VGND sg13cmos5l_decap_8
XFILLER_6_1059 VPWR VGND sg13cmos5l_decap_8
XFILLER_3_292 VPWR VGND sg13cmos5l_fill_2
XANTENNA__365__A1 Tile_X0Y0_N4END[1] VPWR VGND sg13cmos5l_antennanp
XANTENNA__313__X Tile_X1Y0_FrameData_O[9] VPWR VGND sg13cmos5l_antennanp
XFILLER_1_229 VPWR VGND sg13cmos5l_decap_8
XFILLER_15_31 VPWR VGND sg13cmos5l_decap_8
XFILLER_15_64 VPWR VGND sg13cmos5l_decap_8
XFILLER_16_1101 VPWR VGND sg13cmos5l_decap_8
X_380_ _380_/X Tile_X1Y0_N4END[0] Tile_X1Y0_N4END[1] Tile_X1Y0_NN4END[0] Tile_X1Y0_NN4END[2]
+ _112_/Q _111_/Q VPWR VGND sg13cmos5l_mux4_1
XANTENNA__223__X Tile_X1Y0_S2BEGb[4] VPWR VGND sg13cmos5l_antennanp
XFILLER_5_535 VPWR VGND sg13cmos5l_decap_8
XFILLER_16_174 VPWR VGND sg13cmos5l_decap_8
XFILLER_16_196 VPWR VGND sg13cmos5l_decap_8
XFILLER_13_870 VPWR VGND sg13cmos5l_decap_8
XFILLER_8_395 VPWR VGND sg13cmos5l_fill_1
XFILLER_4_590 VPWR VGND sg13cmos5l_decap_8
.ends
