* NGSPICE file created from EXT_PMOD.ext - technology: ihp-sg13cmos5l

* Black-box entry subcircuit for sg13cmos5l_antennanp abstract view
.subckt sg13cmos5l_antennanp A VDD VSS
.ends

* Black-box entry subcircuit for sg13cmos5l_fill_2 abstract view
.subckt sg13cmos5l_fill_2 VDD VSS
.ends

* Black-box entry subcircuit for sg13cmos5l_decap_8 abstract view
.subckt sg13cmos5l_decap_8 VDD VSS
.ends

* Black-box entry subcircuit for sg13cmos5l_buf_1 abstract view
.subckt sg13cmos5l_buf_1 X A VDD VSS
.ends

* Black-box entry subcircuit for latch abstract view
.subckt latch Q D VSS VDD GATE
.ends

* Black-box entry subcircuit for sg13cmos5l_tiehi abstract view
.subckt sg13cmos5l_tiehi L_HI VDD VSS
.ends

* Black-box entry subcircuit for sg13cmos5l_fill_1 abstract view
.subckt sg13cmos5l_fill_1 VDD VSS
.ends

* Black-box entry subcircuit for sg13cmos5l_decap_4 abstract view
.subckt sg13cmos5l_decap_4 VDD VSS
.ends

* Black-box entry subcircuit for sg13cmos5l_mux2_1 abstract view
.subckt sg13cmos5l_mux2_1 X A0 A1 S VDD VSS
.ends

* Black-box entry subcircuit for sg13cmos5l_nor2b_1 abstract view
.subckt sg13cmos5l_nor2b_1 Y A B_N VDD VSS
.ends

* Black-box entry subcircuit for sg13cmos5l_mux4_1 abstract view
.subckt sg13cmos5l_mux4_1 X A0 A1 A2 A3 S0 S1 VDD VSS
.ends

* Black-box entry subcircuit for sg13cmos5l_inv_1 abstract view
.subckt sg13cmos5l_inv_1 Y A VDD VSS
.ends

* Black-box entry subcircuit for sg13cmos5l_dfrbpq_1 abstract view
.subckt sg13cmos5l_dfrbpq_1 Q CLK D RESET_B VDD VSS
.ends

* Black-box entry subcircuit for sg13cmos5l_o21ai_1 abstract view
.subckt sg13cmos5l_o21ai_1 Y A1 A2 B1 VDD VSS
.ends

* Black-box entry subcircuit for sg13cmos5l_or2_1 abstract view
.subckt sg13cmos5l_or2_1 X A B VDD VSS
.ends

* Black-box entry subcircuit for sg13cmos5l_a21oi_1 abstract view
.subckt sg13cmos5l_a21oi_1 Y A1 A2 B1 VDD VSS
.ends

* Black-box entry subcircuit for sg13cmos5l_a221oi_1 abstract view
.subckt sg13cmos5l_a221oi_1 Y A1 A2 B1 B2 C1 VDD VSS
.ends

* Black-box entry subcircuit for sg13cmos5l_nor2_1 abstract view
.subckt sg13cmos5l_nor2_1 Y A B VDD VSS
.ends

.subckt EXT_PMOD PMOD_IO_I0 PMOD_IO_I1 PMOD_IO_I2 PMOD_IO_I3 PMOD_IO_I4 PMOD_IO_I5
+ PMOD_IO_I6 PMOD_IO_I7 PMOD_IO_O0 PMOD_IO_O1 PMOD_IO_O2 PMOD_IO_O3 PMOD_IO_O4 PMOD_IO_O5
+ PMOD_IO_O6 PMOD_IO_O7 PMOD_IO_OE_O0 PMOD_IO_OE_O1 PMOD_IO_OE_O2 PMOD_IO_OE_O3 PMOD_IO_OE_O4
+ PMOD_IO_OE_O5 PMOD_IO_OE_O6 PMOD_IO_OE_O7 Tile_X0Y0_Ci Tile_X0Y0_FrameData[0] Tile_X0Y0_FrameData[10]
+ Tile_X0Y0_FrameData[11] Tile_X0Y0_FrameData[12] Tile_X0Y0_FrameData[13] Tile_X0Y0_FrameData[14]
+ Tile_X0Y0_FrameData[15] Tile_X0Y0_FrameData[16] Tile_X0Y0_FrameData[17] Tile_X0Y0_FrameData[18]
+ Tile_X0Y0_FrameData[19] Tile_X0Y0_FrameData[1] Tile_X0Y0_FrameData[20] Tile_X0Y0_FrameData[21]
+ Tile_X0Y0_FrameData[22] Tile_X0Y0_FrameData[23] Tile_X0Y0_FrameData[24] Tile_X0Y0_FrameData[25]
+ Tile_X0Y0_FrameData[26] Tile_X0Y0_FrameData[27] Tile_X0Y0_FrameData[28] Tile_X0Y0_FrameData[29]
+ Tile_X0Y0_FrameData[2] Tile_X0Y0_FrameData[30] Tile_X0Y0_FrameData[31] Tile_X0Y0_FrameData[3]
+ Tile_X0Y0_FrameData[4] Tile_X0Y0_FrameData[5] Tile_X0Y0_FrameData[6] Tile_X0Y0_FrameData[7]
+ Tile_X0Y0_FrameData[8] Tile_X0Y0_FrameData[9] Tile_X0Y0_FrameStrobe[0] Tile_X0Y0_FrameStrobe[10]
+ Tile_X0Y0_FrameStrobe[11] Tile_X0Y0_FrameStrobe[12] Tile_X0Y0_FrameStrobe[13] Tile_X0Y0_FrameStrobe[14]
+ Tile_X0Y0_FrameStrobe[15] Tile_X0Y0_FrameStrobe[16] Tile_X0Y0_FrameStrobe[17] Tile_X0Y0_FrameStrobe[18]
+ Tile_X0Y0_FrameStrobe[19] Tile_X0Y0_FrameStrobe[1] Tile_X0Y0_FrameStrobe[2] Tile_X0Y0_FrameStrobe[3]
+ Tile_X0Y0_FrameStrobe[4] Tile_X0Y0_FrameStrobe[5] Tile_X0Y0_FrameStrobe[6] Tile_X0Y0_FrameStrobe[7]
+ Tile_X0Y0_FrameStrobe[8] Tile_X0Y0_FrameStrobe[9] Tile_X0Y0_FrameStrobe_O[0] Tile_X0Y0_FrameStrobe_O[10]
+ Tile_X0Y0_FrameStrobe_O[11] Tile_X0Y0_FrameStrobe_O[12] Tile_X0Y0_FrameStrobe_O[13]
+ Tile_X0Y0_FrameStrobe_O[14] Tile_X0Y0_FrameStrobe_O[15] Tile_X0Y0_FrameStrobe_O[16]
+ Tile_X0Y0_FrameStrobe_O[17] Tile_X0Y0_FrameStrobe_O[18] Tile_X0Y0_FrameStrobe_O[19]
+ Tile_X0Y0_FrameStrobe_O[1] Tile_X0Y0_FrameStrobe_O[2] Tile_X0Y0_FrameStrobe_O[3]
+ Tile_X0Y0_FrameStrobe_O[4] Tile_X0Y0_FrameStrobe_O[5] Tile_X0Y0_FrameStrobe_O[6]
+ Tile_X0Y0_FrameStrobe_O[7] Tile_X0Y0_FrameStrobe_O[8] Tile_X0Y0_FrameStrobe_O[9]
+ Tile_X0Y0_N1END[0] Tile_X0Y0_N1END[1] Tile_X0Y0_N1END[2] Tile_X0Y0_N1END[3] Tile_X0Y0_N2END[0]
+ Tile_X0Y0_N2END[1] Tile_X0Y0_N2END[2] Tile_X0Y0_N2END[3] Tile_X0Y0_N2END[4] Tile_X0Y0_N2END[5]
+ Tile_X0Y0_N2END[6] Tile_X0Y0_N2END[7] Tile_X0Y0_N2MID[0] Tile_X0Y0_N2MID[1] Tile_X0Y0_N2MID[2]
+ Tile_X0Y0_N2MID[3] Tile_X0Y0_N2MID[4] Tile_X0Y0_N2MID[5] Tile_X0Y0_N2MID[6] Tile_X0Y0_N2MID[7]
+ Tile_X0Y0_N4END[0] Tile_X0Y0_N4END[10] Tile_X0Y0_N4END[11] Tile_X0Y0_N4END[12] Tile_X0Y0_N4END[13]
+ Tile_X0Y0_N4END[14] Tile_X0Y0_N4END[15] Tile_X0Y0_N4END[1] Tile_X0Y0_N4END[2] Tile_X0Y0_N4END[3]
+ Tile_X0Y0_N4END[4] Tile_X0Y0_N4END[5] Tile_X0Y0_N4END[6] Tile_X0Y0_N4END[7] Tile_X0Y0_N4END[8]
+ Tile_X0Y0_N4END[9] Tile_X0Y0_NN4END[0] Tile_X0Y0_NN4END[10] Tile_X0Y0_NN4END[11]
+ Tile_X0Y0_NN4END[12] Tile_X0Y0_NN4END[13] Tile_X0Y0_NN4END[14] Tile_X0Y0_NN4END[15]
+ Tile_X0Y0_NN4END[1] Tile_X0Y0_NN4END[2] Tile_X0Y0_NN4END[3] Tile_X0Y0_NN4END[4]
+ Tile_X0Y0_NN4END[5] Tile_X0Y0_NN4END[6] Tile_X0Y0_NN4END[7] Tile_X0Y0_NN4END[8]
+ Tile_X0Y0_NN4END[9] Tile_X0Y0_S1BEG[0] Tile_X0Y0_S1BEG[1] Tile_X0Y0_S1BEG[2] Tile_X0Y0_S1BEG[3]
+ Tile_X0Y0_S2BEG[0] Tile_X0Y0_S2BEG[1] Tile_X0Y0_S2BEG[2] Tile_X0Y0_S2BEG[3] Tile_X0Y0_S2BEG[4]
+ Tile_X0Y0_S2BEG[5] Tile_X0Y0_S2BEG[6] Tile_X0Y0_S2BEG[7] Tile_X0Y0_S2BEGb[0] Tile_X0Y0_S2BEGb[1]
+ Tile_X0Y0_S2BEGb[2] Tile_X0Y0_S2BEGb[3] Tile_X0Y0_S2BEGb[4] Tile_X0Y0_S2BEGb[5]
+ Tile_X0Y0_S2BEGb[6] Tile_X0Y0_S2BEGb[7] Tile_X0Y0_S4BEG[0] Tile_X0Y0_S4BEG[10] Tile_X0Y0_S4BEG[11]
+ Tile_X0Y0_S4BEG[12] Tile_X0Y0_S4BEG[13] Tile_X0Y0_S4BEG[14] Tile_X0Y0_S4BEG[15]
+ Tile_X0Y0_S4BEG[1] Tile_X0Y0_S4BEG[2] Tile_X0Y0_S4BEG[3] Tile_X0Y0_S4BEG[4] Tile_X0Y0_S4BEG[5]
+ Tile_X0Y0_S4BEG[6] Tile_X0Y0_S4BEG[7] Tile_X0Y0_S4BEG[8] Tile_X0Y0_S4BEG[9] Tile_X0Y0_SS4BEG[0]
+ Tile_X0Y0_SS4BEG[10] Tile_X0Y0_SS4BEG[11] Tile_X0Y0_SS4BEG[12] Tile_X0Y0_SS4BEG[13]
+ Tile_X0Y0_SS4BEG[14] Tile_X0Y0_SS4BEG[15] Tile_X0Y0_SS4BEG[1] Tile_X0Y0_SS4BEG[2]
+ Tile_X0Y0_SS4BEG[3] Tile_X0Y0_SS4BEG[4] Tile_X0Y0_SS4BEG[5] Tile_X0Y0_SS4BEG[6]
+ Tile_X0Y0_SS4BEG[7] Tile_X0Y0_SS4BEG[8] Tile_X0Y0_SS4BEG[9] Tile_X0Y0_UserCLK Tile_X1Y0_Ci
+ Tile_X1Y0_FrameData_O[0] Tile_X1Y0_FrameData_O[10] Tile_X1Y0_FrameData_O[11] Tile_X1Y0_FrameData_O[12]
+ Tile_X1Y0_FrameData_O[13] Tile_X1Y0_FrameData_O[14] Tile_X1Y0_FrameData_O[15] Tile_X1Y0_FrameData_O[16]
+ Tile_X1Y0_FrameData_O[17] Tile_X1Y0_FrameData_O[18] Tile_X1Y0_FrameData_O[19] Tile_X1Y0_FrameData_O[1]
+ Tile_X1Y0_FrameData_O[20] Tile_X1Y0_FrameData_O[21] Tile_X1Y0_FrameData_O[22] Tile_X1Y0_FrameData_O[23]
+ Tile_X1Y0_FrameData_O[24] Tile_X1Y0_FrameData_O[25] Tile_X1Y0_FrameData_O[26] Tile_X1Y0_FrameData_O[27]
+ Tile_X1Y0_FrameData_O[28] Tile_X1Y0_FrameData_O[29] Tile_X1Y0_FrameData_O[2] Tile_X1Y0_FrameData_O[30]
+ Tile_X1Y0_FrameData_O[31] Tile_X1Y0_FrameData_O[3] Tile_X1Y0_FrameData_O[4] Tile_X1Y0_FrameData_O[5]
+ Tile_X1Y0_FrameData_O[6] Tile_X1Y0_FrameData_O[7] Tile_X1Y0_FrameData_O[8] Tile_X1Y0_FrameData_O[9]
+ Tile_X1Y0_FrameStrobe[0] Tile_X1Y0_FrameStrobe[10] Tile_X1Y0_FrameStrobe[11] Tile_X1Y0_FrameStrobe[12]
+ Tile_X1Y0_FrameStrobe[13] Tile_X1Y0_FrameStrobe[14] Tile_X1Y0_FrameStrobe[15] Tile_X1Y0_FrameStrobe[16]
+ Tile_X1Y0_FrameStrobe[17] Tile_X1Y0_FrameStrobe[18] Tile_X1Y0_FrameStrobe[19] Tile_X1Y0_FrameStrobe[1]
+ Tile_X1Y0_FrameStrobe[2] Tile_X1Y0_FrameStrobe[3] Tile_X1Y0_FrameStrobe[4] Tile_X1Y0_FrameStrobe[5]
+ Tile_X1Y0_FrameStrobe[6] Tile_X1Y0_FrameStrobe[7] Tile_X1Y0_FrameStrobe[8] Tile_X1Y0_FrameStrobe[9]
+ Tile_X1Y0_FrameStrobe_O[0] Tile_X1Y0_FrameStrobe_O[10] Tile_X1Y0_FrameStrobe_O[11]
+ Tile_X1Y0_FrameStrobe_O[12] Tile_X1Y0_FrameStrobe_O[13] Tile_X1Y0_FrameStrobe_O[14]
+ Tile_X1Y0_FrameStrobe_O[15] Tile_X1Y0_FrameStrobe_O[16] Tile_X1Y0_FrameStrobe_O[17]
+ Tile_X1Y0_FrameStrobe_O[18] Tile_X1Y0_FrameStrobe_O[19] Tile_X1Y0_FrameStrobe_O[1]
+ Tile_X1Y0_FrameStrobe_O[2] Tile_X1Y0_FrameStrobe_O[3] Tile_X1Y0_FrameStrobe_O[4]
+ Tile_X1Y0_FrameStrobe_O[5] Tile_X1Y0_FrameStrobe_O[6] Tile_X1Y0_FrameStrobe_O[7]
+ Tile_X1Y0_FrameStrobe_O[8] Tile_X1Y0_FrameStrobe_O[9] Tile_X1Y0_N1END[0] Tile_X1Y0_N1END[1]
+ Tile_X1Y0_N1END[2] Tile_X1Y0_N1END[3] Tile_X1Y0_N2END[0] Tile_X1Y0_N2END[1] Tile_X1Y0_N2END[2]
+ Tile_X1Y0_N2END[3] Tile_X1Y0_N2END[4] Tile_X1Y0_N2END[5] Tile_X1Y0_N2END[6] Tile_X1Y0_N2END[7]
+ Tile_X1Y0_N2MID[0] Tile_X1Y0_N2MID[1] Tile_X1Y0_N2MID[2] Tile_X1Y0_N2MID[3] Tile_X1Y0_N2MID[4]
+ Tile_X1Y0_N2MID[5] Tile_X1Y0_N2MID[6] Tile_X1Y0_N2MID[7] Tile_X1Y0_N4END[0] Tile_X1Y0_N4END[10]
+ Tile_X1Y0_N4END[11] Tile_X1Y0_N4END[12] Tile_X1Y0_N4END[13] Tile_X1Y0_N4END[14]
+ Tile_X1Y0_N4END[15] Tile_X1Y0_N4END[1] Tile_X1Y0_N4END[2] Tile_X1Y0_N4END[3] Tile_X1Y0_N4END[4]
+ Tile_X1Y0_N4END[5] Tile_X1Y0_N4END[6] Tile_X1Y0_N4END[7] Tile_X1Y0_N4END[8] Tile_X1Y0_N4END[9]
+ Tile_X1Y0_NN4END[0] Tile_X1Y0_NN4END[10] Tile_X1Y0_NN4END[11] Tile_X1Y0_NN4END[12]
+ Tile_X1Y0_NN4END[13] Tile_X1Y0_NN4END[14] Tile_X1Y0_NN4END[15] Tile_X1Y0_NN4END[1]
+ Tile_X1Y0_NN4END[2] Tile_X1Y0_NN4END[3] Tile_X1Y0_NN4END[4] Tile_X1Y0_NN4END[5]
+ Tile_X1Y0_NN4END[6] Tile_X1Y0_NN4END[7] Tile_X1Y0_NN4END[8] Tile_X1Y0_NN4END[9]
+ Tile_X1Y0_S1BEG[0] Tile_X1Y0_S1BEG[1] Tile_X1Y0_S1BEG[2] Tile_X1Y0_S1BEG[3] Tile_X1Y0_S2BEG[0]
+ Tile_X1Y0_S2BEG[1] Tile_X1Y0_S2BEG[2] Tile_X1Y0_S2BEG[3] Tile_X1Y0_S2BEG[4] Tile_X1Y0_S2BEG[5]
+ Tile_X1Y0_S2BEG[6] Tile_X1Y0_S2BEG[7] Tile_X1Y0_S2BEGb[0] Tile_X1Y0_S2BEGb[1] Tile_X1Y0_S2BEGb[2]
+ Tile_X1Y0_S2BEGb[3] Tile_X1Y0_S2BEGb[4] Tile_X1Y0_S2BEGb[5] Tile_X1Y0_S2BEGb[6]
+ Tile_X1Y0_S2BEGb[7] Tile_X1Y0_S4BEG[0] Tile_X1Y0_S4BEG[10] Tile_X1Y0_S4BEG[11] Tile_X1Y0_S4BEG[12]
+ Tile_X1Y0_S4BEG[13] Tile_X1Y0_S4BEG[14] Tile_X1Y0_S4BEG[15] Tile_X1Y0_S4BEG[1] Tile_X1Y0_S4BEG[2]
+ Tile_X1Y0_S4BEG[3] Tile_X1Y0_S4BEG[4] Tile_X1Y0_S4BEG[5] Tile_X1Y0_S4BEG[6] Tile_X1Y0_S4BEG[7]
+ Tile_X1Y0_S4BEG[8] Tile_X1Y0_S4BEG[9] Tile_X1Y0_SS4BEG[0] Tile_X1Y0_SS4BEG[10] Tile_X1Y0_SS4BEG[11]
+ Tile_X1Y0_SS4BEG[12] Tile_X1Y0_SS4BEG[13] Tile_X1Y0_SS4BEG[14] Tile_X1Y0_SS4BEG[15]
+ Tile_X1Y0_SS4BEG[1] Tile_X1Y0_SS4BEG[2] Tile_X1Y0_SS4BEG[3] Tile_X1Y0_SS4BEG[4]
+ Tile_X1Y0_SS4BEG[5] Tile_X1Y0_SS4BEG[6] Tile_X1Y0_SS4BEG[7] Tile_X1Y0_SS4BEG[8]
+ Tile_X1Y0_SS4BEG[9] Tile_X1Y0_UserCLKo VGND VPWR
XANTENNA__150__GATE Tile_X1Y0_FrameStrobe[0] VPWR VGND sg13cmos5l_antennanp
XANTENNA__165__GATE Tile_X1Y0_FrameStrobe[1] VPWR VGND sg13cmos5l_antennanp
XANTENNA__586__A1 Tile_X0Y0_N4END[2] VPWR VGND sg13cmos5l_antennanp
XFILLER_11_818 VPWR VGND sg13cmos5l_fill_2
XFILLER_11_1064 VPWR VGND sg13cmos5l_decap_8
XFILLER_2_538 VPWR VGND sg13cmos5l_decap_8
XANTENNA__577__A1 Tile_X0Y0_N4END[6] VPWR VGND sg13cmos5l_antennanp
XFILLER_14_612 VPWR VGND sg13cmos5l_decap_8
X_432_ Tile_X0Y0_S4BEG[1] _569_/X VPWR VGND sg13cmos5l_buf_1
X_501_ Tile_X1Y0_S1BEG[2] Tile_X1Y0_N1END[1] VPWR VGND sg13cmos5l_buf_1
XFILLER_13_177 VPWR VGND sg13cmos5l_decap_8
XFILLER_14_689 VPWR VGND sg13cmos5l_decap_8
X_294_ _294_/Q Tile_X0Y0_FrameData[27] VGND VPWR Tile_X0Y0_FrameStrobe[1] latch
X_363_ _363_/L_HI VPWR VGND sg13cmos5l_tiehi
XFILLER_3_78 VPWR VGND sg13cmos5l_fill_1
XFILLER_3_1029 VPWR VGND sg13cmos5l_fill_1
XFILLER_3_1018 VPWR VGND sg13cmos5l_decap_8
XANTENNA__568__A1 Tile_X0Y0_N4END[15] VPWR VGND sg13cmos5l_antennanp
XANTENNA__559__A1 Tile_X1Y0_N2END[2] VPWR VGND sg13cmos5l_antennanp
XFILLER_15_409 VPWR VGND sg13cmos5l_fill_2
XFILLER_10_103 VPWR VGND sg13cmos5l_decap_4
XFILLER_7_608 VPWR VGND sg13cmos5l_fill_1
XANTENNA__501__X Tile_X1Y0_S1BEG[2] VPWR VGND sg13cmos5l_antennanp
XFILLER_2_335 VPWR VGND sg13cmos5l_decap_4
XFILLER_3_869 VPWR VGND sg13cmos5l_fill_1
XFILLER_14_420 VPWR VGND sg13cmos5l_decap_8
XFILLER_14_442 VPWR VGND sg13cmos5l_fill_2
XFILLER_14_497 VPWR VGND sg13cmos5l_decap_8
XFILLER_2_1084 VPWR VGND sg13cmos5l_decap_8
X_346_ _346_/Q Tile_X0Y0_FrameData[7] VGND VPWR Tile_X0Y0_FrameStrobe[2] latch
X_415_ Tile_X0Y0_S2BEG[0] Tile_X0Y0_N2MID[7] VPWR VGND sg13cmos5l_buf_1
X_277_ _277_/Q Tile_X0Y0_FrameData[12] VGND VPWR Tile_X0Y0_FrameStrobe[0] latch
XFILLER_6_696 VPWR VGND sg13cmos5l_decap_8
XANTENNA__411__X Tile_X0Y0_S1BEG[0] VPWR VGND sg13cmos5l_antennanp
XFILLER_0_806 VPWR VGND sg13cmos5l_fill_1
XFILLER_15_228 VPWR VGND sg13cmos5l_decap_8
X_200_ _200_/Q Tile_X0Y0_FrameData[16] VGND VPWR Tile_X1Y0_FrameStrobe[2] latch
X_131_ _131_/Q Tile_X0Y0_FrameData[21] VGND VPWR Tile_X1Y0_FrameStrobe[0] latch
X_062_ _245_/D _642_/X _229_/Q _232_/Q VPWR VGND sg13cmos5l_mux2_1
XFILLER_7_427 VPWR VGND sg13cmos5l_fill_1
XFILLER_7_416 VPWR VGND sg13cmos5l_decap_8
XFILLER_2_121 VPWR VGND sg13cmos5l_decap_8
XFILLER_3_666 VPWR VGND sg13cmos5l_decap_8
XANTENNA__640__A0 Tile_X0Y0_N2MID[1] VPWR VGND sg13cmos5l_antennanp
XFILLER_4_1102 VPWR VGND sg13cmos5l_decap_8
XANTENNA__406__X Tile_X0Y0_FrameStrobe_O[15] VPWR VGND sg13cmos5l_antennanp
XFILLER_14_261 VPWR VGND sg13cmos5l_decap_8
X_329_ _329_/Q Tile_X0Y0_FrameData[24] VGND VPWR Tile_X0Y0_FrameStrobe[2] latch
XFILLER_9_11 VPWR VGND sg13cmos5l_fill_1
XFILLER_9_1079 VPWR VGND sg13cmos5l_decap_8
XANTENNA__631__A0 Tile_X1Y0_N2END[7] VPWR VGND sg13cmos5l_antennanp
XFILLER_10_1118 VPWR VGND sg13cmos5l_fill_2
XFILLER_0_636 VPWR VGND sg13cmos5l_fill_1
XFILLER_0_658 VPWR VGND sg13cmos5l_fill_1
XANTENNA__622__A0 Tile_X1Y0_N2MID[6] VPWR VGND sg13cmos5l_antennanp
XFILLER_16_537 VPWR VGND sg13cmos5l_decap_8
XFILLER_12_776 VPWR VGND sg13cmos5l_decap_4
X_114_ PMOD_IO_O4 _223_/Q _074_/X VPWR VGND sg13cmos5l_nor2b_1
XFILLER_8_769 VPWR VGND sg13cmos5l_fill_2
XFILLER_3_441 VPWR VGND sg13cmos5l_decap_8
XANTENNA__402__A Tile_X0Y0_FrameStrobe[11] VPWR VGND sg13cmos5l_antennanp
XANTENNA__613__A0 Tile_X1Y0_N2MID[5] VPWR VGND sg13cmos5l_antennanp
XFILLER_15_592 VPWR VGND sg13cmos5l_decap_8
XFILLER_6_290 VPWR VGND sg13cmos5l_decap_4
XANTENNA__604__A0 Tile_X1Y0_N1END[0] VPWR VGND sg13cmos5l_antennanp
XFILLER_14_1073 VPWR VGND sg13cmos5l_decap_8
XFILLER_4_249 VPWR VGND sg13cmos5l_decap_8
XFILLER_0_488 VPWR VGND sg13cmos5l_fill_1
XFILLER_16_334 VPWR VGND sg13cmos5l_decap_8
X_594_ _594_/X Tile_X0Y0_N2END[2] Tile_X0Y0_N4END[10] Tile_X0Y0_NN4END[5] _119_/X
+ _281_/Q _280_/Q VPWR VGND sg13cmos5l_mux4_1
XANTENNA__247__CLK Tile_X0Y0_UserCLK VPWR VGND sg13cmos5l_antennanp
XFILLER_12_540 VPWR VGND sg13cmos5l_decap_8
XFILLER_8_533 VPWR VGND sg13cmos5l_decap_8
XFILLER_6_1049 VPWR VGND sg13cmos5l_decap_4
XFILLER_1_219 VPWR VGND sg13cmos5l_decap_8
XFILLER_13_315 VPWR VGND sg13cmos5l_decap_8
XANTENNA__333__GATE Tile_X0Y0_FrameStrobe[2] VPWR VGND sg13cmos5l_antennanp
XANTENNA__348__GATE Tile_X0Y0_FrameStrobe[2] VPWR VGND sg13cmos5l_antennanp
XFILLER_16_1102 VPWR VGND sg13cmos5l_fill_1
XFILLER_5_514 VPWR VGND sg13cmos5l_decap_8
XANTENNA__504__X Tile_X1Y0_S2BEG[1] VPWR VGND sg13cmos5l_antennanp
XANTENNA__595__A2 Tile_X0Y0_NN4END[4] VPWR VGND sg13cmos5l_antennanp
XFILLER_16_153 VPWR VGND sg13cmos5l_decap_8
X_646_ _646_/X Tile_X1Y0_N2MID[7] Tile_X1Y0_N2END[0] Tile_X1Y0_N4END[15] Tile_X1Y0_NN4END[15]
+ _126_/Q _125_/Q VPWR VGND sg13cmos5l_mux4_1
X_577_ _577_/X Tile_X0Y0_N2MID[1] Tile_X0Y0_N4END[6] Tile_X0Y0_NN4END[9] _092_/X _315_/Q
+ _314_/Q VPWR VGND sg13cmos5l_mux4_1
XANTENNA__414__X Tile_X0Y0_S1BEG[3] VPWR VGND sg13cmos5l_antennanp
XFILLER_9_875 VPWR VGND sg13cmos5l_decap_8
XFILLER_9_853 VPWR VGND sg13cmos5l_fill_1
XANTENNA__586__A2 Tile_X0Y0_NN4END[13] VPWR VGND sg13cmos5l_antennanp
XFILLER_11_0 VPWR VGND sg13cmos5l_fill_2
XFILLER_11_1010 VPWR VGND sg13cmos5l_fill_2
XFILLER_11_1043 VPWR VGND sg13cmos5l_decap_8
XFILLER_2_517 VPWR VGND sg13cmos5l_decap_8
XANTENNA__500__A Tile_X1Y0_N1END[2] VPWR VGND sg13cmos5l_antennanp
X_500_ Tile_X1Y0_S1BEG[1] Tile_X1Y0_N1END[2] VPWR VGND sg13cmos5l_buf_1
XANTENNA__272__GATE Tile_X0Y0_FrameStrobe[0] VPWR VGND sg13cmos5l_antennanp
XANTENNA__577__A2 Tile_X0Y0_NN4END[9] VPWR VGND sg13cmos5l_antennanp
XFILLER_14_668 VPWR VGND sg13cmos5l_decap_8
X_362_ _362_/L_HI VPWR VGND sg13cmos5l_tiehi
X_431_ Tile_X0Y0_S4BEG[0] _568_/X VPWR VGND sg13cmos5l_buf_1
XANTENNA__210__GATE Tile_X1Y0_FrameStrobe[2] VPWR VGND sg13cmos5l_antennanp
XANTENNA__287__GATE Tile_X0Y0_FrameStrobe[0] VPWR VGND sg13cmos5l_antennanp
XFILLER_10_863 VPWR VGND sg13cmos5l_fill_2
X_293_ _293_/Q Tile_X0Y0_FrameData[28] VGND VPWR Tile_X0Y0_FrameStrobe[1] latch
XFILLER_5_344 VPWR VGND sg13cmos5l_decap_8
XANTENNA__225__GATE Tile_X1Y0_FrameStrobe[3] VPWR VGND sg13cmos5l_antennanp
XANTENNA__410__A Tile_X0Y0_FrameStrobe[19] VPWR VGND sg13cmos5l_antennanp
XFILLER_3_46 VPWR VGND sg13cmos5l_decap_8
XANTENNA__409__X Tile_X0Y0_FrameStrobe_O[18] VPWR VGND sg13cmos5l_antennanp
XANTENNA__568__A2 Tile_X0Y0_NN4END[0] VPWR VGND sg13cmos5l_antennanp
X_629_ _629_/X Tile_X1Y0_N2END[5] Tile_X1Y0_N4END[5] Tile_X1Y0_NN4END[10] _064_/X
+ _162_/Q _161_/Q VPWR VGND sg13cmos5l_mux4_1
XANTENNA__559__A2 Tile_X1Y0_N4END[15] VPWR VGND sg13cmos5l_antennanp
XFILLER_12_88 VPWR VGND sg13cmos5l_decap_8
XFILLER_12_99 VPWR VGND sg13cmos5l_decap_4
XFILLER_2_1063 VPWR VGND sg13cmos5l_decap_8
X_276_ _276_/Q Tile_X0Y0_FrameData[13] VGND VPWR Tile_X0Y0_FrameStrobe[0] latch
X_345_ _345_/Q Tile_X0Y0_FrameData[8] VGND VPWR Tile_X0Y0_FrameStrobe[2] latch
X_414_ Tile_X0Y0_S1BEG[3] Tile_X0Y0_N1END[0] VPWR VGND sg13cmos5l_buf_1
XANTENNA__405__A Tile_X0Y0_FrameStrobe[14] VPWR VGND sg13cmos5l_antennanp
XFILLER_6_686 VPWR VGND sg13cmos5l_fill_1
XFILLER_6_642 VPWR VGND sg13cmos5l_decap_4
XFILLER_5_196 VPWR VGND sg13cmos5l_fill_2
XANTENNA__164__GATE Tile_X1Y0_FrameStrobe[1] VPWR VGND sg13cmos5l_antennanp
XFILLER_2_881 VPWR VGND sg13cmos5l_fill_1
XANTENNA__179__GATE Tile_X1Y0_FrameStrobe[1] VPWR VGND sg13cmos5l_antennanp
XFILLER_9_480 VPWR VGND sg13cmos5l_decap_8
XANTENNA__200__D Tile_X0Y0_FrameData[16] VPWR VGND sg13cmos5l_antennanp
XFILLER_15_207 VPWR VGND sg13cmos5l_decap_8
XFILLER_16_708 VPWR VGND sg13cmos5l_fill_1
XFILLER_16_719 VPWR VGND sg13cmos5l_fill_1
X_130_ _130_/Q Tile_X0Y0_FrameData[22] VGND VPWR Tile_X1Y0_FrameStrobe[0] latch
XANTENNA__512__X Tile_X1Y0_S2BEGb[1] VPWR VGND sg13cmos5l_antennanp
XFILLER_2_100 VPWR VGND sg13cmos5l_decap_8
X_061_ _061_/Y _244_/Q VPWR VGND sg13cmos5l_inv_1
XFILLER_7_439 VPWR VGND sg13cmos5l_decap_8
XANTENNA__640__A1 Tile_X0Y0_N2END[6] VPWR VGND sg13cmos5l_antennanp
XFILLER_14_240 VPWR VGND sg13cmos5l_decap_8
XFILLER_15_741 VPWR VGND sg13cmos5l_fill_2
X_328_ _328_/Q Tile_X0Y0_FrameData[25] VGND VPWR Tile_X0Y0_FrameStrobe[2] latch
X_259_ _259_/Q Tile_X0Y0_FrameData[30] VGND VPWR Tile_X0Y0_FrameStrobe[0] latch
XFILLER_9_56 VPWR VGND sg13cmos5l_fill_2
XFILLER_7_951 VPWR VGND sg13cmos5l_decap_8
XANTENNA__422__X Tile_X0Y0_S2BEG[7] VPWR VGND sg13cmos5l_antennanp
XFILLER_9_1014 VPWR VGND sg13cmos5l_decap_8
XFILLER_9_1003 VPWR VGND sg13cmos5l_fill_1
XFILLER_6_494 VPWR VGND sg13cmos5l_decap_8
XANTENNA__631__A1 Tile_X1Y0_N4END[7] VPWR VGND sg13cmos5l_antennanp
XFILLER_9_1058 VPWR VGND sg13cmos5l_decap_8
XFILLER_10_1108 VPWR VGND sg13cmos5l_fill_1
XANTENNA__622__A1 Tile_X1Y0_N4END[1] VPWR VGND sg13cmos5l_antennanp
XFILLER_16_516 VPWR VGND sg13cmos5l_decap_4
XANTENNA__507__X Tile_X1Y0_S2BEG[4] VPWR VGND sg13cmos5l_antennanp
XFILLER_11_276 VPWR VGND sg13cmos5l_fill_2
XFILLER_12_700 VPWR VGND sg13cmos5l_decap_8
XFILLER_12_722 VPWR VGND sg13cmos5l_fill_2
X_113_ PMOD_IO_O3 _223_/Q _081_/X VPWR VGND sg13cmos5l_nor2b_1
XFILLER_8_748 VPWR VGND sg13cmos5l_fill_1
XFILLER_4_987 VPWR VGND sg13cmos5l_decap_4
XFILLER_3_497 VPWR VGND sg13cmos5l_decap_8
XANTENNA__613__A1 Tile_X1Y0_N4END[10] VPWR VGND sg13cmos5l_antennanp
XANTENNA__417__X Tile_X0Y0_S2BEG[2] VPWR VGND sg13cmos5l_antennanp
XFILLER_15_571 VPWR VGND sg13cmos5l_decap_8
XANTENNA__604__A1 Tile_X1Y0_N2MID[4] VPWR VGND sg13cmos5l_antennanp
XFILLER_14_1030 VPWR VGND sg13cmos5l_fill_1
XANTENNA__503__A Tile_X1Y0_N2MID[7] VPWR VGND sg13cmos5l_antennanp
XFILLER_14_1052 VPWR VGND sg13cmos5l_decap_8
XFILLER_1_924 VPWR VGND sg13cmos5l_decap_8
XFILLER_4_206 VPWR VGND sg13cmos5l_decap_8
XFILLER_0_445 VPWR VGND sg13cmos5l_fill_1
XFILLER_1_979 VPWR VGND sg13cmos5l_fill_1
XFILLER_16_313 VPWR VGND sg13cmos5l_decap_8
X_593_ _593_/X Tile_X0Y0_N2END[1] Tile_X0Y0_N4END[9] Tile_X0Y0_NN4END[6] _091_/X _283_/Q
+ _282_/Q VPWR VGND sg13cmos5l_mux4_1
XFILLER_12_596 VPWR VGND sg13cmos5l_decap_8
XFILLER_8_589 VPWR VGND sg13cmos5l_decap_8
XFILLER_8_512 VPWR VGND sg13cmos5l_decap_8
XANTENNA__413__A Tile_X0Y0_N1END[1] VPWR VGND sg13cmos5l_antennanp
XFILLER_6_1017 VPWR VGND sg13cmos5l_decap_8
XFILLER_4_773 VPWR VGND sg13cmos5l_decap_8
XANTENNA__598__A0 Tile_X0Y0_N2END[6] VPWR VGND sg13cmos5l_antennanp
XANTENNA__589__A0 Tile_X0Y0_N2END[5] VPWR VGND sg13cmos5l_antennanp
XFILLER_15_77 VPWR VGND sg13cmos5l_decap_8
XANTENNA__520__X Tile_X1Y0_S4BEG[1] VPWR VGND sg13cmos5l_antennanp
XFILLER_1_721 VPWR VGND sg13cmos5l_decap_4
XFILLER_1_743 VPWR VGND sg13cmos5l_fill_1
XFILLER_16_132 VPWR VGND sg13cmos5l_decap_8
X_645_ _645_/X Tile_X1Y0_N2MID[5] Tile_X1Y0_N2END[2] Tile_X1Y0_N4END[13] Tile_X1Y0_NN4END[13]
+ _130_/Q _129_/Q VPWR VGND sg13cmos5l_mux4_1
XANTENNA__408__A Tile_X0Y0_FrameStrobe[17] VPWR VGND sg13cmos5l_antennanp
X_576_ _576_/X Tile_X0Y0_N2MID[0] Tile_X0Y0_N4END[7] Tile_X0Y0_NN4END[8] _091_/X _317_/Q
+ _316_/Q VPWR VGND sg13cmos5l_mux4_1
XFILLER_9_821 VPWR VGND sg13cmos5l_fill_2
XANTENNA__430__X Tile_X0Y0_S2BEGb[7] VPWR VGND sg13cmos5l_antennanp
XFILLER_4_581 VPWR VGND sg13cmos5l_decap_8
XANTENNA__203__D Tile_X0Y0_FrameData[13] VPWR VGND sg13cmos5l_antennanp
XFILLER_11_1099 VPWR VGND sg13cmos5l_decap_8
XANTENNA__237__CLK Tile_X0Y0_UserCLK VPWR VGND sg13cmos5l_antennanp
XANTENNA__515__X Tile_X1Y0_S2BEGb[4] VPWR VGND sg13cmos5l_antennanp
XFILLER_13_124 VPWR VGND sg13cmos5l_decap_8
XFILLER_13_135 VPWR VGND sg13cmos5l_fill_2
XFILLER_14_647 VPWR VGND sg13cmos5l_decap_8
X_292_ _292_/Q Tile_X0Y0_FrameData[29] VGND VPWR Tile_X0Y0_FrameStrobe[1] latch
X_361_ _361_/L_HI VPWR VGND sg13cmos5l_tiehi
X_430_ Tile_X0Y0_S2BEGb[7] _567_/X VPWR VGND sg13cmos5l_buf_1
XFILLER_1_584 VPWR VGND sg13cmos5l_decap_8
X_628_ _628_/X Tile_X1Y0_N2END[4] Tile_X1Y0_N4END[4] Tile_X1Y0_NN4END[11] _089_/X
+ _164_/Q _163_/Q VPWR VGND sg13cmos5l_mux4_1
XANTENNA__425__X Tile_X0Y0_S2BEGb[2] VPWR VGND sg13cmos5l_antennanp
XFILLER_13_680 VPWR VGND sg13cmos5l_decap_8
X_559_ _559_/X Tile_X1Y0_N1END[0] Tile_X1Y0_N2END[2] Tile_X1Y0_N4END[15] Tile_X1Y0_NN4END[15]
+ _124_/Q _123_/Q VPWR VGND sg13cmos5l_mux4_1
XFILLER_9_684 VPWR VGND sg13cmos5l_decap_8
XFILLER_9_651 VPWR VGND sg13cmos5l_decap_8
XANTENNA__332__GATE Tile_X0Y0_FrameStrobe[2] VPWR VGND sg13cmos5l_antennanp
XANTENNA__347__GATE Tile_X0Y0_FrameStrobe[2] VPWR VGND sg13cmos5l_antennanp
XANTENNA__559__A3 Tile_X1Y0_NN4END[15] VPWR VGND sg13cmos5l_antennanp
XFILLER_11_617 VPWR VGND sg13cmos5l_decap_8
XFILLER_11_639 VPWR VGND sg13cmos5l_fill_1
XFILLER_10_138 VPWR VGND sg13cmos5l_decap_4
XFILLER_13_1106 VPWR VGND sg13cmos5l_fill_2
XFILLER_2_1031 VPWR VGND sg13cmos5l_decap_4
XFILLER_2_1042 VPWR VGND sg13cmos5l_decap_8
X_413_ Tile_X0Y0_S1BEG[2] Tile_X0Y0_N1END[1] VPWR VGND sg13cmos5l_buf_1
XFILLER_14_444 VPWR VGND sg13cmos5l_fill_1
X_275_ _275_/Q Tile_X0Y0_FrameData[14] VGND VPWR Tile_X0Y0_FrameStrobe[0] latch
X_344_ _344_/Q Tile_X0Y0_FrameData[9] VGND VPWR Tile_X0Y0_FrameStrobe[2] latch
XANTENNA__421__A Tile_X0Y0_N2MID[1] VPWR VGND sg13cmos5l_antennanp
XFILLER_6_665 VPWR VGND sg13cmos5l_decap_4
XFILLER_5_175 VPWR VGND sg13cmos5l_decap_8
XANTENNA__271__GATE Tile_X0Y0_FrameStrobe[0] VPWR VGND sg13cmos5l_antennanp
XANTENNA__286__GATE Tile_X0Y0_FrameStrobe[0] VPWR VGND sg13cmos5l_antennanp
XANTENNA__224__GATE Tile_X1Y0_FrameStrobe[3] VPWR VGND sg13cmos5l_antennanp
XANTENNA__506__A Tile_X1Y0_N2MID[4] VPWR VGND sg13cmos5l_antennanp
XFILLER_11_403 VPWR VGND sg13cmos5l_decap_8
XFILLER_11_436 VPWR VGND sg13cmos5l_decap_8
XFILLER_11_447 VPWR VGND sg13cmos5l_decap_8
XFILLER_11_458 VPWR VGND sg13cmos5l_fill_1
XFILLER_8_919 VPWR VGND sg13cmos5l_decap_8
X_060_ _060_/Y _250_/Q VPWR VGND sg13cmos5l_inv_1
XFILLER_3_602 VPWR VGND sg13cmos5l_decap_8
XFILLER_2_178 VPWR VGND sg13cmos5l_decap_8
XFILLER_4_1115 VPWR VGND sg13cmos5l_decap_4
XANTENNA__640__A2 Tile_X0Y0_N4END[9] VPWR VGND sg13cmos5l_antennanp
XANTENNA__416__A Tile_X0Y0_N2MID[6] VPWR VGND sg13cmos5l_antennanp
XFILLER_14_296 VPWR VGND sg13cmos5l_decap_8
X_327_ _327_/Q Tile_X0Y0_FrameData[26] VGND VPWR Tile_X0Y0_FrameStrobe[2] latch
X_258_ _258_/Q Tile_X0Y0_UserCLK _559_/X _352_/L_HI VPWR VGND sg13cmos5l_dfrbpq_1
X_189_ _189_/Q Tile_X0Y0_FrameData[27] VGND VPWR Tile_X1Y0_FrameStrobe[2] latch
XFILLER_7_930 VPWR VGND sg13cmos5l_decap_8
XFILLER_6_462 VPWR VGND sg13cmos5l_decap_4
XFILLER_6_440 VPWR VGND sg13cmos5l_fill_1
XANTENNA__301__D Tile_X0Y0_FrameData[20] VPWR VGND sg13cmos5l_antennanp
XANTENNA__631__A2 Tile_X1Y0_NN4END[8] VPWR VGND sg13cmos5l_antennanp
XANTENNA__083__A0 PMOD_IO_I0 VPWR VGND sg13cmos5l_antennanp
XANTENNA__211__D Tile_X0Y0_FrameData[5] VPWR VGND sg13cmos5l_antennanp
XANTENNA__622__A2 Tile_X1Y0_NN4END[14] VPWR VGND sg13cmos5l_antennanp
XANTENNA__163__GATE Tile_X1Y0_FrameStrobe[1] VPWR VGND sg13cmos5l_antennanp
XANTENNA__178__GATE Tile_X1Y0_FrameStrobe[1] VPWR VGND sg13cmos5l_antennanp
XANTENNA__523__X Tile_X1Y0_S4BEG[4] VPWR VGND sg13cmos5l_antennanp
XFILLER_11_255 VPWR VGND sg13cmos5l_decap_8
XFILLER_11_299 VPWR VGND sg13cmos5l_decap_4
XFILLER_12_734 VPWR VGND sg13cmos5l_decap_4
XFILLER_15_1009 VPWR VGND sg13cmos5l_decap_8
X_112_ PMOD_IO_O2 _223_/Q _071_/X VPWR VGND sg13cmos5l_nor2b_1
XFILLER_1_0 VPWR VGND sg13cmos5l_fill_2
XFILLER_4_966 VPWR VGND sg13cmos5l_decap_8
XFILLER_3_476 VPWR VGND sg13cmos5l_decap_8
XFILLER_3_432 VPWR VGND sg13cmos5l_decap_4
XFILLER_3_421 VPWR VGND sg13cmos5l_fill_1
XANTENNA__613__A2 Tile_X1Y0_NN4END[5] VPWR VGND sg13cmos5l_antennanp
XFILLER_15_550 VPWR VGND sg13cmos5l_decap_8
XANTENNA__433__X Tile_X0Y0_S4BEG[2] VPWR VGND sg13cmos5l_antennanp
XANTENNA__604__A2 Tile_X1Y0_N2END[3] VPWR VGND sg13cmos5l_antennanp
XFILLER_1_80 VPWR VGND sg13cmos5l_fill_2
XANTENNA__206__D Tile_X0Y0_FrameData[10] VPWR VGND sg13cmos5l_antennanp
XFILLER_14_1020 VPWR VGND sg13cmos5l_fill_1
XFILLER_1_903 VPWR VGND sg13cmos5l_decap_8
XFILLER_1_914 VPWR VGND sg13cmos5l_decap_8
XFILLER_1_1118 VPWR VGND sg13cmos5l_fill_2
X_592_ _592_/X Tile_X0Y0_N2END[0] Tile_X0Y0_N4END[8] Tile_X0Y0_NN4END[7] _092_/X _285_/Q
+ _284_/Q VPWR VGND sg13cmos5l_mux4_1
XANTENNA__518__X Tile_X1Y0_S2BEGb[7] VPWR VGND sg13cmos5l_antennanp
XFILLER_16_369 VPWR VGND sg13cmos5l_decap_8
XFILLER_12_575 VPWR VGND sg13cmos5l_decap_8
XFILLER_8_568 VPWR VGND sg13cmos5l_decap_8
XFILLER_6_47 VPWR VGND sg13cmos5l_fill_2
XFILLER_4_741 VPWR VGND sg13cmos5l_decap_8
XFILLER_4_730 VPWR VGND sg13cmos5l_decap_4
XFILLER_4_785 VPWR VGND sg13cmos5l_decap_4
XFILLER_3_240 VPWR VGND sg13cmos5l_decap_8
XANTENNA__428__X Tile_X0Y0_S2BEGb[5] VPWR VGND sg13cmos5l_antennanp
XANTENNA__598__A1 Tile_X0Y0_N4END[14] VPWR VGND sg13cmos5l_antennanp
XFILLER_16_881 VPWR VGND sg13cmos5l_fill_1
XANTENNA__589__A1 Tile_X0Y0_N4END[5] VPWR VGND sg13cmos5l_antennanp
XFILLER_14_829 VPWR VGND sg13cmos5l_decap_4
XFILLER_16_1115 VPWR VGND sg13cmos5l_decap_4
XFILLER_5_549 VPWR VGND sg13cmos5l_decap_8
XFILLER_16_100 VPWR VGND sg13cmos5l_fill_1
XFILLER_16_111 VPWR VGND sg13cmos5l_decap_8
X_644_ _644_/X Tile_X1Y0_N2MID[3] Tile_X1Y0_N2END[4] Tile_X1Y0_N4END[11] Tile_X1Y0_NN4END[11]
+ _134_/Q _133_/Q VPWR VGND sg13cmos5l_mux4_1
X_575_ _575_/X Tile_X0Y0_N2MID[7] Tile_X0Y0_N4END[8] Tile_X0Y0_NN4END[7] _119_/X _319_/Q
+ _318_/Q VPWR VGND sg13cmos5l_mux4_1
XFILLER_5_1084 VPWR VGND sg13cmos5l_decap_8
XFILLER_12_394 VPWR VGND sg13cmos5l_fill_2
XFILLER_16_188 VPWR VGND sg13cmos5l_decap_8
XFILLER_8_343 VPWR VGND sg13cmos5l_decap_8
XFILLER_8_310 VPWR VGND sg13cmos5l_decap_4
XFILLER_4_560 VPWR VGND sg13cmos5l_decap_8
XFILLER_10_309 VPWR VGND sg13cmos5l_decap_4
XFILLER_11_1012 VPWR VGND sg13cmos5l_fill_1
XFILLER_11_1078 VPWR VGND sg13cmos5l_decap_8
XANTENNA__509__A Tile_X1Y0_N2MID[1] VPWR VGND sg13cmos5l_antennanp
XFILLER_13_103 VPWR VGND sg13cmos5l_decap_8
XFILLER_13_147 VPWR VGND sg13cmos5l_decap_8
XFILLER_13_158 VPWR VGND sg13cmos5l_decap_4
XFILLER_14_626 VPWR VGND sg13cmos5l_decap_8
X_291_ _291_/Q Tile_X0Y0_FrameData[30] VGND VPWR Tile_X0Y0_FrameStrobe[1] latch
X_360_ _360_/L_HI VPWR VGND sg13cmos5l_tiehi
XFILLER_9_118 VPWR VGND sg13cmos5l_fill_1
XANTENNA__531__X Tile_X1Y0_S4BEG[12] VPWR VGND sg13cmos5l_antennanp
XFILLER_10_865 VPWR VGND sg13cmos5l_fill_1
XFILLER_5_379 VPWR VGND sg13cmos5l_decap_4
XFILLER_5_335 VPWR VGND sg13cmos5l_decap_4
XFILLER_1_563 VPWR VGND sg13cmos5l_decap_8
XANTENNA__419__A Tile_X0Y0_N2MID[3] VPWR VGND sg13cmos5l_antennanp
X_627_ _627_/X Tile_X1Y0_N2END[3] Tile_X1Y0_N4END[3] Tile_X1Y0_NN4END[12] _087_/X
+ _166_/Q _165_/Q VPWR VGND sg13cmos5l_mux4_1
X_558_ _558_/X Tile_X1Y0_N2MID[6] Tile_X1Y0_N2END[1] Tile_X1Y0_N4END[14] Tile_X1Y0_NN4END[14]
+ _128_/Q _127_/Q VPWR VGND sg13cmos5l_mux4_1
XFILLER_12_191 VPWR VGND sg13cmos5l_decap_8
X_489_ Tile_X1Y0_FrameStrobe_O[10] Tile_X1Y0_FrameStrobe[10] VPWR VGND sg13cmos5l_buf_1
XFILLER_9_630 VPWR VGND sg13cmos5l_decap_8
XANTENNA__304__D Tile_X0Y0_FrameData[17] VPWR VGND sg13cmos5l_antennanp
XANTENNA__441__X Tile_X0Y0_S4BEG[10] VPWR VGND sg13cmos5l_antennanp
XFILLER_5_891 VPWR VGND sg13cmos5l_decap_8
XFILLER_10_117 VPWR VGND sg13cmos5l_decap_8
XANTENNA__214__D Tile_X0Y0_FrameData[2] VPWR VGND sg13cmos5l_antennanp
XFILLER_13_1118 VPWR VGND sg13cmos5l_fill_2
XANTENNA__526__X Tile_X1Y0_S4BEG[7] VPWR VGND sg13cmos5l_antennanp
XFILLER_2_1010 VPWR VGND sg13cmos5l_decap_8
XFILLER_2_1098 VPWR VGND sg13cmos5l_decap_4
X_412_ Tile_X0Y0_S1BEG[1] Tile_X0Y0_N1END[2] VPWR VGND sg13cmos5l_buf_1
XFILLER_10_662 VPWR VGND sg13cmos5l_decap_4
XFILLER_10_684 VPWR VGND sg13cmos5l_fill_2
X_274_ _274_/Q Tile_X0Y0_FrameData[15] VGND VPWR Tile_X0Y0_FrameStrobe[0] latch
X_343_ _343_/Q Tile_X0Y0_FrameData[10] VGND VPWR Tile_X0Y0_FrameStrobe[2] latch
XFILLER_6_611 VPWR VGND sg13cmos5l_decap_8
XANTENNA__124__D Tile_X0Y0_FrameData[28] VPWR VGND sg13cmos5l_antennanp
XFILLER_5_198 VPWR VGND sg13cmos5l_fill_1
XFILLER_2_872 VPWR VGND sg13cmos5l_decap_8
XANTENNA__643__A0 Tile_X1Y0_N2MID[1] VPWR VGND sg13cmos5l_antennanp
XANTENNA__436__X Tile_X0Y0_S4BEG[5] VPWR VGND sg13cmos5l_antennanp
XANTENNA__634__A0 Tile_X1Y0_N2END[2] VPWR VGND sg13cmos5l_antennanp
XFILLER_4_80 VPWR VGND sg13cmos5l_decap_8
XANTENNA__209__D Tile_X0Y0_FrameData[7] VPWR VGND sg13cmos5l_antennanp
XFILLER_11_415 VPWR VGND sg13cmos5l_decap_8
XFILLER_2_135 VPWR VGND sg13cmos5l_decap_8
XFILLER_3_658 VPWR VGND sg13cmos5l_fill_1
XANTENNA__625__A0 Tile_X1Y0_N2END[1] VPWR VGND sg13cmos5l_antennanp
XANTENNA__640__A3 Tile_X0Y0_NN4END[9] VPWR VGND sg13cmos5l_antennanp
XANTENNA__331__GATE Tile_X0Y0_FrameStrobe[2] VPWR VGND sg13cmos5l_antennanp
XFILLER_14_275 VPWR VGND sg13cmos5l_decap_8
XFILLER_15_754 VPWR VGND sg13cmos5l_fill_2
X_326_ _326_/Q Tile_X0Y0_FrameData[27] VGND VPWR Tile_X0Y0_FrameStrobe[2] latch
XANTENNA__346__GATE Tile_X0Y0_FrameStrobe[2] VPWR VGND sg13cmos5l_antennanp
XFILLER_10_492 VPWR VGND sg13cmos5l_decap_8
XFILLER_11_971 VPWR VGND sg13cmos5l_decap_4
XFILLER_11_982 VPWR VGND sg13cmos5l_fill_1
X_257_ _257_/Q Tile_X0Y0_UserCLK _558_/X _364_/L_HI VPWR VGND sg13cmos5l_dfrbpq_1
X_188_ _188_/Q Tile_X0Y0_FrameData[28] VGND VPWR Tile_X1Y0_FrameStrobe[2] latch
XFILLER_7_986 VPWR VGND sg13cmos5l_fill_1
XFILLER_7_975 VPWR VGND sg13cmos5l_decap_8
XFILLER_6_474 VPWR VGND sg13cmos5l_fill_2
XANTENNA__616__A0 Tile_X1Y0_N2MID[0] VPWR VGND sg13cmos5l_antennanp
XFILLER_0_617 VPWR VGND sg13cmos5l_decap_4
XANTENNA__607__A0 Tile_X1Y0_N1END[3] VPWR VGND sg13cmos5l_antennanp
XFILLER_11_201 VPWR VGND sg13cmos5l_decap_8
XFILLER_11_212 VPWR VGND sg13cmos5l_fill_1
XFILLER_12_746 VPWR VGND sg13cmos5l_decap_8
X_111_ PMOD_IO_O1 _223_/Q _110_/X VPWR VGND sg13cmos5l_nor2b_1
XFILLER_8_728 VPWR VGND sg13cmos5l_fill_2
XFILLER_7_249 VPWR VGND sg13cmos5l_decap_8
XFILLER_7_205 VPWR VGND sg13cmos5l_decap_8
XFILLER_3_455 VPWR VGND sg13cmos5l_decap_8
XFILLER_8_1093 VPWR VGND sg13cmos5l_decap_8
XANTENNA__270__GATE Tile_X0Y0_FrameStrobe[0] VPWR VGND sg13cmos5l_antennanp
X_309_ _309_/Q Tile_X0Y0_FrameData[12] VGND VPWR Tile_X0Y0_FrameStrobe[1] latch
XANTENNA__285__GATE Tile_X0Y0_FrameStrobe[0] VPWR VGND sg13cmos5l_antennanp
XANTENNA__312__D Tile_X0Y0_FrameData[9] VPWR VGND sg13cmos5l_antennanp
XFILLER_7_794 VPWR VGND sg13cmos5l_fill_1
XANTENNA__223__GATE Tile_X1Y0_FrameStrobe[3] VPWR VGND sg13cmos5l_antennanp
XFILLER_14_1087 VPWR VGND sg13cmos5l_decap_8
XANTENNA__222__D Tile_X0Y0_FrameData[15] VPWR VGND sg13cmos5l_antennanp
XFILLER_0_414 VPWR VGND sg13cmos5l_decap_4
XFILLER_1_948 VPWR VGND sg13cmos5l_decap_8
XFILLER_16_348 VPWR VGND sg13cmos5l_decap_4
X_591_ _591_/X Tile_X0Y0_N2END[7] Tile_X0Y0_N4END[7] Tile_X0Y0_NN4END[8] _119_/X _287_/Q
+ _286_/Q VPWR VGND sg13cmos5l_mux4_1
XANTENNA__534__X Tile_X1Y0_S4BEG[15] VPWR VGND sg13cmos5l_antennanp
XFILLER_12_554 VPWR VGND sg13cmos5l_decap_8
XANTENNA__132__D Tile_X0Y0_FrameData[20] VPWR VGND sg13cmos5l_antennanp
XFILLER_8_547 VPWR VGND sg13cmos5l_decap_8
XFILLER_6_59 VPWR VGND sg13cmos5l_decap_8
XFILLER_6_26 VPWR VGND sg13cmos5l_decap_8
XFILLER_0_981 VPWR VGND sg13cmos5l_fill_1
XANTENNA__598__A2 Tile_X0Y0_NN4END[1] VPWR VGND sg13cmos5l_antennanp
XFILLER_15_381 VPWR VGND sg13cmos5l_fill_2
XANTENNA__307__D Tile_X0Y0_FrameData[14] VPWR VGND sg13cmos5l_antennanp
XANTENNA__444__X Tile_X0Y0_S4BEG[13] VPWR VGND sg13cmos5l_antennanp
XANTENNA__162__GATE Tile_X1Y0_FrameStrobe[1] VPWR VGND sg13cmos5l_antennanp
XANTENNA__177__GATE Tile_X1Y0_FrameStrobe[1] VPWR VGND sg13cmos5l_antennanp
XANTENNA__589__A2 Tile_X0Y0_NN4END[10] VPWR VGND sg13cmos5l_antennanp
XANTENNA__217__D Tile_X0Y0_FrameData[31] VPWR VGND sg13cmos5l_antennanp
XFILLER_13_329 VPWR VGND sg13cmos5l_decap_8
XFILLER_15_24 VPWR VGND sg13cmos5l_fill_1
XFILLER_15_35 VPWR VGND sg13cmos5l_decap_4
XFILLER_5_528 VPWR VGND sg13cmos5l_decap_8
XFILLER_0_211 VPWR VGND sg13cmos5l_decap_8
XFILLER_1_734 VPWR VGND sg13cmos5l_decap_8
XANTENNA__529__X Tile_X1Y0_S4BEG[10] VPWR VGND sg13cmos5l_antennanp
XFILLER_16_167 VPWR VGND sg13cmos5l_decap_8
X_643_ _643_/X Tile_X1Y0_N2MID[1] Tile_X1Y0_N2END[6] Tile_X1Y0_N4END[9] Tile_X1Y0_NN4END[9]
+ _138_/Q _137_/Q VPWR VGND sg13cmos5l_mux4_1
X_574_ _574_/X Tile_X0Y0_N2MID[6] Tile_X0Y0_N4END[9] Tile_X0Y0_NN4END[6] _092_/X _321_/Q
+ _320_/Q VPWR VGND sg13cmos5l_mux4_1
XFILLER_5_1063 VPWR VGND sg13cmos5l_decap_8
XANTENNA__127__D Tile_X0Y0_FrameData[25] VPWR VGND sg13cmos5l_antennanp
XFILLER_12_373 VPWR VGND sg13cmos5l_decap_8
XFILLER_13_841 VPWR VGND sg13cmos5l_fill_1
XFILLER_8_388 VPWR VGND sg13cmos5l_decap_8
XANTENNA__439__X Tile_X0Y0_S4BEG[8] VPWR VGND sg13cmos5l_antennanp
XFILLER_11_1057 VPWR VGND sg13cmos5l_decap_8
XFILLER_7_80 VPWR VGND sg13cmos5l_fill_1
XFILLER_14_605 VPWR VGND sg13cmos5l_decap_8
X_290_ _290_/Q Tile_X0Y0_FrameData[31] VGND VPWR Tile_X0Y0_FrameStrobe[1] latch
XFILLER_1_542 VPWR VGND sg13cmos5l_decap_8
XFILLER_7_1103 VPWR VGND sg13cmos5l_decap_4
X_488_ Tile_X1Y0_FrameStrobe_O[9] Tile_X1Y0_FrameStrobe[9] VPWR VGND sg13cmos5l_buf_1
X_626_ _626_/X Tile_X1Y0_N2END[2] Tile_X1Y0_N4END[2] Tile_X1Y0_NN4END[13] _085_/X
+ _168_/Q _167_/Q VPWR VGND sg13cmos5l_mux4_1
X_557_ _557_/X Tile_X1Y0_N2MID[4] Tile_X1Y0_N2END[3] Tile_X1Y0_N4END[12] Tile_X1Y0_NN4END[12]
+ _132_/Q _131_/Q VPWR VGND sg13cmos5l_mux4_1
XANTENNA__320__D Tile_X0Y0_FrameData[1] VPWR VGND sg13cmos5l_antennanp
XFILLER_10_1090 VPWR VGND sg13cmos5l_decap_8
XFILLER_2_339 VPWR VGND sg13cmos5l_fill_1
XFILLER_3_829 VPWR VGND sg13cmos5l_fill_1
XANTENNA__230__D Tile_X0Y0_FrameData[23] VPWR VGND sg13cmos5l_antennanp
XFILLER_14_402 VPWR VGND sg13cmos5l_decap_8
XFILLER_2_1077 VPWR VGND sg13cmos5l_decap_8
X_342_ _342_/Q Tile_X0Y0_FrameData[11] VGND VPWR Tile_X0Y0_FrameStrobe[2] latch
X_411_ Tile_X0Y0_S1BEG[0] Tile_X0Y0_N1END[3] VPWR VGND sg13cmos5l_buf_1
XANTENNA__542__X Tile_X1Y0_SS4BEG[7] VPWR VGND sg13cmos5l_antennanp
XFILLER_10_696 VPWR VGND sg13cmos5l_fill_1
X_273_ _273_/Q Tile_X0Y0_FrameData[16] VGND VPWR Tile_X0Y0_FrameStrobe[0] latch
XANTENNA__140__D Tile_X0Y0_FrameData[12] VPWR VGND sg13cmos5l_antennanp
XANTENNA__643__A1 Tile_X1Y0_N2END[6] VPWR VGND sg13cmos5l_antennanp
X_609_ _609_/X Tile_X1Y0_N2MID[1] Tile_X1Y0_N4END[14] Tile_X1Y0_NN4END[1] _087_/X
+ _202_/Q _201_/Q VPWR VGND sg13cmos5l_mux4_1
XANTENNA__315__D Tile_X0Y0_FrameData[6] VPWR VGND sg13cmos5l_antennanp
XANTENNA__452__X Tile_X1Y0_FrameData_O[5] VPWR VGND sg13cmos5l_antennanp
XFILLER_9_494 VPWR VGND sg13cmos5l_decap_8
XANTENNA__634__A1 Tile_X1Y0_N4END[10] VPWR VGND sg13cmos5l_antennanp
XFILLER_4_70 VPWR VGND sg13cmos5l_fill_1
XANTENNA__225__D Tile_X0Y0_FrameData[18] VPWR VGND sg13cmos5l_antennanp
XANTENNA__570__A0 Tile_X0Y0_N2MID[2] VPWR VGND sg13cmos5l_antennanp
XFILLER_2_114 VPWR VGND sg13cmos5l_decap_8
XANTENNA__537__X Tile_X1Y0_SS4BEG[2] VPWR VGND sg13cmos5l_antennanp
XANTENNA__625__A1 Tile_X1Y0_N4END[1] VPWR VGND sg13cmos5l_antennanp
XFILLER_14_254 VPWR VGND sg13cmos5l_decap_8
X_325_ _325_/Q Tile_X0Y0_FrameData[28] VGND VPWR Tile_X0Y0_FrameStrobe[2] latch
XANTENNA__135__D Tile_X0Y0_FrameData[17] VPWR VGND sg13cmos5l_antennanp
XANTENNA__561__A0 Tile_X0Y0_N1END[1] VPWR VGND sg13cmos5l_antennanp
X_256_ _256_/Q Tile_X0Y0_UserCLK _557_/X _353_/L_HI VPWR VGND sg13cmos5l_dfrbpq_1
X_187_ _187_/Q Tile_X0Y0_FrameData[29] VGND VPWR Tile_X1Y0_FrameStrobe[2] latch
XFILLER_7_998 VPWR VGND sg13cmos5l_decap_8
XFILLER_7_965 VPWR VGND sg13cmos5l_decap_4
XFILLER_6_431 VPWR VGND sg13cmos5l_fill_2
XFILLER_6_420 VPWR VGND sg13cmos5l_decap_8
XANTENNA__616__A1 Tile_X1Y0_N4END[7] VPWR VGND sg13cmos5l_antennanp
XFILLER_9_1039 VPWR VGND sg13cmos5l_fill_2
XFILLER_9_1028 VPWR VGND sg13cmos5l_fill_1
XANTENNA__447__X Tile_X1Y0_FrameData_O[0] VPWR VGND sg13cmos5l_antennanp
XANTENNA__552__A0 Tile_X0Y0_N2MID[0] VPWR VGND sg13cmos5l_antennanp
XANTENNA__607__A1 Tile_X1Y0_N2MID[7] VPWR VGND sg13cmos5l_antennanp
XFILLER_12_714 VPWR VGND sg13cmos5l_fill_1
X_110_ _110_/X _252_/Q _553_/X _233_/Q VPWR VGND sg13cmos5l_mux2_1
XFILLER_8_707 VPWR VGND sg13cmos5l_decap_8
XFILLER_3_412 VPWR VGND sg13cmos5l_decap_8
XFILLER_8_1072 VPWR VGND sg13cmos5l_decap_8
XFILLER_15_530 VPWR VGND sg13cmos5l_decap_8
XFILLER_15_585 VPWR VGND sg13cmos5l_decap_8
X_308_ _308_/Q Tile_X0Y0_FrameData[13] VGND VPWR Tile_X0Y0_FrameStrobe[1] latch
X_239_ _239_/Q Tile_X0Y0_UserCLK _239_/D _365_/L_HI VPWR VGND sg13cmos5l_dfrbpq_1
XFILLER_6_294 VPWR VGND sg13cmos5l_fill_2
XFILLER_6_283 VPWR VGND sg13cmos5l_fill_2
XFILLER_3_990 VPWR VGND sg13cmos5l_decap_8
XFILLER_1_82 VPWR VGND sg13cmos5l_fill_1
XFILLER_1_93 VPWR VGND sg13cmos5l_fill_2
XFILLER_14_1066 VPWR VGND sg13cmos5l_decap_8
XANTENNA__330__GATE Tile_X0Y0_FrameStrobe[2] VPWR VGND sg13cmos5l_antennanp
XFILLER_1_938 VPWR VGND sg13cmos5l_decap_8
XANTENNA__345__GATE Tile_X0Y0_FrameStrobe[2] VPWR VGND sg13cmos5l_antennanp
XFILLER_16_327 VPWR VGND sg13cmos5l_decap_8
X_590_ _590_/X Tile_X0Y0_N2END[6] Tile_X0Y0_N4END[6] Tile_X0Y0_NN4END[9] _091_/X _289_/Q
+ _288_/Q VPWR VGND sg13cmos5l_mux4_1
XFILLER_12_533 VPWR VGND sg13cmos5l_decap_8
XFILLER_8_526 VPWR VGND sg13cmos5l_decap_8
XANTENNA__550__X Tile_X1Y0_SS4BEG[15] VPWR VGND sg13cmos5l_antennanp
XFILLER_3_275 VPWR VGND sg13cmos5l_decap_4
XFILLER_15_360 VPWR VGND sg13cmos5l_decap_8
XANTENNA__323__D Tile_X0Y0_FrameData[30] VPWR VGND sg13cmos5l_antennanp
XANTENNA__460__X Tile_X1Y0_FrameData_O[13] VPWR VGND sg13cmos5l_antennanp
XFILLER_7_592 VPWR VGND sg13cmos5l_decap_8
XFILLER_13_308 VPWR VGND sg13cmos5l_decap_8
XFILLER_16_1106 VPWR VGND sg13cmos5l_decap_4
XANTENNA__233__D Tile_X0Y0_FrameData[26] VPWR VGND sg13cmos5l_antennanp
XFILLER_5_507 VPWR VGND sg13cmos5l_decap_8
XANTENNA__284__GATE Tile_X0Y0_FrameStrobe[0] VPWR VGND sg13cmos5l_antennanp
X_642_ _642_/X Tile_X0Y0_N2MID[5] Tile_X0Y0_N2END[2] Tile_X0Y0_N4END[13] Tile_X0Y0_NN4END[13]
+ _259_/Q _350_/Q VPWR VGND sg13cmos5l_mux4_1
XFILLER_5_1042 VPWR VGND sg13cmos5l_decap_8
XFILLER_5_1031 VPWR VGND sg13cmos5l_fill_2
XANTENNA__299__GATE Tile_X0Y0_FrameStrobe[1] VPWR VGND sg13cmos5l_antennanp
XANTENNA__545__X Tile_X1Y0_SS4BEG[10] VPWR VGND sg13cmos5l_antennanp
XFILLER_16_146 VPWR VGND sg13cmos5l_decap_8
X_573_ _573_/X Tile_X0Y0_N2MID[5] Tile_X0Y0_N4END[10] Tile_X0Y0_NN4END[5] _091_/X
+ _323_/Q _322_/Q VPWR VGND sg13cmos5l_mux4_1
XANTENNA__143__D Tile_X0Y0_FrameData[9] VPWR VGND sg13cmos5l_antennanp
XANTENNA__222__GATE Tile_X1Y0_FrameStrobe[3] VPWR VGND sg13cmos5l_antennanp
XFILLER_12_352 VPWR VGND sg13cmos5l_decap_8
XFILLER_12_396 VPWR VGND sg13cmos5l_fill_1
XFILLER_4_595 VPWR VGND sg13cmos5l_decap_8
XANTENNA__318__D Tile_X0Y0_FrameData[3] VPWR VGND sg13cmos5l_antennanp
XANTENNA__455__X Tile_X1Y0_FrameData_O[8] VPWR VGND sg13cmos5l_antennanp
XFILLER_11_1003 VPWR VGND sg13cmos5l_decap_8
XANTENNA__228__D Tile_X0Y0_FrameData[21] VPWR VGND sg13cmos5l_antennanp
XFILLER_10_856 VPWR VGND sg13cmos5l_decap_8
XFILLER_6_816 VPWR VGND sg13cmos5l_fill_2
XFILLER_1_532 VPWR VGND sg13cmos5l_decap_4
XFILLER_7_1115 VPWR VGND sg13cmos5l_decap_4
XFILLER_3_39 VPWR VGND sg13cmos5l_decap_8
XFILLER_1_598 VPWR VGND sg13cmos5l_decap_4
X_625_ _625_/X Tile_X1Y0_N2END[1] Tile_X1Y0_N4END[1] Tile_X1Y0_NN4END[14] _095_/X
+ _170_/Q _169_/Q VPWR VGND sg13cmos5l_mux4_1
XANTENNA__138__D Tile_X0Y0_FrameData[14] VPWR VGND sg13cmos5l_antennanp
XANTENNA__161__GATE Tile_X1Y0_FrameStrobe[1] VPWR VGND sg13cmos5l_antennanp
XFILLER_12_160 VPWR VGND sg13cmos5l_decap_8
XFILLER_13_694 VPWR VGND sg13cmos5l_decap_8
X_487_ Tile_X1Y0_FrameStrobe_O[8] Tile_X1Y0_FrameStrobe[8] VPWR VGND sg13cmos5l_buf_1
X_556_ _556_/X Tile_X1Y0_N2MID[2] Tile_X1Y0_N2END[5] Tile_X1Y0_N4END[10] Tile_X1Y0_NN4END[10]
+ _136_/Q _135_/Q VPWR VGND sg13cmos5l_mux4_1
XFILLER_9_610 VPWR VGND sg13cmos5l_fill_2
XANTENNA__176__GATE Tile_X1Y0_FrameStrobe[1] VPWR VGND sg13cmos5l_antennanp
XANTENNA__451__A Tile_X0Y0_FrameData[4] VPWR VGND sg13cmos5l_antennanp
XFILLER_9_698 VPWR VGND sg13cmos5l_decap_8
XFILLER_8_142 VPWR VGND sg13cmos5l_fill_2
XFILLER_4_381 VPWR VGND sg13cmos5l_decap_4
XANTENNA__129__GATE Tile_X1Y0_FrameStrobe[0] VPWR VGND sg13cmos5l_antennanp
XANTENNA__250__CLK Tile_X0Y0_UserCLK VPWR VGND sg13cmos5l_antennanp
XFILLER_2_1056 VPWR VGND sg13cmos5l_decap_8
XFILLER_15_915 VPWR VGND sg13cmos5l_fill_2
X_272_ _272_/Q Tile_X0Y0_FrameData[17] VGND VPWR Tile_X0Y0_FrameStrobe[0] latch
X_341_ _341_/Q Tile_X0Y0_FrameData[12] VGND VPWR Tile_X0Y0_FrameStrobe[2] latch
X_410_ Tile_X0Y0_FrameStrobe_O[19] Tile_X0Y0_FrameStrobe[19] VPWR VGND sg13cmos5l_buf_1
XFILLER_10_686 VPWR VGND sg13cmos5l_fill_1
XFILLER_6_679 VPWR VGND sg13cmos5l_decap_8
XFILLER_6_646 VPWR VGND sg13cmos5l_fill_2
XFILLER_6_635 VPWR VGND sg13cmos5l_decap_8
XFILLER_5_189 VPWR VGND sg13cmos5l_decap_8
XFILLER_5_101 VPWR VGND sg13cmos5l_decap_8
XANTENNA__643__A2 Tile_X1Y0_N4END[9] VPWR VGND sg13cmos5l_antennanp
XFILLER_2_863 VPWR VGND sg13cmos5l_fill_2
XFILLER_2_852 VPWR VGND sg13cmos5l_decap_8
X_608_ _608_/X Tile_X1Y0_N2MID[0] Tile_X1Y0_N4END[15] Tile_X1Y0_NN4END[0] _089_/X
+ _204_/Q _203_/Q VPWR VGND sg13cmos5l_mux4_1
X_539_ Tile_X1Y0_SS4BEG[4] _628_/X VPWR VGND sg13cmos5l_buf_1
XANTENNA__331__D Tile_X0Y0_FrameData[22] VPWR VGND sg13cmos5l_antennanp
XANTENNA__634__A2 Tile_X1Y0_NN4END[5] VPWR VGND sg13cmos5l_antennanp
XANTENNA__570__A1 Tile_X0Y0_N4END[13] VPWR VGND sg13cmos5l_antennanp
XFILLER_3_616 VPWR VGND sg13cmos5l_decap_8
XANTENNA__086__A0 PMOD_IO_I4 VPWR VGND sg13cmos5l_antennanp
XANTENNA__625__A2 Tile_X1Y0_NN4END[14] VPWR VGND sg13cmos5l_antennanp
XANTENNA__561__A1 Tile_X0Y0_N2MID[1] VPWR VGND sg13cmos5l_antennanp
XFILLER_10_450 VPWR VGND sg13cmos5l_fill_1
XFILLER_14_233 VPWR VGND sg13cmos5l_decap_8
X_324_ _324_/Q Tile_X0Y0_FrameData[29] VGND VPWR Tile_X0Y0_FrameStrobe[2] latch
X_255_ _255_/Q Tile_X0Y0_UserCLK _556_/X _370_/L_HI VPWR VGND sg13cmos5l_dfrbpq_1
XFILLER_7_944 VPWR VGND sg13cmos5l_decap_8
XANTENNA__151__D Tile_X0Y0_FrameData[1] VPWR VGND sg13cmos5l_antennanp
X_186_ _186_/Q Tile_X0Y0_FrameData[30] VGND VPWR Tile_X1Y0_FrameStrobe[2] latch
XFILLER_9_1007 VPWR VGND sg13cmos5l_decap_8
XFILLER_6_487 VPWR VGND sg13cmos5l_decap_8
XFILLER_6_476 VPWR VGND sg13cmos5l_fill_1
XANTENNA__616__A2 Tile_X1Y0_NN4END[8] VPWR VGND sg13cmos5l_antennanp
XFILLER_2_693 VPWR VGND sg13cmos5l_fill_1
XANTENNA__326__D Tile_X0Y0_FrameData[27] VPWR VGND sg13cmos5l_antennanp
XANTENNA__463__X Tile_X1Y0_FrameData_O[16] VPWR VGND sg13cmos5l_antennanp
XANTENNA__552__A1 Tile_X0Y0_N2END[7] VPWR VGND sg13cmos5l_antennanp
XFILLER_9_292 VPWR VGND sg13cmos5l_decap_8
XANTENNA__607__A2 Tile_X1Y0_N2END[0] VPWR VGND sg13cmos5l_antennanp
XFILLER_16_509 VPWR VGND sg13cmos5l_decap_8
XFILLER_11_269 VPWR VGND sg13cmos5l_decap_8
XANTENNA__548__X Tile_X1Y0_SS4BEG[13] VPWR VGND sg13cmos5l_antennanp
XFILLER_8_1051 VPWR VGND sg13cmos5l_decap_8
XFILLER_15_564 VPWR VGND sg13cmos5l_decap_8
XANTENNA__146__D Tile_X0Y0_FrameData[6] VPWR VGND sg13cmos5l_antennanp
X_307_ _307_/Q Tile_X0Y0_FrameData[14] VGND VPWR Tile_X0Y0_FrameStrobe[1] latch
X_238_ _238_/Q Tile_X0Y0_UserCLK _238_/D _363_/L_HI VPWR VGND sg13cmos5l_dfrbpq_1
X_169_ _169_/Q Tile_X0Y0_FrameData[15] VGND VPWR Tile_X1Y0_FrameStrobe[1] latch
XFILLER_6_240 VPWR VGND sg13cmos5l_decap_4
XANTENNA__458__X Tile_X1Y0_FrameData_O[11] VPWR VGND sg13cmos5l_antennanp
XFILLER_12_512 VPWR VGND sg13cmos5l_decap_8
XFILLER_16_306 VPWR VGND sg13cmos5l_decap_8
XFILLER_12_589 VPWR VGND sg13cmos5l_decap_8
XFILLER_8_505 VPWR VGND sg13cmos5l_decap_8
XFILLER_4_755 VPWR VGND sg13cmos5l_decap_4
XFILLER_3_210 VPWR VGND sg13cmos5l_fill_2
XANTENNA__454__A Tile_X0Y0_FrameData[7] VPWR VGND sg13cmos5l_antennanp
XFILLER_15_383 VPWR VGND sg13cmos5l_fill_1
XFILLER_7_571 VPWR VGND sg13cmos5l_decap_8
XFILLER_1_725 VPWR VGND sg13cmos5l_fill_2
X_641_ _641_/X Tile_X0Y0_N2MID[3] Tile_X0Y0_N2END[4] Tile_X0Y0_N4END[11] Tile_X0Y0_NN4END[11]
+ _263_/Q _262_/Q VPWR VGND sg13cmos5l_mux4_1
X_572_ _572_/X Tile_X0Y0_N2MID[4] Tile_X0Y0_N4END[11] Tile_X0Y0_NN4END[4] _119_/X
+ _325_/Q _324_/Q VPWR VGND sg13cmos5l_mux4_1
XFILLER_5_1098 VPWR VGND sg13cmos5l_decap_8
XFILLER_12_331 VPWR VGND sg13cmos5l_decap_8
XFILLER_13_887 VPWR VGND sg13cmos5l_fill_1
XFILLER_16_125 VPWR VGND sg13cmos5l_decap_4
XFILLER_8_335 VPWR VGND sg13cmos5l_fill_1
XFILLER_0_791 VPWR VGND sg13cmos5l_fill_1
XFILLER_4_574 VPWR VGND sg13cmos5l_decap_8
XANTENNA__449__A Tile_X0Y0_FrameData[2] VPWR VGND sg13cmos5l_antennanp
XANTENNA__334__D Tile_X0Y0_FrameData[19] VPWR VGND sg13cmos5l_antennanp
XANTENNA__471__X Tile_X1Y0_FrameData_O[24] VPWR VGND sg13cmos5l_antennanp
XANTENNA__344__GATE Tile_X0Y0_FrameStrobe[2] VPWR VGND sg13cmos5l_antennanp
XFILLER_7_93 VPWR VGND sg13cmos5l_decap_8
XFILLER_13_117 VPWR VGND sg13cmos5l_decap_8
XANTENNA__381__X Tile_X0Y0_SS4BEG[6] VPWR VGND sg13cmos5l_antennanp
XFILLER_5_305 VPWR VGND sg13cmos5l_fill_2
XFILLER_1_511 VPWR VGND sg13cmos5l_decap_8
XFILLER_1_577 VPWR VGND sg13cmos5l_decap_8
X_624_ _624_/X Tile_X1Y0_N2END[0] Tile_X1Y0_N4END[0] Tile_X1Y0_NN4END[15] _064_/X
+ _172_/Q _171_/Q VPWR VGND sg13cmos5l_mux4_1
X_555_ _555_/X Tile_X1Y0_N2MID[0] Tile_X1Y0_N2END[7] Tile_X1Y0_N4END[8] Tile_X1Y0_NN4END[8]
+ _140_/Q _139_/Q VPWR VGND sg13cmos5l_mux4_1
XANTENNA__154__D Tile_X0Y0_FrameData[30] VPWR VGND sg13cmos5l_antennanp
XFILLER_13_673 VPWR VGND sg13cmos5l_decap_8
XFILLER_16_80 VPWR VGND sg13cmos5l_decap_8
XFILLER_16_91 VPWR VGND sg13cmos5l_fill_2
X_486_ Tile_X1Y0_FrameStrobe_O[7] Tile_X1Y0_FrameStrobe[7] VPWR VGND sg13cmos5l_buf_1
XFILLER_9_644 VPWR VGND sg13cmos5l_decap_8
XFILLER_9_600 VPWR VGND sg13cmos5l_decap_8
XFILLER_5_883 VPWR VGND sg13cmos5l_fill_1
XFILLER_4_393 VPWR VGND sg13cmos5l_decap_8
XANTENNA__646__A0 Tile_X1Y0_N2MID[7] VPWR VGND sg13cmos5l_antennanp
XANTENNA__329__D Tile_X0Y0_FrameData[24] VPWR VGND sg13cmos5l_antennanp
XANTENNA__466__X Tile_X1Y0_FrameData_O[19] VPWR VGND sg13cmos5l_antennanp
XANTENNA__283__GATE Tile_X0Y0_FrameStrobe[0] VPWR VGND sg13cmos5l_antennanp
XANTENNA__298__GATE Tile_X0Y0_FrameStrobe[1] VPWR VGND sg13cmos5l_antennanp
XANTENNA__637__A0 Tile_X1Y0_N2END[5] VPWR VGND sg13cmos5l_antennanp
XANTENNA__221__GATE Tile_X1Y0_FrameStrobe[0] VPWR VGND sg13cmos5l_antennanp
XANTENNA__376__X Tile_X0Y0_SS4BEG[1] VPWR VGND sg13cmos5l_antennanp
XFILLER_2_1024 VPWR VGND sg13cmos5l_decap_8
XFILLER_2_1035 VPWR VGND sg13cmos5l_fill_1
XFILLER_10_621 VPWR VGND sg13cmos5l_fill_1
XFILLER_10_632 VPWR VGND sg13cmos5l_decap_4
X_271_ _271_/Q Tile_X0Y0_FrameData[18] VGND VPWR Tile_X0Y0_FrameStrobe[0] latch
X_340_ _340_/Q Tile_X0Y0_FrameData[13] VGND VPWR Tile_X0Y0_FrameStrobe[2] latch
XFILLER_6_658 VPWR VGND sg13cmos5l_decap_8
XFILLER_5_168 VPWR VGND sg13cmos5l_fill_2
XANTENNA__628__A0 Tile_X1Y0_N2END[4] VPWR VGND sg13cmos5l_antennanp
XANTENNA__643__A3 Tile_X1Y0_NN4END[9] VPWR VGND sg13cmos5l_antennanp
XFILLER_1_363 VPWR VGND sg13cmos5l_decap_4
XANTENNA__149__D Tile_X0Y0_FrameData[3] VPWR VGND sg13cmos5l_antennanp
XFILLER_14_960 VPWR VGND sg13cmos5l_fill_1
X_538_ Tile_X1Y0_SS4BEG[3] _627_/X VPWR VGND sg13cmos5l_buf_1
X_607_ _607_/X Tile_X1Y0_N1END[3] Tile_X1Y0_N2MID[7] Tile_X1Y0_N2END[0] _085_/X _206_/Q
+ _205_/Q VPWR VGND sg13cmos5l_mux4_1
XANTENNA__462__A Tile_X0Y0_FrameData[15] VPWR VGND sg13cmos5l_antennanp
X_469_ Tile_X1Y0_FrameData_O[22] Tile_X0Y0_FrameData[22] VPWR VGND sg13cmos5l_buf_1
XANTENNA__619__A0 Tile_X1Y0_N2MID[3] VPWR VGND sg13cmos5l_antennanp
XFILLER_5_691 VPWR VGND sg13cmos5l_decap_8
XFILLER_4_94 VPWR VGND sg13cmos5l_decap_4
XFILLER_4_61 VPWR VGND sg13cmos5l_decap_4
XFILLER_4_50 VPWR VGND sg13cmos5l_fill_1
XFILLER_11_429 VPWR VGND sg13cmos5l_decap_4
XFILLER_1_1090 VPWR VGND sg13cmos5l_decap_8
XANTENNA__570__A2 Tile_X0Y0_NN4END[2] VPWR VGND sg13cmos5l_antennanp
XANTENNA__160__GATE Tile_X1Y0_FrameStrobe[1] VPWR VGND sg13cmos5l_antennanp
XFILLER_4_1119 VPWR VGND sg13cmos5l_fill_1
XANTENNA__175__GATE Tile_X1Y0_FrameStrobe[1] VPWR VGND sg13cmos5l_antennanp
XFILLER_14_212 VPWR VGND sg13cmos5l_decap_8
XANTENNA__561__A2 Tile_X0Y0_N2END[6] VPWR VGND sg13cmos5l_antennanp
XFILLER_11_996 VPWR VGND sg13cmos5l_decap_8
XFILLER_13_70 VPWR VGND sg13cmos5l_fill_2
XFILLER_13_81 VPWR VGND sg13cmos5l_decap_8
XFILLER_14_289 VPWR VGND sg13cmos5l_decap_8
X_323_ _323_/Q Tile_X0Y0_FrameData[30] VGND VPWR Tile_X0Y0_FrameStrobe[2] latch
X_254_ _254_/Q Tile_X0Y0_UserCLK _555_/X _369_/L_HI VPWR VGND sg13cmos5l_dfrbpq_1
X_185_ _185_/Q Tile_X0Y0_FrameData[31] VGND VPWR Tile_X1Y0_FrameStrobe[2] latch
XFILLER_9_39 VPWR VGND sg13cmos5l_fill_2
XFILLER_7_923 VPWR VGND sg13cmos5l_decap_8
XFILLER_7_901 VPWR VGND sg13cmos5l_decap_8
XFILLER_6_444 VPWR VGND sg13cmos5l_fill_1
XFILLER_6_466 VPWR VGND sg13cmos5l_fill_2
XFILLER_6_455 VPWR VGND sg13cmos5l_decap_8
XANTENNA__128__GATE Tile_X1Y0_FrameStrobe[0] VPWR VGND sg13cmos5l_antennanp
XANTENNA__457__A Tile_X0Y0_FrameData[10] VPWR VGND sg13cmos5l_antennanp
XFILLER_1_182 VPWR VGND sg13cmos5l_decap_8
XFILLER_14_790 VPWR VGND sg13cmos5l_fill_1
XANTENNA__240__CLK Tile_X0Y0_UserCLK VPWR VGND sg13cmos5l_antennanp
XANTENNA__342__D Tile_X0Y0_FrameData[11] VPWR VGND sg13cmos5l_antennanp
XANTENNA__552__A2 Tile_X0Y0_N4END[8] VPWR VGND sg13cmos5l_antennanp
XFILLER_9_271 VPWR VGND sg13cmos5l_decap_8
XFILLER_11_248 VPWR VGND sg13cmos5l_decap_8
XFILLER_12_738 VPWR VGND sg13cmos5l_fill_1
XFILLER_4_959 VPWR VGND sg13cmos5l_decap_8
XFILLER_3_469 VPWR VGND sg13cmos5l_decap_8
XFILLER_3_436 VPWR VGND sg13cmos5l_fill_1
XFILLER_3_425 VPWR VGND sg13cmos5l_decap_8
X_306_ _306_/Q Tile_X0Y0_FrameData[15] VGND VPWR Tile_X0Y0_FrameStrobe[1] latch
XANTENNA__162__D Tile_X0Y0_FrameData[22] VPWR VGND sg13cmos5l_antennanp
X_237_ _237_/Q Tile_X0Y0_UserCLK _237_/D _367_/L_HI VPWR VGND sg13cmos5l_dfrbpq_1
X_168_ _168_/Q Tile_X0Y0_FrameData[16] VGND VPWR Tile_X1Y0_FrameStrobe[1] latch
XFILLER_6_285 VPWR VGND sg13cmos5l_fill_1
XFILLER_6_230 VPWR VGND sg13cmos5l_fill_2
X_099_ _099_/Y _120_/A _249_/D _098_/X VPWR VGND sg13cmos5l_o21ai_1
XFILLER_3_970 VPWR VGND sg13cmos5l_decap_8
XFILLER_1_51 VPWR VGND sg13cmos5l_fill_2
XFILLER_1_95 VPWR VGND sg13cmos5l_fill_1
XANTENNA__337__D Tile_X0Y0_FrameData[16] VPWR VGND sg13cmos5l_antennanp
XANTENNA__474__X Tile_X1Y0_FrameData_O[27] VPWR VGND sg13cmos5l_antennanp
XFILLER_14_1002 VPWR VGND sg13cmos5l_decap_8
XFILLER_14_1024 VPWR VGND sg13cmos5l_fill_2
XANTENNA__384__X Tile_X0Y0_SS4BEG[9] VPWR VGND sg13cmos5l_antennanp
XFILLER_12_568 VPWR VGND sg13cmos5l_decap_8
XFILLER_4_723 VPWR VGND sg13cmos5l_decap_8
XFILLER_0_973 VPWR VGND sg13cmos5l_fill_1
XFILLER_10_71 VPWR VGND sg13cmos5l_fill_1
XFILLER_3_233 VPWR VGND sg13cmos5l_decap_8
XANTENNA__157__D Tile_X0Y0_FrameData[27] VPWR VGND sg13cmos5l_antennanp
XFILLER_15_395 VPWR VGND sg13cmos5l_decap_8
XANTENNA__470__A Tile_X0Y0_FrameData[23] VPWR VGND sg13cmos5l_antennanp
XFILLER_11_590 VPWR VGND sg13cmos5l_decap_8
XFILLER_7_550 VPWR VGND sg13cmos5l_decap_8
XANTENNA__469__X Tile_X1Y0_FrameData_O[22] VPWR VGND sg13cmos5l_antennanp
XFILLER_0_1111 VPWR VGND sg13cmos5l_fill_1
XFILLER_16_1119 VPWR VGND sg13cmos5l_fill_1
XANTENNA__379__X Tile_X0Y0_SS4BEG[4] VPWR VGND sg13cmos5l_antennanp
XFILLER_16_104 VPWR VGND sg13cmos5l_decap_8
X_640_ _640_/X Tile_X0Y0_N2MID[1] Tile_X0Y0_N2END[6] Tile_X0Y0_N4END[9] Tile_X0Y0_NN4END[9]
+ _267_/Q _266_/Q VPWR VGND sg13cmos5l_mux4_1
X_571_ _571_/X Tile_X0Y0_N2MID[3] Tile_X0Y0_N4END[12] Tile_X0Y0_NN4END[3] _092_/X
+ _327_/Q _326_/Q VPWR VGND sg13cmos5l_mux4_1
XFILLER_5_1077 VPWR VGND sg13cmos5l_decap_8
XFILLER_5_1022 VPWR VGND sg13cmos5l_fill_2
XFILLER_5_1011 VPWR VGND sg13cmos5l_fill_1
XFILLER_12_310 VPWR VGND sg13cmos5l_decap_8
XFILLER_12_387 VPWR VGND sg13cmos5l_decap_8
XFILLER_8_303 VPWR VGND sg13cmos5l_decap_8
XFILLER_4_553 VPWR VGND sg13cmos5l_decap_8
XANTENNA__465__A Tile_X0Y0_FrameData[18] VPWR VGND sg13cmos5l_antennanp
XFILLER_16_660 VPWR VGND sg13cmos5l_fill_2
XFILLER_11_1016 VPWR VGND sg13cmos5l_fill_1
XFILLER_11_1038 VPWR VGND sg13cmos5l_fill_2
XANTENNA__350__D Tile_X0Y0_FrameData[31] VPWR VGND sg13cmos5l_antennanp
XFILLER_14_619 VPWR VGND sg13cmos5l_decap_8
XFILLER_5_339 VPWR VGND sg13cmos5l_fill_2
XANTENNA__260__D Tile_X0Y0_FrameData[29] VPWR VGND sg13cmos5l_antennanp
XFILLER_1_556 VPWR VGND sg13cmos5l_decap_8
X_485_ Tile_X1Y0_FrameStrobe_O[6] Tile_X1Y0_FrameStrobe[6] VPWR VGND sg13cmos5l_buf_1
X_623_ _623_/X Tile_X1Y0_N2MID[7] Tile_X1Y0_N4END[0] Tile_X1Y0_NN4END[15] _089_/X
+ _174_/Q _173_/Q VPWR VGND sg13cmos5l_mux4_1
X_554_ _554_/X Tile_X0Y0_N2MID[4] Tile_X0Y0_N2END[3] Tile_X0Y0_N4END[12] Tile_X0Y0_NN4END[12]
+ _261_/Q _260_/Q VPWR VGND sg13cmos5l_mux4_1
XANTENNA__591__A0 Tile_X0Y0_N2END[7] VPWR VGND sg13cmos5l_antennanp
XFILLER_12_184 VPWR VGND sg13cmos5l_decap_8
XFILLER_13_652 VPWR VGND sg13cmos5l_decap_8
XANTENNA__170__D Tile_X0Y0_FrameData[14] VPWR VGND sg13cmos5l_antennanp
XANTENNA__646__A1 Tile_X1Y0_N2END[0] VPWR VGND sg13cmos5l_antennanp
XANTENNA__345__D Tile_X0Y0_FrameData[8] VPWR VGND sg13cmos5l_antennanp
XANTENNA__482__X Tile_X1Y0_FrameStrobe_O[3] VPWR VGND sg13cmos5l_antennanp
XANTENNA__582__A0 Tile_X0Y0_N2MID[6] VPWR VGND sg13cmos5l_antennanp
XANTENNA__637__A1 Tile_X1Y0_N4END[13] VPWR VGND sg13cmos5l_antennanp
XFILLER_14_427 VPWR VGND sg13cmos5l_fill_2
XFILLER_14_438 VPWR VGND sg13cmos5l_fill_1
XFILLER_2_1003 VPWR VGND sg13cmos5l_decap_8
XANTENNA__392__X Tile_X0Y0_FrameStrobe_O[1] VPWR VGND sg13cmos5l_antennanp
XANTENNA__573__A0 Tile_X0Y0_N2MID[5] VPWR VGND sg13cmos5l_antennanp
XFILLER_10_655 VPWR VGND sg13cmos5l_decap_8
XFILLER_10_666 VPWR VGND sg13cmos5l_fill_2
XFILLER_10_677 VPWR VGND sg13cmos5l_decap_8
X_270_ _270_/Q Tile_X0Y0_FrameData[19] VGND VPWR Tile_X0Y0_FrameStrobe[0] latch
XFILLER_6_604 VPWR VGND sg13cmos5l_decap_8
XANTENNA__628__A1 Tile_X1Y0_N4END[4] VPWR VGND sg13cmos5l_antennanp
XFILLER_2_821 VPWR VGND sg13cmos5l_fill_2
XANTENNA__165__D Tile_X0Y0_FrameData[19] VPWR VGND sg13cmos5l_antennanp
XANTENNA__343__GATE Tile_X0Y0_FrameStrobe[2] VPWR VGND sg13cmos5l_antennanp
XANTENNA__564__A0 Tile_X0Y0_N1END[0] VPWR VGND sg13cmos5l_antennanp
X_468_ Tile_X1Y0_FrameData_O[21] Tile_X0Y0_FrameData[21] VPWR VGND sg13cmos5l_buf_1
X_537_ Tile_X1Y0_SS4BEG[2] _626_/X VPWR VGND sg13cmos5l_buf_1
X_606_ _606_/X Tile_X1Y0_N1END[2] Tile_X1Y0_N2MID[6] Tile_X1Y0_N2END[1] _087_/X _208_/Q
+ _207_/Q VPWR VGND sg13cmos5l_mux4_1
XFILLER_13_482 VPWR VGND sg13cmos5l_decap_8
X_399_ Tile_X0Y0_FrameStrobe_O[8] Tile_X0Y0_FrameStrobe[8] VPWR VGND sg13cmos5l_buf_1
XFILLER_9_442 VPWR VGND sg13cmos5l_decap_8
XANTENNA__619__A1 Tile_X1Y0_N4END[4] VPWR VGND sg13cmos5l_antennanp
XANTENNA__477__X Tile_X1Y0_FrameData_O[30] VPWR VGND sg13cmos5l_antennanp
XANTENNA__555__A0 Tile_X1Y0_N2MID[0] VPWR VGND sg13cmos5l_antennanp
XFILLER_2_128 VPWR VGND sg13cmos5l_decap_8
XANTENNA__387__X Tile_X0Y0_SS4BEG[12] VPWR VGND sg13cmos5l_antennanp
XFILLER_14_268 VPWR VGND sg13cmos5l_decap_8
X_322_ _322_/Q Tile_X0Y0_FrameData[31] VGND VPWR Tile_X0Y0_FrameStrobe[2] latch
XFILLER_10_485 VPWR VGND sg13cmos5l_decap_8
XFILLER_11_975 VPWR VGND sg13cmos5l_fill_1
X_253_ _253_/Q Tile_X0Y0_UserCLK _554_/X _372_/L_HI VPWR VGND sg13cmos5l_dfrbpq_1
X_184_ _184_/Q Tile_X0Y0_FrameData[0] VGND VPWR Tile_X1Y0_FrameStrobe[1] latch
XFILLER_2_651 VPWR VGND sg13cmos5l_decap_4
XANTENNA__282__GATE Tile_X0Y0_FrameStrobe[0] VPWR VGND sg13cmos5l_antennanp
XANTENNA__297__GATE Tile_X0Y0_FrameStrobe[1] VPWR VGND sg13cmos5l_antennanp
XANTENNA__473__A Tile_X0Y0_FrameData[26] VPWR VGND sg13cmos5l_antennanp
XFILLER_9_250 VPWR VGND sg13cmos5l_decap_8
XANTENNA__220__GATE Tile_X1Y0_FrameStrobe[3] VPWR VGND sg13cmos5l_antennanp
XANTENNA__552__A3 Tile_X0Y0_NN4END[8] VPWR VGND sg13cmos5l_antennanp
XFILLER_3_448 VPWR VGND sg13cmos5l_decap_8
XFILLER_15_511 VPWR VGND sg13cmos5l_decap_8
XFILLER_8_1086 VPWR VGND sg13cmos5l_decap_8
XFILLER_15_544 VPWR VGND sg13cmos5l_fill_2
XFILLER_15_599 VPWR VGND sg13cmos5l_decap_8
X_305_ _305_/Q Tile_X0Y0_FrameData[16] VGND VPWR Tile_X0Y0_FrameStrobe[1] latch
X_236_ _236_/Q Tile_X0Y0_UserCLK _236_/D _366_/L_HI VPWR VGND sg13cmos5l_dfrbpq_1
X_167_ _167_/Q Tile_X0Y0_FrameData[17] VGND VPWR Tile_X1Y0_FrameStrobe[1] latch
X_098_ _098_/X _233_/Q _249_/Q VPWR VGND sg13cmos5l_or2_1
XFILLER_6_253 VPWR VGND sg13cmos5l_fill_2
XANTENNA__468__A Tile_X0Y0_FrameData[21] VPWR VGND sg13cmos5l_antennanp
XFILLER_1_63 VPWR VGND sg13cmos5l_fill_2
XANTENNA__490__X Tile_X1Y0_FrameStrobe_O[11] VPWR VGND sg13cmos5l_antennanp
XANTENNA__174__GATE Tile_X1Y0_FrameStrobe[1] VPWR VGND sg13cmos5l_antennanp
XFILLER_0_418 VPWR VGND sg13cmos5l_fill_1
XANTENNA__189__GATE Tile_X1Y0_FrameStrobe[2] VPWR VGND sg13cmos5l_antennanp
XFILLER_12_547 VPWR VGND sg13cmos5l_decap_8
XANTENNA__127__GATE Tile_X1Y0_FrameStrobe[0] VPWR VGND sg13cmos5l_antennanp
XANTENNA__263__D Tile_X0Y0_FrameData[26] VPWR VGND sg13cmos5l_antennanp
XANTENNA__173__D Tile_X0Y0_FrameData[11] VPWR VGND sg13cmos5l_antennanp
XFILLER_15_374 VPWR VGND sg13cmos5l_decap_8
X_219_ _219_/Q Tile_X0Y0_FrameData[29] VGND VPWR Tile_X1Y0_FrameStrobe[3] latch
XANTENNA__348__D Tile_X0Y0_FrameData[5] VPWR VGND sg13cmos5l_antennanp
XANTENNA__485__X Tile_X1Y0_FrameStrobe_O[6] VPWR VGND sg13cmos5l_antennanp
XFILLER_15_28 VPWR VGND sg13cmos5l_fill_1
XFILLER_15_39 VPWR VGND sg13cmos5l_fill_2
XFILLER_0_226 VPWR VGND sg13cmos5l_fill_2
XANTENNA__253__CLK Tile_X0Y0_UserCLK VPWR VGND sg13cmos5l_antennanp
XANTENNA__395__X Tile_X0Y0_FrameStrobe_O[4] VPWR VGND sg13cmos5l_antennanp
X_570_ _570_/X Tile_X0Y0_N2MID[2] Tile_X0Y0_N4END[13] Tile_X0Y0_NN4END[2] _091_/X
+ _329_/Q _328_/Q VPWR VGND sg13cmos5l_mux4_1
XFILLER_5_1056 VPWR VGND sg13cmos5l_decap_8
XFILLER_12_366 VPWR VGND sg13cmos5l_decap_8
XFILLER_9_805 VPWR VGND sg13cmos5l_decap_4
XFILLER_4_532 VPWR VGND sg13cmos5l_decap_8
XFILLER_0_782 VPWR VGND sg13cmos5l_fill_2
XANTENNA__168__D Tile_X0Y0_FrameData[16] VPWR VGND sg13cmos5l_antennanp
XFILLER_15_193 VPWR VGND sg13cmos5l_decap_8
XFILLER_16_672 VPWR VGND sg13cmos5l_fill_2
XANTENNA__481__A Tile_X1Y0_FrameStrobe[2] VPWR VGND sg13cmos5l_antennanp
XFILLER_8_893 VPWR VGND sg13cmos5l_decap_4
XFILLER_7_73 VPWR VGND sg13cmos5l_decap_8
XFILLER_7_51 VPWR VGND sg13cmos5l_fill_1
XFILLER_7_40 VPWR VGND sg13cmos5l_fill_2
XANTENNA__391__A Tile_X0Y0_FrameStrobe[0] VPWR VGND sg13cmos5l_antennanp
XFILLER_10_848 VPWR VGND sg13cmos5l_fill_1
X_622_ _622_/X Tile_X1Y0_N2MID[6] Tile_X1Y0_N4END[1] Tile_X1Y0_NN4END[14] _064_/X
+ _176_/Q _175_/Q VPWR VGND sg13cmos5l_mux4_1
XFILLER_7_1107 VPWR VGND sg13cmos5l_fill_2
XFILLER_13_631 VPWR VGND sg13cmos5l_decap_8
X_484_ Tile_X1Y0_FrameStrobe_O[5] Tile_X1Y0_FrameStrobe[5] VPWR VGND sg13cmos5l_buf_1
X_553_ _553_/X Tile_X0Y0_N2MID[2] Tile_X0Y0_N2END[5] Tile_X0Y0_N4END[10] Tile_X0Y0_NN4END[10]
+ _265_/Q _264_/Q VPWR VGND sg13cmos5l_mux4_1
XANTENNA__591__A1 Tile_X0Y0_N4END[7] VPWR VGND sg13cmos5l_antennanp
XFILLER_12_141 VPWR VGND sg13cmos5l_fill_2
XFILLER_12_174 VPWR VGND sg13cmos5l_decap_8
XFILLER_9_668 VPWR VGND sg13cmos5l_fill_2
XANTENNA__646__A2 Tile_X1Y0_N4END[15] VPWR VGND sg13cmos5l_antennanp
XFILLER_10_1083 VPWR VGND sg13cmos5l_decap_8
XFILLER_4_362 VPWR VGND sg13cmos5l_decap_4
XANTENNA__476__A Tile_X0Y0_FrameData[29] VPWR VGND sg13cmos5l_antennanp
XANTENNA__582__A1 Tile_X0Y0_N4END[1] VPWR VGND sg13cmos5l_antennanp
XFILLER_16_491 VPWR VGND sg13cmos5l_fill_1
XANTENNA__637__A2 Tile_X1Y0_NN4END[2] VPWR VGND sg13cmos5l_antennanp
XANTENNA__573__A1 Tile_X0Y0_N4END[10] VPWR VGND sg13cmos5l_antennanp
XANTENNA__271__D Tile_X0Y0_FrameData[18] VPWR VGND sg13cmos5l_antennanp
XANTENNA__628__A2 Tile_X1Y0_NN4END[11] VPWR VGND sg13cmos5l_antennanp
XFILLER_2_811 VPWR VGND sg13cmos5l_fill_2
X_605_ _605_/X Tile_X1Y0_N1END[1] Tile_X1Y0_N2MID[5] Tile_X1Y0_N2END[2] _089_/X _210_/Q
+ _209_/Q VPWR VGND sg13cmos5l_mux4_1
XANTENNA__564__A1 Tile_X0Y0_N2MID[4] VPWR VGND sg13cmos5l_antennanp
XFILLER_14_995 VPWR VGND sg13cmos5l_decap_8
X_398_ Tile_X0Y0_FrameStrobe_O[7] Tile_X0Y0_FrameStrobe[7] VPWR VGND sg13cmos5l_buf_1
X_467_ Tile_X1Y0_FrameData_O[20] Tile_X0Y0_FrameData[20] VPWR VGND sg13cmos5l_buf_1
X_536_ Tile_X1Y0_SS4BEG[1] _625_/X VPWR VGND sg13cmos5l_buf_1
XFILLER_9_421 VPWR VGND sg13cmos5l_decap_8
XANTENNA__181__D Tile_X0Y0_FrameData[3] VPWR VGND sg13cmos5l_antennanp
XFILLER_12_1101 VPWR VGND sg13cmos5l_decap_8
XFILLER_9_487 VPWR VGND sg13cmos5l_decap_8
XFILLER_9_476 VPWR VGND sg13cmos5l_fill_1
XANTENNA__619__A2 Tile_X1Y0_NN4END[11] VPWR VGND sg13cmos5l_antennanp
XFILLER_4_192 VPWR VGND sg13cmos5l_decap_8
XANTENNA__493__X Tile_X1Y0_FrameStrobe_O[14] VPWR VGND sg13cmos5l_antennanp
XANTENNA__555__A1 Tile_X1Y0_N2END[7] VPWR VGND sg13cmos5l_antennanp
XFILLER_2_107 VPWR VGND sg13cmos5l_decap_8
XANTENNA__266__D Tile_X0Y0_FrameData[23] VPWR VGND sg13cmos5l_antennanp
XFILLER_14_247 VPWR VGND sg13cmos5l_decap_8
XFILLER_15_759 VPWR VGND sg13cmos5l_fill_2
X_321_ _321_/Q Tile_X0Y0_FrameData[0] VGND VPWR Tile_X0Y0_FrameStrobe[1] latch
X_252_ _252_/Q Tile_X0Y0_UserCLK _553_/X _371_/L_HI VPWR VGND sg13cmos5l_dfrbpq_1
XFILLER_10_431 VPWR VGND sg13cmos5l_decap_8
XFILLER_10_464 VPWR VGND sg13cmos5l_fill_2
XFILLER_11_954 VPWR VGND sg13cmos5l_fill_2
X_183_ _183_/Q Tile_X0Y0_FrameData[1] VGND VPWR Tile_X1Y0_FrameStrobe[1] latch
XFILLER_7_969 VPWR VGND sg13cmos5l_fill_2
XFILLER_7_958 VPWR VGND sg13cmos5l_decap_8
XFILLER_6_413 VPWR VGND sg13cmos5l_decap_8
XFILLER_1_140 VPWR VGND sg13cmos5l_fill_1
XFILLER_1_151 VPWR VGND sg13cmos5l_decap_8
XFILLER_2_663 VPWR VGND sg13cmos5l_fill_2
XANTENNA__176__D Tile_X0Y0_FrameData[8] VPWR VGND sg13cmos5l_antennanp
XFILLER_13_280 VPWR VGND sg13cmos5l_decap_8
X_519_ Tile_X1Y0_S4BEG[0] _608_/X VPWR VGND sg13cmos5l_buf_1
XANTENNA__488__X Tile_X1Y0_FrameStrobe_O[9] VPWR VGND sg13cmos5l_antennanp
XFILLER_12_707 VPWR VGND sg13cmos5l_decap_8
XFILLER_12_718 VPWR VGND sg13cmos5l_decap_4
XANTENNA__342__GATE Tile_X0Y0_FrameStrobe[2] VPWR VGND sg13cmos5l_antennanp
XANTENNA__398__X Tile_X0Y0_FrameStrobe_O[7] VPWR VGND sg13cmos5l_antennanp
XFILLER_8_1065 VPWR VGND sg13cmos5l_decap_8
XFILLER_15_578 VPWR VGND sg13cmos5l_decap_8
X_304_ _304_/Q Tile_X0Y0_FrameData[17] VGND VPWR Tile_X0Y0_FrameStrobe[1] latch
X_235_ _235_/Q Tile_X0Y0_UserCLK _235_/D _368_/L_HI VPWR VGND sg13cmos5l_dfrbpq_1
XFILLER_10_294 VPWR VGND sg13cmos5l_fill_1
X_166_ _166_/Q Tile_X0Y0_FrameData[18] VGND VPWR Tile_X1Y0_FrameStrobe[1] latch
X_097_ _097_/X _257_/Q _558_/X _233_/Q VPWR VGND sg13cmos5l_mux2_1
XFILLER_7_799 VPWR VGND sg13cmos5l_decap_4
XFILLER_6_232 VPWR VGND sg13cmos5l_fill_1
XFILLER_3_983 VPWR VGND sg13cmos5l_decap_8
XFILLER_2_482 VPWR VGND sg13cmos5l_decap_8
XANTENNA__484__A Tile_X1Y0_FrameStrobe[5] VPWR VGND sg13cmos5l_antennanp
XFILLER_1_86 VPWR VGND sg13cmos5l_decap_8
XFILLER_14_1026 VPWR VGND sg13cmos5l_fill_1
XFILLER_14_1059 VPWR VGND sg13cmos5l_decap_8
XANTENNA__394__A Tile_X0Y0_FrameStrobe[3] VPWR VGND sg13cmos5l_antennanp
XFILLER_12_526 VPWR VGND sg13cmos5l_decap_8
XFILLER_8_519 VPWR VGND sg13cmos5l_decap_8
XANTENNA__281__GATE Tile_X0Y0_FrameStrobe[0] VPWR VGND sg13cmos5l_antennanp
XFILLER_3_268 VPWR VGND sg13cmos5l_decap_8
XANTENNA__296__GATE Tile_X0Y0_FrameStrobe[1] VPWR VGND sg13cmos5l_antennanp
XFILLER_0_920 VPWR VGND sg13cmos5l_fill_1
XFILLER_3_279 VPWR VGND sg13cmos5l_fill_2
XFILLER_15_353 VPWR VGND sg13cmos5l_fill_2
XANTENNA__234__GATE Tile_X1Y0_FrameStrobe[3] VPWR VGND sg13cmos5l_antennanp
X_218_ _218_/Q Tile_X0Y0_FrameData[30] VGND VPWR Tile_X1Y0_FrameStrobe[3] latch
X_149_ _149_/Q Tile_X0Y0_FrameData[3] VGND VPWR Tile_X1Y0_FrameStrobe[0] latch
XFILLER_7_585 VPWR VGND sg13cmos5l_decap_8
XANTENNA__479__A Tile_X1Y0_FrameStrobe[0] VPWR VGND sg13cmos5l_antennanp
XFILLER_13_1081 VPWR VGND sg13cmos5l_decap_8
XFILLER_0_1102 VPWR VGND sg13cmos5l_fill_2
XANTENNA__600__A0 Tile_X1Y0_N1END[0] VPWR VGND sg13cmos5l_antennanp
XFILLER_16_139 VPWR VGND sg13cmos5l_decap_8
XANTENNA__274__D Tile_X0Y0_FrameData[15] VPWR VGND sg13cmos5l_antennanp
XFILLER_12_345 VPWR VGND sg13cmos5l_decap_8
XFILLER_4_588 VPWR VGND sg13cmos5l_decap_8
XFILLER_4_511 VPWR VGND sg13cmos5l_decap_8
XFILLER_0_761 VPWR VGND sg13cmos5l_decap_4
XANTENNA__173__GATE Tile_X1Y0_FrameStrobe[1] VPWR VGND sg13cmos5l_antennanp
XANTENNA__184__D Tile_X0Y0_FrameData[0] VPWR VGND sg13cmos5l_antennanp
XFILLER_15_172 VPWR VGND sg13cmos5l_decap_8
XFILLER_16_684 VPWR VGND sg13cmos5l_fill_1
XFILLER_16_695 VPWR VGND sg13cmos5l_fill_2
XANTENNA__188__GATE Tile_X1Y0_FrameStrobe[2] VPWR VGND sg13cmos5l_antennanp
XANTENNA__126__GATE Tile_X1Y0_FrameStrobe[0] VPWR VGND sg13cmos5l_antennanp
XANTENNA__496__X Tile_X1Y0_FrameStrobe_O[17] VPWR VGND sg13cmos5l_antennanp
XFILLER_10_816 VPWR VGND sg13cmos5l_decap_4
XFILLER_1_525 VPWR VGND sg13cmos5l_decap_8
XFILLER_1_536 VPWR VGND sg13cmos5l_fill_2
XANTENNA__269__D Tile_X0Y0_FrameData[20] VPWR VGND sg13cmos5l_antennanp
X_621_ _621_/X Tile_X1Y0_N2MID[5] Tile_X1Y0_N4END[2] Tile_X1Y0_NN4END[13] _095_/X
+ _178_/Q _177_/Q VPWR VGND sg13cmos5l_mux4_1
XFILLER_7_1119 VPWR VGND sg13cmos5l_fill_1
XANTENNA__591__A2 Tile_X0Y0_NN4END[8] VPWR VGND sg13cmos5l_antennanp
XFILLER_12_120 VPWR VGND sg13cmos5l_decap_8
XFILLER_12_153 VPWR VGND sg13cmos5l_decap_8
XFILLER_13_610 VPWR VGND sg13cmos5l_decap_8
X_483_ Tile_X1Y0_FrameStrobe_O[4] Tile_X1Y0_FrameStrobe[4] VPWR VGND sg13cmos5l_buf_1
X_552_ _552_/X Tile_X0Y0_N2MID[0] Tile_X0Y0_N2END[7] Tile_X0Y0_N4END[8] Tile_X0Y0_NN4END[8]
+ _269_/Q _268_/Q VPWR VGND sg13cmos5l_mux4_1
XFILLER_8_102 VPWR VGND sg13cmos5l_decap_4
XFILLER_13_687 VPWR VGND sg13cmos5l_decap_8
XFILLER_9_658 VPWR VGND sg13cmos5l_decap_4
XFILLER_8_179 VPWR VGND sg13cmos5l_fill_2
XFILLER_5_853 VPWR VGND sg13cmos5l_fill_2
XANTENNA__646__A3 Tile_X1Y0_NN4END[15] VPWR VGND sg13cmos5l_antennanp
XFILLER_10_1062 VPWR VGND sg13cmos5l_decap_8
XFILLER_4_385 VPWR VGND sg13cmos5l_fill_1
XANTENNA__179__D Tile_X0Y0_FrameData[5] VPWR VGND sg13cmos5l_antennanp
XANTENNA__492__A Tile_X1Y0_FrameStrobe[13] VPWR VGND sg13cmos5l_antennanp
XANTENNA__582__A2 Tile_X0Y0_NN4END[14] VPWR VGND sg13cmos5l_antennanp
XFILLER_16_481 VPWR VGND sg13cmos5l_fill_2
XANTENNA__243__CLK Tile_X0Y0_UserCLK VPWR VGND sg13cmos5l_antennanp
XFILLER_8_680 VPWR VGND sg13cmos5l_decap_4
XANTENNA__573__A2 Tile_X0Y0_NN4END[5] VPWR VGND sg13cmos5l_antennanp
XFILLER_2_1049 VPWR VGND sg13cmos5l_decap_8
XFILLER_6_628 VPWR VGND sg13cmos5l_decap_8
XFILLER_5_138 VPWR VGND sg13cmos5l_fill_2
XFILLER_5_116 VPWR VGND sg13cmos5l_fill_2
XFILLER_1_322 VPWR VGND sg13cmos5l_fill_2
XFILLER_2_889 VPWR VGND sg13cmos5l_decap_8
XFILLER_2_823 VPWR VGND sg13cmos5l_fill_1
X_535_ Tile_X1Y0_SS4BEG[0] _624_/X VPWR VGND sg13cmos5l_buf_1
X_604_ _604_/X Tile_X1Y0_N1END[0] Tile_X1Y0_N2MID[4] Tile_X1Y0_N2END[3] _064_/X _212_/Q
+ _211_/Q VPWR VGND sg13cmos5l_mux4_1
XANTENNA__564__A2 Tile_X0Y0_N2END[3] VPWR VGND sg13cmos5l_antennanp
X_397_ Tile_X0Y0_FrameStrobe_O[6] Tile_X0Y0_FrameStrobe[6] VPWR VGND sg13cmos5l_buf_1
X_466_ Tile_X1Y0_FrameData_O[19] Tile_X0Y0_FrameData[19] VPWR VGND sg13cmos5l_buf_1
XFILLER_9_400 VPWR VGND sg13cmos5l_decap_8
XFILLER_4_171 VPWR VGND sg13cmos5l_decap_8
XANTENNA__487__A Tile_X1Y0_FrameStrobe[8] VPWR VGND sg13cmos5l_antennanp
XANTENNA__555__A2 Tile_X1Y0_N4END[8] VPWR VGND sg13cmos5l_antennanp
XFILLER_3_609 VPWR VGND sg13cmos5l_decap_8
XANTENNA__397__A Tile_X0Y0_FrameStrobe[6] VPWR VGND sg13cmos5l_antennanp
XFILLER_13_51 VPWR VGND sg13cmos5l_fill_2
XFILLER_14_226 VPWR VGND sg13cmos5l_decap_8
X_320_ _320_/Q Tile_X0Y0_FrameData[1] VGND VPWR Tile_X0Y0_FrameStrobe[1] latch
X_251_ _251_/Q Tile_X0Y0_UserCLK _552_/X _374_/L_HI VPWR VGND sg13cmos5l_dfrbpq_1
X_182_ _182_/Q Tile_X0Y0_FrameData[2] VGND VPWR Tile_X1Y0_FrameStrobe[1] latch
XFILLER_7_915 VPWR VGND sg13cmos5l_decap_4
XANTENNA__282__D Tile_X0Y0_FrameData[7] VPWR VGND sg13cmos5l_antennanp
XFILLER_13_62 VPWR VGND sg13cmos5l_fill_1
XFILLER_13_95 VPWR VGND sg13cmos5l_decap_4
XFILLER_8_0 VPWR VGND sg13cmos5l_fill_2
XFILLER_7_937 VPWR VGND sg13cmos5l_decap_8
XFILLER_6_436 VPWR VGND sg13cmos5l_decap_4
XFILLER_2_686 VPWR VGND sg13cmos5l_decap_8
X_518_ Tile_X1Y0_S2BEGb[7] _607_/X VPWR VGND sg13cmos5l_buf_1
XANTENNA__192__D Tile_X0Y0_FrameData[24] VPWR VGND sg13cmos5l_antennanp
X_449_ Tile_X1Y0_FrameData_O[2] Tile_X0Y0_FrameData[2] VPWR VGND sg13cmos5l_buf_1
XFILLER_9_285 VPWR VGND sg13cmos5l_decap_8
XFILLER_3_1111 VPWR VGND sg13cmos5l_fill_1
XFILLER_8_1044 VPWR VGND sg13cmos5l_decap_8
XFILLER_8_1022 VPWR VGND sg13cmos5l_fill_2
XANTENNA__277__D Tile_X0Y0_FrameData[12] VPWR VGND sg13cmos5l_antennanp
XFILLER_15_557 VPWR VGND sg13cmos5l_decap_8
XFILLER_10_240 VPWR VGND sg13cmos5l_decap_8
X_303_ _303_/Q Tile_X0Y0_FrameData[18] VGND VPWR Tile_X0Y0_FrameStrobe[1] latch
X_234_ _234_/Q Tile_X0Y0_FrameData[27] VGND VPWR Tile_X1Y0_FrameStrobe[3] latch
X_165_ _165_/Q Tile_X0Y0_FrameData[19] VGND VPWR Tile_X1Y0_FrameStrobe[1] latch
XFILLER_6_244 VPWR VGND sg13cmos5l_fill_1
X_096_ _249_/D _646_/X _225_/Q _232_/Q VPWR VGND sg13cmos5l_mux2_1
XANTENNA__187__D Tile_X0Y0_FrameData[29] VPWR VGND sg13cmos5l_antennanp
XFILLER_1_65 VPWR VGND sg13cmos5l_fill_1
XFILLER_14_1016 VPWR VGND sg13cmos5l_decap_4
XANTENNA__499__X Tile_X1Y0_S1BEG[0] VPWR VGND sg13cmos5l_antennanp
XFILLER_12_505 VPWR VGND sg13cmos5l_decap_8
XFILLER_10_96 VPWR VGND sg13cmos5l_fill_1
XFILLER_4_748 VPWR VGND sg13cmos5l_decap_8
XFILLER_15_332 VPWR VGND sg13cmos5l_decap_8
XFILLER_13_1060 VPWR VGND sg13cmos5l_decap_8
X_217_ _217_/Q Tile_X0Y0_FrameData[31] VGND VPWR Tile_X1Y0_FrameStrobe[3] latch
X_148_ _148_/Q Tile_X0Y0_FrameData[4] VGND VPWR Tile_X1Y0_FrameStrobe[0] latch
XFILLER_7_564 VPWR VGND sg13cmos5l_decap_8
X_079_ _246_/D _643_/X _228_/Q _232_/Q VPWR VGND sg13cmos5l_mux2_1
XANTENNA__495__A Tile_X1Y0_FrameStrobe[16] VPWR VGND sg13cmos5l_antennanp
XANTENNA__341__GATE Tile_X0Y0_FrameStrobe[2] VPWR VGND sg13cmos5l_antennanp
XANTENNA__600__A1 Tile_X1Y0_N2MID[0] VPWR VGND sg13cmos5l_antennanp
XFILLER_5_1036 VPWR VGND sg13cmos5l_fill_2
XANTENNA__309__GATE Tile_X0Y0_FrameStrobe[1] VPWR VGND sg13cmos5l_antennanp
XFILLER_12_324 VPWR VGND sg13cmos5l_decap_8
XFILLER_16_118 VPWR VGND sg13cmos5l_decap_8
XANTENNA__290__D Tile_X0Y0_FrameData[31] VPWR VGND sg13cmos5l_antennanp
XFILLER_0_751 VPWR VGND sg13cmos5l_decap_4
XFILLER_4_567 VPWR VGND sg13cmos5l_decap_8
XFILLER_16_641 VPWR VGND sg13cmos5l_decap_8
XANTENNA__594__A0 Tile_X0Y0_N2END[2] VPWR VGND sg13cmos5l_antennanp
XFILLER_15_140 VPWR VGND sg13cmos5l_fill_1
XFILLER_15_151 VPWR VGND sg13cmos5l_decap_8
XFILLER_8_851 VPWR VGND sg13cmos5l_decap_4
XFILLER_7_31 VPWR VGND sg13cmos5l_decap_4
XANTENNA__280__GATE Tile_X0Y0_FrameStrobe[0] VPWR VGND sg13cmos5l_antennanp
XANTENNA__585__A0 Tile_X0Y0_N2END[1] VPWR VGND sg13cmos5l_antennanp
XANTENNA__295__GATE Tile_X0Y0_FrameStrobe[1] VPWR VGND sg13cmos5l_antennanp
XANTENNA__233__GATE Tile_X1Y0_FrameStrobe[3] VPWR VGND sg13cmos5l_antennanp
XFILLER_1_504 VPWR VGND sg13cmos5l_decap_8
X_551_ Tile_X1Y0_UserCLKo Tile_X0Y0_UserCLK VPWR VGND sg13cmos5l_buf_1
X_620_ _620_/X Tile_X1Y0_N2MID[4] Tile_X1Y0_N4END[3] Tile_X1Y0_NN4END[12] _085_/X
+ _180_/Q _179_/Q VPWR VGND sg13cmos5l_mux4_1
XANTENNA__285__D Tile_X0Y0_FrameData[4] VPWR VGND sg13cmos5l_antennanp
XANTENNA__576__A0 Tile_X0Y0_N2MID[0] VPWR VGND sg13cmos5l_antennanp
XFILLER_13_666 VPWR VGND sg13cmos5l_decap_8
XFILLER_16_73 VPWR VGND sg13cmos5l_decap_8
X_482_ Tile_X1Y0_FrameStrobe_O[3] Tile_X1Y0_FrameStrobe[3] VPWR VGND sg13cmos5l_buf_1
XFILLER_9_637 VPWR VGND sg13cmos5l_decap_8
XFILLER_12_198 VPWR VGND sg13cmos5l_decap_8
XFILLER_0_592 VPWR VGND sg13cmos5l_fill_1
XANTENNA__195__D Tile_X0Y0_FrameData[21] VPWR VGND sg13cmos5l_antennanp
XANTENNA__567__A0 Tile_X0Y0_N1END[3] VPWR VGND sg13cmos5l_antennanp
XFILLER_16_460 VPWR VGND sg13cmos5l_decap_4
XFILLER_7_180 VPWR VGND sg13cmos5l_fill_2
XFILLER_2_1017 VPWR VGND sg13cmos5l_decap_8
XANTENNA__558__A0 Tile_X1Y0_N2MID[6] VPWR VGND sg13cmos5l_antennanp
XFILLER_10_625 VPWR VGND sg13cmos5l_decap_8
XFILLER_6_618 VPWR VGND sg13cmos5l_decap_8
XFILLER_2_813 VPWR VGND sg13cmos5l_fill_1
XANTENNA__172__GATE Tile_X1Y0_FrameStrobe[1] VPWR VGND sg13cmos5l_antennanp
XFILLER_1_378 VPWR VGND sg13cmos5l_fill_1
XFILLER_2_879 VPWR VGND sg13cmos5l_fill_2
XANTENNA__187__GATE Tile_X1Y0_FrameStrobe[2] VPWR VGND sg13cmos5l_antennanp
X_465_ Tile_X1Y0_FrameData_O[18] Tile_X0Y0_FrameData[18] VPWR VGND sg13cmos5l_buf_1
X_534_ Tile_X1Y0_S4BEG[15] _623_/X VPWR VGND sg13cmos5l_buf_1
X_603_ _603_/X Tile_X1Y0_N1END[3] Tile_X1Y0_N2MID[3] Tile_X1Y0_N2END[4] _095_/X _214_/Q
+ _213_/Q VPWR VGND sg13cmos5l_mux4_1
XANTENNA__125__GATE Tile_X1Y0_FrameStrobe[0] VPWR VGND sg13cmos5l_antennanp
XFILLER_13_496 VPWR VGND sg13cmos5l_decap_8
X_396_ Tile_X0Y0_FrameStrobe_O[5] Tile_X0Y0_FrameStrobe[5] VPWR VGND sg13cmos5l_buf_1
XFILLER_9_456 VPWR VGND sg13cmos5l_decap_8
XANTENNA__104__Y PMOD_IO_OE_O5 VPWR VGND sg13cmos5l_antennanp
XFILLER_5_684 VPWR VGND sg13cmos5l_decap_8
XFILLER_5_651 VPWR VGND sg13cmos5l_decap_4
XFILLER_4_65 VPWR VGND sg13cmos5l_fill_2
XFILLER_4_54 VPWR VGND sg13cmos5l_decap_8
XFILLER_4_87 VPWR VGND sg13cmos5l_decap_8
XANTENNA__555__A3 Tile_X1Y0_NN4END[8] VPWR VGND sg13cmos5l_antennanp
XFILLER_1_1083 VPWR VGND sg13cmos5l_decap_8
XFILLER_14_205 VPWR VGND sg13cmos5l_decap_8
XFILLER_10_400 VPWR VGND sg13cmos5l_fill_1
XFILLER_10_411 VPWR VGND sg13cmos5l_decap_8
XFILLER_11_989 VPWR VGND sg13cmos5l_decap_8
XFILLER_13_30 VPWR VGND sg13cmos5l_decap_8
X_250_ _250_/Q Tile_X0Y0_UserCLK _250_/D _373_/L_HI VPWR VGND sg13cmos5l_dfrbpq_1
X_181_ _181_/Q Tile_X0Y0_FrameData[3] VGND VPWR Tile_X1Y0_FrameStrobe[1] latch
XFILLER_10_499 VPWR VGND sg13cmos5l_decap_8
XFILLER_6_448 VPWR VGND sg13cmos5l_decap_8
XFILLER_1_175 VPWR VGND sg13cmos5l_decap_8
X_448_ Tile_X1Y0_FrameData_O[1] Tile_X0Y0_FrameData[1] VPWR VGND sg13cmos5l_buf_1
X_517_ Tile_X1Y0_S2BEGb[6] _606_/X VPWR VGND sg13cmos5l_buf_1
X_379_ Tile_X0Y0_SS4BEG[4] _588_/X VPWR VGND sg13cmos5l_buf_1
XFILLER_9_264 VPWR VGND sg13cmos5l_decap_8
XFILLER_6_982 VPWR VGND sg13cmos5l_decap_8
XANTENNA__498__A Tile_X1Y0_FrameStrobe[19] VPWR VGND sg13cmos5l_antennanp
XFILLER_11_208 VPWR VGND sg13cmos5l_decap_4
XFILLER_4_908 VPWR VGND sg13cmos5l_decap_4
XANTENNA__256__CLK Tile_X0Y0_UserCLK VPWR VGND sg13cmos5l_antennanp
XFILLER_8_1034 VPWR VGND sg13cmos5l_decap_8
XANTENNA__293__D Tile_X0Y0_FrameData[28] VPWR VGND sg13cmos5l_antennanp
XFILLER_15_525 VPWR VGND sg13cmos5l_fill_1
X_302_ _302_/Q Tile_X0Y0_FrameData[19] VGND VPWR Tile_X0Y0_FrameStrobe[1] latch
XFILLER_11_753 VPWR VGND sg13cmos5l_fill_2
X_233_ _233_/Q Tile_X0Y0_FrameData[26] VGND VPWR Tile_X1Y0_FrameStrobe[3] latch
X_164_ _164_/Q Tile_X0Y0_FrameData[20] VGND VPWR Tile_X1Y0_FrameStrobe[1] latch
X_095_ _095_/X _241_/Q _241_/D _234_/Q VPWR VGND sg13cmos5l_mux2_1
XFILLER_7_746 VPWR VGND sg13cmos5l_fill_2
XFILLER_6_223 VPWR VGND sg13cmos5l_decap_8
XFILLER_2_473 VPWR VGND sg13cmos5l_decap_4
XFILLER_3_963 VPWR VGND sg13cmos5l_decap_8
XFILLER_1_44 VPWR VGND sg13cmos5l_fill_1
XFILLER_1_99 VPWR VGND sg13cmos5l_fill_2
XFILLER_4_716 VPWR VGND sg13cmos5l_decap_8
XFILLER_3_226 VPWR VGND sg13cmos5l_decap_8
XANTENNA__288__D Tile_X0Y0_FrameData[1] VPWR VGND sg13cmos5l_antennanp
XFILLER_15_311 VPWR VGND sg13cmos5l_decap_8
XFILLER_15_355 VPWR VGND sg13cmos5l_fill_1
XFILLER_15_388 VPWR VGND sg13cmos5l_decap_8
XFILLER_11_583 VPWR VGND sg13cmos5l_decap_8
X_216_ _216_/Q Tile_X0Y0_FrameData[0] VGND VPWR Tile_X1Y0_FrameStrobe[2] latch
X_147_ _147_/Q Tile_X0Y0_FrameData[5] VGND VPWR Tile_X1Y0_FrameStrobe[0] latch
X_078_ _248_/D _645_/X _226_/Q _232_/Q VPWR VGND sg13cmos5l_mux2_1
XFILLER_7_543 VPWR VGND sg13cmos5l_decap_8
XANTENNA__112__Y PMOD_IO_O2 VPWR VGND sg13cmos5l_antennanp
XANTENNA__198__D Tile_X0Y0_FrameData[18] VPWR VGND sg13cmos5l_antennanp
XFILLER_2_281 VPWR VGND sg13cmos5l_decap_8
XFILLER_3_771 VPWR VGND sg13cmos5l_fill_2
XANTENNA__600__A2 Tile_X1Y0_N2END[7] VPWR VGND sg13cmos5l_antennanp
XFILLER_0_1115 VPWR VGND sg13cmos5l_decap_4
XFILLER_0_218 VPWR VGND sg13cmos5l_fill_1
XFILLER_5_1015 VPWR VGND sg13cmos5l_decap_8
XFILLER_12_303 VPWR VGND sg13cmos5l_decap_8
XFILLER_4_546 VPWR VGND sg13cmos5l_decap_8
XANTENNA__594__A1 Tile_X0Y0_N4END[10] VPWR VGND sg13cmos5l_antennanp
XFILLER_16_653 VPWR VGND sg13cmos5l_decap_8
XFILLER_16_697 VPWR VGND sg13cmos5l_fill_1
XFILLER_7_340 VPWR VGND sg13cmos5l_fill_1
XFILLER_16_0 VPWR VGND sg13cmos5l_fill_2
XANTENNA__585__A1 Tile_X0Y0_N4END[1] VPWR VGND sg13cmos5l_antennanp
XFILLER_4_1081 VPWR VGND sg13cmos5l_decap_8
XFILLER_1_549 VPWR VGND sg13cmos5l_decap_8
XANTENNA__576__A1 Tile_X0Y0_N4END[7] VPWR VGND sg13cmos5l_antennanp
XFILLER_13_601 VPWR VGND sg13cmos5l_decap_4
XFILLER_16_52 VPWR VGND sg13cmos5l_decap_8
X_481_ Tile_X1Y0_FrameStrobe_O[2] Tile_X1Y0_FrameStrobe[2] VPWR VGND sg13cmos5l_buf_1
X_550_ Tile_X1Y0_SS4BEG[15] _639_/X VPWR VGND sg13cmos5l_buf_1
XFILLER_13_645 VPWR VGND sg13cmos5l_decap_8
XFILLER_16_96 VPWR VGND sg13cmos5l_decap_4
XFILLER_10_1097 VPWR VGND sg13cmos5l_decap_8
XANTENNA__340__GATE Tile_X0Y0_FrameStrobe[2] VPWR VGND sg13cmos5l_antennanp
XANTENNA__567__A1 Tile_X0Y0_N2MID[7] VPWR VGND sg13cmos5l_antennanp
XANTENNA__308__GATE Tile_X0Y0_FrameStrobe[1] VPWR VGND sg13cmos5l_antennanp
XFILLER_14_409 VPWR VGND sg13cmos5l_fill_2
XANTENNA__558__A1 Tile_X1Y0_N2END[1] VPWR VGND sg13cmos5l_antennanp
XFILLER_10_648 VPWR VGND sg13cmos5l_decap_8
XFILLER_1_324 VPWR VGND sg13cmos5l_fill_1
X_602_ _602_/X Tile_X1Y0_N1END[2] Tile_X1Y0_N2MID[2] Tile_X1Y0_N2END[5] _085_/X _216_/Q
+ _215_/Q VPWR VGND sg13cmos5l_mux4_1
XANTENNA__296__D Tile_X0Y0_FrameData[25] VPWR VGND sg13cmos5l_antennanp
XFILLER_13_420 VPWR VGND sg13cmos5l_decap_8
XFILLER_13_442 VPWR VGND sg13cmos5l_decap_8
XFILLER_14_976 VPWR VGND sg13cmos5l_decap_8
X_464_ Tile_X1Y0_FrameData_O[17] Tile_X0Y0_FrameData[17] VPWR VGND sg13cmos5l_buf_1
X_533_ Tile_X1Y0_S4BEG[14] _622_/X VPWR VGND sg13cmos5l_buf_1
XFILLER_12_1115 VPWR VGND sg13cmos5l_decap_4
XFILLER_13_453 VPWR VGND sg13cmos5l_fill_2
XFILLER_13_475 VPWR VGND sg13cmos5l_decap_8
X_395_ Tile_X0Y0_FrameStrobe_O[4] Tile_X0Y0_FrameStrobe[4] VPWR VGND sg13cmos5l_buf_1
XFILLER_9_435 VPWR VGND sg13cmos5l_decap_8
XANTENNA__401__X Tile_X0Y0_FrameStrobe_O[10] VPWR VGND sg13cmos5l_antennanp
XFILLER_4_140 VPWR VGND sg13cmos5l_decap_8
XANTENNA__294__GATE Tile_X0Y0_FrameStrobe[1] VPWR VGND sg13cmos5l_antennanp
XFILLER_1_1040 VPWR VGND sg13cmos5l_fill_1
XFILLER_1_1051 VPWR VGND sg13cmos5l_fill_1
XANTENNA__232__GATE Tile_X1Y0_FrameStrobe[3] VPWR VGND sg13cmos5l_antennanp
XFILLER_1_1062 VPWR VGND sg13cmos5l_decap_8
XFILLER_9_980 VPWR VGND sg13cmos5l_decap_8
XFILLER_13_53 VPWR VGND sg13cmos5l_fill_1
XFILLER_13_75 VPWR VGND sg13cmos5l_fill_2
X_180_ _180_/Q Tile_X0Y0_FrameData[4] VGND VPWR Tile_X1Y0_FrameStrobe[1] latch
XFILLER_6_427 VPWR VGND sg13cmos5l_decap_4
XFILLER_2_622 VPWR VGND sg13cmos5l_decap_8
XFILLER_13_294 VPWR VGND sg13cmos5l_decap_8
XFILLER_14_784 VPWR VGND sg13cmos5l_fill_2
X_378_ Tile_X0Y0_SS4BEG[3] _587_/X VPWR VGND sg13cmos5l_buf_1
X_447_ Tile_X1Y0_FrameData_O[0] Tile_X0Y0_FrameData[0] VPWR VGND sg13cmos5l_buf_1
X_516_ Tile_X1Y0_S2BEGb[5] _605_/X VPWR VGND sg13cmos5l_buf_1
XANTENNA__115__Y PMOD_IO_O5 VPWR VGND sg13cmos5l_antennanp
XFILLER_6_961 VPWR VGND sg13cmos5l_decap_8
XFILLER_5_493 VPWR VGND sg13cmos5l_decap_8
XANTENNA__630__A0 Tile_X1Y0_N2END[6] VPWR VGND sg13cmos5l_antennanp
XANTENNA__171__GATE Tile_X1Y0_FrameStrobe[1] VPWR VGND sg13cmos5l_antennanp
XANTENNA__186__GATE Tile_X1Y0_FrameStrobe[2] VPWR VGND sg13cmos5l_antennanp
XFILLER_3_419 VPWR VGND sg13cmos5l_fill_2
XANTENNA__124__GATE Tile_X1Y0_FrameStrobe[0] VPWR VGND sg13cmos5l_antennanp
XANTENNA__621__A0 Tile_X1Y0_N2MID[5] VPWR VGND sg13cmos5l_antennanp
XFILLER_8_1079 VPWR VGND sg13cmos5l_decap_8
XANTENNA__139__GATE Tile_X1Y0_FrameStrobe[0] VPWR VGND sg13cmos5l_antennanp
XFILLER_15_504 VPWR VGND sg13cmos5l_decap_8
XFILLER_15_537 VPWR VGND sg13cmos5l_decap_8
X_301_ _301_/Q Tile_X0Y0_FrameData[20] VGND VPWR Tile_X0Y0_FrameStrobe[1] latch
X_232_ _232_/Q Tile_X0Y0_FrameData[25] VGND VPWR Tile_X1Y0_FrameStrobe[3] latch
X_163_ _163_/Q Tile_X0Y0_FrameData[21] VGND VPWR Tile_X1Y0_FrameStrobe[1] latch
X_094_ _241_/D PMOD_IO_I6 _558_/X _222_/Q VPWR VGND sg13cmos5l_mux2_1
XFILLER_2_430 VPWR VGND sg13cmos5l_fill_1
XFILLER_2_452 VPWR VGND sg13cmos5l_decap_8
XFILLER_2_496 VPWR VGND sg13cmos5l_decap_8
XFILLER_3_997 VPWR VGND sg13cmos5l_decap_8
XFILLER_3_942 VPWR VGND sg13cmos5l_decap_8
XANTENNA__612__A0 Tile_X1Y0_N2MID[4] VPWR VGND sg13cmos5l_antennanp
XFILLER_1_56 VPWR VGND sg13cmos5l_decap_8
XFILLER_14_581 VPWR VGND sg13cmos5l_decap_8
XANTENNA__603__A0 Tile_X1Y0_N1END[3] VPWR VGND sg13cmos5l_antennanp
XFILLER_11_551 VPWR VGND sg13cmos5l_decap_8
XFILLER_11_562 VPWR VGND sg13cmos5l_fill_2
XFILLER_15_367 VPWR VGND sg13cmos5l_decap_8
X_215_ _215_/Q Tile_X0Y0_FrameData[1] VGND VPWR Tile_X1Y0_FrameStrobe[2] latch
XFILLER_7_522 VPWR VGND sg13cmos5l_decap_8
XFILLER_13_1095 VPWR VGND sg13cmos5l_decap_8
X_146_ _146_/Q Tile_X0Y0_FrameData[6] VGND VPWR Tile_X1Y0_FrameStrobe[0] latch
X_077_ PMOD_IO_OE_O4 _223_/Q _074_/X _076_/Y VPWR VGND sg13cmos5l_a21oi_1
XFILLER_7_599 VPWR VGND sg13cmos5l_decap_8
XANTENNA__246__CLK Tile_X0Y0_UserCLK VPWR VGND sg13cmos5l_antennanp
XFILLER_5_1049 VPWR VGND sg13cmos5l_decap_8
XFILLER_5_1038 VPWR VGND sg13cmos5l_fill_1
XFILLER_5_1027 VPWR VGND sg13cmos5l_decap_4
XFILLER_12_359 VPWR VGND sg13cmos5l_decap_8
XFILLER_4_525 VPWR VGND sg13cmos5l_decap_8
XANTENNA__299__D Tile_X0Y0_FrameData[22] VPWR VGND sg13cmos5l_antennanp
XANTENNA__594__A2 Tile_X0Y0_NN4END[5] VPWR VGND sg13cmos5l_antennanp
XFILLER_15_131 VPWR VGND sg13cmos5l_decap_8
XFILLER_15_186 VPWR VGND sg13cmos5l_decap_8
XFILLER_16_621 VPWR VGND sg13cmos5l_decap_4
XFILLER_16_665 VPWR VGND sg13cmos5l_decap_4
XANTENNA__404__X Tile_X0Y0_FrameStrobe_O[13] VPWR VGND sg13cmos5l_antennanp
XFILLER_8_897 VPWR VGND sg13cmos5l_fill_2
XFILLER_7_11 VPWR VGND sg13cmos5l_fill_2
X_129_ _129_/Q Tile_X0Y0_FrameData[23] VGND VPWR Tile_X1Y0_FrameStrobe[0] latch
XFILLER_4_1060 VPWR VGND sg13cmos5l_decap_8
XANTENNA__585__A2 Tile_X0Y0_NN4END[14] VPWR VGND sg13cmos5l_antennanp
XANTENNA__576__A2 Tile_X0Y0_NN4END[8] VPWR VGND sg13cmos5l_antennanp
XFILLER_13_624 VPWR VGND sg13cmos5l_decap_8
XFILLER_16_31 VPWR VGND sg13cmos5l_decap_8
X_480_ Tile_X1Y0_FrameStrobe_O[1] Tile_X1Y0_FrameStrobe[1] VPWR VGND sg13cmos5l_buf_1
XFILLER_12_167 VPWR VGND sg13cmos5l_decap_8
XFILLER_4_300 VPWR VGND sg13cmos5l_decap_8
XFILLER_10_1076 VPWR VGND sg13cmos5l_decap_8
XFILLER_4_355 VPWR VGND sg13cmos5l_decap_8
XANTENNA__400__A Tile_X0Y0_FrameStrobe[9] VPWR VGND sg13cmos5l_antennanp
XANTENNA__567__A2 Tile_X0Y0_N2END[0] VPWR VGND sg13cmos5l_antennanp
XFILLER_16_495 VPWR VGND sg13cmos5l_decap_8
XFILLER_8_672 VPWR VGND sg13cmos5l_fill_1
XFILLER_8_650 VPWR VGND sg13cmos5l_decap_8
XFILLER_6_1111 VPWR VGND sg13cmos5l_fill_1
XFILLER_6_1100 VPWR VGND sg13cmos5l_decap_8
XANTENNA__558__A2 Tile_X1Y0_N4END[14] VPWR VGND sg13cmos5l_antennanp
XFILLER_5_108 VPWR VGND sg13cmos5l_fill_1
XFILLER_2_859 VPWR VGND sg13cmos5l_decap_4
XFILLER_2_804 VPWR VGND sg13cmos5l_decap_8
X_601_ _601_/X Tile_X1Y0_N1END[1] Tile_X1Y0_N2MID[1] Tile_X1Y0_N2END[6] _087_/X _218_/Q
+ _217_/Q VPWR VGND sg13cmos5l_mux4_1
XFILLER_13_465 VPWR VGND sg13cmos5l_decap_4
XFILLER_14_988 VPWR VGND sg13cmos5l_decap_8
X_394_ Tile_X0Y0_FrameStrobe_O[3] Tile_X0Y0_FrameStrobe[3] VPWR VGND sg13cmos5l_buf_1
X_463_ Tile_X1Y0_FrameData_O[16] Tile_X0Y0_FrameData[16] VPWR VGND sg13cmos5l_buf_1
X_532_ Tile_X1Y0_S4BEG[13] _621_/X VPWR VGND sg13cmos5l_buf_1
XFILLER_9_414 VPWR VGND sg13cmos5l_decap_8
XFILLER_9_469 VPWR VGND sg13cmos5l_decap_8
XFILLER_0_391 VPWR VGND sg13cmos5l_fill_1
XFILLER_1_870 VPWR VGND sg13cmos5l_fill_1
XFILLER_4_185 VPWR VGND sg13cmos5l_decap_8
XFILLER_16_292 VPWR VGND sg13cmos5l_decap_4
XFILLER_8_491 VPWR VGND sg13cmos5l_decap_8
XFILLER_10_446 VPWR VGND sg13cmos5l_decap_4
XFILLER_10_457 VPWR VGND sg13cmos5l_decap_8
XFILLER_11_947 VPWR VGND sg13cmos5l_decap_8
XFILLER_6_406 VPWR VGND sg13cmos5l_decap_8
XANTENNA__502__X Tile_X1Y0_S1BEG[3] VPWR VGND sg13cmos5l_antennanp
XFILLER_1_144 VPWR VGND sg13cmos5l_decap_8
XFILLER_2_601 VPWR VGND sg13cmos5l_decap_8
X_515_ Tile_X1Y0_S2BEGb[4] _604_/X VPWR VGND sg13cmos5l_buf_1
XANTENNA__307__GATE Tile_X0Y0_FrameStrobe[1] VPWR VGND sg13cmos5l_antennanp
XFILLER_13_273 VPWR VGND sg13cmos5l_decap_8
XFILLER_16_1071 VPWR VGND sg13cmos5l_decap_8
X_377_ Tile_X0Y0_SS4BEG[2] _586_/X VPWR VGND sg13cmos5l_buf_1
X_446_ Tile_X0Y0_S4BEG[15] _583_/X VPWR VGND sg13cmos5l_buf_1
XANTENNA__412__X Tile_X0Y0_S1BEG[1] VPWR VGND sg13cmos5l_antennanp
XFILLER_16_1082 VPWR VGND sg13cmos5l_decap_8
XFILLER_9_299 VPWR VGND sg13cmos5l_fill_1
XFILLER_6_940 VPWR VGND sg13cmos5l_decap_8
XFILLER_5_472 VPWR VGND sg13cmos5l_decap_8
XANTENNA__630__A1 Tile_X1Y0_N4END[6] VPWR VGND sg13cmos5l_antennanp
XFILLER_8_1058 VPWR VGND sg13cmos5l_decap_8
XFILLER_8_1014 VPWR VGND sg13cmos5l_fill_2
XANTENNA__621__A1 Tile_X1Y0_N4END[2] VPWR VGND sg13cmos5l_antennanp
X_300_ _300_/Q Tile_X0Y0_FrameData[21] VGND VPWR Tile_X0Y0_FrameStrobe[1] latch
X_231_ _231_/Q Tile_X0Y0_FrameData[24] VGND VPWR Tile_X1Y0_FrameStrobe[3] latch
X_162_ _162_/Q Tile_X0Y0_FrameData[22] VGND VPWR Tile_X1Y0_FrameStrobe[1] latch
XFILLER_7_704 VPWR VGND sg13cmos5l_decap_4
XANTENNA__293__GATE Tile_X0Y0_FrameStrobe[1] VPWR VGND sg13cmos5l_antennanp
XFILLER_10_254 VPWR VGND sg13cmos5l_decap_4
XFILLER_10_287 VPWR VGND sg13cmos5l_decap_8
X_093_ _244_/D _641_/X _230_/Q _232_/Q VPWR VGND sg13cmos5l_mux2_1
XFILLER_6_0 VPWR VGND sg13cmos5l_fill_2
XANTENNA__231__GATE Tile_X1Y0_FrameStrobe[3] VPWR VGND sg13cmos5l_antennanp
XANTENNA__612__A1 Tile_X1Y0_N4END[11] VPWR VGND sg13cmos5l_antennanp
XANTENNA__407__X Tile_X0Y0_FrameStrobe_O[16] VPWR VGND sg13cmos5l_antennanp
XFILLER_14_560 VPWR VGND sg13cmos5l_decap_8
X_429_ Tile_X0Y0_S2BEGb[6] _566_/X VPWR VGND sg13cmos5l_buf_1
XFILLER_5_291 VPWR VGND sg13cmos5l_decap_8
XANTENNA__603__A1 Tile_X1Y0_N2MID[3] VPWR VGND sg13cmos5l_antennanp
XFILLER_12_519 VPWR VGND sg13cmos5l_decap_8
XFILLER_10_11 VPWR VGND sg13cmos5l_fill_1
XFILLER_3_206 VPWR VGND sg13cmos5l_decap_4
XFILLER_0_902 VPWR VGND sg13cmos5l_fill_2
XFILLER_15_346 VPWR VGND sg13cmos5l_decap_8
XFILLER_16_825 VPWR VGND sg13cmos5l_fill_2
XFILLER_11_530 VPWR VGND sg13cmos5l_decap_8
XFILLER_13_1030 VPWR VGND sg13cmos5l_decap_8
X_214_ _214_/Q Tile_X0Y0_FrameData[2] VGND VPWR Tile_X1Y0_FrameStrobe[2] latch
X_145_ _145_/Q Tile_X0Y0_FrameData[7] VGND VPWR Tile_X1Y0_FrameStrobe[0] latch
XFILLER_7_501 VPWR VGND sg13cmos5l_decap_8
XANTENNA__403__A Tile_X0Y0_FrameStrobe[12] VPWR VGND sg13cmos5l_antennanp
XFILLER_13_1074 VPWR VGND sg13cmos5l_decap_8
X_076_ _076_/Y _120_/A _247_/D _075_/X VPWR VGND sg13cmos5l_o21ai_1
XFILLER_7_578 VPWR VGND sg13cmos5l_decap_8
XANTENNA__170__GATE Tile_X1Y0_FrameStrobe[1] VPWR VGND sg13cmos5l_antennanp
XANTENNA__185__GATE Tile_X1Y0_FrameStrobe[2] VPWR VGND sg13cmos5l_antennanp
XANTENNA__597__A0 Tile_X0Y0_N2END[5] VPWR VGND sg13cmos5l_antennanp
XANTENNA__123__GATE Tile_X1Y0_FrameStrobe[0] VPWR VGND sg13cmos5l_antennanp
XANTENNA__138__GATE Tile_X1Y0_FrameStrobe[0] VPWR VGND sg13cmos5l_antennanp
XANTENNA__588__A0 Tile_X0Y0_N2END[4] VPWR VGND sg13cmos5l_antennanp
XFILLER_12_338 VPWR VGND sg13cmos5l_decap_8
XFILLER_13_839 VPWR VGND sg13cmos5l_fill_2
XFILLER_4_504 VPWR VGND sg13cmos5l_decap_8
XANTENNA__510__X Tile_X1Y0_S2BEG[7] VPWR VGND sg13cmos5l_antennanp
XANTENNA__579__A0 Tile_X0Y0_N2MID[3] VPWR VGND sg13cmos5l_antennanp
XFILLER_0_776 VPWR VGND sg13cmos5l_fill_2
XFILLER_16_600 VPWR VGND sg13cmos5l_decap_8
XFILLER_15_110 VPWR VGND sg13cmos5l_decap_8
XFILLER_15_1103 VPWR VGND sg13cmos5l_fill_1
XFILLER_15_165 VPWR VGND sg13cmos5l_decap_8
XFILLER_16_677 VPWR VGND sg13cmos5l_decap_8
XFILLER_16_688 VPWR VGND sg13cmos5l_decap_8
XFILLER_11_382 VPWR VGND sg13cmos5l_decap_8
X_128_ _128_/Q Tile_X0Y0_FrameData[24] VGND VPWR Tile_X1Y0_FrameStrobe[0] latch
XFILLER_7_45 VPWR VGND sg13cmos5l_fill_2
XFILLER_7_375 VPWR VGND sg13cmos5l_decap_4
XANTENNA__420__X Tile_X0Y0_S2BEG[5] VPWR VGND sg13cmos5l_antennanp
X_059_ _059_/Y _246_/Q VPWR VGND sg13cmos5l_inv_1
XFILLER_3_581 VPWR VGND sg13cmos5l_decap_8
XFILLER_1_518 VPWR VGND sg13cmos5l_decap_8
XFILLER_12_113 VPWR VGND sg13cmos5l_decap_8
XFILLER_16_87 VPWR VGND sg13cmos5l_decap_4
XANTENNA__505__X Tile_X1Y0_S2BEG[2] VPWR VGND sg13cmos5l_antennanp
XFILLER_10_1022 VPWR VGND sg13cmos5l_decap_4
XFILLER_12_146 VPWR VGND sg13cmos5l_decap_8
XFILLER_8_106 VPWR VGND sg13cmos5l_fill_2
XFILLER_4_334 VPWR VGND sg13cmos5l_decap_8
XFILLER_10_1055 VPWR VGND sg13cmos5l_decap_8
XANTENNA__236__CLK Tile_X0Y0_UserCLK VPWR VGND sg13cmos5l_antennanp
XANTENNA__415__X Tile_X0Y0_S2BEG[0] VPWR VGND sg13cmos5l_antennanp
XFILLER_16_474 VPWR VGND sg13cmos5l_decap_8
XFILLER_8_684 VPWR VGND sg13cmos5l_fill_2
XANTENNA__558__A3 Tile_X1Y0_NN4END[14] VPWR VGND sg13cmos5l_antennanp
XFILLER_10_617 VPWR VGND sg13cmos5l_decap_4
XANTENNA__501__A Tile_X1Y0_N1END[1] VPWR VGND sg13cmos5l_antennanp
XFILLER_1_304 VPWR VGND sg13cmos5l_decap_4
X_531_ Tile_X1Y0_S4BEG[12] _620_/X VPWR VGND sg13cmos5l_buf_1
X_600_ _600_/X Tile_X1Y0_N1END[0] Tile_X1Y0_N2MID[0] Tile_X1Y0_N2END[7] _089_/X _220_/Q
+ _219_/Q VPWR VGND sg13cmos5l_mux4_1
XFILLER_13_433 VPWR VGND sg13cmos5l_decap_4
X_393_ Tile_X0Y0_FrameStrobe_O[2] Tile_X0Y0_FrameStrobe[2] VPWR VGND sg13cmos5l_buf_1
X_462_ Tile_X1Y0_FrameData_O[15] Tile_X0Y0_FrameData[15] VPWR VGND sg13cmos5l_buf_1
XFILLER_5_698 VPWR VGND sg13cmos5l_decap_4
XFILLER_4_164 VPWR VGND sg13cmos5l_decap_8
XANTENNA__411__A Tile_X0Y0_N1END[3] VPWR VGND sg13cmos5l_antennanp
XFILLER_4_46 VPWR VGND sg13cmos5l_decap_4
XFILLER_16_271 VPWR VGND sg13cmos5l_decap_8
XFILLER_1_1097 VPWR VGND sg13cmos5l_decap_8
XFILLER_8_470 VPWR VGND sg13cmos5l_decap_8
XFILLER_14_219 VPWR VGND sg13cmos5l_decap_8
XFILLER_7_908 VPWR VGND sg13cmos5l_decap_8
XFILLER_10_469 VPWR VGND sg13cmos5l_decap_4
XFILLER_13_44 VPWR VGND sg13cmos5l_decap_8
XFILLER_13_66 VPWR VGND sg13cmos5l_decap_4
XFILLER_13_77 VPWR VGND sg13cmos5l_fill_1
XFILLER_13_88 VPWR VGND sg13cmos5l_decap_8
XFILLER_7_919 VPWR VGND sg13cmos5l_fill_1
XFILLER_1_189 VPWR VGND sg13cmos5l_fill_2
XFILLER_14_742 VPWR VGND sg13cmos5l_fill_2
X_514_ Tile_X1Y0_S2BEGb[3] _603_/X VPWR VGND sg13cmos5l_buf_1
XANTENNA__406__A Tile_X0Y0_FrameStrobe[15] VPWR VGND sg13cmos5l_antennanp
XFILLER_13_252 VPWR VGND sg13cmos5l_decap_8
XFILLER_16_1050 VPWR VGND sg13cmos5l_decap_8
XFILLER_16_1094 VPWR VGND sg13cmos5l_decap_4
X_376_ Tile_X0Y0_SS4BEG[1] _585_/X VPWR VGND sg13cmos5l_buf_1
X_445_ Tile_X0Y0_S4BEG[14] _582_/X VPWR VGND sg13cmos5l_buf_1
XFILLER_9_278 VPWR VGND sg13cmos5l_decap_8
XFILLER_9_201 VPWR VGND sg13cmos5l_fill_2
XFILLER_6_930 VPWR VGND sg13cmos5l_fill_2
XFILLER_6_996 VPWR VGND sg13cmos5l_decap_8
XFILLER_5_451 VPWR VGND sg13cmos5l_decap_8
XANTENNA__630__A2 Tile_X1Y0_NN4END[9] VPWR VGND sg13cmos5l_antennanp
XANTENNA__201__D Tile_X0Y0_FrameData[15] VPWR VGND sg13cmos5l_antennanp
XANTENNA__621__A2 Tile_X1Y0_NN4END[13] VPWR VGND sg13cmos5l_antennanp
XFILLER_10_200 VPWR VGND sg13cmos5l_decap_4
XFILLER_10_233 VPWR VGND sg13cmos5l_decap_8
X_230_ _230_/Q Tile_X0Y0_FrameData[23] VGND VPWR Tile_X1Y0_FrameStrobe[3] latch
X_161_ _161_/Q Tile_X0Y0_FrameData[23] VGND VPWR Tile_X1Y0_FrameStrobe[1] latch
XFILLER_7_716 VPWR VGND sg13cmos5l_fill_2
XANTENNA__513__X Tile_X1Y0_S2BEGb[2] VPWR VGND sg13cmos5l_antennanp
XFILLER_2_421 VPWR VGND sg13cmos5l_decap_8
X_092_ _092_/X _235_/Q _235_/D _234_/Q VPWR VGND sg13cmos5l_mux2_1
XFILLER_3_977 VPWR VGND sg13cmos5l_fill_2
XFILLER_3_911 VPWR VGND sg13cmos5l_decap_8
XFILLER_3_900 VPWR VGND sg13cmos5l_fill_1
XFILLER_1_14 VPWR VGND sg13cmos5l_fill_2
XFILLER_1_25 VPWR VGND sg13cmos5l_fill_1
XFILLER_1_69 VPWR VGND sg13cmos5l_fill_2
XANTENNA__612__A2 Tile_X1Y0_NN4END[4] VPWR VGND sg13cmos5l_antennanp
X_428_ Tile_X0Y0_S2BEGb[5] _565_/X VPWR VGND sg13cmos5l_buf_1
XANTENNA__423__X Tile_X0Y0_S2BEGb[0] VPWR VGND sg13cmos5l_antennanp
XFILLER_14_1009 VPWR VGND sg13cmos5l_decap_8
X_359_ _359_/L_HI VPWR VGND sg13cmos5l_tiehi
XANTENNA__603__A2 Tile_X1Y0_N2END[4] VPWR VGND sg13cmos5l_antennanp
XANTENNA__306__GATE Tile_X0Y0_FrameStrobe[1] VPWR VGND sg13cmos5l_antennanp
XANTENNA__508__X Tile_X1Y0_S2BEG[5] VPWR VGND sg13cmos5l_antennanp
XFILLER_15_325 VPWR VGND sg13cmos5l_fill_2
XFILLER_13_1053 VPWR VGND sg13cmos5l_decap_8
X_213_ _213_/Q Tile_X0Y0_FrameData[3] VGND VPWR Tile_X1Y0_FrameStrobe[2] latch
X_144_ _144_/Q Tile_X0Y0_FrameData[8] VGND VPWR Tile_X1Y0_FrameStrobe[0] latch
X_075_ _075_/X _233_/Q _247_/Q VPWR VGND sg13cmos5l_or2_1
XFILLER_7_557 VPWR VGND sg13cmos5l_decap_8
XFILLER_2_273 VPWR VGND sg13cmos5l_fill_1
XANTENNA__597__A1 Tile_X0Y0_N4END[13] VPWR VGND sg13cmos5l_antennanp
XFILLER_0_1107 VPWR VGND sg13cmos5l_fill_1
XANTENNA__418__X Tile_X0Y0_S2BEG[3] VPWR VGND sg13cmos5l_antennanp
XFILLER_14_380 VPWR VGND sg13cmos5l_decap_4
XANTENNA__292__GATE Tile_X0Y0_FrameStrobe[1] VPWR VGND sg13cmos5l_antennanp
XANTENNA__588__A1 Tile_X0Y0_N4END[4] VPWR VGND sg13cmos5l_antennanp
XFILLER_12_317 VPWR VGND sg13cmos5l_decap_8
XANTENNA__230__GATE Tile_X1Y0_FrameStrobe[3] VPWR VGND sg13cmos5l_antennanp
XANTENNA__504__A Tile_X1Y0_N2MID[6] VPWR VGND sg13cmos5l_antennanp
XFILLER_0_722 VPWR VGND sg13cmos5l_fill_2
XANTENNA__579__A1 Tile_X0Y0_N4END[4] VPWR VGND sg13cmos5l_antennanp
XFILLER_15_1115 VPWR VGND sg13cmos5l_decap_4
XFILLER_15_144 VPWR VGND sg13cmos5l_decap_8
XANTENNA__414__A Tile_X0Y0_N1END[0] VPWR VGND sg13cmos5l_antennanp
XFILLER_11_361 VPWR VGND sg13cmos5l_decap_8
X_127_ _127_/Q Tile_X0Y0_FrameData[25] VGND VPWR Tile_X1Y0_FrameStrobe[0] latch
X_058_ _058_/Y _245_/Q VPWR VGND sg13cmos5l_inv_1
XFILLER_8_855 VPWR VGND sg13cmos5l_fill_2
XFILLER_7_387 VPWR VGND sg13cmos5l_decap_8
XFILLER_7_35 VPWR VGND sg13cmos5l_fill_2
XFILLER_3_560 VPWR VGND sg13cmos5l_decap_8
XFILLER_4_1095 VPWR VGND sg13cmos5l_decap_8
XFILLER_13_659 VPWR VGND sg13cmos5l_decap_8
XFILLER_16_66 VPWR VGND sg13cmos5l_decap_8
XANTENNA__184__GATE Tile_X1Y0_FrameStrobe[1] VPWR VGND sg13cmos5l_antennanp
XFILLER_5_825 VPWR VGND sg13cmos5l_decap_8
XFILLER_5_803 VPWR VGND sg13cmos5l_decap_4
XANTENNA__199__GATE Tile_X1Y0_FrameStrobe[2] VPWR VGND sg13cmos5l_antennanp
XANTENNA__521__X Tile_X1Y0_S4BEG[2] VPWR VGND sg13cmos5l_antennanp
XFILLER_0_552 VPWR VGND sg13cmos5l_fill_2
XANTENNA__122__GATE Tile_X1Y0_FrameStrobe[0] VPWR VGND sg13cmos5l_antennanp
XANTENNA__409__A Tile_X0Y0_FrameStrobe[18] VPWR VGND sg13cmos5l_antennanp
XFILLER_16_453 VPWR VGND sg13cmos5l_decap_8
XANTENNA__137__GATE Tile_X1Y0_FrameStrobe[0] VPWR VGND sg13cmos5l_antennanp
XFILLER_11_180 VPWR VGND sg13cmos5l_decap_8
XFILLER_16_486 VPWR VGND sg13cmos5l_fill_2
XANTENNA__431__X Tile_X0Y0_S4BEG[0] VPWR VGND sg13cmos5l_antennanp
XFILLER_7_173 VPWR VGND sg13cmos5l_decap_8
XFILLER_4_880 VPWR VGND sg13cmos5l_fill_2
XANTENNA__204__D Tile_X0Y0_FrameData[12] VPWR VGND sg13cmos5l_antennanp
XFILLER_1_316 VPWR VGND sg13cmos5l_fill_2
X_461_ Tile_X1Y0_FrameData_O[14] Tile_X0Y0_FrameData[14] VPWR VGND sg13cmos5l_buf_1
X_530_ Tile_X1Y0_S4BEG[11] _619_/X VPWR VGND sg13cmos5l_buf_1
XANTENNA__516__X Tile_X1Y0_S2BEGb[5] VPWR VGND sg13cmos5l_antennanp
XFILLER_13_489 VPWR VGND sg13cmos5l_decap_8
X_392_ Tile_X0Y0_FrameStrobe_O[1] Tile_X0Y0_FrameStrobe[1] VPWR VGND sg13cmos5l_buf_1
XFILLER_9_449 VPWR VGND sg13cmos5l_decap_8
XFILLER_5_655 VPWR VGND sg13cmos5l_fill_1
XFILLER_4_154 VPWR VGND sg13cmos5l_fill_2
XANTENNA__642__A0 Tile_X0Y0_N2MID[5] VPWR VGND sg13cmos5l_antennanp
XANTENNA__426__X Tile_X0Y0_S2BEGb[3] VPWR VGND sg13cmos5l_antennanp
XFILLER_1_1076 VPWR VGND sg13cmos5l_decap_8
XFILLER_9_994 VPWR VGND sg13cmos5l_decap_8
XANTENNA__633__A0 Tile_X1Y0_N2END[1] VPWR VGND sg13cmos5l_antennanp
XFILLER_10_404 VPWR VGND sg13cmos5l_decap_8
XFILLER_10_426 VPWR VGND sg13cmos5l_fill_2
XFILLER_1_113 VPWR VGND sg13cmos5l_decap_4
XANTENNA__624__A0 Tile_X1Y0_N2END[0] VPWR VGND sg13cmos5l_antennanp
XFILLER_13_231 VPWR VGND sg13cmos5l_decap_8
X_444_ Tile_X0Y0_S4BEG[13] _581_/X VPWR VGND sg13cmos5l_buf_1
X_513_ Tile_X1Y0_S2BEGb[2] _602_/X VPWR VGND sg13cmos5l_buf_1
XFILLER_10_960 VPWR VGND sg13cmos5l_fill_2
X_375_ Tile_X0Y0_SS4BEG[0] _584_/X VPWR VGND sg13cmos5l_buf_1
XFILLER_9_257 VPWR VGND sg13cmos5l_decap_8
XFILLER_9_213 VPWR VGND sg13cmos5l_fill_2
XANTENNA__422__A Tile_X0Y0_N2MID[0] VPWR VGND sg13cmos5l_antennanp
XFILLER_6_975 VPWR VGND sg13cmos5l_decap_8
XANTENNA__615__A0 Tile_X1Y0_N2MID[7] VPWR VGND sg13cmos5l_antennanp
XFILLER_0_190 VPWR VGND sg13cmos5l_fill_1
XANTENNA__249__CLK Tile_X0Y0_UserCLK VPWR VGND sg13cmos5l_antennanp
XANTENNA__606__A0 Tile_X1Y0_N1END[2] VPWR VGND sg13cmos5l_antennanp
XFILLER_8_1027 VPWR VGND sg13cmos5l_decap_8
XFILLER_15_518 VPWR VGND sg13cmos5l_decap_8
XANTENNA__507__A Tile_X1Y0_N2MID[3] VPWR VGND sg13cmos5l_antennanp
X_160_ _160_/Q Tile_X0Y0_FrameData[24] VGND VPWR Tile_X1Y0_FrameStrobe[1] latch
X_091_ _091_/X _237_/Q _237_/D _234_/Q VPWR VGND sg13cmos5l_mux2_1
XFILLER_6_249 VPWR VGND sg13cmos5l_decap_4
XFILLER_6_216 VPWR VGND sg13cmos5l_decap_8
XFILLER_2_466 VPWR VGND sg13cmos5l_decap_8
XFILLER_2_477 VPWR VGND sg13cmos5l_fill_2
XFILLER_3_956 VPWR VGND sg13cmos5l_decap_8
XANTENNA__417__A Tile_X0Y0_N2MID[5] VPWR VGND sg13cmos5l_antennanp
XFILLER_14_595 VPWR VGND sg13cmos5l_decap_8
X_358_ _358_/L_HI VPWR VGND sg13cmos5l_tiehi
X_427_ Tile_X0Y0_S2BEGb[4] _564_/X VPWR VGND sg13cmos5l_buf_1
X_289_ _289_/Q Tile_X0Y0_FrameData[0] VGND VPWR Tile_X0Y0_FrameStrobe[0] latch
XFILLER_6_750 VPWR VGND sg13cmos5l_fill_2
XANTENNA__302__D Tile_X0Y0_FrameData[19] VPWR VGND sg13cmos5l_antennanp
XFILLER_7_1082 VPWR VGND sg13cmos5l_decap_8
XANTENNA__212__D Tile_X0Y0_FrameData[4] VPWR VGND sg13cmos5l_antennanp
XFILLER_4_709 VPWR VGND sg13cmos5l_decap_8
XFILLER_3_219 VPWR VGND sg13cmos5l_decap_8
XFILLER_15_304 VPWR VGND sg13cmos5l_decap_8
X_212_ _212_/Q Tile_X0Y0_FrameData[4] VGND VPWR Tile_X1Y0_FrameStrobe[2] latch
XANTENNA__524__X Tile_X1Y0_S4BEG[5] VPWR VGND sg13cmos5l_antennanp
XFILLER_11_576 VPWR VGND sg13cmos5l_decap_8
X_143_ _143_/Q Tile_X0Y0_FrameData[9] VGND VPWR Tile_X1Y0_FrameStrobe[0] latch
X_074_ _074_/X _255_/Q _556_/X _233_/Q VPWR VGND sg13cmos5l_mux2_1
XFILLER_7_536 VPWR VGND sg13cmos5l_decap_8
XANTENNA__122__D Tile_X0Y0_FrameData[30] VPWR VGND sg13cmos5l_antennanp
XANTENNA__597__A2 Tile_X0Y0_NN4END[2] VPWR VGND sg13cmos5l_antennanp
XFILLER_0_1119 VPWR VGND sg13cmos5l_fill_1
XANTENNA__434__X Tile_X0Y0_S4BEG[3] VPWR VGND sg13cmos5l_antennanp
XFILLER_9_1100 VPWR VGND sg13cmos5l_decap_4
XANTENNA__588__A2 Tile_X0Y0_NN4END[11] VPWR VGND sg13cmos5l_antennanp
XANTENNA__207__D Tile_X0Y0_FrameData[9] VPWR VGND sg13cmos5l_antennanp
XFILLER_4_539 VPWR VGND sg13cmos5l_decap_8
XFILLER_0_778 VPWR VGND sg13cmos5l_fill_1
XANTENNA__519__X Tile_X1Y0_S4BEG[0] VPWR VGND sg13cmos5l_antennanp
XANTENNA__579__A2 Tile_X0Y0_NN4END[11] VPWR VGND sg13cmos5l_antennanp
XFILLER_7_333 VPWR VGND sg13cmos5l_decap_8
XFILLER_7_322 VPWR VGND sg13cmos5l_decap_4
X_126_ _126_/Q Tile_X0Y0_FrameData[26] VGND VPWR Tile_X1Y0_FrameStrobe[0] latch
X_057_ _120_/A _233_/Q VPWR VGND sg13cmos5l_inv_1
XFILLER_8_878 VPWR VGND sg13cmos5l_decap_4
XFILLER_7_47 VPWR VGND sg13cmos5l_fill_1
XFILLER_7_355 VPWR VGND sg13cmos5l_decap_4
XANTENNA__429__X Tile_X0Y0_S2BEGb[6] VPWR VGND sg13cmos5l_antennanp
XFILLER_15_690 VPWR VGND sg13cmos5l_decap_8
XFILLER_4_1074 VPWR VGND sg13cmos5l_decap_8
XANTENNA__305__GATE Tile_X0Y0_FrameStrobe[1] VPWR VGND sg13cmos5l_antennanp
XFILLER_12_137 VPWR VGND sg13cmos5l_decap_4
XFILLER_13_605 VPWR VGND sg13cmos5l_fill_1
XFILLER_13_638 VPWR VGND sg13cmos5l_decap_8
XFILLER_16_45 VPWR VGND sg13cmos5l_decap_8
XFILLER_4_314 VPWR VGND sg13cmos5l_decap_4
XFILLER_0_531 VPWR VGND sg13cmos5l_fill_1
XFILLER_0_564 VPWR VGND sg13cmos5l_fill_2
XFILLER_16_432 VPWR VGND sg13cmos5l_decap_4
XANTENNA__291__GATE Tile_X0Y0_FrameStrobe[1] VPWR VGND sg13cmos5l_antennanp
XFILLER_8_664 VPWR VGND sg13cmos5l_decap_4
X_109_ PMOD_IO_O0 _223_/Q _066_/X VPWR VGND sg13cmos5l_nor2b_1
XFILLER_7_196 VPWR VGND sg13cmos5l_fill_2
XANTENNA__310__D Tile_X0Y0_FrameData[11] VPWR VGND sg13cmos5l_antennanp
XANTENNA__259__GATE Tile_X0Y0_FrameStrobe[0] VPWR VGND sg13cmos5l_antennanp
XANTENNA__220__D Tile_X0Y0_FrameData[28] VPWR VGND sg13cmos5l_antennanp
XFILLER_13_413 VPWR VGND sg13cmos5l_decap_8
XFILLER_14_958 VPWR VGND sg13cmos5l_fill_2
X_391_ Tile_X0Y0_FrameStrobe_O[0] Tile_X0Y0_FrameStrobe[0] VPWR VGND sg13cmos5l_buf_1
X_460_ Tile_X1Y0_FrameData_O[13] Tile_X0Y0_FrameData[13] VPWR VGND sg13cmos5l_buf_1
XFILLER_12_1108 VPWR VGND sg13cmos5l_fill_1
XFILLER_12_1119 VPWR VGND sg13cmos5l_fill_1
XFILLER_9_428 VPWR VGND sg13cmos5l_decap_8
XFILLER_5_612 VPWR VGND sg13cmos5l_decap_8
XANTENNA__532__X Tile_X1Y0_S4BEG[13] VPWR VGND sg13cmos5l_antennanp
XFILLER_4_199 VPWR VGND sg13cmos5l_decap_8
XFILLER_4_133 VPWR VGND sg13cmos5l_decap_8
XANTENNA__130__D Tile_X0Y0_FrameData[22] VPWR VGND sg13cmos5l_antennanp
XANTENNA__642__A1 Tile_X0Y0_N2END[2] VPWR VGND sg13cmos5l_antennanp
XFILLER_1_1011 VPWR VGND sg13cmos5l_fill_2
XFILLER_16_251 VPWR VGND sg13cmos5l_decap_8
XFILLER_1_1044 VPWR VGND sg13cmos5l_fill_1
XFILLER_1_1055 VPWR VGND sg13cmos5l_decap_8
X_589_ _589_/X Tile_X0Y0_N2END[5] Tile_X0Y0_N4END[5] Tile_X0Y0_NN4END[10] _092_/X
+ _291_/Q _290_/Q VPWR VGND sg13cmos5l_mux4_1
XANTENNA__305__D Tile_X0Y0_FrameData[16] VPWR VGND sg13cmos5l_antennanp
XANTENNA__442__X Tile_X0Y0_S4BEG[11] VPWR VGND sg13cmos5l_antennanp
XFILLER_9_973 VPWR VGND sg13cmos5l_decap_8
XANTENNA__183__GATE Tile_X1Y0_FrameStrobe[1] VPWR VGND sg13cmos5l_antennanp
XANTENNA__633__A1 Tile_X1Y0_N4END[9] VPWR VGND sg13cmos5l_antennanp
XANTENNA__198__GATE Tile_X1Y0_FrameStrobe[2] VPWR VGND sg13cmos5l_antennanp
XANTENNA__215__D Tile_X0Y0_FrameData[1] VPWR VGND sg13cmos5l_antennanp
XFILLER_10_438 VPWR VGND sg13cmos5l_fill_2
XFILLER_13_57 VPWR VGND sg13cmos5l_fill_2
XFILLER_1_158 VPWR VGND sg13cmos5l_decap_4
XFILLER_2_659 VPWR VGND sg13cmos5l_decap_4
XFILLER_2_637 VPWR VGND sg13cmos5l_decap_8
XFILLER_2_615 VPWR VGND sg13cmos5l_decap_8
XANTENNA__136__GATE Tile_X1Y0_FrameStrobe[0] VPWR VGND sg13cmos5l_antennanp
XANTENNA__624__A1 Tile_X1Y0_N4END[0] VPWR VGND sg13cmos5l_antennanp
XFILLER_1_169 VPWR VGND sg13cmos5l_fill_2
XANTENNA__527__X Tile_X1Y0_S4BEG[8] VPWR VGND sg13cmos5l_antennanp
XFILLER_13_210 VPWR VGND sg13cmos5l_decap_8
XFILLER_14_700 VPWR VGND sg13cmos5l_fill_1
X_374_ _374_/L_HI VPWR VGND sg13cmos5l_tiehi
X_443_ Tile_X0Y0_S4BEG[12] _580_/X VPWR VGND sg13cmos5l_buf_1
X_512_ Tile_X1Y0_S2BEGb[1] _601_/X VPWR VGND sg13cmos5l_buf_1
XANTENNA__125__D Tile_X0Y0_FrameData[27] VPWR VGND sg13cmos5l_antennanp
XANTENNA__560__A0 Tile_X0Y0_N1END[0] VPWR VGND sg13cmos5l_antennanp
XFILLER_10_972 VPWR VGND sg13cmos5l_fill_1
XFILLER_10_983 VPWR VGND sg13cmos5l_decap_8
XFILLER_13_287 VPWR VGND sg13cmos5l_decap_8
XFILLER_6_954 VPWR VGND sg13cmos5l_decap_8
XFILLER_5_486 VPWR VGND sg13cmos5l_decap_8
XANTENNA__437__X Tile_X0Y0_S4BEG[6] VPWR VGND sg13cmos5l_antennanp
XANTENNA__615__A1 Tile_X1Y0_N4END[8] VPWR VGND sg13cmos5l_antennanp
XFILLER_5_91 VPWR VGND sg13cmos5l_fill_1
XANTENNA__606__A1 Tile_X1Y0_N2MID[6] VPWR VGND sg13cmos5l_antennanp
X_090_ _237_/D PMOD_IO_I2 _554_/X _222_/Q VPWR VGND sg13cmos5l_mux2_1
XFILLER_2_445 VPWR VGND sg13cmos5l_decap_8
XFILLER_2_489 VPWR VGND sg13cmos5l_decap_8
XFILLER_3_935 VPWR VGND sg13cmos5l_decap_8
XFILLER_14_574 VPWR VGND sg13cmos5l_decap_8
X_357_ _357_/L_HI VPWR VGND sg13cmos5l_tiehi
X_426_ Tile_X0Y0_S2BEGb[3] _563_/X VPWR VGND sg13cmos5l_buf_1
X_288_ _288_/Q Tile_X0Y0_FrameData[1] VGND VPWR Tile_X0Y0_FrameStrobe[0] latch
XFILLER_6_784 VPWR VGND sg13cmos5l_decap_4
XFILLER_5_272 VPWR VGND sg13cmos5l_decap_8
XFILLER_7_1061 VPWR VGND sg13cmos5l_decap_8
XFILLER_15_327 VPWR VGND sg13cmos5l_fill_1
XFILLER_11_544 VPWR VGND sg13cmos5l_decap_8
X_211_ _211_/Q Tile_X0Y0_FrameData[5] VGND VPWR Tile_X1Y0_FrameStrobe[2] latch
X_142_ _142_/Q Tile_X0Y0_FrameData[10] VGND VPWR Tile_X1Y0_FrameStrobe[0] latch
XFILLER_7_515 VPWR VGND sg13cmos5l_decap_8
XANTENNA__540__X Tile_X1Y0_SS4BEG[5] VPWR VGND sg13cmos5l_antennanp
XFILLER_13_1088 VPWR VGND sg13cmos5l_decap_8
X_073_ _247_/D _644_/X _227_/Q _232_/Q VPWR VGND sg13cmos5l_mux2_1
XFILLER_4_0 VPWR VGND sg13cmos5l_fill_1
XANTENNA__239__CLK Tile_X0Y0_UserCLK VPWR VGND sg13cmos5l_antennanp
XFILLER_2_297 VPWR VGND sg13cmos5l_decap_4
X_409_ Tile_X0Y0_FrameStrobe_O[18] Tile_X0Y0_FrameStrobe[18] VPWR VGND sg13cmos5l_buf_1
XANTENNA__313__D Tile_X0Y0_FrameData[8] VPWR VGND sg13cmos5l_antennanp
XANTENNA__450__X Tile_X1Y0_FrameData_O[3] VPWR VGND sg13cmos5l_antennanp
XANTENNA__223__D Tile_X0Y0_FrameData[16] VPWR VGND sg13cmos5l_antennanp
XFILLER_4_518 VPWR VGND sg13cmos5l_decap_8
XFILLER_0_724 VPWR VGND sg13cmos5l_fill_1
XFILLER_15_102 VPWR VGND sg13cmos5l_decap_4
XFILLER_15_124 VPWR VGND sg13cmos5l_decap_8
XFILLER_16_614 VPWR VGND sg13cmos5l_decap_8
XFILLER_16_625 VPWR VGND sg13cmos5l_fill_1
XFILLER_16_636 VPWR VGND sg13cmos5l_fill_2
XANTENNA__535__X Tile_X1Y0_SS4BEG[0] VPWR VGND sg13cmos5l_antennanp
XFILLER_11_396 VPWR VGND sg13cmos5l_decap_8
XFILLER_12_853 VPWR VGND sg13cmos5l_fill_1
XFILLER_15_179 VPWR VGND sg13cmos5l_decap_8
X_125_ _125_/Q Tile_X0Y0_FrameData[27] VGND VPWR Tile_X1Y0_FrameStrobe[0] latch
XANTENNA__133__D Tile_X0Y0_FrameData[19] VPWR VGND sg13cmos5l_antennanp
XFILLER_3_595 VPWR VGND sg13cmos5l_decap_8
XFILLER_4_1053 VPWR VGND sg13cmos5l_decap_8
XANTENNA__308__D Tile_X0Y0_FrameData[13] VPWR VGND sg13cmos5l_antennanp
XANTENNA__445__X Tile_X0Y0_S4BEG[14] VPWR VGND sg13cmos5l_antennanp
XFILLER_7_890 VPWR VGND sg13cmos5l_fill_1
XFILLER_13_617 VPWR VGND sg13cmos5l_decap_8
XFILLER_16_24 VPWR VGND sg13cmos5l_decap_8
XANTENNA__218__D Tile_X0Y0_FrameData[30] VPWR VGND sg13cmos5l_antennanp
XFILLER_12_127 VPWR VGND sg13cmos5l_decap_8
XFILLER_10_1003 VPWR VGND sg13cmos5l_fill_2
XFILLER_10_1069 VPWR VGND sg13cmos5l_decap_8
XFILLER_4_348 VPWR VGND sg13cmos5l_decap_8
XANTENNA__128__D Tile_X0Y0_FrameData[24] VPWR VGND sg13cmos5l_antennanp
XFILLER_16_411 VPWR VGND sg13cmos5l_decap_8
X_108_ PMOD_IO_OE_O7 _120_/A _060_/Y _107_/X _223_/Q _106_/Y VPWR VGND sg13cmos5l_a221oi_1
XFILLER_8_643 VPWR VGND sg13cmos5l_decap_8
XFILLER_8_610 VPWR VGND sg13cmos5l_decap_4
XFILLER_4_882 VPWR VGND sg13cmos5l_fill_1
XFILLER_1_318 VPWR VGND sg13cmos5l_fill_1
XANTENNA__069__Y PMOD_IO_OE_O0 VPWR VGND sg13cmos5l_antennanp
XFILLER_13_458 VPWR VGND sg13cmos5l_decap_8
XFILLER_14_948 VPWR VGND sg13cmos5l_fill_2
X_390_ Tile_X0Y0_SS4BEG[15] _599_/X VPWR VGND sg13cmos5l_buf_1
XFILLER_9_407 VPWR VGND sg13cmos5l_decap_8
XFILLER_4_101 VPWR VGND sg13cmos5l_decap_4
XFILLER_0_362 VPWR VGND sg13cmos5l_fill_1
XFILLER_4_178 VPWR VGND sg13cmos5l_decap_8
XFILLER_4_16 VPWR VGND sg13cmos5l_fill_1
XFILLER_4_156 VPWR VGND sg13cmos5l_fill_1
XANTENNA__304__GATE Tile_X0Y0_FrameStrobe[1] VPWR VGND sg13cmos5l_antennanp
XANTENNA__319__GATE Tile_X0Y0_FrameStrobe[1] VPWR VGND sg13cmos5l_antennanp
XANTENNA__642__A2 Tile_X0Y0_N4END[13] VPWR VGND sg13cmos5l_antennanp
XFILLER_16_230 VPWR VGND sg13cmos5l_decap_8
XFILLER_12_491 VPWR VGND sg13cmos5l_decap_8
XFILLER_16_285 VPWR VGND sg13cmos5l_decap_8
X_588_ _588_/X Tile_X0Y0_N2END[4] Tile_X0Y0_N4END[4] Tile_X0Y0_NN4END[11] _119_/X
+ _293_/Q _292_/Q VPWR VGND sg13cmos5l_mux4_1
XFILLER_8_440 VPWR VGND sg13cmos5l_decap_4
XFILLER_8_484 VPWR VGND sg13cmos5l_decap_8
XANTENNA__094__A0 PMOD_IO_I6 VPWR VGND sg13cmos5l_antennanp
XANTENNA__321__D Tile_X0Y0_FrameData[0] VPWR VGND sg13cmos5l_antennanp
XANTENNA__633__A2 Tile_X1Y0_NN4END[6] VPWR VGND sg13cmos5l_antennanp
XFILLER_13_14 VPWR VGND sg13cmos5l_fill_1
XANTENNA__231__D Tile_X0Y0_FrameData[24] VPWR VGND sg13cmos5l_antennanp
XFILLER_1_104 VPWR VGND sg13cmos5l_fill_2
XANTENNA__290__GATE Tile_X0Y0_FrameStrobe[1] VPWR VGND sg13cmos5l_antennanp
XANTENNA__624__A2 Tile_X1Y0_NN4END[15] VPWR VGND sg13cmos5l_antennanp
X_511_ Tile_X1Y0_S2BEGb[0] _600_/X VPWR VGND sg13cmos5l_buf_1
XFILLER_13_266 VPWR VGND sg13cmos5l_decap_8
X_373_ _373_/L_HI VPWR VGND sg13cmos5l_tiehi
X_442_ Tile_X0Y0_S4BEG[11] _579_/X VPWR VGND sg13cmos5l_buf_1
XANTENNA__543__X Tile_X1Y0_SS4BEG[8] VPWR VGND sg13cmos5l_antennanp
XANTENNA__560__A1 Tile_X0Y0_N2MID[0] VPWR VGND sg13cmos5l_antennanp
XFILLER_10_962 VPWR VGND sg13cmos5l_fill_1
XFILLER_16_1064 VPWR VGND sg13cmos5l_decap_8
XFILLER_5_465 VPWR VGND sg13cmos5l_decap_8
XANTENNA__141__D Tile_X0Y0_FrameData[11] VPWR VGND sg13cmos5l_antennanp
XANTENNA__615__A2 Tile_X1Y0_NN4END[7] VPWR VGND sg13cmos5l_antennanp
XFILLER_3_1118 VPWR VGND sg13cmos5l_fill_2
XANTENNA__316__D Tile_X0Y0_FrameData[5] VPWR VGND sg13cmos5l_antennanp
XANTENNA__453__X Tile_X1Y0_FrameData_O[6] VPWR VGND sg13cmos5l_antennanp
XFILLER_9_782 VPWR VGND sg13cmos5l_decap_8
XFILLER_8_1007 VPWR VGND sg13cmos5l_decap_8
XFILLER_5_81 VPWR VGND sg13cmos5l_decap_4
XANTENNA__606__A2 Tile_X1Y0_N2END[1] VPWR VGND sg13cmos5l_antennanp
XANTENNA__226__D Tile_X0Y0_FrameData[19] VPWR VGND sg13cmos5l_antennanp
XANTENNA__082__Y PMOD_IO_OE_O3 VPWR VGND sg13cmos5l_antennanp
XFILLER_10_247 VPWR VGND sg13cmos5l_decap_4
XFILLER_10_258 VPWR VGND sg13cmos5l_fill_1
XFILLER_7_708 VPWR VGND sg13cmos5l_fill_1
XFILLER_3_925 VPWR VGND sg13cmos5l_decap_4
XANTENNA__538__X Tile_X1Y0_SS4BEG[3] VPWR VGND sg13cmos5l_antennanp
XANTENNA__136__D Tile_X0Y0_FrameData[16] VPWR VGND sg13cmos5l_antennanp
XFILLER_14_553 VPWR VGND sg13cmos5l_decap_8
X_287_ _287_/Q Tile_X0Y0_FrameData[2] VGND VPWR Tile_X0Y0_FrameStrobe[0] latch
X_356_ _356_/L_HI VPWR VGND sg13cmos5l_tiehi
X_425_ Tile_X0Y0_S2BEGb[2] _562_/X VPWR VGND sg13cmos5l_buf_1
XANTENNA__182__GATE Tile_X1Y0_FrameStrobe[1] VPWR VGND sg13cmos5l_antennanp
XFILLER_5_251 VPWR VGND sg13cmos5l_decap_8
XANTENNA__197__GATE Tile_X1Y0_FrameStrobe[2] VPWR VGND sg13cmos5l_antennanp
XANTENNA__448__X Tile_X1Y0_FrameData_O[1] VPWR VGND sg13cmos5l_antennanp
XFILLER_1_490 VPWR VGND sg13cmos5l_decap_8
XFILLER_7_1040 VPWR VGND sg13cmos5l_decap_8
XANTENNA__135__GATE Tile_X1Y0_FrameStrobe[0] VPWR VGND sg13cmos5l_antennanp
XFILLER_10_48 VPWR VGND sg13cmos5l_fill_2
XANTENNA__077__Y PMOD_IO_OE_O4 VPWR VGND sg13cmos5l_antennanp
XFILLER_15_339 VPWR VGND sg13cmos5l_decap_8
XFILLER_11_523 VPWR VGND sg13cmos5l_decap_8
XFILLER_13_1023 VPWR VGND sg13cmos5l_decap_8
X_210_ _210_/Q Tile_X0Y0_FrameData[6] VGND VPWR Tile_X1Y0_FrameStrobe[2] latch
X_141_ _141_/Q Tile_X0Y0_FrameData[11] VGND VPWR Tile_X1Y0_FrameStrobe[0] latch
XFILLER_13_1067 VPWR VGND sg13cmos5l_decap_8
X_072_ PMOD_IO_OE_O2 _120_/A _058_/Y _071_/X _223_/Q _070_/Y VPWR VGND sg13cmos5l_a221oi_1
X_408_ Tile_X0Y0_FrameStrobe_O[17] Tile_X0Y0_FrameStrobe[17] VPWR VGND sg13cmos5l_buf_1
X_339_ _339_/Q Tile_X0Y0_FrameData[14] VGND VPWR Tile_X0Y0_FrameStrobe[2] latch
XFILLER_6_571 VPWR VGND sg13cmos5l_fill_2
XFILLER_2_93 VPWR VGND sg13cmos5l_decap_8
XFILLER_15_158 VPWR VGND sg13cmos5l_decap_8
XFILLER_16_648 VPWR VGND sg13cmos5l_fill_2
XANTENNA__551__X Tile_X1Y0_UserCLKo VPWR VGND sg13cmos5l_antennanp
XFILLER_11_331 VPWR VGND sg13cmos5l_decap_8
XFILLER_11_375 VPWR VGND sg13cmos5l_decap_8
X_124_ _124_/Q Tile_X0Y0_FrameData[28] VGND VPWR Tile_X1Y0_FrameStrobe[0] latch
XFILLER_8_814 VPWR VGND sg13cmos5l_fill_2
XFILLER_7_379 VPWR VGND sg13cmos5l_fill_1
XFILLER_7_368 VPWR VGND sg13cmos5l_decap_8
XFILLER_3_574 VPWR VGND sg13cmos5l_decap_8
XFILLER_14_191 VPWR VGND sg13cmos5l_decap_8
XANTENNA__324__D Tile_X0Y0_FrameData[29] VPWR VGND sg13cmos5l_antennanp
XANTENNA__461__X Tile_X1Y0_FrameData_O[14] VPWR VGND sg13cmos5l_antennanp
XFILLER_12_106 VPWR VGND sg13cmos5l_decap_8
XANTENNA__234__D Tile_X0Y0_FrameData[27] VPWR VGND sg13cmos5l_antennanp
XFILLER_0_500 VPWR VGND sg13cmos5l_fill_1
XFILLER_0_511 VPWR VGND sg13cmos5l_fill_1
XFILLER_10_1026 VPWR VGND sg13cmos5l_fill_1
XFILLER_10_1048 VPWR VGND sg13cmos5l_decap_8
XFILLER_0_566 VPWR VGND sg13cmos5l_fill_1
XFILLER_0_588 VPWR VGND sg13cmos5l_decap_4
XANTENNA__546__X Tile_X1Y0_SS4BEG[11] VPWR VGND sg13cmos5l_antennanp
XFILLER_12_673 VPWR VGND sg13cmos5l_fill_1
XFILLER_16_467 VPWR VGND sg13cmos5l_decap_8
XANTENNA__144__D Tile_X0Y0_FrameData[8] VPWR VGND sg13cmos5l_antennanp
XFILLER_11_172 VPWR VGND sg13cmos5l_fill_1
XFILLER_11_194 VPWR VGND sg13cmos5l_decap_8
X_107_ _107_/X _258_/Q _559_/X _233_/Q VPWR VGND sg13cmos5l_mux2_1
XANTENNA__645__A0 Tile_X1Y0_N2MID[5] VPWR VGND sg13cmos5l_antennanp
XFILLER_4_872 VPWR VGND sg13cmos5l_fill_1
XANTENNA__319__D Tile_X0Y0_FrameData[2] VPWR VGND sg13cmos5l_antennanp
XANTENNA__456__X Tile_X1Y0_FrameData_O[9] VPWR VGND sg13cmos5l_antennanp
XFILLER_1_308 VPWR VGND sg13cmos5l_fill_1
XANTENNA__636__A0 Tile_X1Y0_N2END[4] VPWR VGND sg13cmos5l_antennanp
XANTENNA__229__D Tile_X0Y0_FrameData[22] VPWR VGND sg13cmos5l_antennanp
XFILLER_13_437 VPWR VGND sg13cmos5l_fill_2
XANTENNA__627__A0 Tile_X1Y0_N2END[3] VPWR VGND sg13cmos5l_antennanp
XFILLER_4_39 VPWR VGND sg13cmos5l_decap_8
XANTENNA__139__D Tile_X0Y0_FrameData[13] VPWR VGND sg13cmos5l_antennanp
XANTENNA__642__A3 Tile_X0Y0_NN4END[13] VPWR VGND sg13cmos5l_antennanp
XFILLER_1_1024 VPWR VGND sg13cmos5l_decap_4
X_587_ _587_/X Tile_X0Y0_N2END[3] Tile_X0Y0_N4END[3] Tile_X0Y0_NN4END[12] _091_/X
+ _295_/Q _294_/Q VPWR VGND sg13cmos5l_mux4_1
XFILLER_8_463 VPWR VGND sg13cmos5l_decap_8
XANTENNA__452__A Tile_X0Y0_FrameData[5] VPWR VGND sg13cmos5l_antennanp
XFILLER_4_680 VPWR VGND sg13cmos5l_fill_1
XANTENNA__618__A0 Tile_X1Y0_N2MID[2] VPWR VGND sg13cmos5l_antennanp
XFILLER_12_0 VPWR VGND sg13cmos5l_fill_2
XFILLER_10_418 VPWR VGND sg13cmos5l_fill_2
XFILLER_13_37 VPWR VGND sg13cmos5l_decap_8
XANTENNA__609__A0 Tile_X1Y0_N2MID[1] VPWR VGND sg13cmos5l_antennanp
XFILLER_1_138 VPWR VGND sg13cmos5l_fill_2
X_441_ Tile_X0Y0_S4BEG[10] _578_/X VPWR VGND sg13cmos5l_buf_1
X_510_ Tile_X1Y0_S2BEG[7] Tile_X1Y0_N2MID[0] VPWR VGND sg13cmos5l_buf_1
XFILLER_13_245 VPWR VGND sg13cmos5l_decap_8
XFILLER_16_1043 VPWR VGND sg13cmos5l_decap_8
X_372_ _372_/L_HI VPWR VGND sg13cmos5l_tiehi
XANTENNA__560__A2 Tile_X0Y0_N2END[7] VPWR VGND sg13cmos5l_antennanp
XFILLER_10_996 VPWR VGND sg13cmos5l_decap_8
XFILLER_16_1098 VPWR VGND sg13cmos5l_fill_1
XFILLER_6_989 VPWR VGND sg13cmos5l_decap_8
XFILLER_6_923 VPWR VGND sg13cmos5l_decap_8
XFILLER_5_444 VPWR VGND sg13cmos5l_decap_8
XFILLER_5_422 VPWR VGND sg13cmos5l_fill_2
XANTENNA__447__A Tile_X0Y0_FrameData[0] VPWR VGND sg13cmos5l_antennanp
X_639_ _639_/X Tile_X1Y0_N2END[7] Tile_X1Y0_N4END[15] Tile_X1Y0_NN4END[0] _064_/X
+ _142_/Q _141_/Q VPWR VGND sg13cmos5l_mux4_1
XANTENNA__332__D Tile_X0Y0_FrameData[21] VPWR VGND sg13cmos5l_antennanp
XANTENNA__350__GATE Tile_X0Y0_FrameStrobe[0] VPWR VGND sg13cmos5l_antennanp
XANTENNA__303__GATE Tile_X0Y0_FrameStrobe[1] VPWR VGND sg13cmos5l_antennanp
XFILLER_10_204 VPWR VGND sg13cmos5l_fill_1
XFILLER_10_226 VPWR VGND sg13cmos5l_decap_8
XFILLER_11_749 VPWR VGND sg13cmos5l_decap_4
XANTENNA__318__GATE Tile_X0Y0_FrameStrobe[1] VPWR VGND sg13cmos5l_antennanp
XFILLER_3_904 VPWR VGND sg13cmos5l_decap_8
XFILLER_14_532 VPWR VGND sg13cmos5l_decap_8
X_424_ Tile_X0Y0_S2BEGb[1] _561_/X VPWR VGND sg13cmos5l_buf_1
X_286_ _286_/Q Tile_X0Y0_FrameData[3] VGND VPWR Tile_X0Y0_FrameStrobe[0] latch
X_355_ _355_/L_HI VPWR VGND sg13cmos5l_tiehi
XFILLER_6_742 VPWR VGND sg13cmos5l_fill_1
XANTENNA__152__D Tile_X0Y0_FrameData[0] VPWR VGND sg13cmos5l_antennanp
XFILLER_7_1096 VPWR VGND sg13cmos5l_decap_8
XANTENNA__327__D Tile_X0Y0_FrameData[26] VPWR VGND sg13cmos5l_antennanp
XANTENNA__464__X Tile_X1Y0_FrameData_O[17] VPWR VGND sg13cmos5l_antennanp
XFILLER_15_318 VPWR VGND sg13cmos5l_decap_8
XFILLER_11_502 VPWR VGND sg13cmos5l_decap_8
XFILLER_13_1002 VPWR VGND sg13cmos5l_decap_8
XFILLER_13_1046 VPWR VGND sg13cmos5l_decap_8
X_140_ _140_/Q Tile_X0Y0_FrameData[12] VGND VPWR Tile_X1Y0_FrameStrobe[0] latch
X_071_ _071_/X _253_/Q _554_/X _233_/Q VPWR VGND sg13cmos5l_mux2_1
XFILLER_2_211 VPWR VGND sg13cmos5l_decap_8
XFILLER_2_266 VPWR VGND sg13cmos5l_decap_8
XFILLER_2_288 VPWR VGND sg13cmos5l_fill_2
XANTENNA__549__X Tile_X1Y0_SS4BEG[14] VPWR VGND sg13cmos5l_antennanp
XANTENNA__147__D Tile_X0Y0_FrameData[5] VPWR VGND sg13cmos5l_antennanp
XFILLER_14_373 VPWR VGND sg13cmos5l_decap_8
XFILLER_14_384 VPWR VGND sg13cmos5l_fill_1
XFILLER_14_395 VPWR VGND sg13cmos5l_decap_4
X_338_ _338_/Q Tile_X0Y0_FrameData[15] VGND VPWR Tile_X0Y0_FrameStrobe[2] latch
X_407_ Tile_X0Y0_FrameStrobe_O[16] Tile_X0Y0_FrameStrobe[16] VPWR VGND sg13cmos5l_buf_1
XANTENNA__460__A Tile_X0Y0_FrameData[13] VPWR VGND sg13cmos5l_antennanp
X_269_ _269_/Q Tile_X0Y0_FrameData[20] VGND VPWR Tile_X0Y0_FrameStrobe[0] latch
XFILLER_6_583 VPWR VGND sg13cmos5l_fill_2
XFILLER_6_550 VPWR VGND sg13cmos5l_decap_8
XANTENNA__459__X Tile_X1Y0_FrameData_O[12] VPWR VGND sg13cmos5l_antennanp
XFILLER_2_72 VPWR VGND sg13cmos5l_decap_8
XANTENNA__181__GATE Tile_X1Y0_FrameStrobe[1] VPWR VGND sg13cmos5l_antennanp
XFILLER_15_1119 VPWR VGND sg13cmos5l_fill_1
XANTENNA__196__GATE Tile_X1Y0_FrameStrobe[2] VPWR VGND sg13cmos5l_antennanp
XFILLER_11_343 VPWR VGND sg13cmos5l_decap_4
XFILLER_11_354 VPWR VGND sg13cmos5l_decap_8
X_123_ _123_/Q Tile_X0Y0_FrameData[29] VGND VPWR Tile_X1Y0_FrameStrobe[0] latch
XFILLER_3_553 VPWR VGND sg13cmos5l_decap_8
XANTENNA__134__GATE Tile_X1Y0_FrameStrobe[0] VPWR VGND sg13cmos5l_antennanp
XANTENNA__149__GATE Tile_X1Y0_FrameStrobe[0] VPWR VGND sg13cmos5l_antennanp
XFILLER_4_1088 VPWR VGND sg13cmos5l_decap_8
XFILLER_4_1022 VPWR VGND sg13cmos5l_decap_8
XANTENNA__455__A Tile_X0Y0_FrameData[8] VPWR VGND sg13cmos5l_antennanp
XFILLER_14_170 VPWR VGND sg13cmos5l_decap_8
XANTENNA__340__D Tile_X0Y0_FrameData[13] VPWR VGND sg13cmos5l_antennanp
XFILLER_16_59 VPWR VGND sg13cmos5l_decap_8
XFILLER_10_1005 VPWR VGND sg13cmos5l_fill_1
XFILLER_10_1016 VPWR VGND sg13cmos5l_fill_2
XFILLER_5_818 VPWR VGND sg13cmos5l_decap_8
XFILLER_0_523 VPWR VGND sg13cmos5l_fill_1
XFILLER_0_545 VPWR VGND sg13cmos5l_decap_8
XFILLER_16_446 VPWR VGND sg13cmos5l_decap_8
XANTENNA__590__A0 Tile_X0Y0_N2END[6] VPWR VGND sg13cmos5l_antennanp
XFILLER_11_151 VPWR VGND sg13cmos5l_decap_8
XFILLER_12_652 VPWR VGND sg13cmos5l_decap_8
XFILLER_12_685 VPWR VGND sg13cmos5l_decap_4
XFILLER_7_100 VPWR VGND sg13cmos5l_fill_2
XANTENNA__160__D Tile_X0Y0_FrameData[24] VPWR VGND sg13cmos5l_antennanp
X_106_ _106_/Y _120_/A _250_/D VPWR VGND sg13cmos5l_nor2_1
XFILLER_4_851 VPWR VGND sg13cmos5l_decap_8
XFILLER_3_361 VPWR VGND sg13cmos5l_decap_8
XANTENNA__645__A1 Tile_X1Y0_N2END[2] VPWR VGND sg13cmos5l_antennanp
XANTENNA__335__D Tile_X0Y0_FrameData[18] VPWR VGND sg13cmos5l_antennanp
XANTENNA__472__X Tile_X1Y0_FrameData_O[25] VPWR VGND sg13cmos5l_antennanp
XANTENNA__581__A0 Tile_X0Y0_N2MID[5] VPWR VGND sg13cmos5l_antennanp
XANTENNA__636__A1 Tile_X1Y0_N4END[12] VPWR VGND sg13cmos5l_antennanp
XANTENNA__382__X Tile_X0Y0_SS4BEG[7] VPWR VGND sg13cmos5l_antennanp
XANTENNA__572__A0 Tile_X0Y0_N2MID[4] VPWR VGND sg13cmos5l_antennanp
XFILLER_13_427 VPWR VGND sg13cmos5l_fill_2
XFILLER_13_449 VPWR VGND sg13cmos5l_decap_4
XFILLER_4_29 VPWR VGND sg13cmos5l_decap_8
XFILLER_4_147 VPWR VGND sg13cmos5l_decap_8
XANTENNA__627__A1 Tile_X1Y0_N4END[3] VPWR VGND sg13cmos5l_antennanp
XFILLER_16_265 VPWR VGND sg13cmos5l_fill_2
XFILLER_1_1003 VPWR VGND sg13cmos5l_fill_1
XFILLER_1_1069 VPWR VGND sg13cmos5l_decap_8
X_586_ _586_/X Tile_X0Y0_N2END[2] Tile_X0Y0_N4END[2] Tile_X0Y0_NN4END[13] _092_/X
+ _297_/Q _296_/Q VPWR VGND sg13cmos5l_mux4_1
XANTENNA__155__D Tile_X0Y0_FrameData[29] VPWR VGND sg13cmos5l_antennanp
XANTENNA__563__A0 Tile_X0Y0_N1END[3] VPWR VGND sg13cmos5l_antennanp
XFILLER_9_987 VPWR VGND sg13cmos5l_decap_8
XFILLER_9_910 VPWR VGND sg13cmos5l_decap_8
XANTENNA__618__A1 Tile_X1Y0_N4END[5] VPWR VGND sg13cmos5l_antennanp
XANTENNA__467__X Tile_X1Y0_FrameData_O[20] VPWR VGND sg13cmos5l_antennanp
XANTENNA__554__A0 Tile_X0Y0_N2MID[4] VPWR VGND sg13cmos5l_antennanp
XFILLER_2_629 VPWR VGND sg13cmos5l_fill_1
XANTENNA__609__A1 Tile_X1Y0_N4END[14] VPWR VGND sg13cmos5l_antennanp
XANTENNA__377__X Tile_X0Y0_SS4BEG[2] VPWR VGND sg13cmos5l_antennanp
XFILLER_13_224 VPWR VGND sg13cmos5l_decap_8
X_371_ _371_/L_HI VPWR VGND sg13cmos5l_tiehi
X_440_ Tile_X0Y0_S4BEG[9] _577_/X VPWR VGND sg13cmos5l_buf_1
XFILLER_0_1091 VPWR VGND sg13cmos5l_fill_1
XFILLER_16_1011 VPWR VGND sg13cmos5l_decap_8
XFILLER_16_1022 VPWR VGND sg13cmos5l_decap_8
XFILLER_9_206 VPWR VGND sg13cmos5l_decap_8
XFILLER_6_902 VPWR VGND sg13cmos5l_decap_8
XFILLER_6_968 VPWR VGND sg13cmos5l_decap_8
XFILLER_0_183 VPWR VGND sg13cmos5l_decap_8
XANTENNA__463__A Tile_X0Y0_FrameData[16] VPWR VGND sg13cmos5l_antennanp
X_638_ _638_/X Tile_X1Y0_N2END[6] Tile_X1Y0_N4END[14] Tile_X1Y0_NN4END[1] _089_/X
+ _144_/Q _143_/Q VPWR VGND sg13cmos5l_mux4_1
X_569_ _569_/X Tile_X0Y0_N2MID[1] Tile_X0Y0_N4END[14] Tile_X0Y0_NN4END[1] _119_/X
+ _331_/Q _330_/Q VPWR VGND sg13cmos5l_mux4_1
XFILLER_5_990 VPWR VGND sg13cmos5l_decap_8
XFILLER_10_216 VPWR VGND sg13cmos5l_decap_8
XFILLER_11_706 VPWR VGND sg13cmos5l_fill_1
XFILLER_6_209 VPWR VGND sg13cmos5l_decap_8
XFILLER_2_459 VPWR VGND sg13cmos5l_decap_8
XFILLER_3_949 VPWR VGND sg13cmos5l_decap_8
XFILLER_14_511 VPWR VGND sg13cmos5l_decap_8
XFILLER_14_588 VPWR VGND sg13cmos5l_decap_8
X_354_ _354_/L_HI VPWR VGND sg13cmos5l_tiehi
X_423_ Tile_X0Y0_S2BEGb[0] _560_/X VPWR VGND sg13cmos5l_buf_1
XFILLER_14_81 VPWR VGND sg13cmos5l_decap_8
X_285_ _285_/Q Tile_X0Y0_FrameData[4] VGND VPWR Tile_X0Y0_FrameStrobe[0] latch
XFILLER_6_776 VPWR VGND sg13cmos5l_fill_1
XFILLER_6_710 VPWR VGND sg13cmos5l_decap_8
XFILLER_5_286 VPWR VGND sg13cmos5l_fill_2
XFILLER_2_982 VPWR VGND sg13cmos5l_fill_2
XFILLER_2_971 VPWR VGND sg13cmos5l_decap_8
XFILLER_2_960 VPWR VGND sg13cmos5l_fill_2
XANTENNA__458__A Tile_X0Y0_FrameData[11] VPWR VGND sg13cmos5l_antennanp
XFILLER_7_1075 VPWR VGND sg13cmos5l_decap_8
XANTENNA__343__D Tile_X0Y0_FrameData[10] VPWR VGND sg13cmos5l_antennanp
XANTENNA__480__X Tile_X1Y0_FrameStrobe_O[1] VPWR VGND sg13cmos5l_antennanp
XFILLER_9_592 VPWR VGND sg13cmos5l_decap_4
XANTENNA__390__X Tile_X0Y0_SS4BEG[15] VPWR VGND sg13cmos5l_antennanp
XFILLER_11_558 VPWR VGND sg13cmos5l_decap_4
X_070_ _070_/Y _120_/A _245_/D VPWR VGND sg13cmos5l_nor2_1
XFILLER_7_529 VPWR VGND sg13cmos5l_decap_8
XFILLER_14_352 VPWR VGND sg13cmos5l_decap_8
X_337_ _337_/Q Tile_X0Y0_FrameData[16] VGND VPWR Tile_X0Y0_FrameStrobe[2] latch
X_406_ Tile_X0Y0_FrameStrobe_O[15] Tile_X0Y0_FrameStrobe[15] VPWR VGND sg13cmos5l_buf_1
XANTENNA__163__D Tile_X0Y0_FrameData[21] VPWR VGND sg13cmos5l_antennanp
X_268_ _268_/Q Tile_X0Y0_FrameData[21] VGND VPWR Tile_X0Y0_FrameStrobe[0] latch
X_199_ _199_/Q Tile_X0Y0_FrameData[17] VGND VPWR Tile_X1Y0_FrameStrobe[2] latch
XFILLER_9_1104 VPWR VGND sg13cmos5l_fill_1
XFILLER_6_573 VPWR VGND sg13cmos5l_fill_1
XANTENNA__302__GATE Tile_X0Y0_FrameStrobe[1] VPWR VGND sg13cmos5l_antennanp
XFILLER_2_790 VPWR VGND sg13cmos5l_decap_8
XANTENNA__317__GATE Tile_X0Y0_FrameStrobe[1] VPWR VGND sg13cmos5l_antennanp
XANTENNA__338__D Tile_X0Y0_FrameData[15] VPWR VGND sg13cmos5l_antennanp
XANTENNA__475__X Tile_X1Y0_FrameData_O[28] VPWR VGND sg13cmos5l_antennanp
XFILLER_12_1080 VPWR VGND sg13cmos5l_decap_8
XANTENNA__385__X Tile_X0Y0_SS4BEG[10] VPWR VGND sg13cmos5l_antennanp
XFILLER_12_812 VPWR VGND sg13cmos5l_fill_2
XFILLER_12_889 VPWR VGND sg13cmos5l_fill_2
XFILLER_15_138 VPWR VGND sg13cmos5l_fill_2
XFILLER_7_315 VPWR VGND sg13cmos5l_decap_8
X_122_ _122_/Q Tile_X0Y0_FrameData[30] VGND VPWR Tile_X1Y0_FrameStrobe[0] latch
XFILLER_7_359 VPWR VGND sg13cmos5l_fill_2
XFILLER_7_348 VPWR VGND sg13cmos5l_decap_8
XFILLER_3_532 VPWR VGND sg13cmos5l_decap_8
XANTENNA__158__D Tile_X0Y0_FrameData[26] VPWR VGND sg13cmos5l_antennanp
XANTENNA__252__CLK Tile_X0Y0_UserCLK VPWR VGND sg13cmos5l_antennanp
XFILLER_4_1067 VPWR VGND sg13cmos5l_decap_8
XANTENNA__471__A Tile_X0Y0_FrameData[24] VPWR VGND sg13cmos5l_antennanp
XFILLER_15_683 VPWR VGND sg13cmos5l_decap_8
XFILLER_16_38 VPWR VGND sg13cmos5l_decap_8
XFILLER_4_318 VPWR VGND sg13cmos5l_fill_2
XFILLER_4_307 VPWR VGND sg13cmos5l_decap_8
XANTENNA__209__GATE Tile_X1Y0_FrameStrobe[2] VPWR VGND sg13cmos5l_antennanp
XFILLER_0_535 VPWR VGND sg13cmos5l_fill_1
XFILLER_0_557 VPWR VGND sg13cmos5l_decap_8
XFILLER_16_425 VPWR VGND sg13cmos5l_decap_8
XANTENNA__590__A1 Tile_X0Y0_N4END[6] VPWR VGND sg13cmos5l_antennanp
XFILLER_11_130 VPWR VGND sg13cmos5l_decap_8
XFILLER_12_631 VPWR VGND sg13cmos5l_decap_8
X_105_ _250_/D _647_/X _224_/Q _232_/Q VPWR VGND sg13cmos5l_mux2_1
XFILLER_8_668 VPWR VGND sg13cmos5l_fill_1
XFILLER_8_657 VPWR VGND sg13cmos5l_decap_8
XFILLER_7_189 VPWR VGND sg13cmos5l_decap_8
XANTENNA__645__A2 Tile_X1Y0_N4END[13] VPWR VGND sg13cmos5l_antennanp
XFILLER_6_1118 VPWR VGND sg13cmos5l_fill_2
XANTENNA__466__A Tile_X0Y0_FrameData[19] VPWR VGND sg13cmos5l_antennanp
XANTENNA__581__A1 Tile_X0Y0_N4END[2] VPWR VGND sg13cmos5l_antennanp
XANTENNA__180__GATE Tile_X1Y0_FrameStrobe[1] VPWR VGND sg13cmos5l_antennanp
XANTENNA__636__A2 Tile_X1Y0_NN4END[3] VPWR VGND sg13cmos5l_antennanp
XANTENNA__195__GATE Tile_X1Y0_FrameStrobe[2] VPWR VGND sg13cmos5l_antennanp
XFILLER_13_406 VPWR VGND sg13cmos5l_decap_8
XANTENNA__133__GATE Tile_X1Y0_FrameStrobe[0] VPWR VGND sg13cmos5l_antennanp
XANTENNA__572__A1 Tile_X0Y0_N4END[11] VPWR VGND sg13cmos5l_antennanp
XFILLER_5_605 VPWR VGND sg13cmos5l_decap_8
XANTENNA__088__A0 PMOD_IO_I3 VPWR VGND sg13cmos5l_antennanp
XANTENNA__148__GATE Tile_X1Y0_FrameStrobe[0] VPWR VGND sg13cmos5l_antennanp
XANTENNA__261__D Tile_X0Y0_FrameData[28] VPWR VGND sg13cmos5l_antennanp
XFILLER_0_310 VPWR VGND sg13cmos5l_fill_1
XANTENNA__627__A2 Tile_X1Y0_NN4END[12] VPWR VGND sg13cmos5l_antennanp
XFILLER_0_376 VPWR VGND sg13cmos5l_fill_1
XFILLER_16_244 VPWR VGND sg13cmos5l_decap_8
XFILLER_16_299 VPWR VGND sg13cmos5l_decap_8
X_585_ _585_/X Tile_X0Y0_N2END[1] Tile_X0Y0_N4END[1] Tile_X0Y0_NN4END[14] _119_/X
+ _299_/Q _298_/Q VPWR VGND sg13cmos5l_mux4_1
XANTENNA__171__D Tile_X0Y0_FrameData[13] VPWR VGND sg13cmos5l_antennanp
XANTENNA__563__A1 Tile_X0Y0_N2MID[3] VPWR VGND sg13cmos5l_antennanp
XFILLER_13_995 VPWR VGND sg13cmos5l_decap_8
XFILLER_9_966 VPWR VGND sg13cmos5l_decap_4
XFILLER_9_933 VPWR VGND sg13cmos5l_fill_2
XFILLER_9_922 VPWR VGND sg13cmos5l_decap_8
XFILLER_8_498 VPWR VGND sg13cmos5l_decap_8
XANTENNA__618__A2 Tile_X1Y0_NN4END[10] VPWR VGND sg13cmos5l_antennanp
XANTENNA__346__D Tile_X0Y0_FrameData[7] VPWR VGND sg13cmos5l_antennanp
XANTENNA__483__X Tile_X1Y0_FrameStrobe_O[4] VPWR VGND sg13cmos5l_antennanp
XANTENNA__554__A1 Tile_X0Y0_N2END[3] VPWR VGND sg13cmos5l_antennanp
XFILLER_2_608 VPWR VGND sg13cmos5l_decap_8
XANTENNA__609__A2 Tile_X1Y0_NN4END[1] VPWR VGND sg13cmos5l_antennanp
XANTENNA__393__X Tile_X0Y0_FrameStrobe_O[2] VPWR VGND sg13cmos5l_antennanp
XFILLER_13_203 VPWR VGND sg13cmos5l_decap_8
X_370_ _370_/L_HI VPWR VGND sg13cmos5l_tiehi
XFILLER_10_976 VPWR VGND sg13cmos5l_decap_8
XFILLER_16_1078 VPWR VGND sg13cmos5l_fill_1
XFILLER_16_1089 VPWR VGND sg13cmos5l_fill_2
XFILLER_6_947 VPWR VGND sg13cmos5l_decap_8
XFILLER_5_435 VPWR VGND sg13cmos5l_decap_4
XFILLER_1_696 VPWR VGND sg13cmos5l_decap_4
XFILLER_5_479 VPWR VGND sg13cmos5l_decap_8
X_637_ _637_/X Tile_X1Y0_N2END[5] Tile_X1Y0_N4END[13] Tile_X1Y0_NN4END[2] _087_/X
+ _146_/Q _145_/Q VPWR VGND sg13cmos5l_mux4_1
XANTENNA__166__D Tile_X0Y0_FrameData[18] VPWR VGND sg13cmos5l_antennanp
X_499_ Tile_X1Y0_S1BEG[0] Tile_X1Y0_N1END[3] VPWR VGND sg13cmos5l_buf_1
X_568_ _568_/X Tile_X0Y0_N2MID[0] Tile_X0Y0_N4END[15] Tile_X0Y0_NN4END[0] _092_/X
+ _333_/Q _332_/Q VPWR VGND sg13cmos5l_mux4_1
XFILLER_9_796 VPWR VGND sg13cmos5l_fill_2
XFILLER_8_284 VPWR VGND sg13cmos5l_decap_4
XFILLER_8_262 VPWR VGND sg13cmos5l_fill_1
XANTENNA__478__X Tile_X1Y0_FrameData_O[31] VPWR VGND sg13cmos5l_antennanp
XFILLER_4_490 VPWR VGND sg13cmos5l_decap_8
XFILLER_2_438 VPWR VGND sg13cmos5l_decap_8
XANTENNA__388__X Tile_X0Y0_SS4BEG[13] VPWR VGND sg13cmos5l_antennanp
XFILLER_14_567 VPWR VGND sg13cmos5l_decap_8
X_284_ _284_/Q Tile_X0Y0_FrameData[5] VGND VPWR Tile_X0Y0_FrameStrobe[0] latch
X_353_ _353_/L_HI VPWR VGND sg13cmos5l_tiehi
X_422_ Tile_X0Y0_S2BEG[7] Tile_X0Y0_N2MID[0] VPWR VGND sg13cmos5l_buf_1
XFILLER_10_740 VPWR VGND sg13cmos5l_fill_1
XFILLER_5_298 VPWR VGND sg13cmos5l_decap_8
XFILLER_5_265 VPWR VGND sg13cmos5l_decap_8
XFILLER_7_1054 VPWR VGND sg13cmos5l_decap_8
XFILLER_7_1021 VPWR VGND sg13cmos5l_decap_4
XFILLER_2_994 VPWR VGND sg13cmos5l_decap_4
XANTENNA__474__A Tile_X0Y0_FrameData[27] VPWR VGND sg13cmos5l_antennanp
XFILLER_9_571 VPWR VGND sg13cmos5l_decap_8
XFILLER_11_537 VPWR VGND sg13cmos5l_decap_8
XFILLER_13_1037 VPWR VGND sg13cmos5l_fill_2
XFILLER_7_508 VPWR VGND sg13cmos5l_decap_8
XFILLER_2_235 VPWR VGND sg13cmos5l_fill_2
XFILLER_14_331 VPWR VGND sg13cmos5l_decap_8
X_267_ _267_/Q Tile_X0Y0_FrameData[22] VGND VPWR Tile_X0Y0_FrameStrobe[0] latch
X_336_ _336_/Q Tile_X0Y0_FrameData[17] VGND VPWR Tile_X0Y0_FrameStrobe[2] latch
X_405_ Tile_X0Y0_FrameStrobe_O[14] Tile_X0Y0_FrameStrobe[14] VPWR VGND sg13cmos5l_buf_1
X_198_ _198_/Q Tile_X0Y0_FrameData[18] VGND VPWR Tile_X1Y0_FrameStrobe[2] latch
XANTENNA__469__A Tile_X0Y0_FrameData[22] VPWR VGND sg13cmos5l_antennanp
XANTENNA__491__X Tile_X1Y0_FrameStrobe_O[12] VPWR VGND sg13cmos5l_antennanp
XFILLER_15_106 VPWR VGND sg13cmos5l_fill_1
XFILLER_15_117 VPWR VGND sg13cmos5l_decap_8
XFILLER_16_607 VPWR VGND sg13cmos5l_decap_8
XFILLER_16_629 VPWR VGND sg13cmos5l_decap_8
XANTENNA__264__D Tile_X0Y0_FrameData[25] VPWR VGND sg13cmos5l_antennanp
XFILLER_11_389 VPWR VGND sg13cmos5l_decap_8
XFILLER_12_846 VPWR VGND sg13cmos5l_fill_2
X_121_ PMOD_IO_OE_O1 _120_/A _061_/Y _110_/X _223_/Q _120_/Y VPWR VGND sg13cmos5l_a221oi_1
XFILLER_11_72 VPWR VGND sg13cmos5l_decap_8
XFILLER_11_83 VPWR VGND sg13cmos5l_fill_2
XFILLER_3_588 VPWR VGND sg13cmos5l_decap_8
XFILLER_3_511 VPWR VGND sg13cmos5l_decap_8
XFILLER_4_1046 VPWR VGND sg13cmos5l_decap_8
XFILLER_4_1002 VPWR VGND sg13cmos5l_decap_4
XFILLER_15_662 VPWR VGND sg13cmos5l_decap_8
XANTENNA__174__D Tile_X0Y0_FrameData[10] VPWR VGND sg13cmos5l_antennanp
X_319_ _319_/Q Tile_X0Y0_FrameData[2] VGND VPWR Tile_X0Y0_FrameStrobe[1] latch
XFILLER_7_894 VPWR VGND sg13cmos5l_decap_8
XFILLER_7_883 VPWR VGND sg13cmos5l_decap_8
XFILLER_6_382 VPWR VGND sg13cmos5l_fill_2
XANTENNA__349__D Tile_X0Y0_FrameData[4] VPWR VGND sg13cmos5l_antennanp
XANTENNA__486__X Tile_X1Y0_FrameStrobe_O[7] VPWR VGND sg13cmos5l_antennanp
XFILLER_16_17 VPWR VGND sg13cmos5l_decap_8
XFILLER_14_1110 VPWR VGND sg13cmos5l_fill_2
XANTENNA__639__A0 Tile_X1Y0_N2END[7] VPWR VGND sg13cmos5l_antennanp
XFILLER_10_1018 VPWR VGND sg13cmos5l_fill_1
XANTENNA__259__D Tile_X0Y0_FrameData[30] VPWR VGND sg13cmos5l_antennanp
XANTENNA__396__X Tile_X0Y0_FrameStrobe_O[5] VPWR VGND sg13cmos5l_antennanp
XFILLER_12_610 VPWR VGND sg13cmos5l_decap_8
XFILLER_16_404 VPWR VGND sg13cmos5l_decap_4
XANTENNA__301__GATE Tile_X0Y0_FrameStrobe[1] VPWR VGND sg13cmos5l_antennanp
XANTENNA__590__A2 Tile_X0Y0_NN4END[9] VPWR VGND sg13cmos5l_antennanp
X_104_ PMOD_IO_OE_O5 _223_/Q _101_/X _103_/Y VPWR VGND sg13cmos5l_a21oi_1
XFILLER_8_625 VPWR VGND sg13cmos5l_fill_2
XFILLER_8_614 VPWR VGND sg13cmos5l_fill_1
XFILLER_8_603 VPWR VGND sg13cmos5l_decap_8
XFILLER_7_146 VPWR VGND sg13cmos5l_fill_2
XFILLER_7_113 VPWR VGND sg13cmos5l_fill_1
XFILLER_7_102 VPWR VGND sg13cmos5l_fill_1
XANTENNA__316__GATE Tile_X0Y0_FrameStrobe[1] VPWR VGND sg13cmos5l_antennanp
XANTENNA__645__A3 Tile_X1Y0_NN4END[13] VPWR VGND sg13cmos5l_antennanp
XANTENNA__169__D Tile_X0Y0_FrameData[15] VPWR VGND sg13cmos5l_antennanp
XANTENNA__482__A Tile_X1Y0_FrameStrobe[3] VPWR VGND sg13cmos5l_antennanp
XANTENNA__581__A2 Tile_X0Y0_NN4END[13] VPWR VGND sg13cmos5l_antennanp
XFILLER_16_993 VPWR VGND sg13cmos5l_fill_1
XFILLER_8_95 VPWR VGND sg13cmos5l_decap_8
XFILLER_8_62 VPWR VGND sg13cmos5l_decap_8
XFILLER_13_429 VPWR VGND sg13cmos5l_fill_1
XANTENNA__242__CLK Tile_X0Y0_UserCLK VPWR VGND sg13cmos5l_antennanp
XANTENNA__392__A Tile_X0Y0_FrameStrobe[1] VPWR VGND sg13cmos5l_antennanp
XANTENNA__572__A2 Tile_X0Y0_NN4END[4] VPWR VGND sg13cmos5l_antennanp
XFILLER_1_856 VPWR VGND sg13cmos5l_decap_8
XFILLER_16_223 VPWR VGND sg13cmos5l_decap_8
XANTENNA__563__A2 Tile_X0Y0_N2END[4] VPWR VGND sg13cmos5l_antennanp
XFILLER_16_267 VPWR VGND sg13cmos5l_fill_1
XFILLER_16_278 VPWR VGND sg13cmos5l_decap_8
X_584_ _584_/X Tile_X0Y0_N2END[0] Tile_X0Y0_N4END[0] Tile_X0Y0_NN4END[15] _091_/X
+ _301_/Q _300_/Q VPWR VGND sg13cmos5l_mux4_1
XFILLER_12_484 VPWR VGND sg13cmos5l_decap_8
XFILLER_8_477 VPWR VGND sg13cmos5l_decap_8
XFILLER_8_444 VPWR VGND sg13cmos5l_fill_1
XFILLER_8_433 VPWR VGND sg13cmos5l_decap_4
XANTENNA__477__A Tile_X0Y0_FrameData[30] VPWR VGND sg13cmos5l_antennanp
XANTENNA__208__GATE Tile_X1Y0_FrameStrobe[2] VPWR VGND sg13cmos5l_antennanp
XANTENNA__554__A2 Tile_X0Y0_N4END[12] VPWR VGND sg13cmos5l_antennanp
XFILLER_13_259 VPWR VGND sg13cmos5l_decap_8
XANTENNA__272__D Tile_X0Y0_FrameData[17] VPWR VGND sg13cmos5l_antennanp
XFILLER_16_1057 VPWR VGND sg13cmos5l_decap_8
XFILLER_5_458 VPWR VGND sg13cmos5l_decap_8
XFILLER_1_620 VPWR VGND sg13cmos5l_fill_1
XFILLER_1_642 VPWR VGND sg13cmos5l_fill_2
XFILLER_1_664 VPWR VGND sg13cmos5l_decap_4
X_636_ _636_/X Tile_X1Y0_N2END[4] Tile_X1Y0_N4END[12] Tile_X1Y0_NN4END[3] _085_/X
+ _148_/Q _147_/Q VPWR VGND sg13cmos5l_mux4_1
X_567_ _567_/X Tile_X0Y0_N1END[3] Tile_X0Y0_N2MID[7] Tile_X0Y0_N2END[0] _119_/X _335_/Q
+ _334_/Q VPWR VGND sg13cmos5l_mux4_1
XANTENNA__182__D Tile_X0Y0_FrameData[2] VPWR VGND sg13cmos5l_antennanp
XFILLER_13_793 VPWR VGND sg13cmos5l_decap_4
X_498_ Tile_X1Y0_FrameStrobe_O[19] Tile_X1Y0_FrameStrobe[19] VPWR VGND sg13cmos5l_buf_1
XFILLER_9_753 VPWR VGND sg13cmos5l_fill_1
XFILLER_9_742 VPWR VGND sg13cmos5l_decap_8
XFILLER_9_720 VPWR VGND sg13cmos5l_fill_1
XANTENNA__194__GATE Tile_X1Y0_FrameStrobe[2] VPWR VGND sg13cmos5l_antennanp
XFILLER_5_85 VPWR VGND sg13cmos5l_fill_1
XFILLER_5_74 VPWR VGND sg13cmos5l_decap_8
XANTENNA__132__GATE Tile_X1Y0_FrameStrobe[0] VPWR VGND sg13cmos5l_antennanp
XFILLER_10_0 VPWR VGND sg13cmos5l_fill_2
XANTENNA__147__GATE Tile_X1Y0_FrameStrobe[0] VPWR VGND sg13cmos5l_antennanp
XANTENNA__494__X Tile_X1Y0_FrameStrobe_O[15] VPWR VGND sg13cmos5l_antennanp
XFILLER_11_719 VPWR VGND sg13cmos5l_fill_2
XFILLER_3_929 VPWR VGND sg13cmos5l_fill_2
XFILLER_3_918 VPWR VGND sg13cmos5l_decap_8
XFILLER_2_406 VPWR VGND sg13cmos5l_decap_4
XFILLER_2_428 VPWR VGND sg13cmos5l_fill_2
XANTENNA__267__D Tile_X0Y0_FrameData[22] VPWR VGND sg13cmos5l_antennanp
XFILLER_2_1111 VPWR VGND sg13cmos5l_fill_1
X_421_ Tile_X0Y0_S2BEG[6] Tile_X0Y0_N2MID[1] VPWR VGND sg13cmos5l_buf_1
XFILLER_14_546 VPWR VGND sg13cmos5l_decap_8
X_283_ _283_/Q Tile_X0Y0_FrameData[6] VGND VPWR Tile_X0Y0_FrameStrobe[0] latch
X_352_ _352_/L_HI VPWR VGND sg13cmos5l_tiehi
XFILLER_5_244 VPWR VGND sg13cmos5l_decap_8
XFILLER_1_472 VPWR VGND sg13cmos5l_fill_1
XFILLER_1_483 VPWR VGND sg13cmos5l_decap_8
XFILLER_7_1033 VPWR VGND sg13cmos5l_decap_8
XFILLER_2_962 VPWR VGND sg13cmos5l_fill_1
XANTENNA__177__D Tile_X0Y0_FrameData[7] VPWR VGND sg13cmos5l_antennanp
X_619_ _619_/X Tile_X1Y0_N2MID[3] Tile_X1Y0_N4END[4] Tile_X1Y0_NN4END[11] _087_/X
+ _182_/Q _181_/Q VPWR VGND sg13cmos5l_mux4_1
XANTENNA__490__A Tile_X1Y0_FrameStrobe[11] VPWR VGND sg13cmos5l_antennanp
XFILLER_9_550 VPWR VGND sg13cmos5l_decap_8
XANTENNA__489__X Tile_X1Y0_FrameStrobe_O[10] VPWR VGND sg13cmos5l_antennanp
XFILLER_11_516 VPWR VGND sg13cmos5l_decap_8
XFILLER_13_1016 VPWR VGND sg13cmos5l_decap_8
XANTENNA__399__X Tile_X0Y0_FrameStrobe_O[8] VPWR VGND sg13cmos5l_antennanp
XFILLER_14_310 VPWR VGND sg13cmos5l_decap_8
X_404_ Tile_X0Y0_FrameStrobe_O[13] Tile_X0Y0_FrameStrobe[13] VPWR VGND sg13cmos5l_buf_1
X_266_ _266_/Q Tile_X0Y0_FrameData[23] VGND VPWR Tile_X0Y0_FrameStrobe[0] latch
X_335_ _335_/Q Tile_X0Y0_FrameData[18] VGND VPWR Tile_X0Y0_FrameStrobe[2] latch
X_197_ _197_/Q Tile_X0Y0_FrameData[19] VGND VPWR Tile_X1Y0_FrameStrobe[2] latch
XFILLER_6_597 VPWR VGND sg13cmos5l_decap_8
XFILLER_6_564 VPWR VGND sg13cmos5l_decap_8
XANTENNA__485__A Tile_X1Y0_FrameStrobe[6] VPWR VGND sg13cmos5l_antennanp
XFILLER_2_42 VPWR VGND sg13cmos5l_decap_8
XFILLER_2_53 VPWR VGND sg13cmos5l_fill_2
XFILLER_2_86 VPWR VGND sg13cmos5l_decap_8
XANTENNA__395__A Tile_X0Y0_FrameStrobe[4] VPWR VGND sg13cmos5l_antennanp
XFILLER_11_368 VPWR VGND sg13cmos5l_decap_8
X_120_ _120_/Y _120_/A _244_/D VPWR VGND sg13cmos5l_nor2_1
XFILLER_8_807 VPWR VGND sg13cmos5l_fill_2
XANTENNA__280__D Tile_X0Y0_FrameData[9] VPWR VGND sg13cmos5l_antennanp
XFILLER_11_95 VPWR VGND sg13cmos5l_decap_8
XFILLER_3_567 VPWR VGND sg13cmos5l_decap_8
XANTENNA__593__A0 Tile_X0Y0_N2END[1] VPWR VGND sg13cmos5l_antennanp
XFILLER_14_184 VPWR VGND sg13cmos5l_decap_8
XFILLER_15_641 VPWR VGND sg13cmos5l_decap_8
XANTENNA__190__D Tile_X0Y0_FrameData[26] VPWR VGND sg13cmos5l_antennanp
X_318_ _318_/Q Tile_X0Y0_FrameData[3] VGND VPWR Tile_X0Y0_FrameStrobe[1] latch
X_249_ _249_/Q Tile_X0Y0_UserCLK _249_/D _354_/L_HI VPWR VGND sg13cmos5l_dfrbpq_1
XFILLER_7_862 VPWR VGND sg13cmos5l_fill_2
XANTENNA__584__A0 Tile_X0Y0_N2END[0] VPWR VGND sg13cmos5l_antennanp
XANTENNA__639__A1 Tile_X1Y0_N4END[15] VPWR VGND sg13cmos5l_antennanp
XFILLER_0_504 VPWR VGND sg13cmos5l_fill_1
XFILLER_0_515 VPWR VGND sg13cmos5l_fill_1
XANTENNA__275__D Tile_X0Y0_FrameData[14] VPWR VGND sg13cmos5l_antennanp
XANTENNA__575__A0 Tile_X0Y0_N2MID[7] VPWR VGND sg13cmos5l_antennanp
XFILLER_11_165 VPWR VGND sg13cmos5l_decap_8
XFILLER_11_187 VPWR VGND sg13cmos5l_decap_8
XFILLER_12_666 VPWR VGND sg13cmos5l_decap_8
X_103_ _103_/Y _120_/A _248_/D _102_/X VPWR VGND sg13cmos5l_o21ai_1
XFILLER_4_843 VPWR VGND sg13cmos5l_fill_1
XFILLER_4_832 VPWR VGND sg13cmos5l_decap_8
XFILLER_4_865 VPWR VGND sg13cmos5l_decap_8
XANTENNA__185__D Tile_X0Y0_FrameData[31] VPWR VGND sg13cmos5l_antennanp
XANTENNA__566__A0 Tile_X0Y0_N1END[2] VPWR VGND sg13cmos5l_antennanp
XFILLER_16_972 VPWR VGND sg13cmos5l_fill_1
XFILLER_6_180 VPWR VGND sg13cmos5l_fill_1
XANTENNA__497__X Tile_X1Y0_FrameStrobe_O[18] VPWR VGND sg13cmos5l_antennanp
XANTENNA__557__A0 Tile_X1Y0_N2MID[4] VPWR VGND sg13cmos5l_antennanp
XFILLER_0_389 VPWR VGND sg13cmos5l_fill_2
XFILLER_1_802 VPWR VGND sg13cmos5l_fill_2
XFILLER_1_846 VPWR VGND sg13cmos5l_fill_2
XFILLER_16_202 VPWR VGND sg13cmos5l_decap_8
X_583_ _583_/X Tile_X0Y0_N2MID[7] Tile_X0Y0_N4END[0] Tile_X0Y0_NN4END[15] _092_/X
+ _303_/Q _302_/Q VPWR VGND sg13cmos5l_mux4_1
XFILLER_13_920 VPWR VGND sg13cmos5l_fill_2
XFILLER_8_412 VPWR VGND sg13cmos5l_decap_8
XFILLER_8_456 VPWR VGND sg13cmos5l_decap_8
XFILLER_4_651 VPWR VGND sg13cmos5l_fill_2
XANTENNA__493__A Tile_X1Y0_FrameStrobe[14] VPWR VGND sg13cmos5l_antennanp
XANTENNA__554__A3 Tile_X0Y0_NN4END[12] VPWR VGND sg13cmos5l_antennanp
XFILLER_15_290 VPWR VGND sg13cmos5l_decap_8
XANTENNA__300__GATE Tile_X0Y0_FrameStrobe[1] VPWR VGND sg13cmos5l_antennanp
XANTENNA__315__GATE Tile_X0Y0_FrameStrobe[1] VPWR VGND sg13cmos5l_antennanp
XFILLER_0_1083 VPWR VGND sg13cmos5l_fill_1
XFILLER_10_912 VPWR VGND sg13cmos5l_decap_4
XFILLER_13_238 VPWR VGND sg13cmos5l_decap_8
XFILLER_16_1036 VPWR VGND sg13cmos5l_decap_8
XFILLER_6_916 VPWR VGND sg13cmos5l_decap_8
XFILLER_0_164 VPWR VGND sg13cmos5l_decap_4
XFILLER_0_197 VPWR VGND sg13cmos5l_decap_8
X_635_ _635_/X Tile_X1Y0_N2END[3] Tile_X1Y0_N4END[11] Tile_X1Y0_NN4END[4] _095_/X
+ _150_/Q _149_/Q VPWR VGND sg13cmos5l_mux4_1
X_566_ _566_/X Tile_X0Y0_N1END[2] Tile_X0Y0_N2MID[6] Tile_X0Y0_N2END[1] _092_/X _337_/Q
+ _336_/Q VPWR VGND sg13cmos5l_mux4_1
XFILLER_12_282 VPWR VGND sg13cmos5l_decap_8
X_497_ Tile_X1Y0_FrameStrobe_O[18] Tile_X1Y0_FrameStrobe[18] VPWR VGND sg13cmos5l_buf_1
XFILLER_8_297 VPWR VGND sg13cmos5l_fill_2
XFILLER_8_253 VPWR VGND sg13cmos5l_fill_2
XFILLER_8_242 VPWR VGND sg13cmos5l_decap_8
XFILLER_5_64 VPWR VGND sg13cmos5l_decap_8
XANTENNA__488__A Tile_X1Y0_FrameStrobe[9] VPWR VGND sg13cmos5l_antennanp
XANTENNA__398__A Tile_X0Y0_FrameStrobe[7] VPWR VGND sg13cmos5l_antennanp
XFILLER_14_525 VPWR VGND sg13cmos5l_decap_8
X_351_ _351_/L_HI VPWR VGND sg13cmos5l_tiehi
X_420_ Tile_X0Y0_S2BEG[5] Tile_X0Y0_N2MID[2] VPWR VGND sg13cmos5l_buf_1
XANTENNA__269__GATE Tile_X0Y0_FrameStrobe[0] VPWR VGND sg13cmos5l_antennanp
XANTENNA__283__D Tile_X0Y0_FrameData[6] VPWR VGND sg13cmos5l_antennanp
XFILLER_10_764 VPWR VGND sg13cmos5l_fill_1
XFILLER_10_775 VPWR VGND sg13cmos5l_decap_4
XFILLER_14_95 VPWR VGND sg13cmos5l_decap_8
X_282_ _282_/Q Tile_X0Y0_FrameData[7] VGND VPWR Tile_X0Y0_FrameStrobe[0] latch
XFILLER_6_735 VPWR VGND sg13cmos5l_decap_8
XFILLER_6_724 VPWR VGND sg13cmos5l_fill_1
XANTENNA__207__GATE Tile_X1Y0_FrameStrobe[2] VPWR VGND sg13cmos5l_antennanp
XANTENNA__255__CLK Tile_X0Y0_UserCLK VPWR VGND sg13cmos5l_antennanp
XFILLER_7_1089 VPWR VGND sg13cmos5l_decap_8
XANTENNA__193__D Tile_X0Y0_FrameData[23] VPWR VGND sg13cmos5l_antennanp
XFILLER_13_580 VPWR VGND sg13cmos5l_decap_8
X_549_ Tile_X1Y0_SS4BEG[14] _638_/X VPWR VGND sg13cmos5l_buf_1
X_618_ _618_/X Tile_X1Y0_N2MID[2] Tile_X1Y0_N4END[5] Tile_X1Y0_NN4END[10] _089_/X
+ _184_/Q _183_/Q VPWR VGND sg13cmos5l_mux4_1
XFILLER_13_1039 VPWR VGND sg13cmos5l_fill_1
XFILLER_2_204 VPWR VGND sg13cmos5l_decap_8
XFILLER_2_237 VPWR VGND sg13cmos5l_fill_1
XANTENNA__278__D Tile_X0Y0_FrameData[11] VPWR VGND sg13cmos5l_antennanp
XANTENNA__193__GATE Tile_X1Y0_FrameStrobe[2] VPWR VGND sg13cmos5l_antennanp
XFILLER_14_366 VPWR VGND sg13cmos5l_decap_8
XFILLER_14_388 VPWR VGND sg13cmos5l_decap_8
X_334_ _334_/Q Tile_X0Y0_FrameData[19] VGND VPWR Tile_X0Y0_FrameStrobe[2] latch
X_403_ Tile_X0Y0_FrameStrobe_O[12] Tile_X0Y0_FrameStrobe[12] VPWR VGND sg13cmos5l_buf_1
XANTENNA__131__GATE Tile_X1Y0_FrameStrobe[0] VPWR VGND sg13cmos5l_antennanp
XFILLER_10_583 VPWR VGND sg13cmos5l_fill_1
X_265_ _265_/Q Tile_X0Y0_FrameData[24] VGND VPWR Tile_X0Y0_FrameStrobe[0] latch
X_196_ _196_/Q Tile_X0Y0_FrameData[20] VGND VPWR Tile_X1Y0_FrameStrobe[2] latch
XFILLER_6_543 VPWR VGND sg13cmos5l_decap_8
XANTENNA__146__GATE Tile_X1Y0_FrameStrobe[0] VPWR VGND sg13cmos5l_antennanp
XFILLER_1_270 VPWR VGND sg13cmos5l_fill_2
XFILLER_9_1118 VPWR VGND sg13cmos5l_fill_2
XANTENNA__188__D Tile_X0Y0_FrameData[28] VPWR VGND sg13cmos5l_antennanp
XFILLER_2_65 VPWR VGND sg13cmos5l_decap_8
XFILLER_12_1094 VPWR VGND sg13cmos5l_decap_8
XFILLER_11_347 VPWR VGND sg13cmos5l_fill_1
XFILLER_12_848 VPWR VGND sg13cmos5l_fill_1
XFILLER_7_307 VPWR VGND sg13cmos5l_fill_1
XFILLER_3_546 VPWR VGND sg13cmos5l_decap_8
XFILLER_15_620 VPWR VGND sg13cmos5l_decap_8
XFILLER_4_1015 VPWR VGND sg13cmos5l_decap_8
XANTENNA__593__A1 Tile_X0Y0_N4END[9] VPWR VGND sg13cmos5l_antennanp
XFILLER_14_163 VPWR VGND sg13cmos5l_decap_8
XFILLER_15_697 VPWR VGND sg13cmos5l_fill_2
X_317_ _317_/Q Tile_X0Y0_FrameData[4] VGND VPWR Tile_X0Y0_FrameStrobe[1] latch
X_248_ _248_/Q Tile_X0Y0_UserCLK _248_/D _351_/L_HI VPWR VGND sg13cmos5l_dfrbpq_1
X_179_ _179_/Q Tile_X0Y0_FrameData[5] VGND VPWR Tile_X1Y0_FrameStrobe[1] latch
XFILLER_6_384 VPWR VGND sg13cmos5l_fill_1
XANTENNA__496__A Tile_X1Y0_FrameStrobe[17] VPWR VGND sg13cmos5l_antennanp
XANTENNA__584__A1 Tile_X0Y0_N4END[0] VPWR VGND sg13cmos5l_antennanp
XFILLER_10_1009 VPWR VGND sg13cmos5l_decap_4
XFILLER_14_1101 VPWR VGND sg13cmos5l_fill_2
XANTENNA__639__A2 Tile_X1Y0_NN4END[0] VPWR VGND sg13cmos5l_antennanp
XFILLER_0_527 VPWR VGND sg13cmos5l_fill_1
XFILLER_16_439 VPWR VGND sg13cmos5l_decap_8
XANTENNA__575__A1 Tile_X0Y0_N4END[8] VPWR VGND sg13cmos5l_antennanp
XFILLER_11_144 VPWR VGND sg13cmos5l_decap_8
XFILLER_12_645 VPWR VGND sg13cmos5l_decap_8
XFILLER_12_678 VPWR VGND sg13cmos5l_decap_8
XFILLER_12_689 VPWR VGND sg13cmos5l_fill_2
XFILLER_8_627 VPWR VGND sg13cmos5l_fill_1
XANTENNA__291__D Tile_X0Y0_FrameData[30] VPWR VGND sg13cmos5l_antennanp
X_102_ _102_/X _233_/Q _248_/Q VPWR VGND sg13cmos5l_or2_1
XFILLER_7_148 VPWR VGND sg13cmos5l_fill_1
XFILLER_0_0 VPWR VGND sg13cmos5l_fill_1
XANTENNA__566__A1 Tile_X0Y0_N2MID[6] VPWR VGND sg13cmos5l_antennanp
XFILLER_16_940 VPWR VGND sg13cmos5l_decap_4
XFILLER_6_170 VPWR VGND sg13cmos5l_fill_2
XANTENNA__557__A1 Tile_X1Y0_N2END[3] VPWR VGND sg13cmos5l_antennanp
XFILLER_5_619 VPWR VGND sg13cmos5l_decap_4
XANTENNA__286__D Tile_X0Y0_FrameData[3] VPWR VGND sg13cmos5l_antennanp
XFILLER_16_258 VPWR VGND sg13cmos5l_decap_8
XFILLER_1_1007 VPWR VGND sg13cmos5l_decap_4
X_582_ _582_/X Tile_X0Y0_N2MID[6] Tile_X0Y0_N4END[1] Tile_X0Y0_NN4END[14] _091_/X
+ _305_/Q _304_/Q VPWR VGND sg13cmos5l_mux4_1
XFILLER_12_442 VPWR VGND sg13cmos5l_decap_8
XFILLER_8_402 VPWR VGND sg13cmos5l_decap_4
XFILLER_4_630 VPWR VGND sg13cmos5l_decap_8
XANTENNA__196__D Tile_X0Y0_FrameData[20] VPWR VGND sg13cmos5l_antennanp
XFILLER_11_1115 VPWR VGND sg13cmos5l_decap_4
XFILLER_0_1095 VPWR VGND sg13cmos5l_fill_1
XFILLER_10_968 VPWR VGND sg13cmos5l_decap_4
XFILLER_13_217 VPWR VGND sg13cmos5l_decap_8
XFILLER_16_1004 VPWR VGND sg13cmos5l_decap_8
XFILLER_1_644 VPWR VGND sg13cmos5l_fill_1
XFILLER_0_176 VPWR VGND sg13cmos5l_fill_1
X_634_ _634_/X Tile_X1Y0_N2END[2] Tile_X1Y0_N4END[10] Tile_X1Y0_NN4END[5] _064_/X
+ _152_/Q _151_/Q VPWR VGND sg13cmos5l_mux4_1
X_496_ Tile_X1Y0_FrameStrobe_O[17] Tile_X1Y0_FrameStrobe[17] VPWR VGND sg13cmos5l_buf_1
X_565_ _565_/X Tile_X0Y0_N1END[1] Tile_X0Y0_N2MID[5] Tile_X0Y0_N2END[2] _091_/X _339_/Q
+ _338_/Q VPWR VGND sg13cmos5l_mux4_1
XFILLER_12_261 VPWR VGND sg13cmos5l_decap_8
XFILLER_8_221 VPWR VGND sg13cmos5l_decap_8
XFILLER_5_983 VPWR VGND sg13cmos5l_decap_8
XFILLER_5_32 VPWR VGND sg13cmos5l_decap_4
XFILLER_4_471 VPWR VGND sg13cmos5l_fill_2
XFILLER_10_209 VPWR VGND sg13cmos5l_decap_8
XFILLER_2_1102 VPWR VGND sg13cmos5l_fill_1
XANTENNA__620__A0 Tile_X1Y0_N2MID[4] VPWR VGND sg13cmos5l_antennanp
XFILLER_14_504 VPWR VGND sg13cmos5l_decap_8
X_350_ _350_/Q Tile_X0Y0_FrameData[31] VGND VPWR Tile_X0Y0_FrameStrobe[0] latch
XFILLER_14_74 VPWR VGND sg13cmos5l_decap_8
X_281_ _281_/Q Tile_X0Y0_FrameData[8] VGND VPWR Tile_X0Y0_FrameStrobe[0] latch
XFILLER_6_769 VPWR VGND sg13cmos5l_decap_8
XFILLER_6_758 VPWR VGND sg13cmos5l_fill_1
XFILLER_6_703 VPWR VGND sg13cmos5l_decap_8
XFILLER_5_213 VPWR VGND sg13cmos5l_fill_2
XFILLER_1_463 VPWR VGND sg13cmos5l_decap_4
XFILLER_5_279 VPWR VGND sg13cmos5l_decap_8
XFILLER_2_953 VPWR VGND sg13cmos5l_decap_8
XANTENNA__611__A0 Tile_X1Y0_N2MID[3] VPWR VGND sg13cmos5l_antennanp
X_617_ _617_/X Tile_X1Y0_N2MID[1] Tile_X1Y0_N4END[6] Tile_X1Y0_NN4END[9] _064_/X _186_/Q
+ _185_/Q VPWR VGND sg13cmos5l_mux4_1
XFILLER_7_1068 VPWR VGND sg13cmos5l_decap_8
X_479_ Tile_X1Y0_FrameStrobe_O[0] Tile_X1Y0_FrameStrobe[0] VPWR VGND sg13cmos5l_buf_1
X_548_ Tile_X1Y0_SS4BEG[13] _637_/X VPWR VGND sg13cmos5l_buf_1
XFILLER_9_596 VPWR VGND sg13cmos5l_fill_1
XFILLER_9_585 VPWR VGND sg13cmos5l_decap_8
XANTENNA__314__GATE Tile_X0Y0_FrameStrobe[1] VPWR VGND sg13cmos5l_antennanp
XANTENNA__499__A Tile_X1Y0_N1END[3] VPWR VGND sg13cmos5l_antennanp
XANTENNA__329__GATE Tile_X0Y0_FrameStrobe[2] VPWR VGND sg13cmos5l_antennanp
XANTENNA__602__A0 Tile_X1Y0_N1END[2] VPWR VGND sg13cmos5l_antennanp
XANTENNA__294__D Tile_X0Y0_FrameData[27] VPWR VGND sg13cmos5l_antennanp
XFILLER_14_345 VPWR VGND sg13cmos5l_decap_8
X_264_ _264_/Q Tile_X0Y0_FrameData[25] VGND VPWR Tile_X0Y0_FrameStrobe[0] latch
X_333_ _333_/Q Tile_X0Y0_FrameData[20] VGND VPWR Tile_X0Y0_FrameStrobe[2] latch
X_402_ Tile_X0Y0_FrameStrobe_O[11] Tile_X0Y0_FrameStrobe[11] VPWR VGND sg13cmos5l_buf_1
XFILLER_10_562 VPWR VGND sg13cmos5l_decap_8
X_195_ _195_/Q Tile_X0Y0_FrameData[21] VGND VPWR Tile_X1Y0_FrameStrobe[2] latch
XFILLER_6_522 VPWR VGND sg13cmos5l_decap_8
XFILLER_2_783 VPWR VGND sg13cmos5l_decap_8
XFILLER_2_761 VPWR VGND sg13cmos5l_fill_1
XFILLER_9_393 VPWR VGND sg13cmos5l_decap_8
XFILLER_12_1073 VPWR VGND sg13cmos5l_decap_8
XANTENNA__268__GATE Tile_X0Y0_FrameStrobe[0] VPWR VGND sg13cmos5l_antennanp
XFILLER_12_838 VPWR VGND sg13cmos5l_decap_4
XFILLER_8_809 VPWR VGND sg13cmos5l_fill_1
XANTENNA__206__GATE Tile_X1Y0_FrameStrobe[2] VPWR VGND sg13cmos5l_antennanp
XANTENNA__245__CLK Tile_X0Y0_UserCLK VPWR VGND sg13cmos5l_antennanp
XFILLER_11_31 VPWR VGND sg13cmos5l_decap_8
XFILLER_11_42 VPWR VGND sg13cmos5l_fill_2
XFILLER_3_525 VPWR VGND sg13cmos5l_decap_8
XANTENNA__289__D Tile_X0Y0_FrameData[0] VPWR VGND sg13cmos5l_antennanp
XANTENNA__593__A2 Tile_X0Y0_NN4END[6] VPWR VGND sg13cmos5l_antennanp
XFILLER_14_142 VPWR VGND sg13cmos5l_decap_8
XFILLER_15_676 VPWR VGND sg13cmos5l_decap_8
X_316_ _316_/Q Tile_X0Y0_FrameData[5] VGND VPWR Tile_X0Y0_FrameStrobe[1] latch
X_247_ _247_/Q Tile_X0Y0_UserCLK _247_/D _356_/L_HI VPWR VGND sg13cmos5l_dfrbpq_1
XFILLER_7_820 VPWR VGND sg13cmos5l_decap_8
XANTENNA__113__Y PMOD_IO_O3 VPWR VGND sg13cmos5l_antennanp
X_178_ _178_/Q Tile_X0Y0_FrameData[6] VGND VPWR Tile_X1Y0_FrameStrobe[1] latch
XFILLER_7_864 VPWR VGND sg13cmos5l_fill_1
XANTENNA__199__D Tile_X0Y0_FrameData[17] VPWR VGND sg13cmos5l_antennanp
XFILLER_2_580 VPWR VGND sg13cmos5l_decap_8
XANTENNA__584__A2 Tile_X0Y0_NN4END[15] VPWR VGND sg13cmos5l_antennanp
XANTENNA__192__GATE Tile_X1Y0_FrameStrobe[2] VPWR VGND sg13cmos5l_antennanp
XANTENNA__130__GATE Tile_X1Y0_FrameStrobe[0] VPWR VGND sg13cmos5l_antennanp
XFILLER_16_418 VPWR VGND sg13cmos5l_decap_8
XFILLER_3_1082 VPWR VGND sg13cmos5l_decap_8
XANTENNA__145__GATE Tile_X1Y0_FrameStrobe[0] VPWR VGND sg13cmos5l_antennanp
XANTENNA__575__A2 Tile_X0Y0_NN4END[7] VPWR VGND sg13cmos5l_antennanp
XFILLER_11_123 VPWR VGND sg13cmos5l_decap_8
XFILLER_12_624 VPWR VGND sg13cmos5l_decap_8
X_101_ _101_/X _256_/Q _557_/X _233_/Q VPWR VGND sg13cmos5l_mux2_1
XFILLER_3_311 VPWR VGND sg13cmos5l_decap_4
XANTENNA__566__A2 Tile_X0Y0_N2END[1] VPWR VGND sg13cmos5l_antennanp
XFILLER_15_451 VPWR VGND sg13cmos5l_decap_8
XFILLER_16_985 VPWR VGND sg13cmos5l_fill_1
XANTENNA__108__Y PMOD_IO_OE_O7 VPWR VGND sg13cmos5l_antennanp
XFILLER_8_76 VPWR VGND sg13cmos5l_decap_8
XFILLER_8_43 VPWR VGND sg13cmos5l_fill_2
XFILLER_8_21 VPWR VGND sg13cmos5l_decap_8
XANTENNA__557__A2 Tile_X1Y0_N4END[12] VPWR VGND sg13cmos5l_antennanp
XFILLER_0_303 VPWR VGND sg13cmos5l_decap_8
XFILLER_1_815 VPWR VGND sg13cmos5l_fill_2
XFILLER_1_848 VPWR VGND sg13cmos5l_fill_1
XFILLER_16_237 VPWR VGND sg13cmos5l_decap_4
XFILLER_1_1019 VPWR VGND sg13cmos5l_fill_2
X_581_ _581_/X Tile_X0Y0_N2MID[5] Tile_X0Y0_N4END[2] Tile_X0Y0_NN4END[13] _119_/X
+ _307_/Q _306_/Q VPWR VGND sg13cmos5l_mux4_1
XFILLER_12_498 VPWR VGND sg13cmos5l_decap_8
XFILLER_4_664 VPWR VGND sg13cmos5l_decap_8
XFILLER_3_141 VPWR VGND sg13cmos5l_fill_1
XFILLER_15_270 VPWR VGND sg13cmos5l_fill_2
XFILLER_7_480 VPWR VGND sg13cmos5l_decap_8
XFILLER_5_428 VPWR VGND sg13cmos5l_decap_8
XFILLER_1_612 VPWR VGND sg13cmos5l_fill_1
XFILLER_1_656 VPWR VGND sg13cmos5l_fill_1
XFILLER_5_439 VPWR VGND sg13cmos5l_fill_1
XANTENNA__297__D Tile_X0Y0_FrameData[24] VPWR VGND sg13cmos5l_antennanp
XFILLER_1_689 VPWR VGND sg13cmos5l_decap_8
X_633_ _633_/X Tile_X1Y0_N2END[1] Tile_X1Y0_N4END[9] Tile_X1Y0_NN4END[6] _089_/X _154_/Q
+ _153_/Q VPWR VGND sg13cmos5l_mux4_1
XFILLER_12_240 VPWR VGND sg13cmos5l_decap_8
X_495_ Tile_X1Y0_FrameStrobe_O[16] Tile_X1Y0_FrameStrobe[16] VPWR VGND sg13cmos5l_buf_1
X_564_ _564_/X Tile_X0Y0_N1END[0] Tile_X0Y0_N2MID[4] Tile_X0Y0_N2END[3] _119_/X _341_/Q
+ _340_/Q VPWR VGND sg13cmos5l_mux4_1
XFILLER_9_789 VPWR VGND sg13cmos5l_decap_8
XFILLER_8_288 VPWR VGND sg13cmos5l_fill_2
XFILLER_5_962 VPWR VGND sg13cmos5l_decap_8
XFILLER_4_450 VPWR VGND sg13cmos5l_decap_8
XANTENNA__121__Y PMOD_IO_OE_O1 VPWR VGND sg13cmos5l_antennanp
XANTENNA__402__X Tile_X0Y0_FrameStrobe_O[11] VPWR VGND sg13cmos5l_antennanp
XFILLER_4_483 VPWR VGND sg13cmos5l_decap_8
XANTENNA__620__A1 Tile_X1Y0_N4END[3] VPWR VGND sg13cmos5l_antennanp
XFILLER_10_711 VPWR VGND sg13cmos5l_fill_1
X_280_ _280_/Q Tile_X0Y0_FrameData[9] VGND VPWR Tile_X0Y0_FrameStrobe[0] latch
XFILLER_10_733 VPWR VGND sg13cmos5l_decap_8
XFILLER_5_258 VPWR VGND sg13cmos5l_decap_8
XFILLER_1_497 VPWR VGND sg13cmos5l_decap_8
XFILLER_7_1047 VPWR VGND sg13cmos5l_decap_8
XFILLER_7_1025 VPWR VGND sg13cmos5l_fill_2
XFILLER_7_1014 VPWR VGND sg13cmos5l_decap_8
XFILLER_2_998 VPWR VGND sg13cmos5l_fill_1
XFILLER_2_987 VPWR VGND sg13cmos5l_decap_8
XANTENNA__611__A1 Tile_X1Y0_N4END[12] VPWR VGND sg13cmos5l_antennanp
X_547_ Tile_X1Y0_SS4BEG[12] _636_/X VPWR VGND sg13cmos5l_buf_1
X_616_ _616_/X Tile_X1Y0_N2MID[0] Tile_X1Y0_N4END[7] Tile_X1Y0_NN4END[8] _095_/X _188_/Q
+ _187_/Q VPWR VGND sg13cmos5l_mux4_1
XANTENNA__116__Y PMOD_IO_O6 VPWR VGND sg13cmos5l_antennanp
X_478_ Tile_X1Y0_FrameData_O[31] Tile_X0Y0_FrameData[31] VPWR VGND sg13cmos5l_buf_1
XFILLER_9_564 VPWR VGND sg13cmos5l_decap_8
XFILLER_5_781 VPWR VGND sg13cmos5l_decap_4
XFILLER_4_291 VPWR VGND sg13cmos5l_fill_2
XANTENNA__602__A1 Tile_X1Y0_N2MID[2] VPWR VGND sg13cmos5l_antennanp
XANTENNA__118__A0 PMOD_IO_I1 VPWR VGND sg13cmos5l_antennanp
XFILLER_3_707 VPWR VGND sg13cmos5l_fill_1
XFILLER_2_228 VPWR VGND sg13cmos5l_decap_8
XFILLER_3_729 VPWR VGND sg13cmos5l_decap_8
X_401_ Tile_X0Y0_FrameStrobe_O[10] Tile_X0Y0_FrameStrobe[10] VPWR VGND sg13cmos5l_buf_1
XFILLER_10_541 VPWR VGND sg13cmos5l_decap_8
XFILLER_14_324 VPWR VGND sg13cmos5l_decap_8
X_332_ _332_/Q Tile_X0Y0_FrameData[21] VGND VPWR Tile_X0Y0_FrameStrobe[2] latch
X_263_ _263_/Q Tile_X0Y0_FrameData[26] VGND VPWR Tile_X0Y0_FrameStrobe[0] latch
XFILLER_6_501 VPWR VGND sg13cmos5l_decap_8
X_194_ _194_/Q Tile_X0Y0_FrameData[22] VGND VPWR Tile_X1Y0_FrameStrobe[2] latch
XANTENNA__596__A0 Tile_X0Y0_N2END[4] VPWR VGND sg13cmos5l_antennanp
XFILLER_12_1030 VPWR VGND sg13cmos5l_fill_1
XFILLER_12_1052 VPWR VGND sg13cmos5l_decap_8
XANTENNA__587__A0 Tile_X0Y0_N2END[3] VPWR VGND sg13cmos5l_antennanp
XFILLER_11_338 VPWR VGND sg13cmos5l_fill_2
XFILLER_11_65 VPWR VGND sg13cmos5l_decap_8
XFILLER_3_504 VPWR VGND sg13cmos5l_decap_8
XANTENNA__500__X Tile_X1Y0_S1BEG[1] VPWR VGND sg13cmos5l_antennanp
XFILLER_4_1039 VPWR VGND sg13cmos5l_fill_1
XFILLER_4_1006 VPWR VGND sg13cmos5l_fill_1
XANTENNA__578__A0 Tile_X0Y0_N2MID[2] VPWR VGND sg13cmos5l_antennanp
XFILLER_15_655 VPWR VGND sg13cmos5l_decap_8
XANTENNA__313__GATE Tile_X0Y0_FrameStrobe[1] VPWR VGND sg13cmos5l_antennanp
XFILLER_10_371 VPWR VGND sg13cmos5l_decap_8
XFILLER_14_198 VPWR VGND sg13cmos5l_decap_8
XFILLER_15_699 VPWR VGND sg13cmos5l_fill_1
X_315_ _315_/Q Tile_X0Y0_FrameData[6] VGND VPWR Tile_X0Y0_FrameStrobe[1] latch
X_246_ _246_/Q Tile_X0Y0_UserCLK _246_/D _355_/L_HI VPWR VGND sg13cmos5l_dfrbpq_1
X_177_ _177_/Q Tile_X0Y0_FrameData[7] VGND VPWR Tile_X1Y0_FrameStrobe[1] latch
XFILLER_7_876 VPWR VGND sg13cmos5l_decap_8
XANTENNA__328__GATE Tile_X0Y0_FrameStrobe[2] VPWR VGND sg13cmos5l_antennanp
XANTENNA__410__X Tile_X0Y0_FrameStrobe_O[19] VPWR VGND sg13cmos5l_antennanp
XFILLER_6_375 VPWR VGND sg13cmos5l_decap_8
XANTENNA__569__A0 Tile_X0Y0_N2MID[1] VPWR VGND sg13cmos5l_antennanp
XFILLER_12_603 VPWR VGND sg13cmos5l_decap_8
XFILLER_3_1061 VPWR VGND sg13cmos5l_decap_8
XFILLER_11_102 VPWR VGND sg13cmos5l_decap_8
X_100_ PMOD_IO_OE_O6 _223_/Q _097_/X _099_/Y VPWR VGND sg13cmos5l_a21oi_1
XFILLER_8_618 VPWR VGND sg13cmos5l_decap_4
XFILLER_7_139 VPWR VGND sg13cmos5l_decap_8
XFILLER_7_128 VPWR VGND sg13cmos5l_fill_2
XFILLER_7_117 VPWR VGND sg13cmos5l_fill_2
XFILLER_7_106 VPWR VGND sg13cmos5l_decap_8
XFILLER_4_824 VPWR VGND sg13cmos5l_fill_1
XFILLER_15_430 VPWR VGND sg13cmos5l_decap_8
XFILLER_15_474 VPWR VGND sg13cmos5l_decap_4
XFILLER_16_931 VPWR VGND sg13cmos5l_fill_2
XFILLER_16_953 VPWR VGND sg13cmos5l_decap_4
XFILLER_16_997 VPWR VGND sg13cmos5l_decap_8
XFILLER_8_11 VPWR VGND sg13cmos5l_fill_1
XANTENNA__267__GATE Tile_X0Y0_FrameStrobe[0] VPWR VGND sg13cmos5l_antennanp
XANTENNA__405__X Tile_X0Y0_FrameStrobe_O[14] VPWR VGND sg13cmos5l_antennanp
X_229_ _229_/Q Tile_X0Y0_FrameData[22] VGND VPWR Tile_X1Y0_FrameStrobe[3] latch
XFILLER_8_55 VPWR VGND sg13cmos5l_decap_8
XFILLER_7_684 VPWR VGND sg13cmos5l_decap_8
XFILLER_6_150 VPWR VGND sg13cmos5l_decap_8
XANTENNA__205__GATE Tile_X1Y0_FrameStrobe[2] VPWR VGND sg13cmos5l_antennanp
XANTENNA__235__CLK Tile_X0Y0_UserCLK VPWR VGND sg13cmos5l_antennanp
XANTENNA__557__A3 Tile_X1Y0_NN4END[12] VPWR VGND sg13cmos5l_antennanp
X_580_ _580_/X Tile_X0Y0_N2MID[4] Tile_X0Y0_N4END[3] Tile_X0Y0_NN4END[12] _092_/X
+ _309_/Q _308_/Q VPWR VGND sg13cmos5l_mux4_1
XFILLER_12_400 VPWR VGND sg13cmos5l_decap_8
XFILLER_16_216 VPWR VGND sg13cmos5l_decap_8
XFILLER_12_477 VPWR VGND sg13cmos5l_decap_8
XFILLER_8_426 VPWR VGND sg13cmos5l_decap_8
XANTENNA__258__CLK Tile_X0Y0_UserCLK VPWR VGND sg13cmos5l_antennanp
XANTENNA__401__A Tile_X0Y0_FrameStrobe[10] VPWR VGND sg13cmos5l_antennanp
XANTENNA__191__GATE Tile_X1Y0_FrameStrobe[2] VPWR VGND sg13cmos5l_antennanp
XFILLER_11_1106 VPWR VGND sg13cmos5l_fill_2
XFILLER_8_982 VPWR VGND sg13cmos5l_decap_8
XANTENNA__144__GATE Tile_X1Y0_FrameStrobe[0] VPWR VGND sg13cmos5l_antennanp
XANTENNA__159__GATE Tile_X1Y0_FrameStrobe[1] VPWR VGND sg13cmos5l_antennanp
XFILLER_0_1075 VPWR VGND sg13cmos5l_fill_1
XFILLER_5_418 VPWR VGND sg13cmos5l_decap_4
X_632_ _632_/X Tile_X1Y0_N2END[0] Tile_X1Y0_N4END[8] Tile_X1Y0_NN4END[7] _087_/X _156_/Q
+ _155_/Q VPWR VGND sg13cmos5l_mux4_1
X_563_ _563_/X Tile_X0Y0_N1END[3] Tile_X0Y0_N2MID[3] Tile_X0Y0_N2END[4] _092_/X _343_/Q
+ _342_/Q VPWR VGND sg13cmos5l_mux4_1
XFILLER_12_296 VPWR VGND sg13cmos5l_decap_8
XFILLER_13_797 VPWR VGND sg13cmos5l_fill_1
X_494_ Tile_X1Y0_FrameStrobe_O[15] Tile_X1Y0_FrameStrobe[15] VPWR VGND sg13cmos5l_buf_1
XFILLER_5_941 VPWR VGND sg13cmos5l_decap_8
XFILLER_5_89 VPWR VGND sg13cmos5l_fill_2
XANTENNA__090__A0 PMOD_IO_I2 VPWR VGND sg13cmos5l_antennanp
XANTENNA__620__A2 Tile_X1Y0_NN4END[12] VPWR VGND sg13cmos5l_antennanp
XFILLER_14_539 VPWR VGND sg13cmos5l_decap_8
XANTENNA__503__X Tile_X1Y0_S2BEG[0] VPWR VGND sg13cmos5l_antennanp
XFILLER_5_237 VPWR VGND sg13cmos5l_decap_8
XFILLER_5_215 VPWR VGND sg13cmos5l_fill_1
XFILLER_2_900 VPWR VGND sg13cmos5l_fill_2
XFILLER_1_476 VPWR VGND sg13cmos5l_decap_8
XANTENNA__611__A2 Tile_X1Y0_NN4END[3] VPWR VGND sg13cmos5l_antennanp
X_546_ Tile_X1Y0_SS4BEG[11] _635_/X VPWR VGND sg13cmos5l_buf_1
X_615_ _615_/X Tile_X1Y0_N2MID[7] Tile_X1Y0_N4END[8] Tile_X1Y0_NN4END[7] _085_/X _190_/Q
+ _189_/Q VPWR VGND sg13cmos5l_mux4_1
XFILLER_13_594 VPWR VGND sg13cmos5l_decap_8
X_477_ Tile_X1Y0_FrameData_O[30] Tile_X0Y0_FrameData[30] VPWR VGND sg13cmos5l_buf_1
XFILLER_9_543 VPWR VGND sg13cmos5l_decap_8
XANTENNA__413__X Tile_X0Y0_S1BEG[2] VPWR VGND sg13cmos5l_antennanp
XANTENNA__063__A0 PMOD_IO_I7 VPWR VGND sg13cmos5l_antennanp
XANTENNA__602__A2 Tile_X1Y0_N2END[5] VPWR VGND sg13cmos5l_antennanp
XFILLER_11_509 VPWR VGND sg13cmos5l_decap_8
XFILLER_13_1009 VPWR VGND sg13cmos5l_decap_8
XFILLER_2_218 VPWR VGND sg13cmos5l_decap_4
XFILLER_14_303 VPWR VGND sg13cmos5l_decap_8
X_331_ _331_/Q Tile_X0Y0_FrameData[22] VGND VPWR Tile_X0Y0_FrameStrobe[2] latch
X_400_ Tile_X0Y0_FrameStrobe_O[9] Tile_X0Y0_FrameStrobe[9] VPWR VGND sg13cmos5l_buf_1
XFILLER_10_520 VPWR VGND sg13cmos5l_decap_8
X_262_ _262_/Q Tile_X0Y0_FrameData[27] VGND VPWR Tile_X0Y0_FrameStrobe[0] latch
X_193_ _193_/Q Tile_X0Y0_FrameData[23] VGND VPWR Tile_X1Y0_FrameStrobe[2] latch
XFILLER_1_240 VPWR VGND sg13cmos5l_decap_4
XFILLER_6_557 VPWR VGND sg13cmos5l_decap_8
XFILLER_2_752 VPWR VGND sg13cmos5l_decap_8
XFILLER_2_730 VPWR VGND sg13cmos5l_fill_1
XFILLER_2_79 VPWR VGND sg13cmos5l_decap_8
XANTENNA__408__X Tile_X0Y0_FrameStrobe_O[17] VPWR VGND sg13cmos5l_antennanp
XANTENNA__596__A1 Tile_X0Y0_N4END[12] VPWR VGND sg13cmos5l_antennanp
XFILLER_14_870 VPWR VGND sg13cmos5l_fill_2
X_529_ Tile_X1Y0_S4BEG[10] _618_/X VPWR VGND sg13cmos5l_buf_1
XFILLER_9_351 VPWR VGND sg13cmos5l_decap_4
XANTENNA__587__A1 Tile_X0Y0_N4END[3] VPWR VGND sg13cmos5l_antennanp
XFILLER_11_88 VPWR VGND sg13cmos5l_decap_8
XFILLER_4_1029 VPWR VGND sg13cmos5l_decap_8
XANTENNA__578__A1 Tile_X0Y0_N4END[5] VPWR VGND sg13cmos5l_antennanp
XFILLER_14_177 VPWR VGND sg13cmos5l_decap_8
XFILLER_15_634 VPWR VGND sg13cmos5l_decap_8
X_314_ _314_/Q Tile_X0Y0_FrameData[7] VGND VPWR Tile_X0Y0_FrameStrobe[1] latch
XANTENNA__404__A Tile_X0Y0_FrameStrobe[13] VPWR VGND sg13cmos5l_antennanp
X_245_ _245_/Q Tile_X0Y0_UserCLK _245_/D _358_/L_HI VPWR VGND sg13cmos5l_dfrbpq_1
X_176_ _176_/Q Tile_X0Y0_FrameData[8] VGND VPWR Tile_X1Y0_FrameStrobe[1] latch
XANTENNA__569__A1 Tile_X0Y0_N4END[14] VPWR VGND sg13cmos5l_antennanp
XFILLER_14_1115 VPWR VGND sg13cmos5l_decap_4
XFILLER_0_519 VPWR VGND sg13cmos5l_fill_1
XFILLER_11_158 VPWR VGND sg13cmos5l_decap_8
XFILLER_12_659 VPWR VGND sg13cmos5l_decap_8
XFILLER_3_302 VPWR VGND sg13cmos5l_decap_4
XANTENNA__511__X Tile_X1Y0_S2BEGb[0] VPWR VGND sg13cmos5l_antennanp
XFILLER_4_858 VPWR VGND sg13cmos5l_decap_8
XFILLER_3_379 VPWR VGND sg13cmos5l_fill_1
XFILLER_3_368 VPWR VGND sg13cmos5l_decap_4
XANTENNA__421__X Tile_X0Y0_S2BEG[6] VPWR VGND sg13cmos5l_antennanp
X_228_ _228_/Q Tile_X0Y0_FrameData[21] VGND VPWR Tile_X1Y0_FrameStrobe[3] latch
X_159_ _159_/Q Tile_X0Y0_FrameData[25] VGND VPWR Tile_X1Y0_FrameStrobe[1] latch
XFILLER_7_641 VPWR VGND sg13cmos5l_fill_2
XFILLER_6_140 VPWR VGND sg13cmos5l_fill_1
XFILLER_3_891 VPWR VGND sg13cmos5l_decap_8
XFILLER_0_338 VPWR VGND sg13cmos5l_fill_1
XFILLER_1_817 VPWR VGND sg13cmos5l_fill_1
XANTENNA__312__GATE Tile_X0Y0_FrameStrobe[1] VPWR VGND sg13cmos5l_antennanp
XANTENNA__327__GATE Tile_X0Y0_FrameStrobe[2] VPWR VGND sg13cmos5l_antennanp
XANTENNA__506__X Tile_X1Y0_S2BEG[3] VPWR VGND sg13cmos5l_antennanp
XFILLER_9_917 VPWR VGND sg13cmos5l_fill_1
XFILLER_8_449 VPWR VGND sg13cmos5l_decap_8
XFILLER_0_861 VPWR VGND sg13cmos5l_fill_1
XFILLER_0_894 VPWR VGND sg13cmos5l_decap_4
XFILLER_12_8 VPWR VGND sg13cmos5l_fill_1
XANTENNA__641__A0 Tile_X0Y0_N2MID[3] VPWR VGND sg13cmos5l_antennanp
XANTENNA__416__X Tile_X0Y0_S2BEG[1] VPWR VGND sg13cmos5l_antennanp
XFILLER_15_283 VPWR VGND sg13cmos5l_decap_8
XFILLER_8_961 VPWR VGND sg13cmos5l_decap_8
XANTENNA__632__A0 Tile_X1Y0_N2END[0] VPWR VGND sg13cmos5l_antennanp
XFILLER_0_1087 VPWR VGND sg13cmos5l_fill_1
XFILLER_16_1018 VPWR VGND sg13cmos5l_fill_1
XFILLER_16_1029 VPWR VGND sg13cmos5l_decap_8
XFILLER_6_909 VPWR VGND sg13cmos5l_decap_8
XANTENNA__502__A Tile_X1Y0_N1END[0] VPWR VGND sg13cmos5l_antennanp
XFILLER_0_168 VPWR VGND sg13cmos5l_fill_2
XANTENNA__266__GATE Tile_X0Y0_FrameStrobe[0] VPWR VGND sg13cmos5l_antennanp
XANTENNA__623__A0 Tile_X1Y0_N2MID[7] VPWR VGND sg13cmos5l_antennanp
X_493_ Tile_X1Y0_FrameStrobe_O[14] Tile_X1Y0_FrameStrobe[14] VPWR VGND sg13cmos5l_buf_1
X_631_ _631_/X Tile_X1Y0_N2END[7] Tile_X1Y0_N4END[7] Tile_X1Y0_NN4END[8] _085_/X _158_/Q
+ _157_/Q VPWR VGND sg13cmos5l_mux4_1
X_562_ _562_/X Tile_X0Y0_N1END[2] Tile_X0Y0_N2MID[2] Tile_X0Y0_N2END[5] _091_/X _345_/Q
+ _344_/Q VPWR VGND sg13cmos5l_mux4_1
XFILLER_12_275 VPWR VGND sg13cmos5l_decap_8
XFILLER_8_235 VPWR VGND sg13cmos5l_decap_8
XANTENNA__204__GATE Tile_X1Y0_FrameStrobe[2] VPWR VGND sg13cmos5l_antennanp
XANTENNA__219__GATE Tile_X1Y0_FrameStrobe[3] VPWR VGND sg13cmos5l_antennanp
XANTENNA__412__A Tile_X0Y0_N1END[2] VPWR VGND sg13cmos5l_antennanp
XFILLER_5_997 VPWR VGND sg13cmos5l_decap_8
XFILLER_5_57 VPWR VGND sg13cmos5l_decap_8
XANTENNA__614__A0 Tile_X1Y0_N2MID[6] VPWR VGND sg13cmos5l_antennanp
XFILLER_7_290 VPWR VGND sg13cmos5l_decap_8
XANTENNA__605__A0 Tile_X1Y0_N1END[1] VPWR VGND sg13cmos5l_antennanp
XFILLER_14_518 VPWR VGND sg13cmos5l_decap_8
XANTENNA__248__CLK Tile_X0Y0_UserCLK VPWR VGND sg13cmos5l_antennanp
XFILLER_10_757 VPWR VGND sg13cmos5l_decap_8
XFILLER_10_779 VPWR VGND sg13cmos5l_fill_2
XFILLER_14_22 VPWR VGND sg13cmos5l_decap_8
XFILLER_14_44 VPWR VGND sg13cmos5l_fill_1
XFILLER_14_55 VPWR VGND sg13cmos5l_fill_1
XFILLER_14_88 VPWR VGND sg13cmos5l_decap_8
XFILLER_6_717 VPWR VGND sg13cmos5l_decap_8
XANTENNA__190__GATE Tile_X1Y0_FrameStrobe[2] VPWR VGND sg13cmos5l_antennanp
XFILLER_6_728 VPWR VGND sg13cmos5l_decap_8
XFILLER_7_1005 VPWR VGND sg13cmos5l_decap_4
XFILLER_2_978 VPWR VGND sg13cmos5l_decap_4
XANTENNA__407__A Tile_X0Y0_FrameStrobe[16] VPWR VGND sg13cmos5l_antennanp
X_476_ Tile_X1Y0_FrameData_O[29] Tile_X0Y0_FrameData[29] VPWR VGND sg13cmos5l_buf_1
X_545_ Tile_X1Y0_SS4BEG[10] _634_/X VPWR VGND sg13cmos5l_buf_1
X_614_ _614_/X Tile_X1Y0_N2MID[6] Tile_X1Y0_N4END[9] Tile_X1Y0_NN4END[6] _087_/X _192_/Q
+ _191_/Q VPWR VGND sg13cmos5l_mux4_1
XANTENNA__143__GATE Tile_X1Y0_FrameStrobe[0] VPWR VGND sg13cmos5l_antennanp
XFILLER_13_573 VPWR VGND sg13cmos5l_decap_8
XFILLER_9_522 VPWR VGND sg13cmos5l_decap_8
XANTENNA__158__GATE Tile_X1Y0_FrameStrobe[1] VPWR VGND sg13cmos5l_antennanp
XANTENNA__202__D Tile_X0Y0_FrameData[14] VPWR VGND sg13cmos5l_antennanp
XFILLER_14_359 VPWR VGND sg13cmos5l_decap_8
X_330_ _330_/Q Tile_X0Y0_FrameData[23] VGND VPWR Tile_X0Y0_FrameStrobe[2] latch
XFILLER_6_1093 VPWR VGND sg13cmos5l_decap_8
XANTENNA__514__X Tile_X1Y0_S2BEGb[3] VPWR VGND sg13cmos5l_antennanp
XFILLER_10_576 VPWR VGND sg13cmos5l_decap_8
X_261_ _261_/Q Tile_X0Y0_FrameData[28] VGND VPWR Tile_X0Y0_FrameStrobe[0] latch
X_192_ _192_/Q Tile_X0Y0_FrameData[24] VGND VPWR Tile_X1Y0_FrameStrobe[2] latch
XFILLER_6_536 VPWR VGND sg13cmos5l_decap_8
XFILLER_9_0 VPWR VGND sg13cmos5l_fill_2
XANTENNA__596__A2 Tile_X0Y0_NN4END[3] VPWR VGND sg13cmos5l_antennanp
XFILLER_2_58 VPWR VGND sg13cmos5l_decap_8
XFILLER_13_392 VPWR VGND sg13cmos5l_decap_8
X_459_ Tile_X1Y0_FrameData_O[12] Tile_X0Y0_FrameData[12] VPWR VGND sg13cmos5l_buf_1
X_528_ Tile_X1Y0_S4BEG[9] _617_/X VPWR VGND sg13cmos5l_buf_1
XFILLER_9_341 VPWR VGND sg13cmos5l_fill_2
XANTENNA__424__X Tile_X0Y0_S2BEGb[1] VPWR VGND sg13cmos5l_antennanp
XFILLER_12_1087 VPWR VGND sg13cmos5l_decap_8
XFILLER_9_363 VPWR VGND sg13cmos5l_decap_4
XFILLER_5_591 VPWR VGND sg13cmos5l_decap_8
XANTENNA__587__A2 Tile_X0Y0_NN4END[12] VPWR VGND sg13cmos5l_antennanp
XFILLER_12_808 VPWR VGND sg13cmos5l_decap_4
XANTENNA__510__A Tile_X1Y0_N2MID[0] VPWR VGND sg13cmos5l_antennanp
XFILLER_8_1100 VPWR VGND sg13cmos5l_decap_8
XFILLER_3_539 VPWR VGND sg13cmos5l_decap_8
XANTENNA__509__X Tile_X1Y0_S2BEG[6] VPWR VGND sg13cmos5l_antennanp
XANTENNA__578__A2 Tile_X0Y0_NN4END[10] VPWR VGND sg13cmos5l_antennanp
XFILLER_14_156 VPWR VGND sg13cmos5l_decap_8
XFILLER_15_613 VPWR VGND sg13cmos5l_decap_8
X_313_ _313_/Q Tile_X0Y0_FrameData[8] VGND VPWR Tile_X0Y0_FrameStrobe[1] latch
X_244_ _244_/Q Tile_X0Y0_UserCLK _244_/D _357_/L_HI VPWR VGND sg13cmos5l_dfrbpq_1
X_175_ _175_/Q Tile_X0Y0_FrameData[9] VGND VPWR Tile_X1Y0_FrameStrobe[1] latch
XFILLER_7_834 VPWR VGND sg13cmos5l_decap_8
XFILLER_6_300 VPWR VGND sg13cmos5l_decap_4
XANTENNA__420__A Tile_X0Y0_N2MID[2] VPWR VGND sg13cmos5l_antennanp
XFILLER_2_594 VPWR VGND sg13cmos5l_decap_8
XANTENNA__419__X Tile_X0Y0_S2BEG[4] VPWR VGND sg13cmos5l_antennanp
XANTENNA__569__A2 Tile_X0Y0_NN4END[1] VPWR VGND sg13cmos5l_antennanp
XFILLER_9_182 VPWR VGND sg13cmos5l_decap_8
XFILLER_9_160 VPWR VGND sg13cmos5l_fill_1
XFILLER_11_137 VPWR VGND sg13cmos5l_decap_8
XFILLER_12_638 VPWR VGND sg13cmos5l_decap_8
XFILLER_3_1096 VPWR VGND sg13cmos5l_decap_8
XANTENNA__505__A Tile_X1Y0_N2MID[5] VPWR VGND sg13cmos5l_antennanp
XFILLER_16_944 VPWR VGND sg13cmos5l_fill_1
XANTENNA__415__A Tile_X0Y0_N2MID[7] VPWR VGND sg13cmos5l_antennanp
XFILLER_11_660 VPWR VGND sg13cmos5l_decap_8
XFILLER_15_465 VPWR VGND sg13cmos5l_fill_2
X_227_ _227_/Q Tile_X0Y0_FrameData[20] VGND VPWR Tile_X1Y0_FrameStrobe[3] latch
X_158_ _158_/Q Tile_X0Y0_FrameData[26] VGND VPWR Tile_X1Y0_FrameStrobe[1] latch
X_089_ _089_/X _238_/Q _238_/D _234_/Q VPWR VGND sg13cmos5l_mux2_1
XFILLER_6_163 VPWR VGND sg13cmos5l_decap_8
XANTENNA__300__D Tile_X0Y0_FrameData[21] VPWR VGND sg13cmos5l_antennanp
XFILLER_1_807 VPWR VGND sg13cmos5l_fill_2
XANTENNA__210__D Tile_X0Y0_FrameData[6] VPWR VGND sg13cmos5l_antennanp
XFILLER_12_435 VPWR VGND sg13cmos5l_decap_8
XFILLER_9_929 VPWR VGND sg13cmos5l_decap_4
XFILLER_8_406 VPWR VGND sg13cmos5l_fill_2
XANTENNA__522__X Tile_X1Y0_S4BEG[3] VPWR VGND sg13cmos5l_antennanp
XFILLER_4_678 VPWR VGND sg13cmos5l_fill_2
XFILLER_4_623 VPWR VGND sg13cmos5l_decap_8
XFILLER_3_177 VPWR VGND sg13cmos5l_fill_1
XANTENNA__641__A1 Tile_X0Y0_N2END[4] VPWR VGND sg13cmos5l_antennanp
XFILLER_0_873 VPWR VGND sg13cmos5l_fill_2
XANTENNA__432__X Tile_X0Y0_S4BEG[1] VPWR VGND sg13cmos5l_antennanp
XFILLER_11_1108 VPWR VGND sg13cmos5l_fill_1
XFILLER_11_1119 VPWR VGND sg13cmos5l_fill_1
XFILLER_8_940 VPWR VGND sg13cmos5l_decap_8
XFILLER_7_494 VPWR VGND sg13cmos5l_decap_8
XANTENNA__632__A1 Tile_X1Y0_N4END[8] VPWR VGND sg13cmos5l_antennanp
XFILLER_0_1044 VPWR VGND sg13cmos5l_fill_1
XFILLER_10_928 VPWR VGND sg13cmos5l_fill_1
XANTENNA__205__D Tile_X0Y0_FrameData[11] VPWR VGND sg13cmos5l_antennanp
XANTENNA__623__A1 Tile_X1Y0_N4END[0] VPWR VGND sg13cmos5l_antennanp
X_630_ _630_/X Tile_X1Y0_N2END[6] Tile_X1Y0_N4END[6] Tile_X1Y0_NN4END[9] _095_/X _160_/Q
+ _159_/Q VPWR VGND sg13cmos5l_mux4_1
XANTENNA__517__X Tile_X1Y0_S2BEGb[6] VPWR VGND sg13cmos5l_antennanp
X_492_ Tile_X1Y0_FrameStrobe_O[13] Tile_X1Y0_FrameStrobe[13] VPWR VGND sg13cmos5l_buf_1
X_561_ _561_/X Tile_X0Y0_N1END[1] Tile_X0Y0_N2MID[1] Tile_X0Y0_N2END[6] _119_/X _347_/Q
+ _346_/Q VPWR VGND sg13cmos5l_mux4_1
XFILLER_12_254 VPWR VGND sg13cmos5l_decap_8
XFILLER_13_777 VPWR VGND sg13cmos5l_fill_2
XFILLER_8_214 VPWR VGND sg13cmos5l_decap_8
XFILLER_5_976 VPWR VGND sg13cmos5l_decap_8
XFILLER_5_47 VPWR VGND sg13cmos5l_decap_8
XFILLER_5_36 VPWR VGND sg13cmos5l_fill_2
XFILLER_4_497 VPWR VGND sg13cmos5l_decap_8
XFILLER_4_464 VPWR VGND sg13cmos5l_decap_8
XANTENNA__614__A1 Tile_X1Y0_N4END[9] VPWR VGND sg13cmos5l_antennanp
XANTENNA__427__X Tile_X0Y0_S2BEGb[4] VPWR VGND sg13cmos5l_antennanp
XFILLER_15_1030 VPWR VGND sg13cmos5l_decap_8
XFILLER_16_593 VPWR VGND sg13cmos5l_decap_8
XANTENNA__311__GATE Tile_X0Y0_FrameStrobe[1] VPWR VGND sg13cmos5l_antennanp
XANTENNA__326__GATE Tile_X0Y0_FrameStrobe[2] VPWR VGND sg13cmos5l_antennanp
XANTENNA__605__A1 Tile_X1Y0_N2MID[5] VPWR VGND sg13cmos5l_antennanp
XFILLER_10_725 VPWR VGND sg13cmos5l_fill_2
XFILLER_5_206 VPWR VGND sg13cmos5l_decap_8
XFILLER_1_412 VPWR VGND sg13cmos5l_decap_4
XFILLER_1_445 VPWR VGND sg13cmos5l_decap_4
XFILLER_1_456 VPWR VGND sg13cmos5l_decap_8
XFILLER_1_467 VPWR VGND sg13cmos5l_fill_1
XFILLER_2_946 VPWR VGND sg13cmos5l_decap_8
X_613_ _613_/X Tile_X1Y0_N2MID[5] Tile_X1Y0_N4END[10] Tile_X1Y0_NN4END[5] _089_/X
+ _194_/Q _193_/Q VPWR VGND sg13cmos5l_mux4_1
XFILLER_13_552 VPWR VGND sg13cmos5l_decap_8
X_475_ Tile_X1Y0_FrameData_O[28] Tile_X0Y0_FrameData[28] VPWR VGND sg13cmos5l_buf_1
X_544_ Tile_X1Y0_SS4BEG[9] _633_/X VPWR VGND sg13cmos5l_buf_1
XFILLER_9_501 VPWR VGND sg13cmos5l_decap_8
XFILLER_9_578 VPWR VGND sg13cmos5l_decap_8
XANTENNA__599__A0 Tile_X0Y0_N2END[7] VPWR VGND sg13cmos5l_antennanp
XFILLER_16_390 VPWR VGND sg13cmos5l_decap_8
XANTENNA__265__GATE Tile_X0Y0_FrameStrobe[0] VPWR VGND sg13cmos5l_antennanp
XANTENNA__203__GATE Tile_X1Y0_FrameStrobe[2] VPWR VGND sg13cmos5l_antennanp
XFILLER_6_1072 VPWR VGND sg13cmos5l_decap_8
XANTENNA__218__GATE Tile_X1Y0_FrameStrobe[3] VPWR VGND sg13cmos5l_antennanp
XANTENNA__508__A Tile_X1Y0_N2MID[2] VPWR VGND sg13cmos5l_antennanp
XFILLER_14_338 VPWR VGND sg13cmos5l_decap_8
X_260_ _260_/Q Tile_X0Y0_FrameData[29] VGND VPWR Tile_X0Y0_FrameStrobe[0] latch
XFILLER_10_555 VPWR VGND sg13cmos5l_decap_8
X_191_ _191_/Q Tile_X0Y0_FrameData[25] VGND VPWR Tile_X1Y0_FrameStrobe[2] latch
XFILLER_6_515 VPWR VGND sg13cmos5l_decap_8
XANTENNA__530__X Tile_X1Y0_S4BEG[11] VPWR VGND sg13cmos5l_antennanp
XFILLER_1_275 VPWR VGND sg13cmos5l_decap_4
XFILLER_2_776 VPWR VGND sg13cmos5l_decap_8
XANTENNA__418__A Tile_X0Y0_N2MID[4] VPWR VGND sg13cmos5l_antennanp
X_527_ Tile_X1Y0_S4BEG[8] _616_/X VPWR VGND sg13cmos5l_buf_1
XFILLER_12_1011 VPWR VGND sg13cmos5l_decap_8
XFILLER_13_371 VPWR VGND sg13cmos5l_decap_8
XFILLER_14_872 VPWR VGND sg13cmos5l_fill_1
X_389_ Tile_X0Y0_SS4BEG[14] _598_/X VPWR VGND sg13cmos5l_buf_1
X_458_ Tile_X1Y0_FrameData_O[11] Tile_X0Y0_FrameData[11] VPWR VGND sg13cmos5l_buf_1
XFILLER_9_386 VPWR VGND sg13cmos5l_decap_8
XANTENNA__303__D Tile_X0Y0_FrameData[18] VPWR VGND sg13cmos5l_antennanp
XANTENNA__440__X Tile_X0Y0_S4BEG[9] VPWR VGND sg13cmos5l_antennanp
XFILLER_12_1066 VPWR VGND sg13cmos5l_decap_8
XFILLER_5_570 VPWR VGND sg13cmos5l_decap_8
XANTENNA__238__CLK Tile_X0Y0_UserCLK VPWR VGND sg13cmos5l_antennanp
XFILLER_11_24 VPWR VGND sg13cmos5l_decap_8
XFILLER_3_518 VPWR VGND sg13cmos5l_decap_8
XANTENNA__213__D Tile_X0Y0_FrameData[3] VPWR VGND sg13cmos5l_antennanp
XFILLER_11_79 VPWR VGND sg13cmos5l_decap_4
XANTENNA__142__GATE Tile_X1Y0_FrameStrobe[0] VPWR VGND sg13cmos5l_antennanp
XFILLER_14_102 VPWR VGND sg13cmos5l_decap_8
XANTENNA__157__GATE Tile_X1Y0_FrameStrobe[1] VPWR VGND sg13cmos5l_antennanp
XANTENNA__525__X Tile_X1Y0_S4BEG[6] VPWR VGND sg13cmos5l_antennanp
XFILLER_14_135 VPWR VGND sg13cmos5l_decap_8
XFILLER_15_669 VPWR VGND sg13cmos5l_decap_8
X_312_ _312_/Q Tile_X0Y0_FrameData[9] VGND VPWR Tile_X0Y0_FrameStrobe[1] latch
X_243_ _243_/Q Tile_X0Y0_UserCLK _243_/D _360_/L_HI VPWR VGND sg13cmos5l_dfrbpq_1
XANTENNA__123__D Tile_X0Y0_FrameData[29] VPWR VGND sg13cmos5l_antennanp
XFILLER_10_385 VPWR VGND sg13cmos5l_decap_8
XFILLER_10_396 VPWR VGND sg13cmos5l_fill_1
X_174_ _174_/Q Tile_X0Y0_FrameData[10] VGND VPWR Tile_X1Y0_FrameStrobe[1] latch
XFILLER_2_573 VPWR VGND sg13cmos5l_decap_8
XANTENNA__435__X Tile_X0Y0_S4BEG[4] VPWR VGND sg13cmos5l_antennanp
XFILLER_14_1106 VPWR VGND sg13cmos5l_decap_4
XFILLER_3_1075 VPWR VGND sg13cmos5l_decap_8
XANTENNA__208__D Tile_X0Y0_FrameData[8] VPWR VGND sg13cmos5l_antennanp
XFILLER_11_116 VPWR VGND sg13cmos5l_decap_8
XFILLER_12_617 VPWR VGND sg13cmos5l_decap_8
XFILLER_3_315 VPWR VGND sg13cmos5l_fill_2
XFILLER_15_411 VPWR VGND sg13cmos5l_fill_1
XFILLER_15_444 VPWR VGND sg13cmos5l_decap_8
XFILLER_16_989 VPWR VGND sg13cmos5l_decap_4
XFILLER_10_160 VPWR VGND sg13cmos5l_decap_8
X_226_ _226_/Q Tile_X0Y0_FrameData[19] VGND VPWR Tile_X1Y0_FrameStrobe[3] latch
X_157_ _157_/Q Tile_X0Y0_FrameData[27] VGND VPWR Tile_X1Y0_FrameStrobe[1] latch
XFILLER_8_69 VPWR VGND sg13cmos5l_decap_8
X_088_ _238_/D PMOD_IO_I3 _555_/X _222_/Q VPWR VGND sg13cmos5l_mux2_1
XFILLER_5_1115 VPWR VGND sg13cmos5l_decap_4
XFILLER_12_414 VPWR VGND sg13cmos5l_fill_1
XFILLER_4_657 VPWR VGND sg13cmos5l_decap_8
XFILLER_4_602 VPWR VGND sg13cmos5l_decap_8
XFILLER_3_112 VPWR VGND sg13cmos5l_fill_1
XANTENNA__641__A2 Tile_X0Y0_N4END[11] VPWR VGND sg13cmos5l_antennanp
XFILLER_0_885 VPWR VGND sg13cmos5l_fill_2
XFILLER_15_263 VPWR VGND sg13cmos5l_decap_8
X_209_ _209_/Q Tile_X0Y0_FrameData[7] VGND VPWR Tile_X1Y0_FrameStrobe[2] latch
XFILLER_8_996 VPWR VGND sg13cmos5l_decap_8
XANTENNA__311__D Tile_X0Y0_FrameData[10] VPWR VGND sg13cmos5l_antennanp
XANTENNA__632__A2 Tile_X1Y0_NN4END[7] VPWR VGND sg13cmos5l_antennanp
XFILLER_0_126 VPWR VGND sg13cmos5l_fill_2
XFILLER_1_649 VPWR VGND sg13cmos5l_decap_8
XANTENNA__084__A0 PMOD_IO_I5 VPWR VGND sg13cmos5l_antennanp
XANTENNA__221__D Tile_X0Y0_FrameData[31] VPWR VGND sg13cmos5l_antennanp
XANTENNA__623__A2 Tile_X1Y0_NN4END[15] VPWR VGND sg13cmos5l_antennanp
X_560_ _560_/X Tile_X0Y0_N1END[0] Tile_X0Y0_N2MID[0] Tile_X0Y0_N2END[7] _092_/X _349_/Q
+ _348_/Q VPWR VGND sg13cmos5l_mux4_1
XFILLER_13_701 VPWR VGND sg13cmos5l_fill_2
XFILLER_13_734 VPWR VGND sg13cmos5l_fill_2
X_491_ Tile_X1Y0_FrameStrobe_O[12] Tile_X1Y0_FrameStrobe[12] VPWR VGND sg13cmos5l_buf_1
XFILLER_9_705 VPWR VGND sg13cmos5l_fill_1
XANTENNA__533__X Tile_X1Y0_S4BEG[14] VPWR VGND sg13cmos5l_antennanp
XFILLER_9_749 VPWR VGND sg13cmos5l_decap_4
XFILLER_5_955 VPWR VGND sg13cmos5l_decap_8
XFILLER_4_443 VPWR VGND sg13cmos5l_decap_8
XANTENNA__131__D Tile_X0Y0_FrameData[21] VPWR VGND sg13cmos5l_antennanp
XFILLER_4_476 VPWR VGND sg13cmos5l_decap_8
XANTENNA__614__A2 Tile_X1Y0_NN4END[6] VPWR VGND sg13cmos5l_antennanp
XANTENNA__306__D Tile_X0Y0_FrameData[15] VPWR VGND sg13cmos5l_antennanp
XANTENNA__443__X Tile_X0Y0_S4BEG[12] VPWR VGND sg13cmos5l_antennanp
XFILLER_16_572 VPWR VGND sg13cmos5l_decap_8
XANTENNA__605__A2 Tile_X1Y0_N2END[2] VPWR VGND sg13cmos5l_antennanp
XFILLER_2_1118 VPWR VGND sg13cmos5l_fill_2
XANTENNA__072__Y PMOD_IO_OE_O2 VPWR VGND sg13cmos5l_antennanp
XANTENNA__216__D Tile_X0Y0_FrameData[0] VPWR VGND sg13cmos5l_antennanp
XFILLER_10_704 VPWR VGND sg13cmos5l_decap_8
XFILLER_10_748 VPWR VGND sg13cmos5l_fill_2
XANTENNA__528__X Tile_X1Y0_S4BEG[9] VPWR VGND sg13cmos5l_antennanp
X_543_ Tile_X1Y0_SS4BEG[8] _632_/X VPWR VGND sg13cmos5l_buf_1
X_612_ _612_/X Tile_X1Y0_N2MID[4] Tile_X1Y0_N4END[11] Tile_X1Y0_NN4END[4] _064_/X
+ _196_/Q _195_/Q VPWR VGND sg13cmos5l_mux4_1
XANTENNA__126__D Tile_X0Y0_FrameData[26] VPWR VGND sg13cmos5l_antennanp
XFILLER_13_531 VPWR VGND sg13cmos5l_decap_8
X_474_ Tile_X1Y0_FrameData_O[27] Tile_X0Y0_FrameData[27] VPWR VGND sg13cmos5l_buf_1
XFILLER_9_557 VPWR VGND sg13cmos5l_decap_8
XFILLER_5_796 VPWR VGND sg13cmos5l_decap_8
XFILLER_4_284 VPWR VGND sg13cmos5l_decap_8
XFILLER_4_273 VPWR VGND sg13cmos5l_decap_4
XFILLER_4_240 VPWR VGND sg13cmos5l_fill_2
XANTENNA__599__A1 Tile_X0Y0_N4END[15] VPWR VGND sg13cmos5l_antennanp
XFILLER_1_991 VPWR VGND sg13cmos5l_decap_4
XANTENNA__438__X Tile_X0Y0_S4BEG[7] VPWR VGND sg13cmos5l_antennanp
XFILLER_6_91 VPWR VGND sg13cmos5l_fill_1
XFILLER_6_80 VPWR VGND sg13cmos5l_decap_8
XFILLER_10_534 VPWR VGND sg13cmos5l_decap_8
XFILLER_14_317 VPWR VGND sg13cmos5l_decap_8
X_190_ _190_/Q Tile_X0Y0_FrameData[26] VGND VPWR Tile_X1Y0_FrameStrobe[2] latch
XANTENNA__310__GATE Tile_X0Y0_FrameStrobe[1] VPWR VGND sg13cmos5l_antennanp
XFILLER_2_49 VPWR VGND sg13cmos5l_decap_4
XANTENNA__325__GATE Tile_X0Y0_FrameStrobe[2] VPWR VGND sg13cmos5l_antennanp
X_526_ Tile_X1Y0_S4BEG[7] _615_/X VPWR VGND sg13cmos5l_buf_1
XFILLER_12_1023 VPWR VGND sg13cmos5l_fill_1
XFILLER_13_350 VPWR VGND sg13cmos5l_decap_8
X_388_ Tile_X0Y0_SS4BEG[13] _597_/X VPWR VGND sg13cmos5l_buf_1
X_457_ Tile_X1Y0_FrameData_O[10] Tile_X0Y0_FrameData[10] VPWR VGND sg13cmos5l_buf_1
XFILLER_9_343 VPWR VGND sg13cmos5l_fill_1
XFILLER_15_648 VPWR VGND sg13cmos5l_decap_8
XFILLER_10_364 VPWR VGND sg13cmos5l_decap_8
X_311_ _311_/Q Tile_X0Y0_FrameData[10] VGND VPWR Tile_X0Y0_FrameStrobe[1] latch
X_242_ _242_/Q Tile_X0Y0_UserCLK _242_/D _359_/L_HI VPWR VGND sg13cmos5l_dfrbpq_1
X_173_ _173_/Q Tile_X0Y0_FrameData[11] VGND VPWR Tile_X1Y0_FrameStrobe[1] latch
XFILLER_7_803 VPWR VGND sg13cmos5l_fill_2
XANTENNA__541__X Tile_X1Y0_SS4BEG[6] VPWR VGND sg13cmos5l_antennanp
XFILLER_2_552 VPWR VGND sg13cmos5l_decap_8
XFILLER_6_346 VPWR VGND sg13cmos5l_fill_1
XANTENNA__264__GATE Tile_X0Y0_FrameStrobe[0] VPWR VGND sg13cmos5l_antennanp
X_509_ Tile_X1Y0_S2BEG[6] Tile_X1Y0_N2MID[1] VPWR VGND sg13cmos5l_buf_1
XANTENNA__202__GATE Tile_X1Y0_FrameStrobe[2] VPWR VGND sg13cmos5l_antennanp
XANTENNA__279__GATE Tile_X0Y0_FrameStrobe[0] VPWR VGND sg13cmos5l_antennanp
XANTENNA__314__D Tile_X0Y0_FrameData[7] VPWR VGND sg13cmos5l_antennanp
XANTENNA__451__X Tile_X1Y0_FrameData_O[4] VPWR VGND sg13cmos5l_antennanp
XFILLER_13_191 VPWR VGND sg13cmos5l_decap_8
XFILLER_9_151 VPWR VGND sg13cmos5l_decap_8
XANTENNA__217__GATE Tile_X1Y0_FrameStrobe[3] VPWR VGND sg13cmos5l_antennanp
XFILLER_3_92 VPWR VGND sg13cmos5l_decap_8
XFILLER_3_1054 VPWR VGND sg13cmos5l_decap_8
XANTENNA__224__D Tile_X0Y0_FrameData[17] VPWR VGND sg13cmos5l_antennanp
XFILLER_4_839 VPWR VGND sg13cmos5l_decap_4
XFILLER_3_349 VPWR VGND sg13cmos5l_fill_1
XANTENNA__536__X Tile_X1Y0_SS4BEG[1] VPWR VGND sg13cmos5l_antennanp
XFILLER_15_423 VPWR VGND sg13cmos5l_decap_8
XFILLER_15_467 VPWR VGND sg13cmos5l_fill_1
XFILLER_15_478 VPWR VGND sg13cmos5l_fill_2
XFILLER_16_968 VPWR VGND sg13cmos5l_decap_4
XFILLER_16_979 VPWR VGND sg13cmos5l_fill_1
XANTENNA__134__D Tile_X0Y0_FrameData[18] VPWR VGND sg13cmos5l_antennanp
X_225_ _225_/Q Tile_X0Y0_FrameData[18] VGND VPWR Tile_X1Y0_FrameStrobe[3] latch
X_156_ _156_/Q Tile_X0Y0_FrameData[28] VGND VPWR Tile_X1Y0_FrameStrobe[1] latch
X_087_ _087_/X _239_/Q _239_/D _234_/Q VPWR VGND sg13cmos5l_mux2_1
XFILLER_8_48 VPWR VGND sg13cmos5l_decap_8
XFILLER_7_655 VPWR VGND sg13cmos5l_fill_1
XFILLER_6_110 VPWR VGND sg13cmos5l_decap_8
XANTENNA__644__A0 Tile_X1Y0_N2MID[3] VPWR VGND sg13cmos5l_antennanp
XANTENNA__309__D Tile_X0Y0_FrameData[12] VPWR VGND sg13cmos5l_antennanp
XANTENNA__446__X Tile_X0Y0_S4BEG[15] VPWR VGND sg13cmos5l_antennanp
XANTENNA__141__GATE Tile_X1Y0_FrameStrobe[0] VPWR VGND sg13cmos5l_antennanp
XANTENNA__156__GATE Tile_X1Y0_FrameStrobe[1] VPWR VGND sg13cmos5l_antennanp
XANTENNA__635__A0 Tile_X1Y0_N2END[3] VPWR VGND sg13cmos5l_antennanp
XFILLER_5_1105 VPWR VGND sg13cmos5l_decap_4
XANTENNA__219__D Tile_X0Y0_FrameData[29] VPWR VGND sg13cmos5l_antennanp
XFILLER_16_209 VPWR VGND sg13cmos5l_decap_8
XFILLER_8_419 VPWR VGND sg13cmos5l_decap_8
XANTENNA__626__A0 Tile_X1Y0_N2END[2] VPWR VGND sg13cmos5l_antennanp
XFILLER_0_831 VPWR VGND sg13cmos5l_fill_2
XFILLER_4_647 VPWR VGND sg13cmos5l_decap_4
XANTENNA__641__A3 Tile_X0Y0_NN4END[11] VPWR VGND sg13cmos5l_antennanp
XANTENNA__129__D Tile_X0Y0_FrameData[23] VPWR VGND sg13cmos5l_antennanp
XFILLER_12_960 VPWR VGND sg13cmos5l_fill_2
XFILLER_12_982 VPWR VGND sg13cmos5l_decap_4
XFILLER_15_242 VPWR VGND sg13cmos5l_decap_8
XFILLER_15_297 VPWR VGND sg13cmos5l_fill_2
XFILLER_11_481 VPWR VGND sg13cmos5l_decap_8
X_208_ _208_/Q Tile_X0Y0_FrameData[8] VGND VPWR Tile_X1Y0_FrameStrobe[2] latch
X_139_ _139_/Q Tile_X0Y0_FrameData[13] VGND VPWR Tile_X1Y0_FrameStrobe[0] latch
XFILLER_8_975 VPWR VGND sg13cmos5l_decap_8
XFILLER_7_463 VPWR VGND sg13cmos5l_fill_2
XFILLER_7_452 VPWR VGND sg13cmos5l_decap_8
XANTENNA__617__A0 Tile_X1Y0_N2MID[1] VPWR VGND sg13cmos5l_antennanp
XFILLER_3_691 VPWR VGND sg13cmos5l_decap_8
XFILLER_3_680 VPWR VGND sg13cmos5l_decap_4
XFILLER_0_1079 VPWR VGND sg13cmos5l_fill_1
XANTENNA__608__A0 Tile_X1Y0_N2MID[0] VPWR VGND sg13cmos5l_antennanp
XFILLER_9_1093 VPWR VGND sg13cmos5l_decap_8
XFILLER_12_212 VPWR VGND sg13cmos5l_decap_8
X_490_ Tile_X1Y0_FrameStrobe_O[11] Tile_X1Y0_FrameStrobe[11] VPWR VGND sg13cmos5l_buf_1
XFILLER_12_289 VPWR VGND sg13cmos5l_decap_8
XFILLER_8_249 VPWR VGND sg13cmos5l_decap_4
XFILLER_5_934 VPWR VGND sg13cmos5l_decap_8
XFILLER_5_923 VPWR VGND sg13cmos5l_fill_1
XFILLER_4_422 VPWR VGND sg13cmos5l_decap_8
XFILLER_4_400 VPWR VGND sg13cmos5l_decap_8
XFILLER_0_650 VPWR VGND sg13cmos5l_fill_2
XFILLER_16_551 VPWR VGND sg13cmos5l_decap_8
XANTENNA__322__D Tile_X0Y0_FrameData[31] VPWR VGND sg13cmos5l_antennanp
XANTENNA__232__D Tile_X0Y0_FrameData[25] VPWR VGND sg13cmos5l_antennanp
XFILLER_13_510 VPWR VGND sg13cmos5l_decap_8
X_473_ Tile_X1Y0_FrameData_O[26] Tile_X0Y0_FrameData[26] VPWR VGND sg13cmos5l_buf_1
X_542_ Tile_X1Y0_SS4BEG[7] _631_/X VPWR VGND sg13cmos5l_buf_1
X_611_ _611_/X Tile_X1Y0_N2MID[3] Tile_X1Y0_N4END[12] Tile_X1Y0_NN4END[3] _095_/X
+ _198_/Q _197_/Q VPWR VGND sg13cmos5l_mux4_1
XANTENNA__544__X Tile_X1Y0_SS4BEG[9] VPWR VGND sg13cmos5l_antennanp
XFILLER_13_587 VPWR VGND sg13cmos5l_decap_8
XFILLER_9_536 VPWR VGND sg13cmos5l_decap_8
XANTENNA__142__D Tile_X0Y0_FrameData[10] VPWR VGND sg13cmos5l_antennanp
XFILLER_5_775 VPWR VGND sg13cmos5l_fill_2
XANTENNA__599__A2 Tile_X0Y0_NN4END[0] VPWR VGND sg13cmos5l_antennanp
XANTENNA__317__D Tile_X0Y0_FrameData[4] VPWR VGND sg13cmos5l_antennanp
XANTENNA__454__X Tile_X1Y0_FrameData_O[7] VPWR VGND sg13cmos5l_antennanp
XANTENNA__227__D Tile_X0Y0_FrameData[20] VPWR VGND sg13cmos5l_antennanp
XFILLER_10_513 VPWR VGND sg13cmos5l_decap_8
XFILLER_1_233 VPWR VGND sg13cmos5l_decap_8
XFILLER_2_701 VPWR VGND sg13cmos5l_decap_8
XANTENNA__539__X Tile_X1Y0_SS4BEG[4] VPWR VGND sg13cmos5l_antennanp
XFILLER_1_266 VPWR VGND sg13cmos5l_fill_1
XANTENNA__137__D Tile_X0Y0_FrameData[15] VPWR VGND sg13cmos5l_antennanp
X_456_ Tile_X1Y0_FrameData_O[9] Tile_X0Y0_FrameData[9] VPWR VGND sg13cmos5l_buf_1
X_525_ Tile_X1Y0_S4BEG[6] _614_/X VPWR VGND sg13cmos5l_buf_1
X_387_ Tile_X0Y0_SS4BEG[12] _596_/X VPWR VGND sg13cmos5l_buf_1
XFILLER_9_355 VPWR VGND sg13cmos5l_fill_1
XANTENNA__450__A Tile_X0Y0_FrameData[3] VPWR VGND sg13cmos5l_antennanp
XANTENNA__449__X Tile_X1Y0_FrameData_O[2] VPWR VGND sg13cmos5l_antennanp
XFILLER_15_627 VPWR VGND sg13cmos5l_decap_8
X_310_ _310_/Q Tile_X0Y0_FrameData[11] VGND VPWR Tile_X0Y0_FrameStrobe[1] latch
XFILLER_10_332 VPWR VGND sg13cmos5l_decap_4
XFILLER_11_888 VPWR VGND sg13cmos5l_fill_1
X_241_ _241_/Q Tile_X0Y0_UserCLK _241_/D _362_/L_HI VPWR VGND sg13cmos5l_dfrbpq_1
X_172_ _172_/Q Tile_X0Y0_FrameData[12] VGND VPWR Tile_X1Y0_FrameStrobe[1] latch
XFILLER_2_531 VPWR VGND sg13cmos5l_decap_8
XFILLER_7_0 VPWR VGND sg13cmos5l_fill_2
XFILLER_13_170 VPWR VGND sg13cmos5l_decap_8
XFILLER_14_1119 VPWR VGND sg13cmos5l_fill_1
XFILLER_14_682 VPWR VGND sg13cmos5l_decap_8
X_439_ Tile_X0Y0_S4BEG[8] _576_/X VPWR VGND sg13cmos5l_buf_1
X_508_ Tile_X1Y0_S2BEG[5] Tile_X1Y0_N2MID[2] VPWR VGND sg13cmos5l_buf_1
XANTENNA__330__D Tile_X0Y0_FrameData[23] VPWR VGND sg13cmos5l_antennanp
XFILLER_3_71 VPWR VGND sg13cmos5l_fill_1
XFILLER_3_60 VPWR VGND sg13cmos5l_fill_1
XFILLER_3_1011 VPWR VGND sg13cmos5l_decap_8
XFILLER_3_1033 VPWR VGND sg13cmos5l_fill_2
XANTENNA__324__GATE Tile_X0Y0_FrameStrobe[2] VPWR VGND sg13cmos5l_antennanp
XFILLER_3_306 VPWR VGND sg13cmos5l_fill_1
XANTENNA__339__GATE Tile_X0Y0_FrameStrobe[2] VPWR VGND sg13cmos5l_antennanp
XFILLER_15_402 VPWR VGND sg13cmos5l_decap_8
X_224_ _224_/Q Tile_X0Y0_FrameData[17] VGND VPWR Tile_X1Y0_FrameStrobe[3] latch
XFILLER_11_674 VPWR VGND sg13cmos5l_decap_4
X_155_ _155_/Q Tile_X0Y0_FrameData[29] VGND VPWR Tile_X1Y0_FrameStrobe[1] latch
X_086_ _239_/D PMOD_IO_I4 _556_/X _222_/Q VPWR VGND sg13cmos5l_mux2_1
XFILLER_7_634 VPWR VGND sg13cmos5l_decap_8
XANTENNA__150__D Tile_X0Y0_FrameData[2] VPWR VGND sg13cmos5l_antennanp
XANTENNA__644__A1 Tile_X1Y0_N2END[4] VPWR VGND sg13cmos5l_antennanp
XANTENNA__325__D Tile_X0Y0_FrameData[28] VPWR VGND sg13cmos5l_antennanp
XANTENNA__462__X Tile_X1Y0_FrameData_O[15] VPWR VGND sg13cmos5l_antennanp
XANTENNA__580__A0 Tile_X0Y0_N2MID[4] VPWR VGND sg13cmos5l_antennanp
XFILLER_14_490 VPWR VGND sg13cmos5l_decap_8
XFILLER_15_991 VPWR VGND sg13cmos5l_fill_1
XANTENNA__635__A1 Tile_X1Y0_N4END[11] VPWR VGND sg13cmos5l_antennanp
XFILLER_12_449 VPWR VGND sg13cmos5l_fill_1
XANTENNA__571__A0 Tile_X0Y0_N2MID[3] VPWR VGND sg13cmos5l_antennanp
XFILLER_4_637 VPWR VGND sg13cmos5l_fill_2
XFILLER_3_103 VPWR VGND sg13cmos5l_fill_2
XANTENNA__263__GATE Tile_X0Y0_FrameStrobe[0] VPWR VGND sg13cmos5l_antennanp
XANTENNA__278__GATE Tile_X0Y0_FrameStrobe[0] VPWR VGND sg13cmos5l_antennanp
XANTENNA__626__A1 Tile_X1Y0_N4END[2] VPWR VGND sg13cmos5l_antennanp
XFILLER_0_865 VPWR VGND sg13cmos5l_decap_4
XFILLER_0_887 VPWR VGND sg13cmos5l_fill_1
XFILLER_0_898 VPWR VGND sg13cmos5l_fill_1
XANTENNA__201__GATE Tile_X1Y0_FrameStrobe[2] VPWR VGND sg13cmos5l_antennanp
XANTENNA__547__X Tile_X1Y0_SS4BEG[12] VPWR VGND sg13cmos5l_antennanp
XFILLER_15_221 VPWR VGND sg13cmos5l_decap_8
XFILLER_16_733 VPWR VGND sg13cmos5l_fill_2
XANTENNA__145__D Tile_X0Y0_FrameData[7] VPWR VGND sg13cmos5l_antennanp
XANTENNA__216__GATE Tile_X1Y0_FrameStrobe[2] VPWR VGND sg13cmos5l_antennanp
XANTENNA__562__A0 Tile_X0Y0_N1END[2] VPWR VGND sg13cmos5l_antennanp
XFILLER_15_276 VPWR VGND sg13cmos5l_decap_8
X_207_ _207_/Q Tile_X0Y0_FrameData[9] VGND VPWR Tile_X1Y0_FrameStrobe[2] latch
XFILLER_8_954 VPWR VGND sg13cmos5l_decap_8
XFILLER_8_910 VPWR VGND sg13cmos5l_decap_4
X_138_ _138_/Q Tile_X0Y0_FrameData[14] VGND VPWR Tile_X1Y0_FrameStrobe[0] latch
X_069_ PMOD_IO_OE_O0 _223_/Q _066_/X _068_/Y VPWR VGND sg13cmos5l_a21oi_1
XANTENNA__617__A1 Tile_X1Y0_N4END[6] VPWR VGND sg13cmos5l_antennanp
XANTENNA__457__X Tile_X1Y0_FrameData_O[10] VPWR VGND sg13cmos5l_antennanp
XANTENNA__553__A0 Tile_X0Y0_N2MID[2] VPWR VGND sg13cmos5l_antennanp
XFILLER_9_92 VPWR VGND sg13cmos5l_decap_8
XANTENNA__608__A1 Tile_X1Y0_N4END[15] VPWR VGND sg13cmos5l_antennanp
XFILLER_9_1072 VPWR VGND sg13cmos5l_decap_8
XFILLER_12_268 VPWR VGND sg13cmos5l_decap_8
XFILLER_9_718 VPWR VGND sg13cmos5l_fill_2
XFILLER_8_228 VPWR VGND sg13cmos5l_decap_8
XANTENNA__140__GATE Tile_X1Y0_FrameStrobe[0] VPWR VGND sg13cmos5l_antennanp
XANTENNA__155__GATE Tile_X1Y0_FrameStrobe[1] VPWR VGND sg13cmos5l_antennanp
XANTENNA__453__A Tile_X0Y0_FrameData[6] VPWR VGND sg13cmos5l_antennanp
XFILLER_7_283 VPWR VGND sg13cmos5l_decap_8
XFILLER_14_15 VPWR VGND sg13cmos5l_fill_1
XFILLER_14_48 VPWR VGND sg13cmos5l_fill_1
X_610_ _610_/X Tile_X1Y0_N2MID[2] Tile_X1Y0_N4END[13] Tile_X1Y0_NN4END[2] _085_/X
+ _200_/Q _199_/Q VPWR VGND sg13cmos5l_mux4_1
XFILLER_7_1009 VPWR VGND sg13cmos5l_fill_2
X_472_ Tile_X1Y0_FrameData_O[25] Tile_X0Y0_FrameData[25] VPWR VGND sg13cmos5l_buf_1
X_541_ Tile_X1Y0_SS4BEG[6] _630_/X VPWR VGND sg13cmos5l_buf_1
XFILLER_13_566 VPWR VGND sg13cmos5l_decap_8
XFILLER_9_515 VPWR VGND sg13cmos5l_decap_8
XFILLER_5_710 VPWR VGND sg13cmos5l_decap_4
XFILLER_1_971 VPWR VGND sg13cmos5l_fill_1
XFILLER_4_264 VPWR VGND sg13cmos5l_fill_2
XFILLER_4_220 VPWR VGND sg13cmos5l_decap_4
XANTENNA__448__A Tile_X0Y0_FrameData[1] VPWR VGND sg13cmos5l_antennanp
XFILLER_0_481 VPWR VGND sg13cmos5l_decap_4
XFILLER_0_492 VPWR VGND sg13cmos5l_fill_1
XANTENNA__333__D Tile_X0Y0_FrameData[20] VPWR VGND sg13cmos5l_antennanp
XANTENNA__470__X Tile_X1Y0_FrameData_O[23] VPWR VGND sg13cmos5l_antennanp
XFILLER_6_1053 VPWR VGND sg13cmos5l_fill_1
XFILLER_6_1042 VPWR VGND sg13cmos5l_decap_8
XFILLER_6_1031 VPWR VGND sg13cmos5l_decap_4
XFILLER_6_1086 VPWR VGND sg13cmos5l_decap_8
XFILLER_10_569 VPWR VGND sg13cmos5l_decap_8
XFILLER_6_529 VPWR VGND sg13cmos5l_decap_8
XANTENNA__380__X Tile_X0Y0_SS4BEG[5] VPWR VGND sg13cmos5l_antennanp
XFILLER_1_212 VPWR VGND sg13cmos5l_decap_8
XFILLER_1_256 VPWR VGND sg13cmos5l_decap_8
XFILLER_13_385 VPWR VGND sg13cmos5l_decap_8
XFILLER_15_91 VPWR VGND sg13cmos5l_decap_8
X_386_ Tile_X0Y0_SS4BEG[11] _595_/X VPWR VGND sg13cmos5l_buf_1
X_455_ Tile_X1Y0_FrameData_O[8] Tile_X0Y0_FrameData[8] VPWR VGND sg13cmos5l_buf_1
X_524_ Tile_X1Y0_S4BEG[5] _613_/X VPWR VGND sg13cmos5l_buf_1
XFILLER_9_334 VPWR VGND sg13cmos5l_decap_8
XANTENNA__153__D Tile_X0Y0_FrameData[31] VPWR VGND sg13cmos5l_antennanp
XFILLER_12_1003 VPWR VGND sg13cmos5l_decap_4
XFILLER_9_367 VPWR VGND sg13cmos5l_fill_1
XFILLER_5_584 VPWR VGND sg13cmos5l_decap_4
XANTENNA__328__D Tile_X0Y0_FrameData[25] VPWR VGND sg13cmos5l_antennanp
XANTENNA__465__X Tile_X1Y0_FrameData_O[18] VPWR VGND sg13cmos5l_antennanp
XFILLER_11_38 VPWR VGND sg13cmos5l_decap_4
XANTENNA__375__X Tile_X0Y0_SS4BEG[0] VPWR VGND sg13cmos5l_antennanp
XFILLER_14_116 VPWR VGND sg13cmos5l_fill_2
XFILLER_14_149 VPWR VGND sg13cmos5l_decap_8
XFILLER_15_606 VPWR VGND sg13cmos5l_decap_8
X_240_ _240_/Q Tile_X0Y0_UserCLK _240_/D _361_/L_HI VPWR VGND sg13cmos5l_dfrbpq_1
XANTENNA__551__A Tile_X0Y0_UserCLK VPWR VGND sg13cmos5l_antennanp
X_171_ _171_/Q Tile_X0Y0_FrameData[13] VGND VPWR Tile_X1Y0_FrameStrobe[1] latch
XFILLER_7_827 VPWR VGND sg13cmos5l_decap_8
XFILLER_2_510 VPWR VGND sg13cmos5l_decap_8
XFILLER_2_587 VPWR VGND sg13cmos5l_decap_8
XANTENNA__148__D Tile_X0Y0_FrameData[4] VPWR VGND sg13cmos5l_antennanp
XFILLER_14_661 VPWR VGND sg13cmos5l_decap_8
X_369_ _369_/L_HI VPWR VGND sg13cmos5l_tiehi
X_438_ Tile_X0Y0_S4BEG[7] _575_/X VPWR VGND sg13cmos5l_buf_1
X_507_ Tile_X1Y0_S2BEG[4] Tile_X1Y0_N2MID[3] VPWR VGND sg13cmos5l_buf_1
XFILLER_9_175 VPWR VGND sg13cmos5l_decap_8
XFILLER_9_142 VPWR VGND sg13cmos5l_fill_2
XANTENNA__461__A Tile_X0Y0_FrameData[14] VPWR VGND sg13cmos5l_antennanp
XFILLER_9_197 VPWR VGND sg13cmos5l_decap_4
XANTENNA__251__CLK Tile_X0Y0_UserCLK VPWR VGND sg13cmos5l_antennanp
XFILLER_3_1089 VPWR VGND sg13cmos5l_decap_8
XFILLER_11_653 VPWR VGND sg13cmos5l_decap_8
XFILLER_15_458 VPWR VGND sg13cmos5l_decap_8
X_223_ _223_/Q Tile_X0Y0_FrameData[16] VGND VPWR Tile_X1Y0_FrameStrobe[3] latch
XFILLER_7_624 VPWR VGND sg13cmos5l_fill_1
XFILLER_10_174 VPWR VGND sg13cmos5l_decap_4
XFILLER_12_81 VPWR VGND sg13cmos5l_decap_8
X_154_ _154_/Q Tile_X0Y0_FrameData[30] VGND VPWR Tile_X1Y0_FrameStrobe[1] latch
X_085_ _085_/X _240_/Q _240_/D _234_/Q VPWR VGND sg13cmos5l_mux2_1
XFILLER_6_178 VPWR VGND sg13cmos5l_fill_2
XANTENNA__644__A2 Tile_X1Y0_N4END[11] VPWR VGND sg13cmos5l_antennanp
XFILLER_2_351 VPWR VGND sg13cmos5l_decap_4
XANTENNA__456__A Tile_X0Y0_FrameData[9] VPWR VGND sg13cmos5l_antennanp
XANTENNA__580__A1 Tile_X0Y0_N4END[3] VPWR VGND sg13cmos5l_antennanp
XANTENNA__341__D Tile_X0Y0_FrameData[12] VPWR VGND sg13cmos5l_antennanp
XANTENNA__635__A2 Tile_X1Y0_NN4END[4] VPWR VGND sg13cmos5l_antennanp
XANTENNA__571__A1 Tile_X0Y0_N4END[12] VPWR VGND sg13cmos5l_antennanp
XFILLER_4_616 VPWR VGND sg13cmos5l_decap_8
XANTENNA__626__A2 Tile_X1Y0_NN4END[13] VPWR VGND sg13cmos5l_antennanp
XFILLER_0_800 VPWR VGND sg13cmos5l_fill_2
XFILLER_15_200 VPWR VGND sg13cmos5l_decap_8
XFILLER_16_701 VPWR VGND sg13cmos5l_decap_8
XFILLER_16_712 VPWR VGND sg13cmos5l_decap_8
XANTENNA__562__A1 Tile_X0Y0_N2MID[2] VPWR VGND sg13cmos5l_antennanp
XFILLER_12_951 VPWR VGND sg13cmos5l_decap_4
XFILLER_12_962 VPWR VGND sg13cmos5l_fill_1
XFILLER_15_299 VPWR VGND sg13cmos5l_fill_1
X_206_ _206_/Q Tile_X0Y0_FrameData[10] VGND VPWR Tile_X1Y0_FrameStrobe[2] latch
X_137_ _137_/Q Tile_X0Y0_FrameData[15] VGND VPWR Tile_X1Y0_FrameStrobe[0] latch
XFILLER_8_933 VPWR VGND sg13cmos5l_decap_8
XFILLER_7_476 VPWR VGND sg13cmos5l_fill_1
XFILLER_7_432 VPWR VGND sg13cmos5l_decap_8
XANTENNA__161__D Tile_X0Y0_FrameData[23] VPWR VGND sg13cmos5l_antennanp
XFILLER_2_192 VPWR VGND sg13cmos5l_decap_4
X_068_ _068_/Y _120_/A _243_/D _067_/X VPWR VGND sg13cmos5l_o21ai_1
XFILLER_7_487 VPWR VGND sg13cmos5l_decap_8
XANTENNA__617__A2 Tile_X1Y0_NN4END[9] VPWR VGND sg13cmos5l_antennanp
XANTENNA__323__GATE Tile_X0Y0_FrameStrobe[2] VPWR VGND sg13cmos5l_antennanp
XANTENNA__336__D Tile_X0Y0_FrameData[17] VPWR VGND sg13cmos5l_antennanp
XANTENNA__473__X Tile_X1Y0_FrameData_O[26] VPWR VGND sg13cmos5l_antennanp
XFILLER_0_73 VPWR VGND sg13cmos5l_fill_2
XANTENNA__338__GATE Tile_X0Y0_FrameStrobe[2] VPWR VGND sg13cmos5l_antennanp
XANTENNA__553__A1 Tile_X0Y0_N2END[5] VPWR VGND sg13cmos5l_antennanp
XFILLER_1_608 VPWR VGND sg13cmos5l_decap_4
XANTENNA__608__A2 Tile_X1Y0_NN4END[0] VPWR VGND sg13cmos5l_antennanp
XFILLER_9_1051 VPWR VGND sg13cmos5l_decap_8
XANTENNA__383__X Tile_X0Y0_SS4BEG[8] VPWR VGND sg13cmos5l_antennanp
XFILLER_12_247 VPWR VGND sg13cmos5l_decap_8
XFILLER_5_969 VPWR VGND sg13cmos5l_decap_8
XFILLER_4_457 VPWR VGND sg13cmos5l_decap_8
XFILLER_0_641 VPWR VGND sg13cmos5l_fill_2
XFILLER_0_696 VPWR VGND sg13cmos5l_fill_2
XANTENNA__156__D Tile_X0Y0_FrameData[28] VPWR VGND sg13cmos5l_antennanp
XFILLER_16_520 VPWR VGND sg13cmos5l_fill_1
XFILLER_16_531 VPWR VGND sg13cmos5l_fill_2
XFILLER_16_586 VPWR VGND sg13cmos5l_decap_4
XFILLER_15_1023 VPWR VGND sg13cmos5l_decap_8
XFILLER_8_741 VPWR VGND sg13cmos5l_decap_8
XFILLER_8_730 VPWR VGND sg13cmos5l_fill_1
XFILLER_4_980 VPWR VGND sg13cmos5l_decap_8
XFILLER_3_490 VPWR VGND sg13cmos5l_decap_8
XANTENNA__262__GATE Tile_X0Y0_FrameStrobe[0] VPWR VGND sg13cmos5l_antennanp
XANTENNA__468__X Tile_X1Y0_FrameData_O[21] VPWR VGND sg13cmos5l_antennanp
XANTENNA__277__GATE Tile_X0Y0_FrameStrobe[0] VPWR VGND sg13cmos5l_antennanp
XFILLER_10_718 VPWR VGND sg13cmos5l_decap_8
XANTENNA__200__GATE Tile_X1Y0_FrameStrobe[2] VPWR VGND sg13cmos5l_antennanp
XFILLER_1_416 VPWR VGND sg13cmos5l_fill_1
XFILLER_1_438 VPWR VGND sg13cmos5l_decap_8
XFILLER_2_906 VPWR VGND sg13cmos5l_fill_1
XANTENNA__215__GATE Tile_X1Y0_FrameStrobe[2] VPWR VGND sg13cmos5l_antennanp
XANTENNA__378__X Tile_X0Y0_SS4BEG[3] VPWR VGND sg13cmos5l_antennanp
X_540_ Tile_X1Y0_SS4BEG[5] _629_/X VPWR VGND sg13cmos5l_buf_1
XFILLER_13_545 VPWR VGND sg13cmos5l_decap_8
X_471_ Tile_X1Y0_FrameData_O[24] Tile_X0Y0_FrameData[24] VPWR VGND sg13cmos5l_buf_1
XFILLER_5_744 VPWR VGND sg13cmos5l_fill_2
XFILLER_1_983 VPWR VGND sg13cmos5l_decap_4
XANTENNA__464__A Tile_X0Y0_FrameData[17] VPWR VGND sg13cmos5l_antennanp
XFILLER_16_383 VPWR VGND sg13cmos5l_decap_8
XFILLER_8_582 VPWR VGND sg13cmos5l_decap_8
XFILLER_6_1065 VPWR VGND sg13cmos5l_decap_8
XFILLER_6_1010 VPWR VGND sg13cmos5l_decap_8
XFILLER_10_548 VPWR VGND sg13cmos5l_decap_8
XFILLER_6_508 VPWR VGND sg13cmos5l_decap_8
XANTENNA__154__GATE Tile_X1Y0_FrameStrobe[1] VPWR VGND sg13cmos5l_antennanp
XANTENNA__169__GATE Tile_X1Y0_FrameStrobe[1] VPWR VGND sg13cmos5l_antennanp
X_523_ Tile_X1Y0_S4BEG[4] _612_/X VPWR VGND sg13cmos5l_buf_1
XFILLER_13_364 VPWR VGND sg13cmos5l_decap_8
XFILLER_14_887 VPWR VGND sg13cmos5l_fill_2
XFILLER_15_70 VPWR VGND sg13cmos5l_decap_8
X_385_ Tile_X0Y0_SS4BEG[10] _594_/X VPWR VGND sg13cmos5l_buf_1
X_454_ Tile_X1Y0_FrameData_O[7] Tile_X0Y0_FrameData[7] VPWR VGND sg13cmos5l_buf_1
XFILLER_12_1059 VPWR VGND sg13cmos5l_decap_8
XFILLER_9_379 VPWR VGND sg13cmos5l_decap_8
XFILLER_5_563 VPWR VGND sg13cmos5l_decap_8
XANTENNA__459__A Tile_X0Y0_FrameData[12] VPWR VGND sg13cmos5l_antennanp
XFILLER_0_290 VPWR VGND sg13cmos5l_decap_8
XANTENNA__344__D Tile_X0Y0_FrameData[9] VPWR VGND sg13cmos5l_antennanp
XANTENNA__481__X Tile_X1Y0_FrameStrobe_O[2] VPWR VGND sg13cmos5l_antennanp
XFILLER_11_17 VPWR VGND sg13cmos5l_decap_8
XFILLER_14_128 VPWR VGND sg13cmos5l_decap_8
X_170_ _170_/Q Tile_X0Y0_FrameData[14] VGND VPWR Tile_X1Y0_FrameStrobe[1] latch
XANTENNA__391__X Tile_X0Y0_FrameStrobe_O[0] VPWR VGND sg13cmos5l_antennanp
XFILLER_10_378 VPWR VGND sg13cmos5l_decap_8
XFILLER_11_1092 VPWR VGND sg13cmos5l_decap_8
XFILLER_2_566 VPWR VGND sg13cmos5l_decap_8
XFILLER_14_640 VPWR VGND sg13cmos5l_decap_8
X_506_ Tile_X1Y0_S2BEG[3] Tile_X1Y0_N2MID[4] VPWR VGND sg13cmos5l_buf_1
XANTENNA__164__D Tile_X0Y0_FrameData[20] VPWR VGND sg13cmos5l_antennanp
X_299_ _299_/Q Tile_X0Y0_FrameData[22] VGND VPWR Tile_X0Y0_FrameStrobe[1] latch
X_368_ _368_/L_HI VPWR VGND sg13cmos5l_tiehi
X_437_ Tile_X0Y0_S4BEG[6] _574_/X VPWR VGND sg13cmos5l_buf_1
XANTENNA__647__A0 Tile_X1Y0_N1END[1] VPWR VGND sg13cmos5l_antennanp
XFILLER_6_850 VPWR VGND sg13cmos5l_decap_4
XANTENNA__339__D Tile_X0Y0_FrameData[14] VPWR VGND sg13cmos5l_antennanp
XANTENNA__476__X Tile_X1Y0_FrameData_O[29] VPWR VGND sg13cmos5l_antennanp
XFILLER_3_1068 VPWR VGND sg13cmos5l_decap_8
XFILLER_11_109 VPWR VGND sg13cmos5l_decap_4
XANTENNA__638__A0 Tile_X1Y0_N2END[6] VPWR VGND sg13cmos5l_antennanp
XANTENNA__386__X Tile_X0Y0_SS4BEG[11] VPWR VGND sg13cmos5l_antennanp
XFILLER_15_437 VPWR VGND sg13cmos5l_fill_2
XFILLER_10_131 VPWR VGND sg13cmos5l_decap_4
XFILLER_10_142 VPWR VGND sg13cmos5l_fill_2
XFILLER_10_153 VPWR VGND sg13cmos5l_decap_8
XFILLER_11_610 VPWR VGND sg13cmos5l_decap_8
X_222_ _222_/Q Tile_X0Y0_FrameData[15] VGND VPWR Tile_X1Y0_FrameStrobe[3] latch
X_153_ _153_/Q Tile_X0Y0_FrameData[31] VGND VPWR Tile_X1Y0_FrameStrobe[1] latch
XANTENNA__629__A0 Tile_X1Y0_N2END[5] VPWR VGND sg13cmos5l_antennanp
X_084_ _240_/D PMOD_IO_I5 _557_/X _222_/Q VPWR VGND sg13cmos5l_mux2_1
XANTENNA__159__D Tile_X0Y0_FrameData[25] VPWR VGND sg13cmos5l_antennanp
XANTENNA__644__A3 Tile_X1Y0_NN4END[11] VPWR VGND sg13cmos5l_antennanp
XANTENNA__472__A Tile_X0Y0_FrameData[25] VPWR VGND sg13cmos5l_antennanp
XANTENNA__580__A2 Tile_X0Y0_NN4END[12] VPWR VGND sg13cmos5l_antennanp
XFILLER_5_1119 VPWR VGND sg13cmos5l_fill_1
XANTENNA__571__A2 Tile_X0Y0_NN4END[3] VPWR VGND sg13cmos5l_antennanp
XFILLER_12_407 VPWR VGND sg13cmos5l_decap_8
XFILLER_12_418 VPWR VGND sg13cmos5l_fill_2
XFILLER_4_639 VPWR VGND sg13cmos5l_fill_1
XFILLER_0_878 VPWR VGND sg13cmos5l_decap_8
XFILLER_15_256 VPWR VGND sg13cmos5l_decap_8
XFILLER_16_779 VPWR VGND sg13cmos5l_fill_1
XANTENNA__241__CLK Tile_X0Y0_UserCLK VPWR VGND sg13cmos5l_antennanp
XANTENNA__562__A2 Tile_X0Y0_N2END[5] VPWR VGND sg13cmos5l_antennanp
XFILLER_11_495 VPWR VGND sg13cmos5l_decap_8
X_205_ _205_/Q Tile_X0Y0_FrameData[11] VGND VPWR Tile_X1Y0_FrameStrobe[2] latch
X_136_ _136_/Q Tile_X0Y0_FrameData[16] VGND VPWR Tile_X1Y0_FrameStrobe[0] latch
XFILLER_8_989 VPWR VGND sg13cmos5l_decap_8
XFILLER_7_411 VPWR VGND sg13cmos5l_fill_2
XFILLER_2_171 VPWR VGND sg13cmos5l_decap_8
X_067_ _067_/X _233_/Q _243_/Q VPWR VGND sg13cmos5l_or2_1
XANTENNA__467__A Tile_X0Y0_FrameData[20] VPWR VGND sg13cmos5l_antennanp
XANTENNA__553__A2 Tile_X0Y0_N4END[10] VPWR VGND sg13cmos5l_antennanp
XFILLER_9_72 VPWR VGND sg13cmos5l_fill_1
XFILLER_9_61 VPWR VGND sg13cmos5l_fill_1
XFILLER_12_226 VPWR VGND sg13cmos5l_decap_8
XANTENNA__262__D Tile_X0Y0_FrameData[27] VPWR VGND sg13cmos5l_antennanp
XFILLER_5_948 VPWR VGND sg13cmos5l_decap_8
XFILLER_5_915 VPWR VGND sg13cmos5l_decap_4
XFILLER_4_436 VPWR VGND sg13cmos5l_decap_8
XFILLER_12_760 VPWR VGND sg13cmos5l_fill_2
XFILLER_15_1002 VPWR VGND sg13cmos5l_decap_8
XFILLER_16_565 VPWR VGND sg13cmos5l_decap_8
XANTENNA__172__D Tile_X0Y0_FrameData[12] VPWR VGND sg13cmos5l_antennanp
XFILLER_11_292 VPWR VGND sg13cmos5l_decap_8
X_119_ _119_/X _236_/Q _236_/D _234_/Q VPWR VGND sg13cmos5l_mux2_1
XFILLER_7_263 VPWR VGND sg13cmos5l_decap_4
XANTENNA__347__D Tile_X0Y0_FrameData[6] VPWR VGND sg13cmos5l_antennanp
XANTENNA__484__X Tile_X1Y0_FrameStrobe_O[5] VPWR VGND sg13cmos5l_antennanp
XANTENNA__394__X Tile_X0Y0_FrameStrobe_O[3] VPWR VGND sg13cmos5l_antennanp
XFILLER_13_524 VPWR VGND sg13cmos5l_decap_8
X_470_ Tile_X1Y0_FrameData_O[23] Tile_X0Y0_FrameData[23] VPWR VGND sg13cmos5l_buf_1
XFILLER_5_789 VPWR VGND sg13cmos5l_decap_8
XFILLER_4_233 VPWR VGND sg13cmos5l_decap_8
XANTENNA__322__GATE Tile_X0Y0_FrameStrobe[2] VPWR VGND sg13cmos5l_antennanp
XFILLER_1_962 VPWR VGND sg13cmos5l_decap_4
XFILLER_1_995 VPWR VGND sg13cmos5l_fill_2
XANTENNA__167__D Tile_X0Y0_FrameData[17] VPWR VGND sg13cmos5l_antennanp
XANTENNA__337__GATE Tile_X0Y0_FrameStrobe[2] VPWR VGND sg13cmos5l_antennanp
XFILLER_16_362 VPWR VGND sg13cmos5l_decap_8
XFILLER_1_1111 VPWR VGND sg13cmos5l_decap_8
X_599_ _599_/X Tile_X0Y0_N2END[7] Tile_X0Y0_N4END[15] Tile_X0Y0_NN4END[0] _091_/X
+ _271_/Q _270_/Q VPWR VGND sg13cmos5l_mux4_1
XFILLER_8_561 VPWR VGND sg13cmos5l_decap_8
XANTENNA__480__A Tile_X1Y0_FrameStrobe[1] VPWR VGND sg13cmos5l_antennanp
XFILLER_6_73 VPWR VGND sg13cmos5l_decap_8
XANTENNA__479__X Tile_X1Y0_FrameStrobe_O[0] VPWR VGND sg13cmos5l_antennanp
XFILLER_10_527 VPWR VGND sg13cmos5l_decap_8
XANTENNA__389__X Tile_X0Y0_SS4BEG[14] VPWR VGND sg13cmos5l_antennanp
XFILLER_1_247 VPWR VGND sg13cmos5l_fill_2
XFILLER_2_759 VPWR VGND sg13cmos5l_fill_2
XFILLER_2_726 VPWR VGND sg13cmos5l_decap_4
XFILLER_14_800 VPWR VGND sg13cmos5l_fill_1
X_453_ Tile_X1Y0_FrameData_O[6] Tile_X0Y0_FrameData[6] VPWR VGND sg13cmos5l_buf_1
X_522_ Tile_X1Y0_S4BEG[3] _611_/X VPWR VGND sg13cmos5l_buf_1
XFILLER_13_343 VPWR VGND sg13cmos5l_decap_8
X_384_ Tile_X0Y0_SS4BEG[9] _593_/X VPWR VGND sg13cmos5l_buf_1
XANTENNA__261__GATE Tile_X0Y0_FrameStrobe[0] VPWR VGND sg13cmos5l_antennanp
XFILLER_5_542 VPWR VGND sg13cmos5l_decap_8
XANTENNA__276__GATE Tile_X0Y0_FrameStrobe[0] VPWR VGND sg13cmos5l_antennanp
XANTENNA__475__A Tile_X0Y0_FrameData[28] VPWR VGND sg13cmos5l_antennanp
XFILLER_16_181 VPWR VGND sg13cmos5l_decap_8
XANTENNA__214__GATE Tile_X1Y0_FrameStrobe[2] VPWR VGND sg13cmos5l_antennanp
XFILLER_9_892 VPWR VGND sg13cmos5l_fill_1
XANTENNA__229__GATE Tile_X1Y0_FrameStrobe[3] VPWR VGND sg13cmos5l_antennanp
XFILLER_14_118 VPWR VGND sg13cmos5l_fill_1
XFILLER_10_302 VPWR VGND sg13cmos5l_decap_8
XFILLER_11_814 VPWR VGND sg13cmos5l_decap_4
XANTENNA__270__D Tile_X0Y0_FrameData[19] VPWR VGND sg13cmos5l_antennanp
XFILLER_11_1071 VPWR VGND sg13cmos5l_decap_8
XFILLER_2_545 VPWR VGND sg13cmos5l_decap_8
XFILLER_6_339 VPWR VGND sg13cmos5l_decap_8
XANTENNA__592__A0 Tile_X0Y0_N2END[0] VPWR VGND sg13cmos5l_antennanp
XFILLER_13_140 VPWR VGND sg13cmos5l_decap_8
X_436_ Tile_X0Y0_S4BEG[5] _573_/X VPWR VGND sg13cmos5l_buf_1
X_505_ Tile_X1Y0_S2BEG[2] Tile_X1Y0_N2MID[5] VPWR VGND sg13cmos5l_buf_1
XFILLER_13_162 VPWR VGND sg13cmos5l_fill_2
XFILLER_13_184 VPWR VGND sg13cmos5l_decap_8
XFILLER_14_696 VPWR VGND sg13cmos5l_decap_4
X_298_ _298_/Q Tile_X0Y0_FrameData[23] VGND VPWR Tile_X0Y0_FrameStrobe[1] latch
X_367_ _367_/L_HI VPWR VGND sg13cmos5l_tiehi
XFILLER_9_122 VPWR VGND sg13cmos5l_decap_8
XFILLER_9_111 VPWR VGND sg13cmos5l_decap_8
XANTENNA__180__D Tile_X0Y0_FrameData[4] VPWR VGND sg13cmos5l_antennanp
XANTENNA__647__A1 Tile_X1Y0_N2END[3] VPWR VGND sg13cmos5l_antennanp
XFILLER_6_895 VPWR VGND sg13cmos5l_decap_8
XFILLER_3_85 VPWR VGND sg13cmos5l_decap_8
XFILLER_3_1047 VPWR VGND sg13cmos5l_decap_8
XFILLER_3_1025 VPWR VGND sg13cmos5l_decap_4
XANTENNA__153__GATE Tile_X1Y0_FrameStrobe[1] VPWR VGND sg13cmos5l_antennanp
XANTENNA__492__X Tile_X1Y0_FrameStrobe_O[13] VPWR VGND sg13cmos5l_antennanp
XANTENNA__583__A0 Tile_X0Y0_N2MID[7] VPWR VGND sg13cmos5l_antennanp
XANTENNA__168__GATE Tile_X1Y0_FrameStrobe[1] VPWR VGND sg13cmos5l_antennanp
XANTENNA__638__A1 Tile_X1Y0_N4END[14] VPWR VGND sg13cmos5l_antennanp
XANTENNA__265__D Tile_X0Y0_FrameData[24] VPWR VGND sg13cmos5l_antennanp
XFILLER_11_600 VPWR VGND sg13cmos5l_decap_8
XFILLER_15_416 VPWR VGND sg13cmos5l_decap_8
XANTENNA__574__A0 Tile_X0Y0_N2MID[6] VPWR VGND sg13cmos5l_antennanp
XFILLER_10_110 VPWR VGND sg13cmos5l_decap_8
X_221_ _221_/Q Tile_X0Y0_FrameData[31] VGND VPWR Tile_X1Y0_FrameStrobe[0] latch
X_152_ _152_/Q Tile_X0Y0_FrameData[0] VGND VPWR Tile_X1Y0_FrameStrobe[0] latch
X_083_ _235_/D PMOD_IO_I0 _552_/X _222_/Q VPWR VGND sg13cmos5l_mux2_1
XANTENNA__629__A1 Tile_X1Y0_N4END[5] VPWR VGND sg13cmos5l_antennanp
XFILLER_5_0 VPWR VGND sg13cmos5l_fill_2
XFILLER_3_898 VPWR VGND sg13cmos5l_fill_2
XANTENNA__175__D Tile_X0Y0_FrameData[9] VPWR VGND sg13cmos5l_antennanp
XANTENNA__565__A0 Tile_X0Y0_N1END[1] VPWR VGND sg13cmos5l_antennanp
XFILLER_14_460 VPWR VGND sg13cmos5l_fill_2
XFILLER_2_1091 VPWR VGND sg13cmos5l_decap_8
X_419_ Tile_X0Y0_S2BEG[4] Tile_X0Y0_N2MID[3] VPWR VGND sg13cmos5l_buf_1
XANTENNA__487__X Tile_X1Y0_FrameStrobe_O[8] VPWR VGND sg13cmos5l_antennanp
XANTENNA__556__A0 Tile_X1Y0_N2MID[2] VPWR VGND sg13cmos5l_antennanp
XANTENNA__397__X Tile_X0Y0_FrameStrobe_O[6] VPWR VGND sg13cmos5l_antennanp
XFILLER_15_235 VPWR VGND sg13cmos5l_decap_8
X_204_ _204_/Q Tile_X0Y0_FrameData[12] VGND VPWR Tile_X1Y0_FrameStrobe[2] latch
XFILLER_12_997 VPWR VGND sg13cmos5l_fill_2
X_135_ _135_/Q Tile_X0Y0_FrameData[17] VGND VPWR Tile_X1Y0_FrameStrobe[0] latch
X_066_ _066_/X _251_/Q _552_/X _233_/Q VPWR VGND sg13cmos5l_mux2_1
XFILLER_8_968 VPWR VGND sg13cmos5l_decap_8
XFILLER_7_423 VPWR VGND sg13cmos5l_decap_4
XFILLER_3_684 VPWR VGND sg13cmos5l_fill_1
XANTENNA__483__A Tile_X1Y0_FrameStrobe[4] VPWR VGND sg13cmos5l_antennanp
XANTENNA__553__A3 Tile_X0Y0_NN4END[10] VPWR VGND sg13cmos5l_antennanp
XFILLER_9_1086 VPWR VGND sg13cmos5l_decap_8
XANTENNA__393__A Tile_X0Y0_FrameStrobe[2] VPWR VGND sg13cmos5l_antennanp
XFILLER_12_205 VPWR VGND sg13cmos5l_decap_8
XFILLER_5_927 VPWR VGND sg13cmos5l_decap_8
XFILLER_5_905 VPWR VGND sg13cmos5l_fill_2
XFILLER_0_621 VPWR VGND sg13cmos5l_fill_1
XFILLER_0_665 VPWR VGND sg13cmos5l_fill_1
XFILLER_16_533 VPWR VGND sg13cmos5l_fill_1
XFILLER_16_544 VPWR VGND sg13cmos5l_decap_4
XFILLER_8_721 VPWR VGND sg13cmos5l_decap_4
X_118_ _236_/D PMOD_IO_I1 _553_/X _222_/Q VPWR VGND sg13cmos5l_mux2_1
XFILLER_7_297 VPWR VGND sg13cmos5l_decap_8
XFILLER_7_242 VPWR VGND sg13cmos5l_decap_8
XANTENNA__478__A Tile_X0Y0_FrameData[31] VPWR VGND sg13cmos5l_antennanp
XFILLER_1_407 VPWR VGND sg13cmos5l_fill_1
XANTENNA__273__D Tile_X0Y0_FrameData[16] VPWR VGND sg13cmos5l_antennanp
XFILLER_13_503 VPWR VGND sg13cmos5l_decap_8
XFILLER_9_529 VPWR VGND sg13cmos5l_decap_8
XFILLER_14_1080 VPWR VGND sg13cmos5l_decap_8
XFILLER_5_746 VPWR VGND sg13cmos5l_fill_1
XFILLER_5_702 VPWR VGND sg13cmos5l_fill_1
XFILLER_4_256 VPWR VGND sg13cmos5l_fill_1
XFILLER_16_341 VPWR VGND sg13cmos5l_decap_8
X_598_ _598_/X Tile_X0Y0_N2END[6] Tile_X0Y0_N4END[14] Tile_X0Y0_NN4END[1] _092_/X
+ _273_/Q _272_/Q VPWR VGND sg13cmos5l_mux4_1
XANTENNA_1 _640_/X VPWR VGND sg13cmos5l_antennanp
XANTENNA__183__D Tile_X0Y0_FrameData[1] VPWR VGND sg13cmos5l_antennanp
XFILLER_8_540 VPWR VGND sg13cmos5l_decap_8
XFILLER_6_52 VPWR VGND sg13cmos5l_decap_8
XANTENNA__254__CLK Tile_X0Y0_UserCLK VPWR VGND sg13cmos5l_antennanp
XANTENNA__495__X Tile_X1Y0_FrameStrobe_O[16] VPWR VGND sg13cmos5l_antennanp
XFILLER_10_506 VPWR VGND sg13cmos5l_decap_8
XFILLER_1_226 VPWR VGND sg13cmos5l_decap_8
XANTENNA__268__D Tile_X0Y0_FrameData[21] VPWR VGND sg13cmos5l_antennanp
XFILLER_13_322 VPWR VGND sg13cmos5l_decap_8
X_383_ Tile_X0Y0_SS4BEG[8] _592_/X VPWR VGND sg13cmos5l_buf_1
X_452_ Tile_X1Y0_FrameData_O[5] Tile_X0Y0_FrameData[5] VPWR VGND sg13cmos5l_buf_1
X_521_ Tile_X1Y0_S4BEG[2] _610_/X VPWR VGND sg13cmos5l_buf_1
XFILLER_13_399 VPWR VGND sg13cmos5l_decap_8
XFILLER_5_521 VPWR VGND sg13cmos5l_decap_8
XFILLER_5_598 VPWR VGND sg13cmos5l_decap_8
XANTENNA__178__D Tile_X0Y0_FrameData[6] VPWR VGND sg13cmos5l_antennanp
XANTENNA__491__A Tile_X1Y0_FrameStrobe[12] VPWR VGND sg13cmos5l_antennanp
XFILLER_16_160 VPWR VGND sg13cmos5l_decap_8
XFILLER_8_381 VPWR VGND sg13cmos5l_decap_8
XFILLER_8_1118 VPWR VGND sg13cmos5l_fill_2
XFILLER_8_1107 VPWR VGND sg13cmos5l_fill_2
XANTENNA__321__GATE Tile_X0Y0_FrameStrobe[1] VPWR VGND sg13cmos5l_antennanp
XANTENNA__336__GATE Tile_X0Y0_FrameStrobe[2] VPWR VGND sg13cmos5l_antennanp
XFILLER_11_1050 VPWR VGND sg13cmos5l_decap_8
XFILLER_2_524 VPWR VGND sg13cmos5l_decap_8
XANTENNA__592__A1 Tile_X0Y0_N4END[8] VPWR VGND sg13cmos5l_antennanp
XFILLER_14_675 VPWR VGND sg13cmos5l_decap_8
X_366_ _366_/L_HI VPWR VGND sg13cmos5l_tiehi
X_435_ Tile_X0Y0_S4BEG[4] _572_/X VPWR VGND sg13cmos5l_buf_1
X_504_ Tile_X1Y0_S2BEG[1] Tile_X1Y0_N2MID[6] VPWR VGND sg13cmos5l_buf_1
X_297_ _297_/Q Tile_X0Y0_FrameData[24] VGND VPWR Tile_X0Y0_FrameStrobe[1] latch
XFILLER_9_189 VPWR VGND sg13cmos5l_fill_1
XANTENNA__647__A2 Tile_X1Y0_N4END[14] VPWR VGND sg13cmos5l_antennanp
XFILLER_3_64 VPWR VGND sg13cmos5l_decap_8
XFILLER_3_53 VPWR VGND sg13cmos5l_decap_8
XANTENNA__486__A Tile_X1Y0_FrameStrobe[7] VPWR VGND sg13cmos5l_antennanp
XFILLER_3_1004 VPWR VGND sg13cmos5l_decap_8
XANTENNA__583__A1 Tile_X0Y0_N4END[0] VPWR VGND sg13cmos5l_antennanp
XANTENNA__638__A2 Tile_X1Y0_NN4END[1] VPWR VGND sg13cmos5l_antennanp
XANTENNA__396__A Tile_X0Y0_FrameStrobe[5] VPWR VGND sg13cmos5l_antennanp
XANTENNA__260__GATE Tile_X0Y0_FrameStrobe[0] VPWR VGND sg13cmos5l_antennanp
XANTENNA__574__A1 Tile_X0Y0_N4END[9] VPWR VGND sg13cmos5l_antennanp
XFILLER_15_439 VPWR VGND sg13cmos5l_fill_1
X_220_ _220_/Q Tile_X0Y0_FrameData[28] VGND VPWR Tile_X1Y0_FrameStrobe[3] latch
XANTENNA__275__GATE Tile_X0Y0_FrameStrobe[0] VPWR VGND sg13cmos5l_antennanp
XANTENNA__281__D Tile_X0Y0_FrameData[8] VPWR VGND sg13cmos5l_antennanp
XFILLER_11_667 VPWR VGND sg13cmos5l_decap_8
XFILLER_12_95 VPWR VGND sg13cmos5l_fill_1
X_151_ _151_/Q Tile_X0Y0_FrameData[1] VGND VPWR Tile_X1Y0_FrameStrobe[0] latch
X_082_ PMOD_IO_OE_O3 _120_/A _059_/Y _081_/X _223_/Q _080_/Y VPWR VGND sg13cmos5l_a221oi_1
XFILLER_3_822 VPWR VGND sg13cmos5l_decap_8
XANTENNA__629__A2 Tile_X1Y0_NN4END[10] VPWR VGND sg13cmos5l_antennanp
XFILLER_2_376 VPWR VGND sg13cmos5l_fill_2
XANTENNA__213__GATE Tile_X1Y0_FrameStrobe[2] VPWR VGND sg13cmos5l_antennanp
XFILLER_2_1070 VPWR VGND sg13cmos5l_decap_8
XANTENNA__228__GATE Tile_X1Y0_FrameStrobe[3] VPWR VGND sg13cmos5l_antennanp
XANTENNA__565__A1 Tile_X0Y0_N2MID[5] VPWR VGND sg13cmos5l_antennanp
XFILLER_14_483 VPWR VGND sg13cmos5l_decap_8
XFILLER_15_995 VPWR VGND sg13cmos5l_decap_8
X_349_ _349_/Q Tile_X0Y0_FrameData[4] VGND VPWR Tile_X0Y0_FrameStrobe[2] latch
X_418_ Tile_X0Y0_S2BEG[3] Tile_X0Y0_N2MID[4] VPWR VGND sg13cmos5l_buf_1
XANTENNA__191__D Tile_X0Y0_FrameData[25] VPWR VGND sg13cmos5l_antennanp
XFILLER_5_170 VPWR VGND sg13cmos5l_fill_1
XANTENNA__556__A1 Tile_X1Y0_N2END[5] VPWR VGND sg13cmos5l_antennanp
XFILLER_0_847 VPWR VGND sg13cmos5l_fill_2
XFILLER_0_869 VPWR VGND sg13cmos5l_fill_1
XANTENNA__276__D Tile_X0Y0_FrameData[13] VPWR VGND sg13cmos5l_antennanp
XFILLER_15_214 VPWR VGND sg13cmos5l_decap_8
X_203_ _203_/Q Tile_X0Y0_FrameData[13] VGND VPWR Tile_X1Y0_FrameStrobe[2] latch
XFILLER_8_947 VPWR VGND sg13cmos5l_decap_8
XFILLER_8_914 VPWR VGND sg13cmos5l_fill_1
XFILLER_8_903 VPWR VGND sg13cmos5l_decap_8
X_134_ _134_/Q Tile_X0Y0_FrameData[18] VGND VPWR Tile_X1Y0_FrameStrobe[0] latch
X_065_ _243_/D _640_/X _231_/Q _232_/Q VPWR VGND sg13cmos5l_mux2_1
XFILLER_7_468 VPWR VGND sg13cmos5l_fill_2
XFILLER_7_446 VPWR VGND sg13cmos5l_fill_2
XFILLER_3_630 VPWR VGND sg13cmos5l_fill_2
XANTENNA__100__Y PMOD_IO_OE_O6 VPWR VGND sg13cmos5l_antennanp
XANTENNA__152__GATE Tile_X1Y0_FrameStrobe[0] VPWR VGND sg13cmos5l_antennanp
XANTENNA__167__GATE Tile_X1Y0_FrameStrobe[1] VPWR VGND sg13cmos5l_antennanp
XANTENNA__186__D Tile_X0Y0_FrameData[30] VPWR VGND sg13cmos5l_antennanp
XFILLER_15_781 VPWR VGND sg13cmos5l_fill_2
XFILLER_9_85 VPWR VGND sg13cmos5l_decap_8
XANTENNA__498__X Tile_X1Y0_FrameStrobe_O[19] VPWR VGND sg13cmos5l_antennanp
XFILLER_9_1065 VPWR VGND sg13cmos5l_decap_8
XFILLER_9_1032 VPWR VGND sg13cmos5l_decap_8
XFILLER_9_1021 VPWR VGND sg13cmos5l_decap_8
XFILLER_7_991 VPWR VGND sg13cmos5l_decap_8
XFILLER_10_1104 VPWR VGND sg13cmos5l_decap_4
XFILLER_12_762 VPWR VGND sg13cmos5l_fill_1
XFILLER_12_795 VPWR VGND sg13cmos5l_decap_8
XFILLER_15_1037 VPWR VGND sg13cmos5l_fill_1
X_117_ PMOD_IO_O7 _223_/Q _107_/X VPWR VGND sg13cmos5l_nor2b_1
XFILLER_8_755 VPWR VGND sg13cmos5l_decap_8
XANTENNA__494__A Tile_X1Y0_FrameStrobe[15] VPWR VGND sg13cmos5l_antennanp
XFILLER_13_559 VPWR VGND sg13cmos5l_decap_8
XFILLER_9_508 VPWR VGND sg13cmos5l_decap_8
XFILLER_5_714 VPWR VGND sg13cmos5l_fill_2
XFILLER_1_931 VPWR VGND sg13cmos5l_decap_8
XFILLER_4_224 VPWR VGND sg13cmos5l_fill_2
XFILLER_4_213 VPWR VGND sg13cmos5l_decap_8
XFILLER_0_496 VPWR VGND sg13cmos5l_fill_1
XANTENNA__610__A0 Tile_X1Y0_N2MID[2] VPWR VGND sg13cmos5l_antennanp
XFILLER_16_320 VPWR VGND sg13cmos5l_decap_4
XFILLER_16_397 VPWR VGND sg13cmos5l_decap_8
X_597_ _597_/X Tile_X0Y0_N2END[5] Tile_X0Y0_N4END[13] Tile_X0Y0_NN4END[2] _119_/X
+ _275_/Q _274_/Q VPWR VGND sg13cmos5l_mux4_1
XANTENNA_2 Tile_X0Y0_FrameData[7] VPWR VGND sg13cmos5l_antennanp
XFILLER_8_596 VPWR VGND sg13cmos5l_decap_8
XFILLER_6_20 VPWR VGND sg13cmos5l_fill_2
XANTENNA__489__A Tile_X1Y0_FrameStrobe[10] VPWR VGND sg13cmos5l_antennanp
XFILLER_6_1035 VPWR VGND sg13cmos5l_fill_1
XFILLER_6_1024 VPWR VGND sg13cmos5l_decap_8
XFILLER_4_780 VPWR VGND sg13cmos5l_fill_2
XANTENNA__601__A0 Tile_X1Y0_N1END[1] VPWR VGND sg13cmos5l_antennanp
XFILLER_13_0 VPWR VGND sg13cmos5l_fill_2
XFILLER_6_1079 VPWR VGND sg13cmos5l_decap_8
XANTENNA__399__A Tile_X0Y0_FrameStrobe[8] VPWR VGND sg13cmos5l_antennanp
XFILLER_1_249 VPWR VGND sg13cmos5l_fill_1
X_520_ Tile_X1Y0_S4BEG[1] _609_/X VPWR VGND sg13cmos5l_buf_1
XANTENNA__284__D Tile_X0Y0_FrameData[5] VPWR VGND sg13cmos5l_antennanp
XFILLER_13_301 VPWR VGND sg13cmos5l_decap_8
XFILLER_15_84 VPWR VGND sg13cmos5l_decap_8
XFILLER_16_1110 VPWR VGND sg13cmos5l_fill_2
X_382_ Tile_X0Y0_SS4BEG[7] _591_/X VPWR VGND sg13cmos5l_buf_1
X_451_ Tile_X1Y0_FrameData_O[4] Tile_X0Y0_FrameData[4] VPWR VGND sg13cmos5l_buf_1
XFILLER_12_1007 VPWR VGND sg13cmos5l_fill_1
XFILLER_12_1018 VPWR VGND sg13cmos5l_fill_2
XFILLER_13_378 VPWR VGND sg13cmos5l_decap_8
XFILLER_5_500 VPWR VGND sg13cmos5l_decap_8
XFILLER_1_772 VPWR VGND sg13cmos5l_fill_1
XFILLER_1_794 VPWR VGND sg13cmos5l_fill_2
XFILLER_5_577 VPWR VGND sg13cmos5l_decap_8
XANTENNA__194__D Tile_X0Y0_FrameData[22] VPWR VGND sg13cmos5l_antennanp
XFILLER_8_371 VPWR VGND sg13cmos5l_decap_8
XFILLER_14_109 VPWR VGND sg13cmos5l_decap_8
XFILLER_7_809 VPWR VGND sg13cmos5l_decap_8
XFILLER_2_503 VPWR VGND sg13cmos5l_decap_8
XANTENNA__279__D Tile_X0Y0_FrameData[10] VPWR VGND sg13cmos5l_antennanp
X_503_ Tile_X1Y0_S2BEG[0] Tile_X1Y0_N2MID[7] VPWR VGND sg13cmos5l_buf_1
XANTENNA__592__A2 Tile_X0Y0_NN4END[7] VPWR VGND sg13cmos5l_antennanp
XFILLER_13_131 VPWR VGND sg13cmos5l_decap_4
XFILLER_14_654 VPWR VGND sg13cmos5l_decap_8
X_296_ _296_/Q Tile_X0Y0_FrameData[25] VGND VPWR Tile_X0Y0_FrameStrobe[1] latch
X_365_ _365_/L_HI VPWR VGND sg13cmos5l_tiehi
X_434_ Tile_X0Y0_S4BEG[3] _571_/X VPWR VGND sg13cmos5l_buf_1
XANTENNA__244__CLK Tile_X0Y0_UserCLK VPWR VGND sg13cmos5l_antennanp
XFILLER_9_168 VPWR VGND sg13cmos5l_decap_8
XANTENNA__189__D Tile_X0Y0_FrameData[27] VPWR VGND sg13cmos5l_antennanp
XANTENNA__647__A3 Tile_X1Y0_NN4END[14] VPWR VGND sg13cmos5l_antennanp
XFILLER_1_591 VPWR VGND sg13cmos5l_decap_8
XFILLER_3_32 VPWR VGND sg13cmos5l_fill_1
XANTENNA__583__A2 Tile_X0Y0_NN4END[15] VPWR VGND sg13cmos5l_antennanp
XFILLER_9_691 VPWR VGND sg13cmos5l_decap_8
XANTENNA__574__A2 Tile_X0Y0_NN4END[6] VPWR VGND sg13cmos5l_antennanp
X_150_ _150_/Q Tile_X0Y0_FrameData[2] VGND VPWR Tile_X1Y0_FrameStrobe[0] latch
XFILLER_7_606 VPWR VGND sg13cmos5l_fill_2
XFILLER_10_167 VPWR VGND sg13cmos5l_decap_8
XFILLER_10_178 VPWR VGND sg13cmos5l_fill_1
XFILLER_13_1102 VPWR VGND sg13cmos5l_decap_4
X_081_ _081_/X _254_/Q _555_/X _233_/Q VPWR VGND sg13cmos5l_mux2_1
XFILLER_6_138 VPWR VGND sg13cmos5l_fill_2
XFILLER_2_344 VPWR VGND sg13cmos5l_decap_8
XANTENNA__565__A2 Tile_X0Y0_N2END[2] VPWR VGND sg13cmos5l_antennanp
X_279_ _279_/Q Tile_X0Y0_FrameData[10] VGND VPWR Tile_X0Y0_FrameStrobe[0] latch
X_348_ _348_/Q Tile_X0Y0_FrameData[5] VGND VPWR Tile_X0Y0_FrameStrobe[2] latch
X_417_ Tile_X0Y0_S2BEG[2] Tile_X0Y0_N2MID[5] VPWR VGND sg13cmos5l_buf_1
XFILLER_6_672 VPWR VGND sg13cmos5l_decap_8
XFILLER_5_182 VPWR VGND sg13cmos5l_decap_8
XANTENNA__320__GATE Tile_X0Y0_FrameStrobe[1] VPWR VGND sg13cmos5l_antennanp
XANTENNA__497__A Tile_X1Y0_FrameStrobe[18] VPWR VGND sg13cmos5l_antennanp
XANTENNA__335__GATE Tile_X0Y0_FrameStrobe[2] VPWR VGND sg13cmos5l_antennanp
XANTENNA__556__A2 Tile_X1Y0_N4END[10] VPWR VGND sg13cmos5l_antennanp
XFILLER_4_609 VPWR VGND sg13cmos5l_decap_8
XFILLER_0_815 VPWR VGND sg13cmos5l_fill_2
XANTENNA__292__D Tile_X0Y0_FrameData[29] VPWR VGND sg13cmos5l_antennanp
XFILLER_11_410 VPWR VGND sg13cmos5l_fill_2
XFILLER_11_443 VPWR VGND sg13cmos5l_fill_1
XFILLER_11_454 VPWR VGND sg13cmos5l_fill_1
XFILLER_12_955 VPWR VGND sg13cmos5l_fill_2
XFILLER_12_977 VPWR VGND sg13cmos5l_fill_2
XFILLER_12_999 VPWR VGND sg13cmos5l_fill_1
X_202_ _202_/Q Tile_X0Y0_FrameData[14] VGND VPWR Tile_X1Y0_FrameStrobe[2] latch
X_133_ _133_/Q Tile_X0Y0_FrameData[19] VGND VPWR Tile_X1Y0_FrameStrobe[0] latch
XFILLER_8_926 VPWR VGND sg13cmos5l_decap_8
X_064_ _064_/X _242_/Q _242_/D _234_/Q VPWR VGND sg13cmos5l_mux2_1
XFILLER_2_196 VPWR VGND sg13cmos5l_fill_1
XFILLER_6_480 VPWR VGND sg13cmos5l_decap_8
XFILLER_9_1044 VPWR VGND sg13cmos5l_decap_8
XANTENNA__274__GATE Tile_X0Y0_FrameStrobe[0] VPWR VGND sg13cmos5l_antennanp
XANTENNA__289__GATE Tile_X0Y0_FrameStrobe[0] VPWR VGND sg13cmos5l_antennanp
XANTENNA__212__GATE Tile_X1Y0_FrameStrobe[2] VPWR VGND sg13cmos5l_antennanp
XFILLER_5_907 VPWR VGND sg13cmos5l_fill_1
XANTENNA__227__GATE Tile_X1Y0_FrameStrobe[3] VPWR VGND sg13cmos5l_antennanp
XANTENNA__287__D Tile_X0Y0_FrameData[2] VPWR VGND sg13cmos5l_antennanp
XFILLER_0_634 VPWR VGND sg13cmos5l_fill_2
XFILLER_0_678 VPWR VGND sg13cmos5l_fill_2
XFILLER_16_502 VPWR VGND sg13cmos5l_decap_8
XFILLER_16_524 VPWR VGND sg13cmos5l_decap_8
XFILLER_16_579 VPWR VGND sg13cmos5l_decap_8
XFILLER_11_262 VPWR VGND sg13cmos5l_decap_8
XFILLER_15_1016 VPWR VGND sg13cmos5l_decap_8
X_116_ PMOD_IO_O6 _223_/Q _097_/X VPWR VGND sg13cmos5l_nor2b_1
XFILLER_8_778 VPWR VGND sg13cmos5l_fill_1
XANTENNA__111__Y PMOD_IO_O1 VPWR VGND sg13cmos5l_antennanp
XFILLER_4_995 VPWR VGND sg13cmos5l_decap_8
XFILLER_4_973 VPWR VGND sg13cmos5l_decap_8
XFILLER_4_940 VPWR VGND sg13cmos5l_decap_8
XFILLER_3_483 VPWR VGND sg13cmos5l_decap_8
XANTENNA__197__D Tile_X0Y0_FrameData[19] VPWR VGND sg13cmos5l_antennanp
XFILLER_13_538 VPWR VGND sg13cmos5l_decap_8
XANTENNA__151__GATE Tile_X1Y0_FrameStrobe[0] VPWR VGND sg13cmos5l_antennanp
XANTENNA__166__GATE Tile_X1Y0_FrameStrobe[1] VPWR VGND sg13cmos5l_antennanp
XFILLER_1_987 VPWR VGND sg13cmos5l_fill_1
XANTENNA__610__A1 Tile_X1Y0_N4END[13] VPWR VGND sg13cmos5l_antennanp
XFILLER_12_582 VPWR VGND sg13cmos5l_decap_8
XFILLER_16_376 VPWR VGND sg13cmos5l_decap_4
X_596_ _596_/X Tile_X0Y0_N2END[4] Tile_X0Y0_N4END[12] Tile_X0Y0_NN4END[3] _091_/X
+ _277_/Q _276_/Q VPWR VGND sg13cmos5l_mux4_1
XFILLER_8_575 VPWR VGND sg13cmos5l_decap_8
XFILLER_6_87 VPWR VGND sg13cmos5l_decap_4
XFILLER_6_1058 VPWR VGND sg13cmos5l_decap_8
XFILLER_6_1003 VPWR VGND sg13cmos5l_decap_8
XANTENNA__601__A1 Tile_X1Y0_N2MID[1] VPWR VGND sg13cmos5l_antennanp
XFILLER_13_357 VPWR VGND sg13cmos5l_decap_8
XFILLER_15_63 VPWR VGND sg13cmos5l_decap_8
X_381_ Tile_X0Y0_SS4BEG[6] _590_/X VPWR VGND sg13cmos5l_buf_1
X_450_ Tile_X1Y0_FrameData_O[3] Tile_X0Y0_FrameData[3] VPWR VGND sg13cmos5l_buf_1
XFILLER_5_556 VPWR VGND sg13cmos5l_decap_8
XFILLER_0_283 VPWR VGND sg13cmos5l_decap_4
XANTENNA__595__A0 Tile_X0Y0_N2END[3] VPWR VGND sg13cmos5l_antennanp
XFILLER_5_1091 VPWR VGND sg13cmos5l_decap_8
XFILLER_16_195 VPWR VGND sg13cmos5l_decap_8
X_579_ _579_/X Tile_X0Y0_N2MID[3] Tile_X0Y0_N4END[4] Tile_X0Y0_NN4END[11] _091_/X
+ _311_/Q _310_/Q VPWR VGND sg13cmos5l_mux4_1
XFILLER_9_851 VPWR VGND sg13cmos5l_fill_2
XANTENNA__586__A0 Tile_X0Y0_N2END[2] VPWR VGND sg13cmos5l_antennanp
XFILLER_10_316 VPWR VGND sg13cmos5l_fill_2
XFILLER_11_1085 VPWR VGND sg13cmos5l_decap_8
XFILLER_2_559 VPWR VGND sg13cmos5l_decap_8
XANTENNA__295__D Tile_X0Y0_FrameData[26] VPWR VGND sg13cmos5l_antennanp
XANTENNA__577__A0 Tile_X0Y0_N2MID[1] VPWR VGND sg13cmos5l_antennanp
X_433_ Tile_X0Y0_S4BEG[2] _570_/X VPWR VGND sg13cmos5l_buf_1
X_502_ Tile_X1Y0_S1BEG[3] Tile_X1Y0_N1END[0] VPWR VGND sg13cmos5l_buf_1
XFILLER_13_110 VPWR VGND sg13cmos5l_decap_8
XFILLER_13_154 VPWR VGND sg13cmos5l_fill_1
XFILLER_13_198 VPWR VGND sg13cmos5l_fill_2
XFILLER_14_633 VPWR VGND sg13cmos5l_decap_8
X_295_ _295_/Q Tile_X0Y0_FrameData[26] VGND VPWR Tile_X0Y0_FrameStrobe[1] latch
X_364_ _364_/L_HI VPWR VGND sg13cmos5l_tiehi
XFILLER_9_158 VPWR VGND sg13cmos5l_fill_2
XFILLER_10_894 VPWR VGND sg13cmos5l_fill_1
XFILLER_6_854 VPWR VGND sg13cmos5l_fill_2
XANTENNA__400__X Tile_X0Y0_FrameStrobe_O[9] VPWR VGND sg13cmos5l_antennanp
XFILLER_1_570 VPWR VGND sg13cmos5l_decap_8
XFILLER_3_99 VPWR VGND sg13cmos5l_decap_4
XANTENNA__568__A0 Tile_X0Y0_N2MID[0] VPWR VGND sg13cmos5l_antennanp
XFILLER_9_670 VPWR VGND sg13cmos5l_fill_1
XANTENNA__559__A0 Tile_X1Y0_N1END[0] VPWR VGND sg13cmos5l_antennanp
XFILLER_10_124 VPWR VGND sg13cmos5l_decap_8
X_080_ _080_/Y _120_/A _246_/D VPWR VGND sg13cmos5l_nor2_1
XFILLER_12_75 VPWR VGND sg13cmos5l_fill_2
XFILLER_2_301 VPWR VGND sg13cmos5l_fill_2
X_416_ Tile_X0Y0_S2BEG[1] Tile_X0Y0_N2MID[6] VPWR VGND sg13cmos5l_buf_1
X_278_ _278_/Q Tile_X0Y0_FrameData[11] VGND VPWR Tile_X0Y0_FrameStrobe[0] latch
X_347_ _347_/Q Tile_X0Y0_FrameData[6] VGND VPWR Tile_X0Y0_FrameStrobe[2] latch
XFILLER_6_651 VPWR VGND sg13cmos5l_decap_8
XANTENNA__114__Y PMOD_IO_O4 VPWR VGND sg13cmos5l_antennanp
XANTENNA__556__A3 Tile_X1Y0_NN4END[10] VPWR VGND sg13cmos5l_antennanp
XFILLER_12_912 VPWR VGND sg13cmos5l_decap_4
XFILLER_15_249 VPWR VGND sg13cmos5l_decap_8
XFILLER_11_422 VPWR VGND sg13cmos5l_decap_8
XFILLER_11_477 VPWR VGND sg13cmos5l_fill_1
XFILLER_11_488 VPWR VGND sg13cmos5l_decap_8
XFILLER_12_967 VPWR VGND sg13cmos5l_decap_8
XFILLER_12_989 VPWR VGND sg13cmos5l_fill_2
X_201_ _201_/Q Tile_X0Y0_FrameData[15] VGND VPWR Tile_X1Y0_FrameStrobe[2] latch
X_132_ _132_/Q Tile_X0Y0_FrameData[20] VGND VPWR Tile_X1Y0_FrameStrobe[0] latch
X_063_ _242_/D PMOD_IO_I7 _559_/X _222_/Q VPWR VGND sg13cmos5l_mux2_1
XFILLER_7_459 VPWR VGND sg13cmos5l_decap_4
XFILLER_7_448 VPWR VGND sg13cmos5l_fill_1
XFILLER_7_404 VPWR VGND sg13cmos5l_decap_8
XFILLER_2_142 VPWR VGND sg13cmos5l_fill_1
XFILLER_3_698 VPWR VGND sg13cmos5l_fill_2
XFILLER_3_654 VPWR VGND sg13cmos5l_decap_4
XFILLER_3_632 VPWR VGND sg13cmos5l_fill_1
XFILLER_3_0 VPWR VGND sg13cmos5l_fill_2
XANTENNA__109__Y PMOD_IO_O0 VPWR VGND sg13cmos5l_antennanp
XFILLER_14_282 VPWR VGND sg13cmos5l_decap_8
XFILLER_15_750 VPWR VGND sg13cmos5l_decap_4
XFILLER_9_65 VPWR VGND sg13cmos5l_decap_8
XFILLER_7_982 VPWR VGND sg13cmos5l_decap_4
XANTENNA__257__CLK Tile_X0Y0_UserCLK VPWR VGND sg13cmos5l_antennanp
XFILLER_9_1001 VPWR VGND sg13cmos5l_fill_2
XFILLER_12_219 VPWR VGND sg13cmos5l_decap_4
XFILLER_0_646 VPWR VGND sg13cmos5l_decap_4
XFILLER_4_429 VPWR VGND sg13cmos5l_decap_8
XFILLER_11_241 VPWR VGND sg13cmos5l_decap_8
XFILLER_12_753 VPWR VGND sg13cmos5l_decap_8
XFILLER_16_558 VPWR VGND sg13cmos5l_decap_8
XFILLER_11_285 VPWR VGND sg13cmos5l_decap_8
X_115_ PMOD_IO_O5 _223_/Q _101_/X VPWR VGND sg13cmos5l_nor2b_1
XFILLER_7_267 VPWR VGND sg13cmos5l_fill_2
XFILLER_7_256 VPWR VGND sg13cmos5l_decap_8
XFILLER_7_212 VPWR VGND sg13cmos5l_fill_2
XANTENNA__334__GATE Tile_X0Y0_FrameStrobe[2] VPWR VGND sg13cmos5l_antennanp
XFILLER_3_462 VPWR VGND sg13cmos5l_decap_8
XANTENNA__349__GATE Tile_X0Y0_FrameStrobe[2] VPWR VGND sg13cmos5l_antennanp
XFILLER_7_790 VPWR VGND sg13cmos5l_decap_4
XFILLER_13_517 VPWR VGND sg13cmos5l_decap_8
XFILLER_14_1094 VPWR VGND sg13cmos5l_decap_8
XANTENNA__298__D Tile_X0Y0_FrameData[23] VPWR VGND sg13cmos5l_antennanp
XFILLER_0_476 VPWR VGND sg13cmos5l_fill_2
XFILLER_1_955 VPWR VGND sg13cmos5l_decap_8
XFILLER_1_966 VPWR VGND sg13cmos5l_fill_2
XANTENNA__610__A2 Tile_X1Y0_NN4END[2] VPWR VGND sg13cmos5l_antennanp
XFILLER_16_355 VPWR VGND sg13cmos5l_decap_8
XFILLER_1_1104 VPWR VGND sg13cmos5l_decap_8
X_595_ _595_/X Tile_X0Y0_N2END[3] Tile_X0Y0_N4END[11] Tile_X0Y0_NN4END[4] _092_/X
+ _279_/Q _278_/Q VPWR VGND sg13cmos5l_mux4_1
XFILLER_12_561 VPWR VGND sg13cmos5l_decap_8
XFILLER_8_554 VPWR VGND sg13cmos5l_decap_8
XANTENNA__273__GATE Tile_X0Y0_FrameStrobe[0] VPWR VGND sg13cmos5l_antennanp
XANTENNA__403__X Tile_X0Y0_FrameStrobe_O[12] VPWR VGND sg13cmos5l_antennanp
XFILLER_6_66 VPWR VGND sg13cmos5l_decap_4
XFILLER_6_33 VPWR VGND sg13cmos5l_fill_2
XFILLER_6_22 VPWR VGND sg13cmos5l_fill_1
XANTENNA__288__GATE Tile_X0Y0_FrameStrobe[0] VPWR VGND sg13cmos5l_antennanp
XANTENNA__211__GATE Tile_X1Y0_FrameStrobe[2] VPWR VGND sg13cmos5l_antennanp
XANTENNA__226__GATE Tile_X1Y0_FrameStrobe[3] VPWR VGND sg13cmos5l_antennanp
XANTENNA__601__A2 Tile_X1Y0_N2END[6] VPWR VGND sg13cmos5l_antennanp
XFILLER_2_708 VPWR VGND sg13cmos5l_decap_4
XFILLER_13_336 VPWR VGND sg13cmos5l_decap_8
XFILLER_15_53 VPWR VGND sg13cmos5l_decap_8
X_380_ Tile_X0Y0_SS4BEG[5] _589_/X VPWR VGND sg13cmos5l_buf_1
XFILLER_5_535 VPWR VGND sg13cmos5l_decap_8
XFILLER_1_741 VPWR VGND sg13cmos5l_fill_2
XANTENNA__595__A1 Tile_X0Y0_N4END[11] VPWR VGND sg13cmos5l_antennanp
XFILLER_16_174 VPWR VGND sg13cmos5l_decap_8
X_647_ _647_/X Tile_X1Y0_N1END[1] Tile_X1Y0_N2END[3] Tile_X1Y0_N4END[14] Tile_X1Y0_NN4END[14]
+ _122_/Q _221_/Q VPWR VGND sg13cmos5l_mux4_1
X_578_ _578_/X Tile_X0Y0_N2MID[2] Tile_X0Y0_N4END[5] Tile_X0Y0_NN4END[10] _119_/X
+ _313_/Q _312_/Q VPWR VGND sg13cmos5l_mux4_1
XFILLER_5_1070 VPWR VGND sg13cmos5l_decap_8
XANTENNA__117__Y PMOD_IO_O7 VPWR VGND sg13cmos5l_antennanp
XFILLER_12_380 VPWR VGND sg13cmos5l_decap_8
XFILLER_13_892 VPWR VGND sg13cmos5l_fill_1
XFILLER_8_395 VPWR VGND sg13cmos5l_decap_8
.ends
