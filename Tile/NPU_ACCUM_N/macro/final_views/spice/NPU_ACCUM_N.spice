* NGSPICE file created from NPU_ACCUM_N.ext - technology: ihp-sg13cmos5l

* Black-box entry subcircuit for sg13cmos5l_antennanp abstract view
.subckt sg13cmos5l_antennanp A VDD VSS
.ends

* Black-box entry subcircuit for latch abstract view
.subckt latch Q D VSS VDD GATE
.ends

* Black-box entry subcircuit for sg13cmos5l_fill_1 abstract view
.subckt sg13cmos5l_fill_1 VDD VSS
.ends

* Black-box entry subcircuit for sg13cmos5l_decap_8 abstract view
.subckt sg13cmos5l_decap_8 VDD VSS
.ends

* Black-box entry subcircuit for sg13cmos5l_fill_2 abstract view
.subckt sg13cmos5l_fill_2 VDD VSS
.ends

* Black-box entry subcircuit for sg13cmos5l_mux4_1 abstract view
.subckt sg13cmos5l_mux4_1 X A0 A1 A2 A3 S0 S1 VDD VSS
.ends

* Black-box entry subcircuit for sg13cmos5l_nor2b_1 abstract view
.subckt sg13cmos5l_nor2b_1 Y A B_N VDD VSS
.ends

* Black-box entry subcircuit for sg13cmos5l_buf_1 abstract view
.subckt sg13cmos5l_buf_1 X A VDD VSS
.ends

* Black-box entry subcircuit for sg13cmos5l_decap_4 abstract view
.subckt sg13cmos5l_decap_4 VDD VSS
.ends

* Black-box entry subcircuit for sg13cmos5l_tiehi abstract view
.subckt sg13cmos5l_tiehi L_HI VDD VSS
.ends

* Black-box entry subcircuit for sg13cmos5l_dfrbpq_1 abstract view
.subckt sg13cmos5l_dfrbpq_1 Q CLK D RESET_B VDD VSS
.ends

.subckt NPU_ACCUM_N NPU_ADDR0 NPU_ADDR1 NPU_ADDR2 NPU_ADDR3 NPU_ADDR4 NPU_ADDR5 NPU_ADDR6
+ NPU_ADDR7 NPU_RDATA0 NPU_RDATA1 NPU_RDATA10 NPU_RDATA11 NPU_RDATA12 NPU_RDATA13
+ NPU_RDATA14 NPU_RDATA15 NPU_RDATA16 NPU_RDATA17 NPU_RDATA18 NPU_RDATA19 NPU_RDATA2
+ NPU_RDATA20 NPU_RDATA21 NPU_RDATA22 NPU_RDATA23 NPU_RDATA24 NPU_RDATA25 NPU_RDATA26
+ NPU_RDATA27 NPU_RDATA28 NPU_RDATA29 NPU_RDATA3 NPU_RDATA30 NPU_RDATA31 NPU_RDATA4
+ NPU_RDATA5 NPU_RDATA6 NPU_RDATA7 NPU_RDATA8 NPU_RDATA9 NPU_READ_BANK_SEL0 NPU_READ_BANK_SEL1
+ NPU_READ_BANK_SEL2 NPU_WDATA0 NPU_WDATA1 NPU_WDATA10 NPU_WDATA11 NPU_WDATA12 NPU_WDATA13
+ NPU_WDATA14 NPU_WDATA15 NPU_WDATA16 NPU_WDATA17 NPU_WDATA18 NPU_WDATA19 NPU_WDATA2
+ NPU_WDATA20 NPU_WDATA21 NPU_WDATA22 NPU_WDATA23 NPU_WDATA24 NPU_WDATA25 NPU_WDATA26
+ NPU_WDATA27 NPU_WDATA28 NPU_WDATA29 NPU_WDATA3 NPU_WDATA30 NPU_WDATA31 NPU_WDATA4
+ NPU_WDATA5 NPU_WDATA6 NPU_WDATA7 NPU_WDATA8 NPU_WDATA9 NPU_WE0 NPU_WE1 NPU_WE2 NPU_WE3
+ NPU_WE4 NPU_WE5 NPU_WE6 NPU_WE7 Tile_X0Y0_Ci Tile_X0Y0_FrameData[0] Tile_X0Y0_FrameData[10]
+ Tile_X0Y0_FrameData[11] Tile_X0Y0_FrameData[12] Tile_X0Y0_FrameData[13] Tile_X0Y0_FrameData[14]
+ Tile_X0Y0_FrameData[15] Tile_X0Y0_FrameData[16] Tile_X0Y0_FrameData[17] Tile_X0Y0_FrameData[18]
+ Tile_X0Y0_FrameData[19] Tile_X0Y0_FrameData[1] Tile_X0Y0_FrameData[20] Tile_X0Y0_FrameData[21]
+ Tile_X0Y0_FrameData[22] Tile_X0Y0_FrameData[23] Tile_X0Y0_FrameData[24] Tile_X0Y0_FrameData[25]
+ Tile_X0Y0_FrameData[26] Tile_X0Y0_FrameData[27] Tile_X0Y0_FrameData[28] Tile_X0Y0_FrameData[29]
+ Tile_X0Y0_FrameData[2] Tile_X0Y0_FrameData[30] Tile_X0Y0_FrameData[31] Tile_X0Y0_FrameData[3]
+ Tile_X0Y0_FrameData[4] Tile_X0Y0_FrameData[5] Tile_X0Y0_FrameData[6] Tile_X0Y0_FrameData[7]
+ Tile_X0Y0_FrameData[8] Tile_X0Y0_FrameData[9] Tile_X0Y0_FrameStrobe[0] Tile_X0Y0_FrameStrobe[10]
+ Tile_X0Y0_FrameStrobe[11] Tile_X0Y0_FrameStrobe[12] Tile_X0Y0_FrameStrobe[13] Tile_X0Y0_FrameStrobe[14]
+ Tile_X0Y0_FrameStrobe[15] Tile_X0Y0_FrameStrobe[16] Tile_X0Y0_FrameStrobe[17] Tile_X0Y0_FrameStrobe[18]
+ Tile_X0Y0_FrameStrobe[19] Tile_X0Y0_FrameStrobe[1] Tile_X0Y0_FrameStrobe[2] Tile_X0Y0_FrameStrobe[3]
+ Tile_X0Y0_FrameStrobe[4] Tile_X0Y0_FrameStrobe[5] Tile_X0Y0_FrameStrobe[6] Tile_X0Y0_FrameStrobe[7]
+ Tile_X0Y0_FrameStrobe[8] Tile_X0Y0_FrameStrobe[9] Tile_X0Y0_FrameStrobe_O[0] Tile_X0Y0_FrameStrobe_O[10]
+ Tile_X0Y0_FrameStrobe_O[11] Tile_X0Y0_FrameStrobe_O[12] Tile_X0Y0_FrameStrobe_O[13]
+ Tile_X0Y0_FrameStrobe_O[14] Tile_X0Y0_FrameStrobe_O[15] Tile_X0Y0_FrameStrobe_O[16]
+ Tile_X0Y0_FrameStrobe_O[17] Tile_X0Y0_FrameStrobe_O[18] Tile_X0Y0_FrameStrobe_O[19]
+ Tile_X0Y0_FrameStrobe_O[1] Tile_X0Y0_FrameStrobe_O[2] Tile_X0Y0_FrameStrobe_O[3]
+ Tile_X0Y0_FrameStrobe_O[4] Tile_X0Y0_FrameStrobe_O[5] Tile_X0Y0_FrameStrobe_O[6]
+ Tile_X0Y0_FrameStrobe_O[7] Tile_X0Y0_FrameStrobe_O[8] Tile_X0Y0_FrameStrobe_O[9]
+ Tile_X0Y0_N1END[0] Tile_X0Y0_N1END[1] Tile_X0Y0_N1END[2] Tile_X0Y0_N1END[3] Tile_X0Y0_N2END[0]
+ Tile_X0Y0_N2END[1] Tile_X0Y0_N2END[2] Tile_X0Y0_N2END[3] Tile_X0Y0_N2END[4] Tile_X0Y0_N2END[5]
+ Tile_X0Y0_N2END[6] Tile_X0Y0_N2END[7] Tile_X0Y0_N2MID[0] Tile_X0Y0_N2MID[1] Tile_X0Y0_N2MID[2]
+ Tile_X0Y0_N2MID[3] Tile_X0Y0_N2MID[4] Tile_X0Y0_N2MID[5] Tile_X0Y0_N2MID[6] Tile_X0Y0_N2MID[7]
+ Tile_X0Y0_N4END[0] Tile_X0Y0_N4END[10] Tile_X0Y0_N4END[11] Tile_X0Y0_N4END[12] Tile_X0Y0_N4END[13]
+ Tile_X0Y0_N4END[14] Tile_X0Y0_N4END[15] Tile_X0Y0_N4END[1] Tile_X0Y0_N4END[2] Tile_X0Y0_N4END[3]
+ Tile_X0Y0_N4END[4] Tile_X0Y0_N4END[5] Tile_X0Y0_N4END[6] Tile_X0Y0_N4END[7] Tile_X0Y0_N4END[8]
+ Tile_X0Y0_N4END[9] Tile_X0Y0_NN4END[0] Tile_X0Y0_NN4END[10] Tile_X0Y0_NN4END[11]
+ Tile_X0Y0_NN4END[12] Tile_X0Y0_NN4END[13] Tile_X0Y0_NN4END[14] Tile_X0Y0_NN4END[15]
+ Tile_X0Y0_NN4END[1] Tile_X0Y0_NN4END[2] Tile_X0Y0_NN4END[3] Tile_X0Y0_NN4END[4]
+ Tile_X0Y0_NN4END[5] Tile_X0Y0_NN4END[6] Tile_X0Y0_NN4END[7] Tile_X0Y0_NN4END[8]
+ Tile_X0Y0_NN4END[9] Tile_X0Y0_S1BEG[0] Tile_X0Y0_S1BEG[1] Tile_X0Y0_S1BEG[2] Tile_X0Y0_S1BEG[3]
+ Tile_X0Y0_S2BEG[0] Tile_X0Y0_S2BEG[1] Tile_X0Y0_S2BEG[2] Tile_X0Y0_S2BEG[3] Tile_X0Y0_S2BEG[4]
+ Tile_X0Y0_S2BEG[5] Tile_X0Y0_S2BEG[6] Tile_X0Y0_S2BEG[7] Tile_X0Y0_S2BEGb[0] Tile_X0Y0_S2BEGb[1]
+ Tile_X0Y0_S2BEGb[2] Tile_X0Y0_S2BEGb[3] Tile_X0Y0_S2BEGb[4] Tile_X0Y0_S2BEGb[5]
+ Tile_X0Y0_S2BEGb[6] Tile_X0Y0_S2BEGb[7] Tile_X0Y0_S4BEG[0] Tile_X0Y0_S4BEG[10] Tile_X0Y0_S4BEG[11]
+ Tile_X0Y0_S4BEG[12] Tile_X0Y0_S4BEG[13] Tile_X0Y0_S4BEG[14] Tile_X0Y0_S4BEG[15]
+ Tile_X0Y0_S4BEG[1] Tile_X0Y0_S4BEG[2] Tile_X0Y0_S4BEG[3] Tile_X0Y0_S4BEG[4] Tile_X0Y0_S4BEG[5]
+ Tile_X0Y0_S4BEG[6] Tile_X0Y0_S4BEG[7] Tile_X0Y0_S4BEG[8] Tile_X0Y0_S4BEG[9] Tile_X0Y0_SS4BEG[0]
+ Tile_X0Y0_SS4BEG[10] Tile_X0Y0_SS4BEG[11] Tile_X0Y0_SS4BEG[12] Tile_X0Y0_SS4BEG[13]
+ Tile_X0Y0_SS4BEG[14] Tile_X0Y0_SS4BEG[15] Tile_X0Y0_SS4BEG[1] Tile_X0Y0_SS4BEG[2]
+ Tile_X0Y0_SS4BEG[3] Tile_X0Y0_SS4BEG[4] Tile_X0Y0_SS4BEG[5] Tile_X0Y0_SS4BEG[6]
+ Tile_X0Y0_SS4BEG[7] Tile_X0Y0_SS4BEG[8] Tile_X0Y0_SS4BEG[9] Tile_X0Y0_UserCLK Tile_X1Y0_Ci
+ Tile_X1Y0_FrameStrobe[0] Tile_X1Y0_FrameStrobe[10] Tile_X1Y0_FrameStrobe[11] Tile_X1Y0_FrameStrobe[12]
+ Tile_X1Y0_FrameStrobe[13] Tile_X1Y0_FrameStrobe[14] Tile_X1Y0_FrameStrobe[15] Tile_X1Y0_FrameStrobe[16]
+ Tile_X1Y0_FrameStrobe[17] Tile_X1Y0_FrameStrobe[18] Tile_X1Y0_FrameStrobe[19] Tile_X1Y0_FrameStrobe[1]
+ Tile_X1Y0_FrameStrobe[2] Tile_X1Y0_FrameStrobe[3] Tile_X1Y0_FrameStrobe[4] Tile_X1Y0_FrameStrobe[5]
+ Tile_X1Y0_FrameStrobe[6] Tile_X1Y0_FrameStrobe[7] Tile_X1Y0_FrameStrobe[8] Tile_X1Y0_FrameStrobe[9]
+ Tile_X1Y0_FrameStrobe_O[0] Tile_X1Y0_FrameStrobe_O[10] Tile_X1Y0_FrameStrobe_O[11]
+ Tile_X1Y0_FrameStrobe_O[12] Tile_X1Y0_FrameStrobe_O[13] Tile_X1Y0_FrameStrobe_O[14]
+ Tile_X1Y0_FrameStrobe_O[15] Tile_X1Y0_FrameStrobe_O[16] Tile_X1Y0_FrameStrobe_O[17]
+ Tile_X1Y0_FrameStrobe_O[18] Tile_X1Y0_FrameStrobe_O[19] Tile_X1Y0_FrameStrobe_O[1]
+ Tile_X1Y0_FrameStrobe_O[2] Tile_X1Y0_FrameStrobe_O[3] Tile_X1Y0_FrameStrobe_O[4]
+ Tile_X1Y0_FrameStrobe_O[5] Tile_X1Y0_FrameStrobe_O[6] Tile_X1Y0_FrameStrobe_O[7]
+ Tile_X1Y0_FrameStrobe_O[8] Tile_X1Y0_FrameStrobe_O[9] Tile_X1Y0_N1END[0] Tile_X1Y0_N1END[1]
+ Tile_X1Y0_N1END[2] Tile_X1Y0_N1END[3] Tile_X1Y0_N2END[0] Tile_X1Y0_N2END[1] Tile_X1Y0_N2END[2]
+ Tile_X1Y0_N2END[3] Tile_X1Y0_N2END[4] Tile_X1Y0_N2END[5] Tile_X1Y0_N2END[6] Tile_X1Y0_N2END[7]
+ Tile_X1Y0_N2MID[0] Tile_X1Y0_N2MID[1] Tile_X1Y0_N2MID[2] Tile_X1Y0_N2MID[3] Tile_X1Y0_N2MID[4]
+ Tile_X1Y0_N2MID[5] Tile_X1Y0_N2MID[6] Tile_X1Y0_N2MID[7] Tile_X1Y0_N4END[0] Tile_X1Y0_N4END[10]
+ Tile_X1Y0_N4END[11] Tile_X1Y0_N4END[12] Tile_X1Y0_N4END[13] Tile_X1Y0_N4END[14]
+ Tile_X1Y0_N4END[15] Tile_X1Y0_N4END[1] Tile_X1Y0_N4END[2] Tile_X1Y0_N4END[3] Tile_X1Y0_N4END[4]
+ Tile_X1Y0_N4END[5] Tile_X1Y0_N4END[6] Tile_X1Y0_N4END[7] Tile_X1Y0_N4END[8] Tile_X1Y0_N4END[9]
+ Tile_X1Y0_NN4END[0] Tile_X1Y0_NN4END[10] Tile_X1Y0_NN4END[11] Tile_X1Y0_NN4END[12]
+ Tile_X1Y0_NN4END[13] Tile_X1Y0_NN4END[14] Tile_X1Y0_NN4END[15] Tile_X1Y0_NN4END[1]
+ Tile_X1Y0_NN4END[2] Tile_X1Y0_NN4END[3] Tile_X1Y0_NN4END[4] Tile_X1Y0_NN4END[5]
+ Tile_X1Y0_NN4END[6] Tile_X1Y0_NN4END[7] Tile_X1Y0_NN4END[8] Tile_X1Y0_NN4END[9]
+ Tile_X1Y0_S1BEG[0] Tile_X1Y0_S1BEG[1] Tile_X1Y0_S1BEG[2] Tile_X1Y0_S1BEG[3] Tile_X1Y0_S2BEG[0]
+ Tile_X1Y0_S2BEG[1] Tile_X1Y0_S2BEG[2] Tile_X1Y0_S2BEG[3] Tile_X1Y0_S2BEG[4] Tile_X1Y0_S2BEG[5]
+ Tile_X1Y0_S2BEG[6] Tile_X1Y0_S2BEG[7] Tile_X1Y0_S2BEGb[0] Tile_X1Y0_S2BEGb[1] Tile_X1Y0_S2BEGb[2]
+ Tile_X1Y0_S2BEGb[3] Tile_X1Y0_S2BEGb[4] Tile_X1Y0_S2BEGb[5] Tile_X1Y0_S2BEGb[6]
+ Tile_X1Y0_S2BEGb[7] Tile_X1Y0_S4BEG[0] Tile_X1Y0_S4BEG[10] Tile_X1Y0_S4BEG[11] Tile_X1Y0_S4BEG[12]
+ Tile_X1Y0_S4BEG[13] Tile_X1Y0_S4BEG[14] Tile_X1Y0_S4BEG[15] Tile_X1Y0_S4BEG[1] Tile_X1Y0_S4BEG[2]
+ Tile_X1Y0_S4BEG[3] Tile_X1Y0_S4BEG[4] Tile_X1Y0_S4BEG[5] Tile_X1Y0_S4BEG[6] Tile_X1Y0_S4BEG[7]
+ Tile_X1Y0_S4BEG[8] Tile_X1Y0_S4BEG[9] Tile_X1Y0_SS4BEG[0] Tile_X1Y0_SS4BEG[10] Tile_X1Y0_SS4BEG[11]
+ Tile_X1Y0_SS4BEG[12] Tile_X1Y0_SS4BEG[13] Tile_X1Y0_SS4BEG[14] Tile_X1Y0_SS4BEG[15]
+ Tile_X1Y0_SS4BEG[1] Tile_X1Y0_SS4BEG[2] Tile_X1Y0_SS4BEG[3] Tile_X1Y0_SS4BEG[4]
+ Tile_X1Y0_SS4BEG[5] Tile_X1Y0_SS4BEG[6] Tile_X1Y0_SS4BEG[7] Tile_X1Y0_SS4BEG[8]
+ Tile_X1Y0_SS4BEG[9] Tile_X2Y0_Ci Tile_X2Y0_FrameStrobe[0] Tile_X2Y0_FrameStrobe[10]
+ Tile_X2Y0_FrameStrobe[11] Tile_X2Y0_FrameStrobe[12] Tile_X2Y0_FrameStrobe[13] Tile_X2Y0_FrameStrobe[14]
+ Tile_X2Y0_FrameStrobe[15] Tile_X2Y0_FrameStrobe[16] Tile_X2Y0_FrameStrobe[17] Tile_X2Y0_FrameStrobe[18]
+ Tile_X2Y0_FrameStrobe[19] Tile_X2Y0_FrameStrobe[1] Tile_X2Y0_FrameStrobe[2] Tile_X2Y0_FrameStrobe[3]
+ Tile_X2Y0_FrameStrobe[4] Tile_X2Y0_FrameStrobe[5] Tile_X2Y0_FrameStrobe[6] Tile_X2Y0_FrameStrobe[7]
+ Tile_X2Y0_FrameStrobe[8] Tile_X2Y0_FrameStrobe[9] Tile_X2Y0_FrameStrobe_O[0] Tile_X2Y0_FrameStrobe_O[10]
+ Tile_X2Y0_FrameStrobe_O[11] Tile_X2Y0_FrameStrobe_O[12] Tile_X2Y0_FrameStrobe_O[13]
+ Tile_X2Y0_FrameStrobe_O[14] Tile_X2Y0_FrameStrobe_O[15] Tile_X2Y0_FrameStrobe_O[16]
+ Tile_X2Y0_FrameStrobe_O[17] Tile_X2Y0_FrameStrobe_O[18] Tile_X2Y0_FrameStrobe_O[19]
+ Tile_X2Y0_FrameStrobe_O[1] Tile_X2Y0_FrameStrobe_O[2] Tile_X2Y0_FrameStrobe_O[3]
+ Tile_X2Y0_FrameStrobe_O[4] Tile_X2Y0_FrameStrobe_O[5] Tile_X2Y0_FrameStrobe_O[6]
+ Tile_X2Y0_FrameStrobe_O[7] Tile_X2Y0_FrameStrobe_O[8] Tile_X2Y0_FrameStrobe_O[9]
+ Tile_X2Y0_N1END[0] Tile_X2Y0_N1END[1] Tile_X2Y0_N1END[2] Tile_X2Y0_N1END[3] Tile_X2Y0_N2END[0]
+ Tile_X2Y0_N2END[1] Tile_X2Y0_N2END[2] Tile_X2Y0_N2END[3] Tile_X2Y0_N2END[4] Tile_X2Y0_N2END[5]
+ Tile_X2Y0_N2END[6] Tile_X2Y0_N2END[7] Tile_X2Y0_N2MID[0] Tile_X2Y0_N2MID[1] Tile_X2Y0_N2MID[2]
+ Tile_X2Y0_N2MID[3] Tile_X2Y0_N2MID[4] Tile_X2Y0_N2MID[5] Tile_X2Y0_N2MID[6] Tile_X2Y0_N2MID[7]
+ Tile_X2Y0_N4END[0] Tile_X2Y0_N4END[10] Tile_X2Y0_N4END[11] Tile_X2Y0_N4END[12] Tile_X2Y0_N4END[13]
+ Tile_X2Y0_N4END[14] Tile_X2Y0_N4END[15] Tile_X2Y0_N4END[1] Tile_X2Y0_N4END[2] Tile_X2Y0_N4END[3]
+ Tile_X2Y0_N4END[4] Tile_X2Y0_N4END[5] Tile_X2Y0_N4END[6] Tile_X2Y0_N4END[7] Tile_X2Y0_N4END[8]
+ Tile_X2Y0_N4END[9] Tile_X2Y0_NN4END[0] Tile_X2Y0_NN4END[10] Tile_X2Y0_NN4END[11]
+ Tile_X2Y0_NN4END[12] Tile_X2Y0_NN4END[13] Tile_X2Y0_NN4END[14] Tile_X2Y0_NN4END[15]
+ Tile_X2Y0_NN4END[1] Tile_X2Y0_NN4END[2] Tile_X2Y0_NN4END[3] Tile_X2Y0_NN4END[4]
+ Tile_X2Y0_NN4END[5] Tile_X2Y0_NN4END[6] Tile_X2Y0_NN4END[7] Tile_X2Y0_NN4END[8]
+ Tile_X2Y0_NN4END[9] Tile_X2Y0_S1BEG[0] Tile_X2Y0_S1BEG[1] Tile_X2Y0_S1BEG[2] Tile_X2Y0_S1BEG[3]
+ Tile_X2Y0_S2BEG[0] Tile_X2Y0_S2BEG[1] Tile_X2Y0_S2BEG[2] Tile_X2Y0_S2BEG[3] Tile_X2Y0_S2BEG[4]
+ Tile_X2Y0_S2BEG[5] Tile_X2Y0_S2BEG[6] Tile_X2Y0_S2BEG[7] Tile_X2Y0_S2BEGb[0] Tile_X2Y0_S2BEGb[1]
+ Tile_X2Y0_S2BEGb[2] Tile_X2Y0_S2BEGb[3] Tile_X2Y0_S2BEGb[4] Tile_X2Y0_S2BEGb[5]
+ Tile_X2Y0_S2BEGb[6] Tile_X2Y0_S2BEGb[7] Tile_X2Y0_S4BEG[0] Tile_X2Y0_S4BEG[10] Tile_X2Y0_S4BEG[11]
+ Tile_X2Y0_S4BEG[12] Tile_X2Y0_S4BEG[13] Tile_X2Y0_S4BEG[14] Tile_X2Y0_S4BEG[15]
+ Tile_X2Y0_S4BEG[1] Tile_X2Y0_S4BEG[2] Tile_X2Y0_S4BEG[3] Tile_X2Y0_S4BEG[4] Tile_X2Y0_S4BEG[5]
+ Tile_X2Y0_S4BEG[6] Tile_X2Y0_S4BEG[7] Tile_X2Y0_S4BEG[8] Tile_X2Y0_S4BEG[9] Tile_X2Y0_SS4BEG[0]
+ Tile_X2Y0_SS4BEG[10] Tile_X2Y0_SS4BEG[11] Tile_X2Y0_SS4BEG[12] Tile_X2Y0_SS4BEG[13]
+ Tile_X2Y0_SS4BEG[14] Tile_X2Y0_SS4BEG[15] Tile_X2Y0_SS4BEG[1] Tile_X2Y0_SS4BEG[2]
+ Tile_X2Y0_SS4BEG[3] Tile_X2Y0_SS4BEG[4] Tile_X2Y0_SS4BEG[5] Tile_X2Y0_SS4BEG[6]
+ Tile_X2Y0_SS4BEG[7] Tile_X2Y0_SS4BEG[8] Tile_X2Y0_SS4BEG[9] Tile_X3Y0_Ci Tile_X3Y0_FrameStrobe[0]
+ Tile_X3Y0_FrameStrobe[10] Tile_X3Y0_FrameStrobe[11] Tile_X3Y0_FrameStrobe[12] Tile_X3Y0_FrameStrobe[13]
+ Tile_X3Y0_FrameStrobe[14] Tile_X3Y0_FrameStrobe[15] Tile_X3Y0_FrameStrobe[16] Tile_X3Y0_FrameStrobe[17]
+ Tile_X3Y0_FrameStrobe[18] Tile_X3Y0_FrameStrobe[19] Tile_X3Y0_FrameStrobe[1] Tile_X3Y0_FrameStrobe[2]
+ Tile_X3Y0_FrameStrobe[3] Tile_X3Y0_FrameStrobe[4] Tile_X3Y0_FrameStrobe[5] Tile_X3Y0_FrameStrobe[6]
+ Tile_X3Y0_FrameStrobe[7] Tile_X3Y0_FrameStrobe[8] Tile_X3Y0_FrameStrobe[9] Tile_X3Y0_FrameStrobe_O[0]
+ Tile_X3Y0_FrameStrobe_O[10] Tile_X3Y0_FrameStrobe_O[11] Tile_X3Y0_FrameStrobe_O[12]
+ Tile_X3Y0_FrameStrobe_O[13] Tile_X3Y0_FrameStrobe_O[14] Tile_X3Y0_FrameStrobe_O[15]
+ Tile_X3Y0_FrameStrobe_O[16] Tile_X3Y0_FrameStrobe_O[17] Tile_X3Y0_FrameStrobe_O[18]
+ Tile_X3Y0_FrameStrobe_O[19] Tile_X3Y0_FrameStrobe_O[1] Tile_X3Y0_FrameStrobe_O[2]
+ Tile_X3Y0_FrameStrobe_O[3] Tile_X3Y0_FrameStrobe_O[4] Tile_X3Y0_FrameStrobe_O[5]
+ Tile_X3Y0_FrameStrobe_O[6] Tile_X3Y0_FrameStrobe_O[7] Tile_X3Y0_FrameStrobe_O[8]
+ Tile_X3Y0_FrameStrobe_O[9] Tile_X3Y0_N1END[0] Tile_X3Y0_N1END[1] Tile_X3Y0_N1END[2]
+ Tile_X3Y0_N1END[3] Tile_X3Y0_N2END[0] Tile_X3Y0_N2END[1] Tile_X3Y0_N2END[2] Tile_X3Y0_N2END[3]
+ Tile_X3Y0_N2END[4] Tile_X3Y0_N2END[5] Tile_X3Y0_N2END[6] Tile_X3Y0_N2END[7] Tile_X3Y0_N2MID[0]
+ Tile_X3Y0_N2MID[1] Tile_X3Y0_N2MID[2] Tile_X3Y0_N2MID[3] Tile_X3Y0_N2MID[4] Tile_X3Y0_N2MID[5]
+ Tile_X3Y0_N2MID[6] Tile_X3Y0_N2MID[7] Tile_X3Y0_N4END[0] Tile_X3Y0_N4END[10] Tile_X3Y0_N4END[11]
+ Tile_X3Y0_N4END[12] Tile_X3Y0_N4END[13] Tile_X3Y0_N4END[14] Tile_X3Y0_N4END[15]
+ Tile_X3Y0_N4END[1] Tile_X3Y0_N4END[2] Tile_X3Y0_N4END[3] Tile_X3Y0_N4END[4] Tile_X3Y0_N4END[5]
+ Tile_X3Y0_N4END[6] Tile_X3Y0_N4END[7] Tile_X3Y0_N4END[8] Tile_X3Y0_N4END[9] Tile_X3Y0_NN4END[0]
+ Tile_X3Y0_NN4END[10] Tile_X3Y0_NN4END[11] Tile_X3Y0_NN4END[12] Tile_X3Y0_NN4END[13]
+ Tile_X3Y0_NN4END[14] Tile_X3Y0_NN4END[15] Tile_X3Y0_NN4END[1] Tile_X3Y0_NN4END[2]
+ Tile_X3Y0_NN4END[3] Tile_X3Y0_NN4END[4] Tile_X3Y0_NN4END[5] Tile_X3Y0_NN4END[6]
+ Tile_X3Y0_NN4END[7] Tile_X3Y0_NN4END[8] Tile_X3Y0_NN4END[9] Tile_X3Y0_S1BEG[0] Tile_X3Y0_S1BEG[1]
+ Tile_X3Y0_S1BEG[2] Tile_X3Y0_S1BEG[3] Tile_X3Y0_S2BEG[0] Tile_X3Y0_S2BEG[1] Tile_X3Y0_S2BEG[2]
+ Tile_X3Y0_S2BEG[3] Tile_X3Y0_S2BEG[4] Tile_X3Y0_S2BEG[5] Tile_X3Y0_S2BEG[6] Tile_X3Y0_S2BEG[7]
+ Tile_X3Y0_S2BEGb[0] Tile_X3Y0_S2BEGb[1] Tile_X3Y0_S2BEGb[2] Tile_X3Y0_S2BEGb[3]
+ Tile_X3Y0_S2BEGb[4] Tile_X3Y0_S2BEGb[5] Tile_X3Y0_S2BEGb[6] Tile_X3Y0_S2BEGb[7]
+ Tile_X3Y0_S4BEG[0] Tile_X3Y0_S4BEG[10] Tile_X3Y0_S4BEG[11] Tile_X3Y0_S4BEG[12] Tile_X3Y0_S4BEG[13]
+ Tile_X3Y0_S4BEG[14] Tile_X3Y0_S4BEG[15] Tile_X3Y0_S4BEG[1] Tile_X3Y0_S4BEG[2] Tile_X3Y0_S4BEG[3]
+ Tile_X3Y0_S4BEG[4] Tile_X3Y0_S4BEG[5] Tile_X3Y0_S4BEG[6] Tile_X3Y0_S4BEG[7] Tile_X3Y0_S4BEG[8]
+ Tile_X3Y0_S4BEG[9] Tile_X3Y0_SS4BEG[0] Tile_X3Y0_SS4BEG[10] Tile_X3Y0_SS4BEG[11]
+ Tile_X3Y0_SS4BEG[12] Tile_X3Y0_SS4BEG[13] Tile_X3Y0_SS4BEG[14] Tile_X3Y0_SS4BEG[15]
+ Tile_X3Y0_SS4BEG[1] Tile_X3Y0_SS4BEG[2] Tile_X3Y0_SS4BEG[3] Tile_X3Y0_SS4BEG[4]
+ Tile_X3Y0_SS4BEG[5] Tile_X3Y0_SS4BEG[6] Tile_X3Y0_SS4BEG[7] Tile_X3Y0_SS4BEG[8]
+ Tile_X3Y0_SS4BEG[9] Tile_X4Y0_Ci Tile_X4Y0_FrameData_O[0] Tile_X4Y0_FrameData_O[10]
+ Tile_X4Y0_FrameData_O[11] Tile_X4Y0_FrameData_O[12] Tile_X4Y0_FrameData_O[13] Tile_X4Y0_FrameData_O[14]
+ Tile_X4Y0_FrameData_O[15] Tile_X4Y0_FrameData_O[16] Tile_X4Y0_FrameData_O[17] Tile_X4Y0_FrameData_O[18]
+ Tile_X4Y0_FrameData_O[19] Tile_X4Y0_FrameData_O[1] Tile_X4Y0_FrameData_O[20] Tile_X4Y0_FrameData_O[21]
+ Tile_X4Y0_FrameData_O[22] Tile_X4Y0_FrameData_O[23] Tile_X4Y0_FrameData_O[24] Tile_X4Y0_FrameData_O[25]
+ Tile_X4Y0_FrameData_O[26] Tile_X4Y0_FrameData_O[27] Tile_X4Y0_FrameData_O[28] Tile_X4Y0_FrameData_O[29]
+ Tile_X4Y0_FrameData_O[2] Tile_X4Y0_FrameData_O[30] Tile_X4Y0_FrameData_O[31] Tile_X4Y0_FrameData_O[3]
+ Tile_X4Y0_FrameData_O[4] Tile_X4Y0_FrameData_O[5] Tile_X4Y0_FrameData_O[6] Tile_X4Y0_FrameData_O[7]
+ Tile_X4Y0_FrameData_O[8] Tile_X4Y0_FrameData_O[9] Tile_X4Y0_FrameStrobe[0] Tile_X4Y0_FrameStrobe[10]
+ Tile_X4Y0_FrameStrobe[11] Tile_X4Y0_FrameStrobe[12] Tile_X4Y0_FrameStrobe[13] Tile_X4Y0_FrameStrobe[14]
+ Tile_X4Y0_FrameStrobe[15] Tile_X4Y0_FrameStrobe[16] Tile_X4Y0_FrameStrobe[17] Tile_X4Y0_FrameStrobe[18]
+ Tile_X4Y0_FrameStrobe[19] Tile_X4Y0_FrameStrobe[1] Tile_X4Y0_FrameStrobe[2] Tile_X4Y0_FrameStrobe[3]
+ Tile_X4Y0_FrameStrobe[4] Tile_X4Y0_FrameStrobe[5] Tile_X4Y0_FrameStrobe[6] Tile_X4Y0_FrameStrobe[7]
+ Tile_X4Y0_FrameStrobe[8] Tile_X4Y0_FrameStrobe[9] Tile_X4Y0_FrameStrobe_O[0] Tile_X4Y0_FrameStrobe_O[10]
+ Tile_X4Y0_FrameStrobe_O[11] Tile_X4Y0_FrameStrobe_O[12] Tile_X4Y0_FrameStrobe_O[13]
+ Tile_X4Y0_FrameStrobe_O[14] Tile_X4Y0_FrameStrobe_O[15] Tile_X4Y0_FrameStrobe_O[16]
+ Tile_X4Y0_FrameStrobe_O[17] Tile_X4Y0_FrameStrobe_O[18] Tile_X4Y0_FrameStrobe_O[19]
+ Tile_X4Y0_FrameStrobe_O[1] Tile_X4Y0_FrameStrobe_O[2] Tile_X4Y0_FrameStrobe_O[3]
+ Tile_X4Y0_FrameStrobe_O[4] Tile_X4Y0_FrameStrobe_O[5] Tile_X4Y0_FrameStrobe_O[6]
+ Tile_X4Y0_FrameStrobe_O[7] Tile_X4Y0_FrameStrobe_O[8] Tile_X4Y0_FrameStrobe_O[9]
+ Tile_X4Y0_N1END[0] Tile_X4Y0_N1END[1] Tile_X4Y0_N1END[2] Tile_X4Y0_N1END[3] Tile_X4Y0_N2END[0]
+ Tile_X4Y0_N2END[1] Tile_X4Y0_N2END[2] Tile_X4Y0_N2END[3] Tile_X4Y0_N2END[4] Tile_X4Y0_N2END[5]
+ Tile_X4Y0_N2END[6] Tile_X4Y0_N2END[7] Tile_X4Y0_N2MID[0] Tile_X4Y0_N2MID[1] Tile_X4Y0_N2MID[2]
+ Tile_X4Y0_N2MID[3] Tile_X4Y0_N2MID[4] Tile_X4Y0_N2MID[5] Tile_X4Y0_N2MID[6] Tile_X4Y0_N2MID[7]
+ Tile_X4Y0_N4END[0] Tile_X4Y0_N4END[10] Tile_X4Y0_N4END[11] Tile_X4Y0_N4END[12] Tile_X4Y0_N4END[13]
+ Tile_X4Y0_N4END[14] Tile_X4Y0_N4END[15] Tile_X4Y0_N4END[1] Tile_X4Y0_N4END[2] Tile_X4Y0_N4END[3]
+ Tile_X4Y0_N4END[4] Tile_X4Y0_N4END[5] Tile_X4Y0_N4END[6] Tile_X4Y0_N4END[7] Tile_X4Y0_N4END[8]
+ Tile_X4Y0_N4END[9] Tile_X4Y0_NN4END[0] Tile_X4Y0_NN4END[10] Tile_X4Y0_NN4END[11]
+ Tile_X4Y0_NN4END[12] Tile_X4Y0_NN4END[13] Tile_X4Y0_NN4END[14] Tile_X4Y0_NN4END[15]
+ Tile_X4Y0_NN4END[1] Tile_X4Y0_NN4END[2] Tile_X4Y0_NN4END[3] Tile_X4Y0_NN4END[4]
+ Tile_X4Y0_NN4END[5] Tile_X4Y0_NN4END[6] Tile_X4Y0_NN4END[7] Tile_X4Y0_NN4END[8]
+ Tile_X4Y0_NN4END[9] Tile_X4Y0_S1BEG[0] Tile_X4Y0_S1BEG[1] Tile_X4Y0_S1BEG[2] Tile_X4Y0_S1BEG[3]
+ Tile_X4Y0_S2BEG[0] Tile_X4Y0_S2BEG[1] Tile_X4Y0_S2BEG[2] Tile_X4Y0_S2BEG[3] Tile_X4Y0_S2BEG[4]
+ Tile_X4Y0_S2BEG[5] Tile_X4Y0_S2BEG[6] Tile_X4Y0_S2BEG[7] Tile_X4Y0_S2BEGb[0] Tile_X4Y0_S2BEGb[1]
+ Tile_X4Y0_S2BEGb[2] Tile_X4Y0_S2BEGb[3] Tile_X4Y0_S2BEGb[4] Tile_X4Y0_S2BEGb[5]
+ Tile_X4Y0_S2BEGb[6] Tile_X4Y0_S2BEGb[7] Tile_X4Y0_S4BEG[0] Tile_X4Y0_S4BEG[10] Tile_X4Y0_S4BEG[11]
+ Tile_X4Y0_S4BEG[12] Tile_X4Y0_S4BEG[13] Tile_X4Y0_S4BEG[14] Tile_X4Y0_S4BEG[15]
+ Tile_X4Y0_S4BEG[1] Tile_X4Y0_S4BEG[2] Tile_X4Y0_S4BEG[3] Tile_X4Y0_S4BEG[4] Tile_X4Y0_S4BEG[5]
+ Tile_X4Y0_S4BEG[6] Tile_X4Y0_S4BEG[7] Tile_X4Y0_S4BEG[8] Tile_X4Y0_S4BEG[9] Tile_X4Y0_SS4BEG[0]
+ Tile_X4Y0_SS4BEG[10] Tile_X4Y0_SS4BEG[11] Tile_X4Y0_SS4BEG[12] Tile_X4Y0_SS4BEG[13]
+ Tile_X4Y0_SS4BEG[14] Tile_X4Y0_SS4BEG[15] Tile_X4Y0_SS4BEG[1] Tile_X4Y0_SS4BEG[2]
+ Tile_X4Y0_SS4BEG[3] Tile_X4Y0_SS4BEG[4] Tile_X4Y0_SS4BEG[5] Tile_X4Y0_SS4BEG[6]
+ Tile_X4Y0_SS4BEG[7] Tile_X4Y0_SS4BEG[8] Tile_X4Y0_SS4BEG[9] Tile_X4Y0_UserCLKo VGND
+ VPWR
XANTENNA__1151__A0 Tile_X0Y0_N2MID[4] VPWR VGND sg13cmos5l_antennanp
X_0367_ _0367_/Q Tile_X0Y0_FrameData[10] VGND VPWR Tile_X2Y0_FrameStrobe[1] latch
XFILLER_7_1880 VPWR VGND sg13cmos5l_fill_1
XFILLER_3_1722 VPWR VGND sg13cmos5l_decap_8
X_0298_ _0298_/Q Tile_X0Y0_FrameData[31] VGND VPWR Tile_X1Y0_FrameStrobe[3] latch
XFILLER_3_1766 VPWR VGND sg13cmos5l_fill_1
XANTENNA__1206__A1 Tile_X1Y0_N4END[11] VPWR VGND sg13cmos5l_antennanp
XANTENNA__0125__D Tile_X0Y0_FrameData[28] VPWR VGND sg13cmos5l_antennanp
XANTENNA__0703__A Tile_X0Y0_FrameStrobe[16] VPWR VGND sg13cmos5l_antennanp
XFILLER_2_505 VPWR VGND sg13cmos5l_decap_8
XFILLER_8_2312 VPWR VGND sg13cmos5l_decap_8
XFILLER_8_2389 VPWR VGND sg13cmos5l_decap_8
XFILLER_8_1633 VPWR VGND sg13cmos5l_decap_8
XANTENNA__1142__A0 Tile_X0Y0_N2MID[3] VPWR VGND sg13cmos5l_antennanp
XFILLER_8_1699 VPWR VGND sg13cmos5l_decap_8
XFILLER_4_1519 VPWR VGND sg13cmos5l_fill_1
XFILLER_14_623 VPWR VGND sg13cmos5l_decap_8
XFILLER_9_148 VPWR VGND sg13cmos5l_fill_1
XFILLER_13_177 VPWR VGND sg13cmos5l_decap_8
XFILLER_6_800 VPWR VGND sg13cmos5l_fill_2
XFILLER_10_851 VPWR VGND sg13cmos5l_fill_1
XANTENNA__0180__GATE Tile_X0Y0_FrameStrobe[2] VPWR VGND sg13cmos5l_antennanp
XFILLER_13_2586 VPWR VGND sg13cmos5l_decap_8
XFILLER_13_1863 VPWR VGND sg13cmos5l_decap_8
XFILLER_10_884 VPWR VGND sg13cmos5l_fill_1
XANTENNA__0900__X Tile_X2Y0_SS4BEG[1] VPWR VGND sg13cmos5l_antennanp
XANTENNA__0195__GATE Tile_X0Y0_FrameStrobe[3] VPWR VGND sg13cmos5l_antennanp
XFILLER_3_12 VPWR VGND sg13cmos5l_fill_2
XFILLER_7_1110 VPWR VGND sg13cmos5l_decap_8
XFILLER_3_56 VPWR VGND sg13cmos5l_fill_2
X_1270_ _1270_/X Tile_X3Y0_N2MID[3] Tile_X3Y0_N4END[4] Tile_X3Y0_NN4END[11] _0575_/Q
+ _0467_/Q _0466_/Q VPWR VGND sg13cmos5l_mux4_1
XFILLER_4_2710 VPWR VGND sg13cmos5l_decap_8
XANTENNA__1133__A0 Tile_X0Y0_N1END[2] VPWR VGND sg13cmos5l_antennanp
X_0221_ _0221_/Q Tile_X0Y0_FrameData[12] VGND VPWR Tile_X1Y0_FrameStrobe[0] latch
XFILLER_4_2776 VPWR VGND sg13cmos5l_decap_8
X_0152_ _0152_/Q Tile_X0Y0_FrameData[1] VGND VPWR Tile_X0Y0_FrameStrobe[1] latch
X_0083_ _0558_/D _0518_/Q _1090_/X VPWR VGND sg13cmos5l_nor2b_1
XANTENNA__0133__GATE Tile_X0Y0_FrameStrobe[1] VPWR VGND sg13cmos5l_antennanp
XFILLER_14_2339 VPWR VGND sg13cmos5l_fill_2
XANTENNA__0148__GATE Tile_X0Y0_FrameStrobe[1] VPWR VGND sg13cmos5l_antennanp
X_0985_ Tile_X0Y0_SS4BEG[10] _1165_/X VPWR VGND sg13cmos5l_buf_1
XFILLER_14_1627 VPWR VGND sg13cmos5l_decap_8
XFILLER_8_181 VPWR VGND sg13cmos5l_fill_2
XFILLER_12_2074 VPWR VGND sg13cmos5l_decap_8
XANTENNA__0810__X Tile_X3Y0_SS4BEG[15] VPWR VGND sg13cmos5l_antennanp
XFILLER_12_1395 VPWR VGND sg13cmos5l_fill_2
XFILLER_9_1942 VPWR VGND sg13cmos5l_fill_2
XFILLER_9_2676 VPWR VGND sg13cmos5l_decap_8
XANTENNA__1124__A0 Tile_X0Y0_N4END[12] VPWR VGND sg13cmos5l_antennanp
X_0419_ _0419_/Q Tile_X0Y0_FrameData[22] VGND VPWR Tile_X3Y0_FrameStrobe[0] latch
XFILLER_3_2286 VPWR VGND sg13cmos5l_decap_4
XFILLER_3_1552 VPWR VGND sg13cmos5l_decap_8
XFILLER_11_626 VPWR VGND sg13cmos5l_decap_8
XFILLER_7_608 VPWR VGND sg13cmos5l_decap_8
XFILLER_13_1126 VPWR VGND sg13cmos5l_decap_8
XFILLER_6_129 VPWR VGND sg13cmos5l_fill_1
XFILLER_6_118 VPWR VGND sg13cmos5l_decap_4
XFILLER_10_2737 VPWR VGND sg13cmos5l_decap_8
XFILLER_12_87 VPWR VGND sg13cmos5l_fill_1
XANTENNA__0720__X Tile_X1Y0_S4BEG[5] VPWR VGND sg13cmos5l_antennanp
XFILLER_3_858 VPWR VGND sg13cmos5l_fill_2
XFILLER_2_379 VPWR VGND sg13cmos5l_fill_1
XFILLER_8_2186 VPWR VGND sg13cmos5l_decap_8
XFILLER_8_1452 VPWR VGND sg13cmos5l_fill_2
XANTENNA__1115__A0 Tile_X0Y0_N4END[0] VPWR VGND sg13cmos5l_antennanp
XFILLER_4_1316 VPWR VGND sg13cmos5l_decap_8
XFILLER_4_1327 VPWR VGND sg13cmos5l_fill_1
XANTENNA__1130__A3 Tile_X4Y0_N2END[5] VPWR VGND sg13cmos5l_antennanp
XFILLER_15_2637 VPWR VGND sg13cmos5l_decap_8
XFILLER_15_1903 VPWR VGND sg13cmos5l_fill_2
XFILLER_14_497 VPWR VGND sg13cmos5l_decap_8
XFILLER_15_1936 VPWR VGND sg13cmos5l_decap_8
XFILLER_13_2350 VPWR VGND sg13cmos5l_decap_8
X_0770_ Tile_X3Y0_S2BEG[7] Tile_X3Y0_N2MID[0] VPWR VGND sg13cmos5l_buf_1
XFILLER_6_663 VPWR VGND sg13cmos5l_decap_8
XFILLER_13_1671 VPWR VGND sg13cmos5l_decap_8
XFILLER_5_151 VPWR VGND sg13cmos5l_decap_8
XFILLER_9_1238 VPWR VGND sg13cmos5l_decap_8
XFILLER_2_880 VPWR VGND sg13cmos5l_decap_8
XANTENNA__1106__A0 Tile_X1Y0_N4END[10] VPWR VGND sg13cmos5l_antennanp
X_1253_ _1253_/X Tile_X3Y0_N1END[2] Tile_X3Y0_N2MID[2] Tile_X3Y0_N2END[5] _0574_/Q
+ _0501_/Q _0500_/Q VPWR VGND sg13cmos5l_mux4_1
X_0204_ _0204_/Q Tile_X0Y0_FrameData[29] VGND VPWR Tile_X1Y0_FrameStrobe[0] latch
XFILLER_4_2584 VPWR VGND sg13cmos5l_decap_8
XANTENNA__1121__A3 Tile_X0Y0_NN4END[11] VPWR VGND sg13cmos5l_antennanp
X_1184_ _1184_/X Tile_X1Y0_N2MID[5] Tile_X1Y0_N4END[10] Tile_X1Y0_NN4END[5] _0593_/Q
+ _0287_/Q _0286_/Q VPWR VGND sg13cmos5l_mux4_1
XFILLER_0_1725 VPWR VGND sg13cmos5l_fill_1
XFILLER_0_1736 VPWR VGND sg13cmos5l_decap_4
XFILLER_0_1747 VPWR VGND sg13cmos5l_fill_2
X_0135_ _0135_/Q Tile_X0Y0_FrameData[18] VGND VPWR Tile_X0Y0_FrameStrobe[1] latch
XFILLER_0_1758 VPWR VGND sg13cmos5l_fill_2
XANTENNA__0805__X Tile_X3Y0_SS4BEG[10] VPWR VGND sg13cmos5l_antennanp
XFILLER_14_2136 VPWR VGND sg13cmos5l_decap_8
XFILLER_14_2147 VPWR VGND sg13cmos5l_fill_2
X_0968_ Tile_X1Y0_FrameStrobe_O[13] Tile_X1Y0_FrameStrobe[13] VPWR VGND sg13cmos5l_buf_1
XFILLER_14_1479 VPWR VGND sg13cmos5l_decap_8
XANTENNA__0403__D Tile_X0Y0_FrameData[6] VPWR VGND sg13cmos5l_antennanp
X_0899_ Tile_X2Y0_SS4BEG[0] _1235_/X VPWR VGND sg13cmos5l_buf_1
XFILLER_0_817 VPWR VGND sg13cmos5l_fill_2
XFILLER_9_2473 VPWR VGND sg13cmos5l_decap_8
XFILLER_9_1761 VPWR VGND sg13cmos5l_decap_4
XFILLER_5_2348 VPWR VGND sg13cmos5l_decap_8
XFILLER_5_1669 VPWR VGND sg13cmos5l_decap_8
XFILLER_3_2094 VPWR VGND sg13cmos5l_decap_4
XFILLER_3_2083 VPWR VGND sg13cmos5l_fill_1
XANTENNA__1112__A3 Tile_X0Y0_NN4END[2] VPWR VGND sg13cmos5l_antennanp
XFILLER_15_217 VPWR VGND sg13cmos5l_decap_8
XFILLER_15_206 VPWR VGND sg13cmos5l_decap_8
XFILLER_15_228 VPWR VGND sg13cmos5l_fill_1
XANTENNA__0715__X Tile_X1Y0_S4BEG[0] VPWR VGND sg13cmos5l_antennanp
XFILLER_7_438 VPWR VGND sg13cmos5l_fill_2
XFILLER_10_2545 VPWR VGND sg13cmos5l_fill_1
XANTENNA__0313__D Tile_X0Y0_FrameData[16] VPWR VGND sg13cmos5l_antennanp
XFILLER_3_600 VPWR VGND sg13cmos5l_decap_8
XFILLER_10_1855 VPWR VGND sg13cmos5l_decap_4
XFILLER_8_1271 VPWR VGND sg13cmos5l_decap_8
XFILLER_4_1113 VPWR VGND sg13cmos5l_decap_8
XFILLER_4_1168 VPWR VGND sg13cmos5l_decap_8
XANTENNA__1103__A3 Tile_X1Y0_NN4END[7] VPWR VGND sg13cmos5l_antennanp
XFILLER_15_751 VPWR VGND sg13cmos5l_decap_8
XFILLER_14_283 VPWR VGND sg13cmos5l_decap_8
XFILLER_15_2456 VPWR VGND sg13cmos5l_decap_8
X_0822_ Tile_X4Y0_FrameData_O[11] Tile_X0Y0_FrameData[11] VPWR VGND sg13cmos5l_buf_1
XFILLER_15_1766 VPWR VGND sg13cmos5l_decap_8
XFILLER_11_1608 VPWR VGND sg13cmos5l_decap_8
XANTENNA__0223__D Tile_X0Y0_FrameData[10] VPWR VGND sg13cmos5l_antennanp
X_0753_ Tile_X1Y0_S2BEG[2] Tile_X1Y0_N2MID[5] VPWR VGND sg13cmos5l_buf_1
X_0684_ _0684_/L_HI VPWR VGND sg13cmos5l_tiehi
XFILLER_9_1013 VPWR VGND sg13cmos5l_decap_8
XFILLER_6_2668 VPWR VGND sg13cmos5l_decap_8
XFILLER_0_2212 VPWR VGND sg13cmos5l_fill_1
X_1236_ _1236_/X Tile_X2Y0_N2END[1] Tile_X2Y0_N4END[1] Tile_X2Y0_NN4END[14] _0586_/Q
+ _0359_/Q _0358_/Q VPWR VGND sg13cmos5l_mux4_1
XFILLER_0_1511 VPWR VGND sg13cmos5l_decap_4
XFILLER_0_2234 VPWR VGND sg13cmos5l_fill_2
X_1167_ _1167_/X Tile_X0Y0_N2END[4] Tile_X0Y0_N4END[12] Tile_X0Y0_NN4END[3] _0597_/Q
+ _0129_/Q _0128_/Q VPWR VGND sg13cmos5l_mux4_1
X_0118_ _0118_/Q Tile_X0Y0_FrameData[3] VGND VPWR Tile_X0Y0_FrameStrobe[0] latch
XFILLER_4_1691 VPWR VGND sg13cmos5l_decap_8
X_1098_ _1098_/X Tile_X1Y0_N4END[2] Tile_X1Y0_N4END[3] Tile_X1Y0_NN4END[0] Tile_X1Y0_NN4END[2]
+ _0229_/Q _0228_/Q VPWR VGND sg13cmos5l_mux4_1
XANTENNA__1079__A Tile_X0Y0_UserCLK VPWR VGND sg13cmos5l_antennanp
XFILLER_14_1221 VPWR VGND sg13cmos5l_decap_8
XFILLER_10_1107 VPWR VGND sg13cmos5l_decap_8
XANTENNA__0133__D Tile_X0Y0_FrameData[20] VPWR VGND sg13cmos5l_antennanp
XFILLER_9_2270 VPWR VGND sg13cmos5l_decap_8
XFILLER_5_2123 VPWR VGND sg13cmos5l_decap_4
XFILLER_9_1580 VPWR VGND sg13cmos5l_decap_8
XFILLER_5_2167 VPWR VGND sg13cmos5l_decap_8
XFILLER_5_1466 VPWR VGND sg13cmos5l_decap_8
XANTENNA__1097__A2 Tile_X1Y0_NN4END[1] VPWR VGND sg13cmos5l_antennanp
XANTENNA__0308__D Tile_X0Y0_FrameData[21] VPWR VGND sg13cmos5l_antennanp
XFILLER_16_2743 VPWR VGND sg13cmos5l_fill_1
XFILLER_16_2732 VPWR VGND sg13cmos5l_fill_2
XFILLER_16_2754 VPWR VGND sg13cmos5l_decap_8
XFILLER_8_736 VPWR VGND sg13cmos5l_fill_1
XFILLER_7_257 VPWR VGND sg13cmos5l_fill_1
XFILLER_12_1917 VPWR VGND sg13cmos5l_decap_8
XFILLER_10_2342 VPWR VGND sg13cmos5l_decap_8
XFILLER_7_279 VPWR VGND sg13cmos5l_decap_8
XFILLER_10_1641 VPWR VGND sg13cmos5l_decap_8
XFILLER_3_452 VPWR VGND sg13cmos5l_decap_4
XFILLER_3_474 VPWR VGND sg13cmos5l_decap_8
XFILLER_5_2690 VPWR VGND sg13cmos5l_decap_8
XANTENNA__1088__A2 Tile_X3Y0_N2MID[7] VPWR VGND sg13cmos5l_antennanp
X_1021_ Tile_X0Y0_S2BEG[6] Tile_X0Y0_N2MID[1] VPWR VGND sg13cmos5l_buf_1
XFILLER_1_2598 VPWR VGND sg13cmos5l_decap_4
XANTENNA__0218__D Tile_X0Y0_FrameData[15] VPWR VGND sg13cmos5l_antennanp
XFILLER_15_570 VPWR VGND sg13cmos5l_decap_8
XFILLER_15_2231 VPWR VGND sg13cmos5l_decap_8
XANTENNA__1260__A2 Tile_X3Y0_NN4END[1] VPWR VGND sg13cmos5l_antennanp
X_0805_ Tile_X3Y0_SS4BEG[10] _1285_/X VPWR VGND sg13cmos5l_buf_1
X_0736_ Tile_X1Y0_SS4BEG[5] _1200_/X VPWR VGND sg13cmos5l_buf_1
XFILLER_8_2719 VPWR VGND sg13cmos5l_decap_8
X_0667_ _0667_/L_HI VPWR VGND sg13cmos5l_tiehi
X_0598_ _0598_/Q Tile_X0Y0_UserCLK NPU_RDATA26 _0614_/L_HI VPWR VGND sg13cmos5l_dfrbpq_1
XFILLER_2_2307 VPWR VGND sg13cmos5l_decap_8
XFILLER_6_2498 VPWR VGND sg13cmos5l_decap_8
XFILLER_6_1753 VPWR VGND sg13cmos5l_decap_8
X_1219_ _1219_/X Tile_X2Y0_N2MID[0] Tile_X2Y0_N4END[15] Tile_X2Y0_NN4END[0] _0586_/Q
+ _0393_/Q _0392_/Q VPWR VGND sg13cmos5l_mux4_1
XANTENNA__0128__D Tile_X0Y0_FrameData[25] VPWR VGND sg13cmos5l_antennanp
XANTENNA__0706__A Tile_X0Y0_FrameStrobe[19] VPWR VGND sg13cmos5l_antennanp
XFILLER_16_2017 VPWR VGND sg13cmos5l_decap_8
XFILLER_16_1349 VPWR VGND sg13cmos5l_decap_8
XANTENNA__1251__A2 Tile_X3Y0_N2END[7] VPWR VGND sg13cmos5l_antennanp
XFILLER_14_1095 VPWR VGND sg13cmos5l_decap_8
XFILLER_11_2695 VPWR VGND sg13cmos5l_decap_8
XANTENNA__0471__GATE Tile_X3Y0_FrameStrobe[1] VPWR VGND sg13cmos5l_antennanp
XFILLER_16_345 VPWR VGND sg13cmos5l_fill_1
XANTENNA__0903__X Tile_X2Y0_SS4BEG[4] VPWR VGND sg13cmos5l_antennanp
XFILLER_12_562 VPWR VGND sg13cmos5l_decap_8
XANTENNA__0486__GATE Tile_X3Y0_FrameStrobe[2] VPWR VGND sg13cmos5l_antennanp
XANTENNA__1242__A2 Tile_X2Y0_NN4END[8] VPWR VGND sg13cmos5l_antennanp
XFILLER_8_544 VPWR VGND sg13cmos5l_decap_8
XFILLER_12_2459 VPWR VGND sg13cmos5l_decap_8
XFILLER_12_1714 VPWR VGND sg13cmos5l_decap_8
XANTENNA_5 Tile_X0Y0_FrameData[14] VPWR VGND sg13cmos5l_antennanp
X_0521_ NPU_READ_BANK_SEL0 Tile_X0Y0_UserCLK _1128_/X _0631_/L_HI VPWR VGND sg13cmos5l_dfrbpq_1
XANTENNA__0501__D Tile_X0Y0_FrameData[4] VPWR VGND sg13cmos5l_antennanp
XFILLER_4_783 VPWR VGND sg13cmos5l_decap_8
X_0452_ _0452_/Q Tile_X0Y0_FrameData[21] VGND VPWR Tile_X3Y0_FrameStrobe[1] latch
XANTENNA__0424__GATE Tile_X3Y0_FrameStrobe[0] VPWR VGND sg13cmos5l_antennanp
X_0383_ _0383_/Q Tile_X0Y0_FrameData[26] VGND VPWR Tile_X2Y0_FrameStrobe[2] latch
XFILLER_7_2785 VPWR VGND sg13cmos5l_decap_4
XFILLER_6_1016 VPWR VGND sg13cmos5l_decap_4
XFILLER_3_2638 VPWR VGND sg13cmos5l_decap_8
XANTENNA__0439__GATE Tile_X3Y0_FrameStrobe[0] VPWR VGND sg13cmos5l_antennanp
X_1004_ Tile_X0Y0_S4BEG[13] _1152_/X VPWR VGND sg13cmos5l_buf_1
XFILLER_1_2395 VPWR VGND sg13cmos5l_fill_1
XFILLER_1_2384 VPWR VGND sg13cmos5l_fill_1
XFILLER_15_2050 VPWR VGND sg13cmos5l_decap_8
XANTENNA__0813__X Tile_X4Y0_FrameData_O[2] VPWR VGND sg13cmos5l_antennanp
XANTENNA__1233__A2 Tile_X2Y0_NN4END[14] VPWR VGND sg13cmos5l_antennanp
XFILLER_15_1382 VPWR VGND sg13cmos5l_fill_1
XFILLER_11_1224 VPWR VGND sg13cmos5l_decap_8
XANTENNA__0411__D Tile_X0Y0_FrameData[30] VPWR VGND sg13cmos5l_antennanp
X_0719_ Tile_X1Y0_S4BEG[4] _1183_/X VPWR VGND sg13cmos5l_buf_1
XFILLER_1_208 VPWR VGND sg13cmos5l_decap_8
XFILLER_6_2251 VPWR VGND sg13cmos5l_decap_8
XFILLER_6_1550 VPWR VGND sg13cmos5l_decap_8
XFILLER_2_2126 VPWR VGND sg13cmos5l_decap_8
XFILLER_2_2115 VPWR VGND sg13cmos5l_decap_4
XFILLER_2_1414 VPWR VGND sg13cmos5l_fill_2
XFILLER_2_1403 VPWR VGND sg13cmos5l_decap_8
XFILLER_2_1425 VPWR VGND sg13cmos5l_fill_1
XFILLER_16_1124 VPWR VGND sg13cmos5l_decap_8
XFILLER_15_98 VPWR VGND sg13cmos5l_decap_8
XANTENNA__0723__X Tile_X1Y0_S4BEG[8] VPWR VGND sg13cmos5l_antennanp
XANTENNA__1224__A2 Tile_X2Y0_NN4END[5] VPWR VGND sg13cmos5l_antennanp
XFILLER_13_2735 VPWR VGND sg13cmos5l_decap_8
XFILLER_5_525 VPWR VGND sg13cmos5l_decap_8
XANTENNA__0321__D Tile_X0Y0_FrameData[24] VPWR VGND sg13cmos5l_antennanp
XFILLER_7_2004 VPWR VGND sg13cmos5l_decap_8
XFILLER_7_2015 VPWR VGND sg13cmos5l_fill_1
XFILLER_1_742 VPWR VGND sg13cmos5l_fill_2
XFILLER_7_1325 VPWR VGND sg13cmos5l_fill_1
XFILLER_1_786 VPWR VGND sg13cmos5l_decap_8
XFILLER_7_1358 VPWR VGND sg13cmos5l_fill_2
XANTENNA__1160__A1 Tile_X0Y0_N4END[5] VPWR VGND sg13cmos5l_antennanp
XFILLER_2_1970 VPWR VGND sg13cmos5l_decap_4
XFILLER_2_1981 VPWR VGND sg13cmos5l_fill_1
XFILLER_16_142 VPWR VGND sg13cmos5l_decap_8
XANTENNA__1215__A2 Tile_X2Y0_N2END[3] VPWR VGND sg13cmos5l_antennanp
XFILLER_16_2381 VPWR VGND sg13cmos5l_decap_8
XFILLER_14_1809 VPWR VGND sg13cmos5l_decap_8
XFILLER_12_2256 VPWR VGND sg13cmos5l_decap_8
XFILLER_12_1511 VPWR VGND sg13cmos5l_decap_8
XANTENNA__0231__D Tile_X0Y0_FrameData[2] VPWR VGND sg13cmos5l_antennanp
XANTENNA__0363__GATE Tile_X2Y0_FrameStrobe[1] VPWR VGND sg13cmos5l_antennanp
X_0504_ _0504_/Q Tile_X0Y0_FrameData[1] VGND VPWR Tile_X3Y0_FrameStrobe[2] latch
XFILLER_4_580 VPWR VGND sg13cmos5l_fill_2
X_0435_ _0435_/Q Tile_X0Y0_FrameData[6] VGND VPWR Tile_X3Y0_FrameStrobe[0] latch
XANTENNA__1151__A1 Tile_X0Y0_N4END[3] VPWR VGND sg13cmos5l_antennanp
X_0366_ _0366_/Q Tile_X0Y0_FrameData[11] VGND VPWR Tile_X2Y0_FrameStrobe[1] latch
XFILLER_7_1870 VPWR VGND sg13cmos5l_fill_2
XFILLER_3_2468 VPWR VGND sg13cmos5l_decap_8
XFILLER_3_1701 VPWR VGND sg13cmos5l_decap_8
XANTENNA__0378__GATE Tile_X2Y0_FrameStrobe[2] VPWR VGND sg13cmos5l_antennanp
XANTENNA__0808__X Tile_X3Y0_SS4BEG[13] VPWR VGND sg13cmos5l_antennanp
X_0297_ _0297_/Q Tile_X0Y0_FrameData[0] VGND VPWR Tile_X1Y0_FrameStrobe[2] latch
XFILLER_1_2181 VPWR VGND sg13cmos5l_decap_8
XANTENNA__0301__GATE Tile_X1Y0_FrameStrobe[3] VPWR VGND sg13cmos5l_antennanp
XANTENNA__0406__D Tile_X0Y0_FrameData[3] VPWR VGND sg13cmos5l_antennanp
XANTENNA__1206__A2 Tile_X1Y0_NN4END[4] VPWR VGND sg13cmos5l_antennanp
XANTENNA__0316__GATE Tile_X2Y0_FrameStrobe[0] VPWR VGND sg13cmos5l_antennanp
XANTENNA__0550__CLK Tile_X0Y0_UserCLK VPWR VGND sg13cmos5l_antennanp
XANTENNA__0141__D Tile_X0Y0_FrameData[12] VPWR VGND sg13cmos5l_antennanp
XFILLER_11_1098 VPWR VGND sg13cmos5l_decap_8
XFILLER_8_2368 VPWR VGND sg13cmos5l_decap_8
XFILLER_8_1612 VPWR VGND sg13cmos5l_decap_8
XFILLER_6_2070 VPWR VGND sg13cmos5l_decap_8
XANTENNA__1142__A1 Tile_X0Y0_N4END[12] VPWR VGND sg13cmos5l_antennanp
XFILLER_6_2081 VPWR VGND sg13cmos5l_fill_2
XANTENNA__0718__X Tile_X1Y0_S4BEG[3] VPWR VGND sg13cmos5l_antennanp
XFILLER_14_602 VPWR VGND sg13cmos5l_decap_8
XFILLER_15_2808 VPWR VGND sg13cmos5l_fill_1
XFILLER_14_679 VPWR VGND sg13cmos5l_decap_8
XANTENNA__0316__D Tile_X0Y0_FrameData[29] VPWR VGND sg13cmos5l_antennanp
XFILLER_13_2532 VPWR VGND sg13cmos5l_decap_8
XFILLER_6_834 VPWR VGND sg13cmos5l_fill_2
XFILLER_5_322 VPWR VGND sg13cmos5l_decap_4
XFILLER_13_1842 VPWR VGND sg13cmos5l_decap_8
XFILLER_6_889 VPWR VGND sg13cmos5l_decap_8
XFILLER_1_561 VPWR VGND sg13cmos5l_decap_8
XFILLER_1_572 VPWR VGND sg13cmos5l_fill_2
XANTENNA__1133__A1 Tile_X0Y0_N2MID[2] VPWR VGND sg13cmos5l_antennanp
X_0220_ _0220_/Q Tile_X0Y0_FrameData[13] VGND VPWR Tile_X1Y0_FrameStrobe[0] latch
XFILLER_4_2755 VPWR VGND sg13cmos5l_decap_8
X_0151_ _0151_/Q Tile_X0Y0_FrameData[2] VGND VPWR Tile_X0Y0_FrameStrobe[1] latch
XFILLER_0_1929 VPWR VGND sg13cmos5l_fill_2
XFILLER_2_2490 VPWR VGND sg13cmos5l_fill_1
XANTENNA__0573__CLK Tile_X0Y0_UserCLK VPWR VGND sg13cmos5l_antennanp
XFILLER_14_2318 VPWR VGND sg13cmos5l_decap_8
XANTENNA__0226__D Tile_X0Y0_FrameData[7] VPWR VGND sg13cmos5l_antennanp
X_0984_ Tile_X0Y0_SS4BEG[9] _1164_/X VPWR VGND sg13cmos5l_buf_1
XFILLER_9_683 VPWR VGND sg13cmos5l_fill_2
XFILLER_12_2053 VPWR VGND sg13cmos5l_decap_8
XFILLER_12_1374 VPWR VGND sg13cmos5l_decap_8
XFILLER_9_2655 VPWR VGND sg13cmos5l_decap_8
XANTENNA__1124__A1 Tile_X0Y0_N4END[13] VPWR VGND sg13cmos5l_antennanp
X_0418_ _0418_/Q Tile_X0Y0_FrameData[23] VGND VPWR Tile_X3Y0_FrameStrobe[0] latch
X_0349_ _0349_/Q Tile_X0Y0_FrameData[28] VGND VPWR Tile_X2Y0_FrameStrobe[1] latch
XFILLER_3_2265 VPWR VGND sg13cmos5l_decap_8
XFILLER_3_1531 VPWR VGND sg13cmos5l_fill_1
XANTENNA__0240__GATE Tile_X1Y0_FrameStrobe[1] VPWR VGND sg13cmos5l_antennanp
XFILLER_3_1597 VPWR VGND sg13cmos5l_decap_8
XFILLER_11_605 VPWR VGND sg13cmos5l_decap_8
XANTENNA__0136__D Tile_X0Y0_FrameData[17] VPWR VGND sg13cmos5l_antennanp
XANTENNA__0255__GATE Tile_X1Y0_FrameStrobe[1] VPWR VGND sg13cmos5l_antennanp
XFILLER_13_1105 VPWR VGND sg13cmos5l_decap_8
XFILLER_12_22 VPWR VGND sg13cmos5l_fill_1
XFILLER_10_2716 VPWR VGND sg13cmos5l_decap_8
XFILLER_3_815 VPWR VGND sg13cmos5l_decap_8
XFILLER_2_347 VPWR VGND sg13cmos5l_fill_1
XFILLER_8_2165 VPWR VGND sg13cmos5l_decap_8
XANTENNA__1115__A1 Tile_X0Y0_N4END[3] VPWR VGND sg13cmos5l_antennanp
XFILLER_8_1486 VPWR VGND sg13cmos5l_fill_1
XFILLER_8_1475 VPWR VGND sg13cmos5l_decap_8
XANTENNA__0208__GATE Tile_X1Y0_FrameStrobe[0] VPWR VGND sg13cmos5l_antennanp
XANTENNA__0596__CLK Tile_X0Y0_UserCLK VPWR VGND sg13cmos5l_antennanp
XFILLER_2_1085 VPWR VGND sg13cmos5l_decap_8
XFILLER_15_2616 VPWR VGND sg13cmos5l_decap_8
XFILLER_15_1915 VPWR VGND sg13cmos5l_decap_8
XANTENNA__0911__X Tile_X2Y0_SS4BEG[12] VPWR VGND sg13cmos5l_antennanp
XFILLER_13_1650 VPWR VGND sg13cmos5l_decap_8
XFILLER_10_682 VPWR VGND sg13cmos5l_fill_2
XFILLER_9_1217 VPWR VGND sg13cmos5l_decap_8
XANTENNA__1106__A1 Tile_X1Y0_N4END[11] VPWR VGND sg13cmos5l_antennanp
X_1252_ _1252_/X Tile_X3Y0_N1END[1] Tile_X3Y0_N2MID[1] Tile_X3Y0_N2END[6] _0573_/Q
+ _0503_/Q _0502_/Q VPWR VGND sg13cmos5l_mux4_1
X_0203_ _0203_/Q Tile_X0Y0_FrameData[30] VGND VPWR Tile_X1Y0_FrameStrobe[0] latch
XFILLER_4_2563 VPWR VGND sg13cmos5l_decap_8
XFILLER_0_2449 VPWR VGND sg13cmos5l_decap_8
X_1183_ _1183_/X Tile_X1Y0_N2MID[4] Tile_X1Y0_N4END[11] Tile_X1Y0_NN4END[4] _0592_/Q
+ _0289_/Q _0288_/Q VPWR VGND sg13cmos5l_mux4_1
X_0134_ _0134_/Q Tile_X0Y0_FrameData[19] VGND VPWR Tile_X0Y0_FrameStrobe[1] latch
XANTENNA__1290__A0 Tile_X3Y0_N2END[7] VPWR VGND sg13cmos5l_antennanp
X_0967_ Tile_X1Y0_FrameStrobe_O[12] Tile_X1Y0_FrameStrobe[12] VPWR VGND sg13cmos5l_buf_1
XFILLER_14_1458 VPWR VGND sg13cmos5l_decap_8
XANTENNA__0821__X Tile_X4Y0_FrameData_O[10] VPWR VGND sg13cmos5l_antennanp
X_0898_ Tile_X2Y0_S4BEG[15] _1234_/X VPWR VGND sg13cmos5l_buf_1
XFILLER_12_1182 VPWR VGND sg13cmos5l_decap_8
XFILLER_9_2452 VPWR VGND sg13cmos5l_decap_8
XFILLER_5_2327 VPWR VGND sg13cmos5l_decap_8
XFILLER_5_1648 VPWR VGND sg13cmos5l_decap_8
XFILLER_3_2040 VPWR VGND sg13cmos5l_fill_1
XFILLER_3_1394 VPWR VGND sg13cmos5l_decap_4
XANTENNA__0194__GATE Tile_X0Y0_FrameStrobe[3] VPWR VGND sg13cmos5l_antennanp
XANTENNA__1281__A0 Tile_X3Y0_N2END[6] VPWR VGND sg13cmos5l_antennanp
XFILLER_14_2682 VPWR VGND sg13cmos5l_decap_8
XANTENNA__0731__X Tile_X1Y0_SS4BEG[0] VPWR VGND sg13cmos5l_antennanp
XFILLER_10_2524 VPWR VGND sg13cmos5l_decap_8
XFILLER_10_2535 VPWR VGND sg13cmos5l_fill_2
XFILLER_10_1834 VPWR VGND sg13cmos5l_decap_8
XFILLER_10_1878 VPWR VGND sg13cmos5l_decap_8
XANTENNA__0132__GATE Tile_X0Y0_FrameStrobe[1] VPWR VGND sg13cmos5l_antennanp
XFILLER_3_656 VPWR VGND sg13cmos5l_decap_8
XFILLER_2_199 VPWR VGND sg13cmos5l_fill_1
XFILLER_8_1250 VPWR VGND sg13cmos5l_decap_8
XFILLER_1_2714 VPWR VGND sg13cmos5l_decap_8
XFILLER_1_2703 VPWR VGND sg13cmos5l_fill_2
XANTENNA__0147__GATE Tile_X0Y0_FrameStrobe[1] VPWR VGND sg13cmos5l_antennanp
XFILLER_1_2758 VPWR VGND sg13cmos5l_decap_8
XANTENNA__0906__X Tile_X2Y0_SS4BEG[7] VPWR VGND sg13cmos5l_antennanp
XANTENNA__1272__A0 Tile_X3Y0_N2MID[5] VPWR VGND sg13cmos5l_antennanp
XFILLER_15_2435 VPWR VGND sg13cmos5l_decap_8
XFILLER_14_262 VPWR VGND sg13cmos5l_fill_1
XFILLER_9_67 VPWR VGND sg13cmos5l_fill_1
XFILLER_9_78 VPWR VGND sg13cmos5l_fill_2
X_0821_ Tile_X4Y0_FrameData_O[10] Tile_X0Y0_FrameData[10] VPWR VGND sg13cmos5l_buf_1
XFILLER_15_1745 VPWR VGND sg13cmos5l_decap_8
XANTENNA__0504__D Tile_X0Y0_FrameData[1] VPWR VGND sg13cmos5l_antennanp
X_0752_ Tile_X1Y0_S2BEG[1] Tile_X1Y0_N2MID[6] VPWR VGND sg13cmos5l_buf_1
XFILLER_7_962 VPWR VGND sg13cmos5l_fill_1
XFILLER_13_1480 VPWR VGND sg13cmos5l_decap_8
X_0683_ _0683_/L_HI VPWR VGND sg13cmos5l_tiehi
XFILLER_6_494 VPWR VGND sg13cmos5l_decap_8
XFILLER_6_483 VPWR VGND sg13cmos5l_fill_2
XFILLER_6_2647 VPWR VGND sg13cmos5l_decap_8
XFILLER_6_1924 VPWR VGND sg13cmos5l_decap_8
XFILLER_0_2224 VPWR VGND sg13cmos5l_fill_1
X_1235_ _1235_/X Tile_X2Y0_N2END[0] Tile_X2Y0_N4END[0] Tile_X2Y0_NN4END[15] _0587_/Q
+ _0361_/Q _0360_/Q VPWR VGND sg13cmos5l_mux4_1
X_1166_ _1166_/X Tile_X0Y0_N2END[3] Tile_X0Y0_N4END[11] Tile_X0Y0_NN4END[4] _0598_/Q
+ _0131_/Q _0130_/Q VPWR VGND sg13cmos5l_mux4_1
XFILLER_4_1670 VPWR VGND sg13cmos5l_decap_8
XANTENNA__0816__X Tile_X4Y0_FrameData_O[5] VPWR VGND sg13cmos5l_antennanp
X_0117_ _0117_/Q Tile_X0Y0_FrameData[4] VGND VPWR Tile_X0Y0_FrameStrobe[0] latch
X_1097_ _1097_/X Tile_X1Y0_N4END[1] Tile_X1Y0_N4END[2] Tile_X1Y0_NN4END[1] Tile_X1Y0_NN4END[3]
+ _0231_/Q _0230_/Q VPWR VGND sg13cmos5l_mux4_1
XANTENNA__1263__A0 Tile_X3Y0_N2MID[4] VPWR VGND sg13cmos5l_antennanp
XFILLER_14_1200 VPWR VGND sg13cmos5l_decap_8
XANTENNA__0414__D Tile_X0Y0_FrameData[27] VPWR VGND sg13cmos5l_antennanp
XFILLER_14_1277 VPWR VGND sg13cmos5l_decap_8
XFILLER_5_2146 VPWR VGND sg13cmos5l_decap_8
XFILLER_5_1423 VPWR VGND sg13cmos5l_decap_4
XANTENNA__1097__A3 Tile_X1Y0_NN4END[3] VPWR VGND sg13cmos5l_antennanp
XANTENNA__0726__X Tile_X1Y0_S4BEG[11] VPWR VGND sg13cmos5l_antennanp
XFILLER_0_2791 VPWR VGND sg13cmos5l_fill_2
XANTENNA__1254__A0 Tile_X3Y0_N1END[3] VPWR VGND sg13cmos5l_antennanp
XFILLER_16_2711 VPWR VGND sg13cmos5l_decap_8
XFILLER_12_744 VPWR VGND sg13cmos5l_decap_8
XFILLER_16_2799 VPWR VGND sg13cmos5l_decap_8
XFILLER_12_2619 VPWR VGND sg13cmos5l_decap_8
XANTENNA__0324__D Tile_X0Y0_FrameData[21] VPWR VGND sg13cmos5l_antennanp
XFILLER_10_2321 VPWR VGND sg13cmos5l_decap_8
XFILLER_11_298 VPWR VGND sg13cmos5l_decap_8
XFILLER_10_1620 VPWR VGND sg13cmos5l_decap_8
XFILLER_10_2398 VPWR VGND sg13cmos5l_decap_8
XFILLER_4_954 VPWR VGND sg13cmos5l_decap_4
XFILLER_10_1697 VPWR VGND sg13cmos5l_decap_8
XFILLER_8_1080 VPWR VGND sg13cmos5l_decap_8
XANTENNA__1088__A3 Tile_X3Y0_N2END[7] VPWR VGND sg13cmos5l_antennanp
X_1020_ Tile_X0Y0_S2BEG[5] Tile_X0Y0_N2MID[2] VPWR VGND sg13cmos5l_buf_1
XFILLER_1_2555 VPWR VGND sg13cmos5l_fill_1
XFILLER_1_2577 VPWR VGND sg13cmos5l_fill_2
XANTENNA__1245__A0 Tile_X2Y0_N2END[2] VPWR VGND sg13cmos5l_antennanp
XFILLER_11_2107 VPWR VGND sg13cmos5l_fill_1
XANTENNA__0234__D Tile_X0Y0_FrameData[31] VPWR VGND sg13cmos5l_antennanp
X_0804_ Tile_X3Y0_SS4BEG[9] _1284_/X VPWR VGND sg13cmos5l_buf_1
XFILLER_15_2287 VPWR VGND sg13cmos5l_decap_8
XFILLER_15_1564 VPWR VGND sg13cmos5l_decap_4
XANTENNA__0812__A Tile_X0Y0_FrameData[1] VPWR VGND sg13cmos5l_antennanp
XFILLER_7_770 VPWR VGND sg13cmos5l_decap_4
XFILLER_15_1586 VPWR VGND sg13cmos5l_decap_8
XFILLER_11_1439 VPWR VGND sg13cmos5l_decap_8
X_0735_ Tile_X1Y0_SS4BEG[4] _1199_/X VPWR VGND sg13cmos5l_buf_1
XFILLER_7_781 VPWR VGND sg13cmos5l_decap_8
X_0666_ _0666_/L_HI VPWR VGND sg13cmos5l_tiehi
X_0597_ _0597_/Q Tile_X0Y0_UserCLK NPU_RDATA25 _0613_/L_HI VPWR VGND sg13cmos5l_dfrbpq_1
XFILLER_6_2455 VPWR VGND sg13cmos5l_decap_8
X_1218_ _1218_/X Tile_X2Y0_N1END[3] Tile_X2Y0_N2MID[7] Tile_X2Y0_N2END[0] _0587_/Q
+ _0395_/Q _0394_/Q VPWR VGND sg13cmos5l_mux4_1
XFILLER_2_1629 VPWR VGND sg13cmos5l_decap_8
XANTENNA__0409__D Tile_X0Y0_FrameData[0] VPWR VGND sg13cmos5l_antennanp
XFILLER_0_1353 VPWR VGND sg13cmos5l_fill_2
XFILLER_0_2098 VPWR VGND sg13cmos5l_fill_1
X_1149_ _1149_/X Tile_X0Y0_N2MID[2] Tile_X0Y0_N4END[5] Tile_X0Y0_NN4END[10] _0598_/Q
+ _0165_/Q _0164_/Q VPWR VGND sg13cmos5l_mux4_1
XANTENNA__1236__A0 Tile_X2Y0_N2END[1] VPWR VGND sg13cmos5l_antennanp
XFILLER_16_1328 VPWR VGND sg13cmos5l_decap_8
XANTENNA__0144__D Tile_X0Y0_FrameData[9] VPWR VGND sg13cmos5l_antennanp
XFILLER_5_729 VPWR VGND sg13cmos5l_fill_2
XFILLER_11_2674 VPWR VGND sg13cmos5l_decap_8
XFILLER_1_902 VPWR VGND sg13cmos5l_decap_8
XFILLER_5_1275 VPWR VGND sg13cmos5l_decap_8
XANTENNA__0319__D Tile_X0Y0_FrameData[26] VPWR VGND sg13cmos5l_antennanp
XFILLER_16_357 VPWR VGND sg13cmos5l_fill_1
XFILLER_16_335 VPWR VGND sg13cmos5l_decap_4
XANTENNA__1227__A0 Tile_X2Y0_N2MID[0] VPWR VGND sg13cmos5l_antennanp
XFILLER_12_530 VPWR VGND sg13cmos5l_fill_1
XFILLER_16_2574 VPWR VGND sg13cmos5l_fill_2
XFILLER_16_2563 VPWR VGND sg13cmos5l_decap_8
XFILLER_12_541 VPWR VGND sg13cmos5l_decap_8
XFILLER_8_523 VPWR VGND sg13cmos5l_decap_8
XFILLER_16_2596 VPWR VGND sg13cmos5l_fill_1
XFILLER_12_2438 VPWR VGND sg13cmos5l_decap_8
XFILLER_16_1884 VPWR VGND sg13cmos5l_decap_8
XANTENNA_6 Tile_X0Y0_FrameData[14] VPWR VGND sg13cmos5l_antennanp
XFILLER_10_2162 VPWR VGND sg13cmos5l_fill_1
XFILLER_6_57 VPWR VGND sg13cmos5l_fill_1
XFILLER_10_1461 VPWR VGND sg13cmos5l_decap_8
XFILLER_10_2195 VPWR VGND sg13cmos5l_decap_8
X_0520_ _0520_/Q Tile_X0Y0_FrameData[25] VGND VPWR Tile_X4Y0_FrameStrobe[0] latch
X_0451_ _0451_/Q Tile_X0Y0_FrameData[22] VGND VPWR Tile_X3Y0_FrameStrobe[1] latch
XFILLER_3_283 VPWR VGND sg13cmos5l_fill_2
X_0382_ _0382_/Q Tile_X0Y0_FrameData[27] VGND VPWR Tile_X2Y0_FrameStrobe[2] latch
XFILLER_7_2764 VPWR VGND sg13cmos5l_decap_8
XFILLER_6_1006 VPWR VGND sg13cmos5l_decap_8
XFILLER_3_2617 VPWR VGND sg13cmos5l_decap_8
XFILLER_3_2606 VPWR VGND sg13cmos5l_decap_8
XANTENNA__0229__D Tile_X0Y0_FrameData[4] VPWR VGND sg13cmos5l_antennanp
X_1003_ Tile_X0Y0_S4BEG[12] _1151_/X VPWR VGND sg13cmos5l_buf_1
XFILLER_1_2363 VPWR VGND sg13cmos5l_decap_4
XFILLER_1_1695 VPWR VGND sg13cmos5l_decap_4
XANTENNA__1218__A0 Tile_X2Y0_N1END[3] VPWR VGND sg13cmos5l_antennanp
XFILLER_15_2073 VPWR VGND sg13cmos5l_fill_1
XFILLER_11_1203 VPWR VGND sg13cmos5l_decap_8
X_0718_ Tile_X1Y0_S4BEG[3] _1182_/X VPWR VGND sg13cmos5l_buf_1
X_0649_ _0649_/L_HI VPWR VGND sg13cmos5l_tiehi
XFILLER_8_1827 VPWR VGND sg13cmos5l_decap_4
XFILLER_6_2230 VPWR VGND sg13cmos5l_decap_8
XANTENNA__0139__D Tile_X0Y0_FrameData[14] VPWR VGND sg13cmos5l_antennanp
XANTENNA__1209__A0 Tile_X1Y0_N2END[6] VPWR VGND sg13cmos5l_antennanp
XFILLER_15_55 VPWR VGND sg13cmos5l_fill_2
XFILLER_16_1103 VPWR VGND sg13cmos5l_decap_8
XFILLER_5_504 VPWR VGND sg13cmos5l_decap_8
XANTENNA__0602__D NPU_RDATA30 VPWR VGND sg13cmos5l_antennanp
XFILLER_11_2482 VPWR VGND sg13cmos5l_decap_8
XFILLER_0_286 VPWR VGND sg13cmos5l_fill_2
XANTENNA__1160__A2 Tile_X0Y0_NN4END[10] VPWR VGND sg13cmos5l_antennanp
XFILLER_5_1083 VPWR VGND sg13cmos5l_decap_8
XFILLER_16_121 VPWR VGND sg13cmos5l_decap_8
XANTENNA__0914__X Tile_X2Y0_SS4BEG[15] VPWR VGND sg13cmos5l_antennanp
XFILLER_16_198 VPWR VGND sg13cmos5l_decap_8
XFILLER_16_2360 VPWR VGND sg13cmos5l_decap_8
XFILLER_12_382 VPWR VGND sg13cmos5l_fill_1
XFILLER_12_2235 VPWR VGND sg13cmos5l_decap_8
XFILLER_16_1692 VPWR VGND sg13cmos5l_decap_8
XANTENNA__0512__D Tile_X0Y0_FrameData[31] VPWR VGND sg13cmos5l_antennanp
XFILLER_12_1567 VPWR VGND sg13cmos5l_decap_8
X_0503_ _0503_/Q Tile_X0Y0_FrameData[2] VGND VPWR Tile_X3Y0_FrameStrobe[2] latch
X_0434_ _0434_/Q Tile_X0Y0_FrameData[7] VGND VPWR Tile_X3Y0_FrameStrobe[0] latch
XFILLER_3_2414 VPWR VGND sg13cmos5l_decap_8
XANTENNA__1151__A2 Tile_X0Y0_NN4END[12] VPWR VGND sg13cmos5l_antennanp
X_0365_ _0365_/Q Tile_X0Y0_FrameData[12] VGND VPWR Tile_X2Y0_FrameStrobe[1] latch
XFILLER_3_2447 VPWR VGND sg13cmos5l_decap_8
XFILLER_3_2436 VPWR VGND sg13cmos5l_fill_1
X_0296_ _0296_/Q Tile_X0Y0_FrameData[1] VGND VPWR Tile_X1Y0_FrameStrobe[2] latch
XFILLER_3_1757 VPWR VGND sg13cmos5l_decap_8
XANTENNA__0824__X Tile_X4Y0_FrameData_O[13] VPWR VGND sg13cmos5l_antennanp
XFILLER_11_809 VPWR VGND sg13cmos5l_decap_8
XANTENNA__0422__D Tile_X0Y0_FrameData[19] VPWR VGND sg13cmos5l_antennanp
XFILLER_11_1077 VPWR VGND sg13cmos5l_decap_8
XANTENNA__0470__GATE Tile_X3Y0_FrameStrobe[1] VPWR VGND sg13cmos5l_antennanp
XFILLER_8_2347 VPWR VGND sg13cmos5l_decap_8
XFILLER_8_1668 VPWR VGND sg13cmos5l_decap_8
XANTENNA__0485__GATE Tile_X3Y0_FrameStrobe[2] VPWR VGND sg13cmos5l_antennanp
XANTENNA__1142__A2 Tile_X0Y0_NN4END[3] VPWR VGND sg13cmos5l_antennanp
XFILLER_6_1370 VPWR VGND sg13cmos5l_decap_8
XANTENNA__0734__X Tile_X1Y0_SS4BEG[3] VPWR VGND sg13cmos5l_antennanp
XFILLER_14_658 VPWR VGND sg13cmos5l_decap_8
XFILLER_13_2511 VPWR VGND sg13cmos5l_decap_8
XANTENNA__0423__GATE Tile_X3Y0_FrameStrobe[0] VPWR VGND sg13cmos5l_antennanp
XFILLER_13_1821 VPWR VGND sg13cmos5l_decap_8
XFILLER_10_842 VPWR VGND sg13cmos5l_decap_8
XFILLER_6_813 VPWR VGND sg13cmos5l_decap_8
XANTENNA__0332__D Tile_X0Y0_FrameData[13] VPWR VGND sg13cmos5l_antennanp
XFILLER_6_857 VPWR VGND sg13cmos5l_decap_8
XFILLER_13_1898 VPWR VGND sg13cmos5l_decap_8
XANTENNA__0438__GATE Tile_X3Y0_FrameStrobe[0] VPWR VGND sg13cmos5l_antennanp
XFILLER_1_540 VPWR VGND sg13cmos5l_decap_8
XANTENNA__0909__X Tile_X2Y0_SS4BEG[10] VPWR VGND sg13cmos5l_antennanp
XANTENNA__1133__A2 Tile_X0Y0_N2END[5] VPWR VGND sg13cmos5l_antennanp
XFILLER_7_1145 VPWR VGND sg13cmos5l_decap_8
XFILLER_4_2734 VPWR VGND sg13cmos5l_decap_8
XFILLER_0_2609 VPWR VGND sg13cmos5l_fill_1
X_0150_ _0150_/Q Tile_X0Y0_FrameData[3] VGND VPWR Tile_X0Y0_FrameStrobe[1] latch
XANTENNA__0507__D Tile_X0Y0_FrameData[30] VPWR VGND sg13cmos5l_antennanp
X_0983_ Tile_X0Y0_SS4BEG[8] _1163_/X VPWR VGND sg13cmos5l_buf_1
XFILLER_9_662 VPWR VGND sg13cmos5l_decap_8
XANTENNA__0242__D Tile_X0Y0_FrameData[23] VPWR VGND sg13cmos5l_antennanp
XFILLER_12_1353 VPWR VGND sg13cmos5l_decap_8
XANTENNA__0820__A Tile_X0Y0_FrameData[9] VPWR VGND sg13cmos5l_antennanp
XFILLER_12_1397 VPWR VGND sg13cmos5l_fill_1
XFILLER_9_2634 VPWR VGND sg13cmos5l_decap_8
XFILLER_9_1944 VPWR VGND sg13cmos5l_fill_1
XANTENNA__0819__X Tile_X4Y0_FrameData_O[8] VPWR VGND sg13cmos5l_antennanp
XANTENNA__1124__A2 Tile_X0Y0_NN4END[12] VPWR VGND sg13cmos5l_antennanp
X_0417_ _0417_/Q Tile_X0Y0_FrameData[24] VGND VPWR Tile_X3Y0_FrameStrobe[0] latch
X_0348_ _0348_/Q Tile_X0Y0_FrameData[29] VGND VPWR Tile_X2Y0_FrameStrobe[1] latch
XFILLER_3_2244 VPWR VGND sg13cmos5l_decap_8
XFILLER_3_1510 VPWR VGND sg13cmos5l_fill_1
X_0279_ _0279_/Q Tile_X0Y0_FrameData[18] VGND VPWR Tile_X1Y0_FrameStrobe[2] latch
XFILLER_3_1587 VPWR VGND sg13cmos5l_decap_8
XANTENNA__0417__D Tile_X0Y0_FrameData[24] VPWR VGND sg13cmos5l_antennanp
XFILLER_12_45 VPWR VGND sg13cmos5l_fill_2
XANTENNA__0152__D Tile_X0Y0_FrameData[1] VPWR VGND sg13cmos5l_antennanp
XFILLER_8_2144 VPWR VGND sg13cmos5l_decap_8
XFILLER_8_2122 VPWR VGND sg13cmos5l_decap_8
XFILLER_8_2155 VPWR VGND sg13cmos5l_fill_1
XANTENNA__0729__X Tile_X1Y0_S4BEG[14] VPWR VGND sg13cmos5l_antennanp
XANTENNA__1115__A2 Tile_X0Y0_NN4END[1] VPWR VGND sg13cmos5l_antennanp
XFILLER_8_1498 VPWR VGND sg13cmos5l_fill_2
XFILLER_2_1064 VPWR VGND sg13cmos5l_decap_8
XANTENNA__0327__D Tile_X0Y0_FrameData[18] VPWR VGND sg13cmos5l_antennanp
XANTENNA__0362__GATE Tile_X2Y0_FrameStrobe[1] VPWR VGND sg13cmos5l_antennanp
XFILLER_6_621 VPWR VGND sg13cmos5l_decap_8
XFILLER_10_661 VPWR VGND sg13cmos5l_decap_8
XANTENNA__0377__GATE Tile_X2Y0_FrameStrobe[1] VPWR VGND sg13cmos5l_antennanp
XFILLER_13_2385 VPWR VGND sg13cmos5l_decap_8
XFILLER_6_687 VPWR VGND sg13cmos5l_decap_8
XANTENNA__0300__GATE Tile_X1Y0_FrameStrobe[3] VPWR VGND sg13cmos5l_antennanp
XFILLER_2_871 VPWR VGND sg13cmos5l_fill_2
X_1251_ _1251_/X Tile_X3Y0_N1END[0] Tile_X3Y0_N2MID[0] Tile_X3Y0_N2END[7] _0572_/Q
+ _0505_/Q _0504_/Q VPWR VGND sg13cmos5l_mux4_1
XFILLER_1_392 VPWR VGND sg13cmos5l_fill_1
XANTENNA__1106__A2 Tile_X1Y0_NN4END[8] VPWR VGND sg13cmos5l_antennanp
X_0202_ _0202_/Q Tile_X0Y0_FrameData[31] VGND VPWR Tile_X0Y0_FrameStrobe[0] latch
X_1182_ _1182_/X Tile_X1Y0_N2MID[3] Tile_X1Y0_N4END[12] Tile_X1Y0_NN4END[3] _0595_/Q
+ _0291_/Q _0290_/Q VPWR VGND sg13cmos5l_mux4_1
XFILLER_4_2542 VPWR VGND sg13cmos5l_decap_8
XANTENNA__0315__GATE Tile_X2Y0_FrameStrobe[0] VPWR VGND sg13cmos5l_antennanp
XANTENNA__0540__CLK Tile_X0Y0_UserCLK VPWR VGND sg13cmos5l_antennanp
XFILLER_0_2428 VPWR VGND sg13cmos5l_decap_8
X_0133_ _0133_/Q Tile_X0Y0_FrameData[20] VGND VPWR Tile_X0Y0_FrameStrobe[1] latch
XFILLER_4_1874 VPWR VGND sg13cmos5l_decap_8
XANTENNA__0237__D Tile_X0Y0_FrameData[28] VPWR VGND sg13cmos5l_antennanp
XANTENNA__0815__A Tile_X0Y0_FrameData[4] VPWR VGND sg13cmos5l_antennanp
XANTENNA__1290__A1 Tile_X3Y0_N4END[15] VPWR VGND sg13cmos5l_antennanp
X_0966_ Tile_X1Y0_FrameStrobe_O[11] Tile_X1Y0_FrameStrobe[11] VPWR VGND sg13cmos5l_buf_1
X_0897_ Tile_X2Y0_S4BEG[14] _1233_/X VPWR VGND sg13cmos5l_buf_1
XFILLER_12_1161 VPWR VGND sg13cmos5l_decap_8
XFILLER_9_2431 VPWR VGND sg13cmos5l_decap_8
XFILLER_5_2306 VPWR VGND sg13cmos5l_decap_8
XFILLER_5_1627 VPWR VGND sg13cmos5l_decap_8
XFILLER_3_1351 VPWR VGND sg13cmos5l_fill_1
XANTENNA__0147__D Tile_X0Y0_FrameData[6] VPWR VGND sg13cmos5l_antennanp
XANTENNA__1281__A1 Tile_X3Y0_N4END[6] VPWR VGND sg13cmos5l_antennanp
XFILLER_12_915 VPWR VGND sg13cmos5l_fill_2
XFILLER_11_414 VPWR VGND sg13cmos5l_decap_8
XFILLER_12_948 VPWR VGND sg13cmos5l_fill_2
XFILLER_11_425 VPWR VGND sg13cmos5l_fill_1
XFILLER_10_2503 VPWR VGND sg13cmos5l_decap_8
XFILLER_14_2661 VPWR VGND sg13cmos5l_decap_8
XFILLER_10_1813 VPWR VGND sg13cmos5l_decap_8
XFILLER_3_635 VPWR VGND sg13cmos5l_decap_8
XFILLER_2_145 VPWR VGND sg13cmos5l_decap_8
XFILLER_2_167 VPWR VGND sg13cmos5l_decap_8
XANTENNA__0563__CLK Tile_X0Y0_UserCLK VPWR VGND sg13cmos5l_antennanp
XFILLER_4_1148 VPWR VGND sg13cmos5l_fill_2
XFILLER_1_2737 VPWR VGND sg13cmos5l_decap_8
XANTENNA__1272__A1 Tile_X3Y0_N4END[2] VPWR VGND sg13cmos5l_antennanp
XFILLER_15_786 VPWR VGND sg13cmos5l_decap_8
XFILLER_15_2414 VPWR VGND sg13cmos5l_decap_8
XFILLER_15_1724 VPWR VGND sg13cmos5l_decap_8
XANTENNA__0922__X Tile_X3Y0_FrameStrobe_O[7] VPWR VGND sg13cmos5l_antennanp
X_0820_ Tile_X4Y0_FrameData_O[9] Tile_X0Y0_FrameData[9] VPWR VGND sg13cmos5l_buf_1
X_0751_ Tile_X1Y0_S2BEG[0] Tile_X1Y0_N2MID[7] VPWR VGND sg13cmos5l_buf_1
XFILLER_13_2182 VPWR VGND sg13cmos5l_decap_8
XFILLER_11_992 VPWR VGND sg13cmos5l_fill_2
X_0682_ _0682_/L_HI VPWR VGND sg13cmos5l_tiehi
XANTENNA__0520__D Tile_X0Y0_FrameData[25] VPWR VGND sg13cmos5l_antennanp
XFILLER_6_2626 VPWR VGND sg13cmos5l_decap_8
XFILLER_6_1903 VPWR VGND sg13cmos5l_fill_1
XANTENNA__0254__GATE Tile_X1Y0_FrameStrobe[1] VPWR VGND sg13cmos5l_antennanp
X_1234_ _1234_/X Tile_X2Y0_N2MID[7] Tile_X2Y0_N4END[0] Tile_X2Y0_NN4END[15] _0581_/Q
+ _0363_/Q _0362_/Q VPWR VGND sg13cmos5l_mux4_1
XFILLER_4_2383 VPWR VGND sg13cmos5l_fill_1
XFILLER_4_2372 VPWR VGND sg13cmos5l_fill_1
XFILLER_0_2236 VPWR VGND sg13cmos5l_fill_1
XFILLER_0_2247 VPWR VGND sg13cmos5l_decap_8
X_1165_ _1165_/X Tile_X0Y0_N2END[2] Tile_X0Y0_N4END[10] Tile_X0Y0_NN4END[5] _0599_/Q
+ _0133_/Q _0132_/Q VPWR VGND sg13cmos5l_mux4_1
X_0116_ _0116_/Q Tile_X0Y0_FrameData[5] VGND VPWR Tile_X0Y0_FrameStrobe[0] latch
X_1096_ _1096_/X Tile_X1Y0_N4END[0] Tile_X1Y0_N4END[1] Tile_X1Y0_NN4END[0] Tile_X1Y0_NN4END[2]
+ _0233_/Q _0232_/Q VPWR VGND sg13cmos5l_mux4_1
XANTENNA__0269__GATE Tile_X1Y0_FrameStrobe[2] VPWR VGND sg13cmos5l_antennanp
XANTENNA__1263__A1 Tile_X3Y0_N4END[11] VPWR VGND sg13cmos5l_antennanp
XANTENNA__0832__X Tile_X4Y0_FrameData_O[21] VPWR VGND sg13cmos5l_antennanp
XFILLER_14_1256 VPWR VGND sg13cmos5l_decap_8
X_0949_ Tile_X2Y0_FrameStrobe_O[14] Tile_X2Y0_FrameStrobe[14] VPWR VGND sg13cmos5l_buf_1
XANTENNA__0207__GATE Tile_X1Y0_FrameStrobe[0] VPWR VGND sg13cmos5l_antennanp
XANTENNA__0430__D Tile_X0Y0_FrameData[11] VPWR VGND sg13cmos5l_antennanp
XANTENNA__0586__CLK Tile_X0Y0_UserCLK VPWR VGND sg13cmos5l_antennanp
XFILLER_16_506 VPWR VGND sg13cmos5l_decap_8
XFILLER_3_1181 VPWR VGND sg13cmos5l_decap_8
XFILLER_16_539 VPWR VGND sg13cmos5l_fill_2
XFILLER_16_2734 VPWR VGND sg13cmos5l_fill_1
XANTENNA__1254__A1 Tile_X3Y0_N2MID[3] VPWR VGND sg13cmos5l_antennanp
XFILLER_12_723 VPWR VGND sg13cmos5l_decap_8
XFILLER_11_211 VPWR VGND sg13cmos5l_decap_4
XANTENNA__0742__X Tile_X1Y0_SS4BEG[11] VPWR VGND sg13cmos5l_antennanp
XFILLER_8_727 VPWR VGND sg13cmos5l_decap_8
XFILLER_16_2789 VPWR VGND sg13cmos5l_decap_4
XFILLER_11_266 VPWR VGND sg13cmos5l_fill_2
XFILLER_10_2300 VPWR VGND sg13cmos5l_decap_8
XFILLER_7_248 VPWR VGND sg13cmos5l_decap_8
XFILLER_10_2377 VPWR VGND sg13cmos5l_decap_8
XFILLER_10_1676 VPWR VGND sg13cmos5l_decap_8
XFILLER_3_443 VPWR VGND sg13cmos5l_fill_2
XANTENNA__0340__D Tile_X0Y0_FrameData[5] VPWR VGND sg13cmos5l_antennanp
XFILLER_4_988 VPWR VGND sg13cmos5l_fill_2
XANTENNA__1190__A0 Tile_X1Y0_N2MID[3] VPWR VGND sg13cmos5l_antennanp
XANTENNA__0917__X Tile_X3Y0_FrameStrobe_O[2] VPWR VGND sg13cmos5l_antennanp
XFILLER_1_1833 VPWR VGND sg13cmos5l_fill_2
XFILLER_1_1888 VPWR VGND sg13cmos5l_decap_8
XANTENNA__1245__A1 Tile_X2Y0_N4END[10] VPWR VGND sg13cmos5l_antennanp
XANTENNA__0515__D Tile_X0Y0_FrameData[20] VPWR VGND sg13cmos5l_antennanp
XFILLER_15_2266 VPWR VGND sg13cmos5l_decap_4
X_0803_ Tile_X3Y0_SS4BEG[8] _1283_/X VPWR VGND sg13cmos5l_buf_1
XFILLER_15_1543 VPWR VGND sg13cmos5l_decap_8
X_0734_ Tile_X1Y0_SS4BEG[3] _1198_/X VPWR VGND sg13cmos5l_buf_1
X_0665_ _0665_/L_HI VPWR VGND sg13cmos5l_tiehi
XANTENNA__0250__D Tile_X0Y0_FrameData[15] VPWR VGND sg13cmos5l_antennanp
XANTENNA__0193__GATE Tile_X0Y0_FrameStrobe[3] VPWR VGND sg13cmos5l_antennanp
X_0596_ _0596_/Q Tile_X0Y0_UserCLK NPU_RDATA24 _0612_/L_HI VPWR VGND sg13cmos5l_dfrbpq_1
XFILLER_6_2434 VPWR VGND sg13cmos5l_decap_8
XFILLER_6_2412 VPWR VGND sg13cmos5l_decap_8
XANTENNA__1181__A0 Tile_X1Y0_N2MID[2] VPWR VGND sg13cmos5l_antennanp
XFILLER_6_1722 VPWR VGND sg13cmos5l_fill_2
XANTENNA__0827__X Tile_X4Y0_FrameData_O[16] VPWR VGND sg13cmos5l_antennanp
XFILLER_0_2000 VPWR VGND sg13cmos5l_fill_2
XFILLER_0_2011 VPWR VGND sg13cmos5l_fill_1
X_1217_ _1217_/X Tile_X2Y0_N1END[2] Tile_X2Y0_N2MID[6] Tile_X2Y0_N2END[1] _0586_/Q
+ _0397_/Q _0396_/Q VPWR VGND sg13cmos5l_mux4_1
XFILLER_6_1788 VPWR VGND sg13cmos5l_decap_8
XFILLER_4_2191 VPWR VGND sg13cmos5l_fill_2
XFILLER_4_2180 VPWR VGND sg13cmos5l_decap_8
XFILLER_2_1608 VPWR VGND sg13cmos5l_decap_8
XFILLER_0_1332 VPWR VGND sg13cmos5l_decap_8
XFILLER_0_2077 VPWR VGND sg13cmos5l_fill_1
X_1148_ _1148_/X Tile_X0Y0_N2MID[1] Tile_X0Y0_N4END[6] Tile_X0Y0_NN4END[9] _0599_/Q
+ _0167_/Q _0166_/Q VPWR VGND sg13cmos5l_mux4_1
X_1079_ Tile_X4Y0_UserCLKo Tile_X0Y0_UserCLK VPWR VGND sg13cmos5l_buf_1
XANTENNA__0131__GATE Tile_X0Y0_FrameStrobe[1] VPWR VGND sg13cmos5l_antennanp
XANTENNA__1236__A1 Tile_X2Y0_N4END[1] VPWR VGND sg13cmos5l_antennanp
XFILLER_16_1307 VPWR VGND sg13cmos5l_decap_4
XANTENNA__0425__D Tile_X0Y0_FrameData[16] VPWR VGND sg13cmos5l_antennanp
XFILLER_5_708 VPWR VGND sg13cmos5l_decap_8
XFILLER_14_1075 VPWR VGND sg13cmos5l_fill_2
XFILLER_11_2653 VPWR VGND sg13cmos5l_decap_8
XANTENNA__0146__GATE Tile_X0Y0_FrameStrobe[1] VPWR VGND sg13cmos5l_antennanp
XFILLER_4_207 VPWR VGND sg13cmos5l_decap_8
XFILLER_11_1930 VPWR VGND sg13cmos5l_decap_8
XANTENNA__0160__D Tile_X0Y0_FrameData[25] VPWR VGND sg13cmos5l_antennanp
XANTENNA__1172__A0 Tile_X1Y0_N1END[1] VPWR VGND sg13cmos5l_antennanp
XFILLER_9_2091 VPWR VGND sg13cmos5l_decap_4
XFILLER_9_1390 VPWR VGND sg13cmos5l_fill_2
XANTENNA__0737__X Tile_X1Y0_SS4BEG[6] VPWR VGND sg13cmos5l_antennanp
XFILLER_5_1265 VPWR VGND sg13cmos5l_fill_1
XANTENNA__0601__CLK Tile_X0Y0_UserCLK VPWR VGND sg13cmos5l_antennanp
XFILLER_16_314 VPWR VGND sg13cmos5l_decap_4
XFILLER_16_369 VPWR VGND sg13cmos5l_fill_1
XANTENNA__1227__A1 Tile_X2Y0_N4END[7] VPWR VGND sg13cmos5l_antennanp
XFILLER_16_2542 VPWR VGND sg13cmos5l_decap_8
XANTENNA__0335__D Tile_X0Y0_FrameData[10] VPWR VGND sg13cmos5l_antennanp
XFILLER_8_502 VPWR VGND sg13cmos5l_decap_8
XFILLER_16_1863 VPWR VGND sg13cmos5l_decap_8
XFILLER_12_597 VPWR VGND sg13cmos5l_decap_8
XFILLER_12_2417 VPWR VGND sg13cmos5l_decap_8
XFILLER_8_579 VPWR VGND sg13cmos5l_decap_8
XANTENNA_7 Tile_X0Y0_FrameData[14] VPWR VGND sg13cmos5l_antennanp
XFILLER_6_47 VPWR VGND sg13cmos5l_fill_1
XFILLER_12_1749 VPWR VGND sg13cmos5l_decap_8
X_0450_ _0450_/Q Tile_X0Y0_FrameData[23] VGND VPWR Tile_X3Y0_FrameStrobe[1] latch
XFILLER_7_2743 VPWR VGND sg13cmos5l_decap_8
XFILLER_3_273 VPWR VGND sg13cmos5l_fill_2
XANTENNA__1163__A0 Tile_X0Y0_N2END[0] VPWR VGND sg13cmos5l_antennanp
X_0381_ _0381_/Q Tile_X0Y0_FrameData[28] VGND VPWR Tile_X2Y0_FrameStrobe[2] latch
XFILLER_3_1928 VPWR VGND sg13cmos5l_fill_1
X_1002_ Tile_X0Y0_S4BEG[11] _1150_/X VPWR VGND sg13cmos5l_buf_1
XFILLER_1_2342 VPWR VGND sg13cmos5l_decap_8
XFILLER_1_1674 VPWR VGND sg13cmos5l_decap_8
XFILLER_16_870 VPWR VGND sg13cmos5l_decap_4
XANTENNA__1218__A1 Tile_X2Y0_N2MID[7] VPWR VGND sg13cmos5l_antennanp
XANTENNA__0245__D Tile_X0Y0_FrameData[20] VPWR VGND sg13cmos5l_antennanp
XANTENNA__0823__A Tile_X0Y0_FrameData[12] VPWR VGND sg13cmos5l_antennanp
XFILLER_15_2030 VPWR VGND sg13cmos5l_decap_8
XFILLER_15_2085 VPWR VGND sg13cmos5l_fill_2
X_0717_ Tile_X1Y0_S4BEG[2] _1181_/X VPWR VGND sg13cmos5l_buf_1
XFILLER_11_1259 VPWR VGND sg13cmos5l_decap_8
XFILLER_8_2529 VPWR VGND sg13cmos5l_decap_8
X_0648_ _0648_/L_HI VPWR VGND sg13cmos5l_tiehi
XFILLER_8_1806 VPWR VGND sg13cmos5l_decap_8
XANTENNA__1154__A0 Tile_X0Y0_N2MID[7] VPWR VGND sg13cmos5l_antennanp
X_0579_ _0579_/Q Tile_X0Y0_UserCLK NPU_RDATA7 _0642_/L_HI VPWR VGND sg13cmos5l_dfrbpq_1
XFILLER_6_2286 VPWR VGND sg13cmos5l_decap_8
XFILLER_6_1585 VPWR VGND sg13cmos5l_decap_4
XFILLER_13_306 VPWR VGND sg13cmos5l_decap_8
XANTENNA__1209__A1 Tile_X1Y0_N4END[14] VPWR VGND sg13cmos5l_antennanp
XFILLER_15_34 VPWR VGND sg13cmos5l_fill_1
XFILLER_13_328 VPWR VGND sg13cmos5l_fill_2
XFILLER_13_317 VPWR VGND sg13cmos5l_fill_1
XANTENNA__0155__D Tile_X0Y0_FrameData[30] VPWR VGND sg13cmos5l_antennanp
XFILLER_15_89 VPWR VGND sg13cmos5l_fill_2
XFILLER_16_1159 VPWR VGND sg13cmos5l_decap_8
XFILLER_11_2461 VPWR VGND sg13cmos5l_decap_8
XFILLER_1_733 VPWR VGND sg13cmos5l_fill_2
XANTENNA__1145__A0 Tile_X0Y0_N2MID[6] VPWR VGND sg13cmos5l_antennanp
XFILLER_0_243 VPWR VGND sg13cmos5l_fill_2
XFILLER_7_1349 VPWR VGND sg13cmos5l_fill_2
XFILLER_7_1338 VPWR VGND sg13cmos5l_fill_1
XFILLER_0_298 VPWR VGND sg13cmos5l_fill_2
XFILLER_5_1062 VPWR VGND sg13cmos5l_decap_8
XFILLER_2_2684 VPWR VGND sg13cmos5l_decap_8
XFILLER_16_177 VPWR VGND sg13cmos5l_decap_8
XFILLER_13_862 VPWR VGND sg13cmos5l_fill_2
XFILLER_12_2214 VPWR VGND sg13cmos5l_decap_8
XFILLER_8_343 VPWR VGND sg13cmos5l_fill_2
XFILLER_16_1671 VPWR VGND sg13cmos5l_decap_8
XFILLER_16_1660 VPWR VGND sg13cmos5l_decap_8
XFILLER_12_394 VPWR VGND sg13cmos5l_decap_8
XANTENNA__0930__X Tile_X3Y0_FrameStrobe_O[15] VPWR VGND sg13cmos5l_antennanp
XFILLER_12_1546 VPWR VGND sg13cmos5l_decap_8
XFILLER_10_1281 VPWR VGND sg13cmos5l_decap_8
X_0502_ _0502_/Q Tile_X0Y0_FrameData[3] VGND VPWR Tile_X3Y0_FrameStrobe[2] latch
XANTENNA__1136__A0 Tile_X0Y0_N1END[1] VPWR VGND sg13cmos5l_antennanp
X_0433_ _0433_/Q Tile_X0Y0_FrameData[8] VGND VPWR Tile_X3Y0_FrameStrobe[0] latch
X_0364_ _0364_/Q Tile_X0Y0_FrameData[13] VGND VPWR Tile_X2Y0_FrameStrobe[1] latch
XFILLER_7_1872 VPWR VGND sg13cmos5l_fill_1
XFILLER_7_1861 VPWR VGND sg13cmos5l_fill_2
XANTENNA__0818__A Tile_X0Y0_FrameData[7] VPWR VGND sg13cmos5l_antennanp
X_0295_ _0295_/Q Tile_X0Y0_FrameData[2] VGND VPWR Tile_X1Y0_FrameStrobe[2] latch
XFILLER_3_1736 VPWR VGND sg13cmos5l_decap_8
XANTENNA__1001__X Tile_X0Y0_S4BEG[10] VPWR VGND sg13cmos5l_antennanp
XANTENNA__0840__X Tile_X4Y0_FrameData_O[29] VPWR VGND sg13cmos5l_antennanp
XFILLER_15_1181 VPWR VGND sg13cmos5l_decap_8
XFILLER_2_519 VPWR VGND sg13cmos5l_decap_8
XFILLER_8_2326 VPWR VGND sg13cmos5l_decap_8
XANTENNA__1127__A0 Tile_X0Y0_N4END[12] VPWR VGND sg13cmos5l_antennanp
XFILLER_8_1647 VPWR VGND sg13cmos5l_decap_8
XFILLER_2_1246 VPWR VGND sg13cmos5l_decap_4
XFILLER_2_1279 VPWR VGND sg13cmos5l_fill_1
XFILLER_2_1268 VPWR VGND sg13cmos5l_fill_1
XFILLER_14_637 VPWR VGND sg13cmos5l_decap_8
XFILLER_13_125 VPWR VGND sg13cmos5l_fill_1
XFILLER_13_169 VPWR VGND sg13cmos5l_decap_4
XFILLER_10_821 VPWR VGND sg13cmos5l_decap_8
XFILLER_13_1800 VPWR VGND sg13cmos5l_decap_8
XANTENNA__0750__X Tile_X1Y0_S1BEG[3] VPWR VGND sg13cmos5l_antennanp
XFILLER_13_1877 VPWR VGND sg13cmos5l_decap_8
XFILLER_11_1590 VPWR VGND sg13cmos5l_fill_1
XANTENNA__1118__A0 Tile_X0Y0_N4END[6] VPWR VGND sg13cmos5l_antennanp
XFILLER_7_1124 VPWR VGND sg13cmos5l_decap_8
XFILLER_1_585 VPWR VGND sg13cmos5l_decap_4
XFILLER_7_1179 VPWR VGND sg13cmos5l_decap_8
XANTENNA__0925__X Tile_X3Y0_FrameStrobe_O[10] VPWR VGND sg13cmos5l_antennanp
X_0982_ Tile_X0Y0_SS4BEG[7] _1162_/X VPWR VGND sg13cmos5l_buf_1
XFILLER_9_641 VPWR VGND sg13cmos5l_decap_8
XFILLER_13_681 VPWR VGND sg13cmos5l_decap_8
XFILLER_12_2022 VPWR VGND sg13cmos5l_decap_8
XFILLER_12_2088 VPWR VGND sg13cmos5l_decap_4
XFILLER_12_1343 VPWR VGND sg13cmos5l_decap_8
XFILLER_9_2613 VPWR VGND sg13cmos5l_decap_8
XANTENNA__1109__A0 Tile_X1Y0_N4END[13] VPWR VGND sg13cmos5l_antennanp
XFILLER_9_1901 VPWR VGND sg13cmos5l_decap_4
X_0416_ _0416_/Q Tile_X0Y0_FrameData[25] VGND VPWR Tile_X3Y0_FrameStrobe[0] latch
XFILLER_7_2392 VPWR VGND sg13cmos5l_decap_8
XFILLER_3_2223 VPWR VGND sg13cmos5l_decap_8
XANTENNA__1124__A3 Tile_X0Y0_NN4END[14] VPWR VGND sg13cmos5l_antennanp
X_0347_ _0347_/Q Tile_X0Y0_FrameData[30] VGND VPWR Tile_X2Y0_FrameStrobe[1] latch
XANTENNA__0835__X Tile_X4Y0_FrameData_O[24] VPWR VGND sg13cmos5l_antennanp
X_0278_ _0278_/Q Tile_X0Y0_FrameData[19] VGND VPWR Tile_X1Y0_FrameStrobe[2] latch
XFILLER_3_1566 VPWR VGND sg13cmos5l_decap_8
XANTENNA__0433__D Tile_X0Y0_FrameData[8] VPWR VGND sg13cmos5l_antennanp
XFILLER_8_2101 VPWR VGND sg13cmos5l_decap_8
XFILLER_2_338 VPWR VGND sg13cmos5l_decap_8
XFILLER_8_1411 VPWR VGND sg13cmos5l_decap_4
XANTENNA__1115__A3 Tile_X0Y0_NN4END[3] VPWR VGND sg13cmos5l_antennanp
XFILLER_2_1010 VPWR VGND sg13cmos5l_fill_1
XANTENNA__0745__X Tile_X1Y0_SS4BEG[14] VPWR VGND sg13cmos5l_antennanp
XANTENNA__0343__D Tile_X0Y0_FrameData[2] VPWR VGND sg13cmos5l_antennanp
XFILLER_13_2364 VPWR VGND sg13cmos5l_decap_8
XFILLER_10_640 VPWR VGND sg13cmos5l_decap_8
XANTENNA__0921__A Tile_X3Y0_FrameStrobe[6] VPWR VGND sg13cmos5l_antennanp
XFILLER_5_143 VPWR VGND sg13cmos5l_fill_1
XFILLER_5_132 VPWR VGND sg13cmos5l_fill_2
XFILLER_13_1685 VPWR VGND sg13cmos5l_decap_8
XFILLER_6_2808 VPWR VGND sg13cmos5l_fill_1
X_1250_ _1250_/X Tile_X2Y0_N2END[7] Tile_X2Y0_N4END[15] Tile_X2Y0_NN4END[0] _0580_/Q
+ _0331_/Q _0330_/Q VPWR VGND sg13cmos5l_mux4_1
XFILLER_4_2521 VPWR VGND sg13cmos5l_decap_8
XANTENNA__1106__A3 Tile_X1Y0_NN4END[10] VPWR VGND sg13cmos5l_antennanp
X_0201_ _0201_/Q Tile_X0Y0_FrameData[16] VGND VPWR Tile_X0Y0_FrameStrobe[3] latch
X_1181_ _1181_/X Tile_X1Y0_N2MID[2] Tile_X1Y0_N4END[13] Tile_X1Y0_NN4END[2] _0594_/Q
+ _0293_/Q _0292_/Q VPWR VGND sg13cmos5l_mux4_1
XFILLER_0_2407 VPWR VGND sg13cmos5l_decap_8
X_0132_ _0132_/Q Tile_X0Y0_FrameData[21] VGND VPWR Tile_X0Y0_FrameStrobe[1] latch
XFILLER_4_2598 VPWR VGND sg13cmos5l_decap_8
XFILLER_4_1842 VPWR VGND sg13cmos5l_fill_1
XANTENNA__0518__D Tile_X0Y0_FrameData[23] VPWR VGND sg13cmos5l_antennanp
XANTENNA__1290__A2 Tile_X3Y0_NN4END[0] VPWR VGND sg13cmos5l_antennanp
XANTENNA__0253__D Tile_X0Y0_FrameData[12] VPWR VGND sg13cmos5l_antennanp
XFILLER_9_471 VPWR VGND sg13cmos5l_decap_8
X_0965_ Tile_X1Y0_FrameStrobe_O[10] Tile_X1Y0_FrameStrobe[10] VPWR VGND sg13cmos5l_buf_1
XANTENNA__0484__GATE Tile_X3Y0_FrameStrobe[2] VPWR VGND sg13cmos5l_antennanp
XANTENNA__0831__A Tile_X0Y0_FrameData[20] VPWR VGND sg13cmos5l_antennanp
X_0896_ Tile_X2Y0_S4BEG[13] _1232_/X VPWR VGND sg13cmos5l_buf_1
XFILLER_12_1140 VPWR VGND sg13cmos5l_decap_8
XFILLER_9_2410 VPWR VGND sg13cmos5l_decap_8
XANTENNA__0499__GATE Tile_X3Y0_FrameStrobe[2] VPWR VGND sg13cmos5l_antennanp
XFILLER_9_2487 VPWR VGND sg13cmos5l_decap_8
XFILLER_5_1606 VPWR VGND sg13cmos5l_decap_8
XFILLER_4_80 VPWR VGND sg13cmos5l_fill_2
XANTENNA__0422__GATE Tile_X3Y0_FrameStrobe[0] VPWR VGND sg13cmos5l_antennanp
XFILLER_9_1786 VPWR VGND sg13cmos5l_decap_8
XANTENNA__0428__D Tile_X0Y0_FrameData[13] VPWR VGND sg13cmos5l_antennanp
XANTENNA__0437__GATE Tile_X3Y0_FrameStrobe[0] VPWR VGND sg13cmos5l_antennanp
XANTENNA__1281__A2 Tile_X3Y0_NN4END[9] VPWR VGND sg13cmos5l_antennanp
XFILLER_14_2640 VPWR VGND sg13cmos5l_decap_8
XANTENNA__0163__D Tile_X0Y0_FrameData[22] VPWR VGND sg13cmos5l_antennanp
XFILLER_14_1983 VPWR VGND sg13cmos5l_decap_8
XFILLER_3_614 VPWR VGND sg13cmos5l_decap_8
XFILLER_2_113 VPWR VGND sg13cmos5l_fill_1
XFILLER_2_124 VPWR VGND sg13cmos5l_decap_8
XFILLER_8_1285 VPWR VGND sg13cmos5l_decap_8
XFILLER_1_2705 VPWR VGND sg13cmos5l_fill_1
XFILLER_4_1127 VPWR VGND sg13cmos5l_decap_8
XANTENNA__0338__D Tile_X0Y0_FrameData[7] VPWR VGND sg13cmos5l_antennanp
XANTENNA__0916__A Tile_X3Y0_FrameStrobe[1] VPWR VGND sg13cmos5l_antennanp
XFILLER_15_765 VPWR VGND sg13cmos5l_decap_8
XANTENNA__1272__A2 Tile_X3Y0_NN4END[13] VPWR VGND sg13cmos5l_antennanp
XFILLER_15_1703 VPWR VGND sg13cmos5l_decap_8
XFILLER_14_297 VPWR VGND sg13cmos5l_decap_8
X_0750_ Tile_X1Y0_S1BEG[3] Tile_X1Y0_N1END[0] VPWR VGND sg13cmos5l_buf_1
XFILLER_7_953 VPWR VGND sg13cmos5l_decap_8
XFILLER_7_920 VPWR VGND sg13cmos5l_fill_2
XFILLER_13_2161 VPWR VGND sg13cmos5l_decap_8
XFILLER_11_971 VPWR VGND sg13cmos5l_fill_2
X_0681_ _0681_/L_HI VPWR VGND sg13cmos5l_tiehi
XFILLER_6_2605 VPWR VGND sg13cmos5l_decap_8
XFILLER_2_680 VPWR VGND sg13cmos5l_decap_8
X_1233_ _1233_/X Tile_X2Y0_N2MID[6] Tile_X2Y0_N4END[1] Tile_X2Y0_NN4END[14] _0580_/Q
+ _0365_/Q _0364_/Q VPWR VGND sg13cmos5l_mux4_1
XFILLER_0_2204 VPWR VGND sg13cmos5l_decap_4
XFILLER_4_2351 VPWR VGND sg13cmos5l_fill_2
X_1164_ _1164_/X Tile_X0Y0_N2END[1] Tile_X0Y0_N4END[9] Tile_X0Y0_NN4END[6] _0598_/Q
+ _0135_/Q _0134_/Q VPWR VGND sg13cmos5l_mux4_1
XFILLER_4_2395 VPWR VGND sg13cmos5l_fill_1
XANTENNA__0248__D Tile_X0Y0_FrameData[17] VPWR VGND sg13cmos5l_antennanp
XANTENNA__0826__A Tile_X0Y0_FrameData[15] VPWR VGND sg13cmos5l_antennanp
X_0115_ _0115_/Q Tile_X0Y0_FrameData[6] VGND VPWR Tile_X0Y0_FrameStrobe[0] latch
X_1095_ _1095_/X Tile_X3Y0_N1END[3] Tile_X3Y0_N2MID[0] Tile_X3Y0_N2MID[7] Tile_X3Y0_N2END[0]
+ _0411_/Q _0506_/Q VPWR VGND sg13cmos5l_mux4_1
XANTENNA__1263__A2 Tile_X3Y0_NN4END[4] VPWR VGND sg13cmos5l_antennanp
X_0948_ Tile_X2Y0_FrameStrobe_O[13] Tile_X2Y0_FrameStrobe[13] VPWR VGND sg13cmos5l_buf_1
XFILLER_14_1235 VPWR VGND sg13cmos5l_decap_8
X_0879_ Tile_X2Y0_S2BEGb[4] _1215_/X VPWR VGND sg13cmos5l_buf_1
XANTENNA__0361__GATE Tile_X2Y0_FrameStrobe[1] VPWR VGND sg13cmos5l_antennanp
XFILLER_9_2284 VPWR VGND sg13cmos5l_decap_8
XANTENNA__0158__D Tile_X0Y0_FrameData[27] VPWR VGND sg13cmos5l_antennanp
XANTENNA__0376__GATE Tile_X2Y0_FrameStrobe[1] VPWR VGND sg13cmos5l_antennanp
XFILLER_3_1160 VPWR VGND sg13cmos5l_decap_8
XFILLER_0_2771 VPWR VGND sg13cmos5l_fill_1
XFILLER_12_702 VPWR VGND sg13cmos5l_decap_8
XANTENNA__1254__A2 Tile_X3Y0_N2END[4] VPWR VGND sg13cmos5l_antennanp
XFILLER_11_223 VPWR VGND sg13cmos5l_decap_8
XFILLER_16_2768 VPWR VGND sg13cmos5l_decap_8
XFILLER_11_289 VPWR VGND sg13cmos5l_fill_2
XFILLER_11_278 VPWR VGND sg13cmos5l_decap_8
XFILLER_10_2356 VPWR VGND sg13cmos5l_decap_8
XANTENNA__0314__GATE Tile_X1Y0_FrameStrobe[0] VPWR VGND sg13cmos5l_antennanp
XANTENNA__0530__CLK Tile_X0Y0_UserCLK VPWR VGND sg13cmos5l_antennanp
XFILLER_3_400 VPWR VGND sg13cmos5l_fill_1
XFILLER_10_1655 VPWR VGND sg13cmos5l_decap_8
XFILLER_3_422 VPWR VGND sg13cmos5l_decap_8
XFILLER_3_488 VPWR VGND sg13cmos5l_decap_8
XANTENNA__0329__GATE Tile_X2Y0_FrameStrobe[0] VPWR VGND sg13cmos5l_antennanp
XANTENNA__1190__A1 Tile_X1Y0_N4END[4] VPWR VGND sg13cmos5l_antennanp
XFILLER_1_2535 VPWR VGND sg13cmos5l_decap_8
XFILLER_1_2524 VPWR VGND sg13cmos5l_decap_8
XFILLER_1_2579 VPWR VGND sg13cmos5l_fill_1
XFILLER_15_551 VPWR VGND sg13cmos5l_fill_1
XFILLER_15_2201 VPWR VGND sg13cmos5l_decap_8
XANTENNA__0933__X Tile_X3Y0_FrameStrobe_O[18] VPWR VGND sg13cmos5l_antennanp
XANTENNA__1245__A2 Tile_X2Y0_NN4END[5] VPWR VGND sg13cmos5l_antennanp
XFILLER_15_584 VPWR VGND sg13cmos5l_decap_8
XFILLER_15_2212 VPWR VGND sg13cmos5l_fill_1
XFILLER_15_2245 VPWR VGND sg13cmos5l_decap_8
XFILLER_15_1522 VPWR VGND sg13cmos5l_decap_8
X_0802_ Tile_X3Y0_SS4BEG[7] _1282_/X VPWR VGND sg13cmos5l_buf_1
X_0733_ Tile_X1Y0_SS4BEG[2] _1197_/X VPWR VGND sg13cmos5l_buf_1
X_0664_ _0664_/L_HI VPWR VGND sg13cmos5l_tiehi
X_0595_ _0595_/Q Tile_X0Y0_UserCLK NPU_RDATA23 _0611_/L_HI VPWR VGND sg13cmos5l_dfrbpq_1
XANTENNA__1181__A1 Tile_X1Y0_N4END[13] VPWR VGND sg13cmos5l_antennanp
XFILLER_6_2468 VPWR VGND sg13cmos5l_decap_8
XFILLER_6_1701 VPWR VGND sg13cmos5l_decap_8
X_1216_ _1216_/X Tile_X2Y0_N1END[1] Tile_X2Y0_N2MID[5] Tile_X2Y0_N2END[2] _0585_/Q
+ _0399_/Q _0398_/Q VPWR VGND sg13cmos5l_mux4_1
XFILLER_6_1767 VPWR VGND sg13cmos5l_decap_8
X_1147_ _1147_/X Tile_X0Y0_N2MID[0] Tile_X0Y0_N4END[7] Tile_X0Y0_NN4END[8] _0598_/Q
+ _0169_/Q _0168_/Q VPWR VGND sg13cmos5l_mux4_1
XANTENNA__1004__X Tile_X0Y0_S4BEG[13] VPWR VGND sg13cmos5l_antennanp
X_1078_ Tile_X4Y0_SS4BEG[15] Tile_X4Y0_NN4END[0] VPWR VGND sg13cmos5l_buf_1
XFILLER_16_2009 VPWR VGND sg13cmos5l_decap_4
XANTENNA__0843__X Tile_X4Y0_FrameStrobe_O[0] VPWR VGND sg13cmos5l_antennanp
XANTENNA__1236__A2 Tile_X2Y0_NN4END[14] VPWR VGND sg13cmos5l_antennanp
XANTENNA__0553__CLK Tile_X0Y0_UserCLK VPWR VGND sg13cmos5l_antennanp
XFILLER_14_1010 VPWR VGND sg13cmos5l_fill_2
XFILLER_11_2632 VPWR VGND sg13cmos5l_decap_8
XANTENNA__0441__D Tile_X0Y0_FrameData[0] VPWR VGND sg13cmos5l_antennanp
XFILLER_11_1986 VPWR VGND sg13cmos5l_decap_8
XFILLER_11_1964 VPWR VGND sg13cmos5l_decap_8
XFILLER_0_403 VPWR VGND sg13cmos5l_fill_1
XFILLER_1_926 VPWR VGND sg13cmos5l_fill_2
XFILLER_11_1997 VPWR VGND sg13cmos5l_fill_2
XFILLER_9_2070 VPWR VGND sg13cmos5l_decap_8
XANTENNA__1172__A1 Tile_X1Y0_N2MID[1] VPWR VGND sg13cmos5l_antennanp
XFILLER_5_1222 VPWR VGND sg13cmos5l_decap_8
XFILLER_1_1119 VPWR VGND sg13cmos5l_decap_8
XFILLER_1_1108 VPWR VGND sg13cmos5l_decap_8
XANTENNA__0753__X Tile_X1Y0_S2BEG[2] VPWR VGND sg13cmos5l_antennanp
XANTENNA__1227__A2 Tile_X2Y0_NN4END[8] VPWR VGND sg13cmos5l_antennanp
XFILLER_16_2521 VPWR VGND sg13cmos5l_decap_8
XFILLER_16_2587 VPWR VGND sg13cmos5l_decap_4
XFILLER_12_576 VPWR VGND sg13cmos5l_decap_8
XANTENNA__0253__GATE Tile_X1Y0_FrameStrobe[1] VPWR VGND sg13cmos5l_antennanp
XFILLER_8_558 VPWR VGND sg13cmos5l_decap_8
XFILLER_12_1728 VPWR VGND sg13cmos5l_decap_8
XANTENNA_8 Tile_X0Y0_FrameData[14] VPWR VGND sg13cmos5l_antennanp
XANTENNA__0351__D Tile_X0Y0_FrameData[26] VPWR VGND sg13cmos5l_antennanp
XFILLER_10_2142 VPWR VGND sg13cmos5l_decap_8
XANTENNA__0268__GATE Tile_X1Y0_FrameStrobe[2] VPWR VGND sg13cmos5l_antennanp
XFILLER_4_775 VPWR VGND sg13cmos5l_decap_4
XFILLER_3_241 VPWR VGND sg13cmos5l_decap_8
XFILLER_7_2722 VPWR VGND sg13cmos5l_decap_8
XFILLER_4_797 VPWR VGND sg13cmos5l_decap_8
XFILLER_10_90 VPWR VGND sg13cmos5l_fill_1
XANTENNA__1163__A1 Tile_X0Y0_N4END[8] VPWR VGND sg13cmos5l_antennanp
X_0380_ _0380_/Q Tile_X0Y0_FrameData[29] VGND VPWR Tile_X2Y0_FrameStrobe[2] latch
XANTENNA__0928__X Tile_X3Y0_FrameStrobe_O[13] VPWR VGND sg13cmos5l_antennanp
XFILLER_0_992 VPWR VGND sg13cmos5l_fill_1
XFILLER_7_2799 VPWR VGND sg13cmos5l_fill_1
X_1001_ Tile_X0Y0_S4BEG[10] _1149_/X VPWR VGND sg13cmos5l_buf_1
XFILLER_1_1653 VPWR VGND sg13cmos5l_decap_8
XANTENNA__0206__GATE Tile_X1Y0_FrameStrobe[0] VPWR VGND sg13cmos5l_antennanp
XANTENNA__0576__CLK Tile_X0Y0_UserCLK VPWR VGND sg13cmos5l_antennanp
XANTENNA__1218__A2 Tile_X2Y0_N2END[0] VPWR VGND sg13cmos5l_antennanp
XFILLER_15_2064 VPWR VGND sg13cmos5l_decap_8
XFILLER_15_1363 VPWR VGND sg13cmos5l_fill_1
XFILLER_15_1352 VPWR VGND sg13cmos5l_decap_8
XFILLER_11_1238 VPWR VGND sg13cmos5l_decap_8
XANTENNA__0261__D Tile_X0Y0_FrameData[4] VPWR VGND sg13cmos5l_antennanp
X_0716_ Tile_X1Y0_S4BEG[1] _1180_/X VPWR VGND sg13cmos5l_buf_1
XFILLER_7_580 VPWR VGND sg13cmos5l_decap_8
XFILLER_8_2508 VPWR VGND sg13cmos5l_decap_8
X_0647_ _0647_/L_HI VPWR VGND sg13cmos5l_tiehi
XANTENNA__1154__A1 Tile_X0Y0_N4END[0] VPWR VGND sg13cmos5l_antennanp
X_0578_ _0578_/Q Tile_X0Y0_UserCLK NPU_RDATA6 _0643_/L_HI VPWR VGND sg13cmos5l_dfrbpq_1
XANTENNA__0838__X Tile_X4Y0_FrameData_O[27] VPWR VGND sg13cmos5l_antennanp
XFILLER_6_2265 VPWR VGND sg13cmos5l_decap_8
XFILLER_6_1564 VPWR VGND sg13cmos5l_decap_8
XFILLER_14_808 VPWR VGND sg13cmos5l_decap_8
XANTENNA__0436__D Tile_X0Y0_FrameData[5] VPWR VGND sg13cmos5l_antennanp
XANTENNA__1209__A2 Tile_X1Y0_NN4END[1] VPWR VGND sg13cmos5l_antennanp
XFILLER_15_79 VPWR VGND sg13cmos5l_fill_1
XFILLER_13_2705 VPWR VGND sg13cmos5l_decap_4
XANTENNA__1090__A0 Tile_X3Y0_N1END[2] VPWR VGND sg13cmos5l_antennanp
XFILLER_16_1138 VPWR VGND sg13cmos5l_decap_8
XFILLER_13_2749 VPWR VGND sg13cmos5l_decap_8
XANTENNA__0522__Q NPU_READ_BANK_SEL1 VPWR VGND sg13cmos5l_antennanp
XFILLER_11_2440 VPWR VGND sg13cmos5l_decap_8
XANTENNA__0171__D Tile_X0Y0_FrameData[14] VPWR VGND sg13cmos5l_antennanp
XFILLER_5_539 VPWR VGND sg13cmos5l_decap_8
XFILLER_11_1783 VPWR VGND sg13cmos5l_decap_8
XFILLER_0_200 VPWR VGND sg13cmos5l_decap_4
XFILLER_1_712 VPWR VGND sg13cmos5l_decap_8
XANTENNA__1145__A1 Tile_X0Y0_N4END[9] VPWR VGND sg13cmos5l_antennanp
XANTENNA__0748__X Tile_X1Y0_S1BEG[1] VPWR VGND sg13cmos5l_antennanp
XANTENNA__0599__CLK Tile_X0Y0_UserCLK VPWR VGND sg13cmos5l_antennanp
XFILLER_2_2663 VPWR VGND sg13cmos5l_decap_8
XFILLER_16_156 VPWR VGND sg13cmos5l_decap_8
XANTENNA__0346__D Tile_X0Y0_FrameData[31] VPWR VGND sg13cmos5l_antennanp
XANTENNA__0924__A Tile_X3Y0_FrameStrobe[9] VPWR VGND sg13cmos5l_antennanp
XANTENNA__0192__GATE Tile_X0Y0_FrameStrobe[3] VPWR VGND sg13cmos5l_antennanp
XANTENNA__1081__A0 Tile_X2Y0_N1END[1] VPWR VGND sg13cmos5l_antennanp
XFILLER_13_874 VPWR VGND sg13cmos5l_fill_2
XFILLER_12_340 VPWR VGND sg13cmos5l_decap_8
XFILLER_8_355 VPWR VGND sg13cmos5l_decap_4
XFILLER_16_2395 VPWR VGND sg13cmos5l_decap_8
XFILLER_12_1525 VPWR VGND sg13cmos5l_decap_8
XFILLER_10_1260 VPWR VGND sg13cmos5l_decap_8
X_0501_ _0501_/Q Tile_X0Y0_FrameData[4] VGND VPWR Tile_X3Y0_FrameStrobe[2] latch
XFILLER_4_594 VPWR VGND sg13cmos5l_decap_8
XANTENNA__1136__A1 Tile_X0Y0_N2MID[5] VPWR VGND sg13cmos5l_antennanp
X_0432_ _0432_/Q Tile_X0Y0_FrameData[9] VGND VPWR Tile_X3Y0_FrameStrobe[0] latch
XANTENNA__0130__GATE Tile_X0Y0_FrameStrobe[1] VPWR VGND sg13cmos5l_antennanp
X_0363_ _0363_/Q Tile_X0Y0_FrameData[14] VGND VPWR Tile_X2Y0_FrameStrobe[1] latch
X_0294_ _0294_/Q Tile_X0Y0_FrameData[3] VGND VPWR Tile_X1Y0_FrameStrobe[2] latch
XFILLER_3_1715 VPWR VGND sg13cmos5l_decap_8
XFILLER_1_2140 VPWR VGND sg13cmos5l_decap_8
XANTENNA__0145__GATE Tile_X0Y0_FrameStrobe[1] VPWR VGND sg13cmos5l_antennanp
XFILLER_1_2195 VPWR VGND sg13cmos5l_decap_8
XANTENNA__0256__D Tile_X0Y0_FrameData[9] VPWR VGND sg13cmos5l_antennanp
XANTENNA__0834__A Tile_X0Y0_FrameData[23] VPWR VGND sg13cmos5l_antennanp
XFILLER_16_690 VPWR VGND sg13cmos5l_fill_2
XFILLER_15_1160 VPWR VGND sg13cmos5l_decap_8
XFILLER_12_2771 VPWR VGND sg13cmos5l_decap_8
XFILLER_8_2305 VPWR VGND sg13cmos5l_decap_8
XANTENNA__1127__A1 Tile_X0Y0_N4END[15] VPWR VGND sg13cmos5l_antennanp
XFILLER_8_1626 VPWR VGND sg13cmos5l_decap_8
XANTENNA__0166__D Tile_X0Y0_FrameData[19] VPWR VGND sg13cmos5l_antennanp
XFILLER_14_616 VPWR VGND sg13cmos5l_decap_8
XFILLER_10_800 VPWR VGND sg13cmos5l_decap_8
XFILLER_13_2546 VPWR VGND sg13cmos5l_decap_4
XFILLER_10_888 VPWR VGND sg13cmos5l_decap_8
XFILLER_13_1856 VPWR VGND sg13cmos5l_decap_8
XFILLER_5_358 VPWR VGND sg13cmos5l_decap_4
XANTENNA__1118__A1 Tile_X0Y0_N4END[7] VPWR VGND sg13cmos5l_antennanp
XFILLER_7_1103 VPWR VGND sg13cmos5l_decap_8
XFILLER_4_2703 VPWR VGND sg13cmos5l_decap_8
XANTENNA__0919__A Tile_X3Y0_FrameStrobe[4] VPWR VGND sg13cmos5l_antennanp
XFILLER_7_1169 VPWR VGND sg13cmos5l_decap_4
XFILLER_4_2769 VPWR VGND sg13cmos5l_decap_8
XFILLER_9_620 VPWR VGND sg13cmos5l_decap_8
X_0981_ Tile_X0Y0_SS4BEG[6] _1161_/X VPWR VGND sg13cmos5l_buf_1
XFILLER_13_660 VPWR VGND sg13cmos5l_decap_8
XANTENNA__0941__X Tile_X2Y0_FrameStrobe_O[6] VPWR VGND sg13cmos5l_antennanp
XFILLER_16_2192 VPWR VGND sg13cmos5l_decap_8
XFILLER_16_2181 VPWR VGND sg13cmos5l_fill_1
XFILLER_16_2170 VPWR VGND sg13cmos5l_decap_8
XFILLER_12_2001 VPWR VGND sg13cmos5l_decap_8
XFILLER_8_141 VPWR VGND sg13cmos5l_fill_1
XFILLER_12_2067 VPWR VGND sg13cmos5l_decap_8
XFILLER_12_1322 VPWR VGND sg13cmos5l_decap_8
XFILLER_12_1388 VPWR VGND sg13cmos5l_decap_8
XFILLER_9_2669 VPWR VGND sg13cmos5l_decap_8
XFILLER_4_391 VPWR VGND sg13cmos5l_fill_2
XANTENNA__1109__A1 Tile_X1Y0_N4END[14] VPWR VGND sg13cmos5l_antennanp
XFILLER_9_1935 VPWR VGND sg13cmos5l_decap_8
X_0415_ _0415_/Q Tile_X0Y0_FrameData[26] VGND VPWR Tile_X3Y0_FrameStrobe[0] latch
XANTENNA__0829__A Tile_X0Y0_FrameData[18] VPWR VGND sg13cmos5l_antennanp
XFILLER_7_2371 VPWR VGND sg13cmos5l_decap_8
XFILLER_3_2202 VPWR VGND sg13cmos5l_decap_8
X_0346_ _0346_/Q Tile_X0Y0_FrameData[31] VGND VPWR Tile_X2Y0_FrameStrobe[1] latch
XFILLER_7_1681 VPWR VGND sg13cmos5l_decap_8
X_0277_ _0277_/Q Tile_X0Y0_FrameData[20] VGND VPWR Tile_X1Y0_FrameStrobe[2] latch
XANTENNA__0099__GATE Tile_X0Y0_FrameStrobe[0] VPWR VGND sg13cmos5l_antennanp
XANTENNA__1012__X Tile_X0Y0_S2BEGb[5] VPWR VGND sg13cmos5l_antennanp
XFILLER_11_619 VPWR VGND sg13cmos5l_decap_8
XANTENNA__0851__X Tile_X4Y0_FrameStrobe_O[8] VPWR VGND sg13cmos5l_antennanp
XFILLER_10_118 VPWR VGND sg13cmos5l_fill_2
XFILLER_13_1119 VPWR VGND sg13cmos5l_decap_8
XFILLER_8_2179 VPWR VGND sg13cmos5l_decap_8
XFILLER_8_1423 VPWR VGND sg13cmos5l_fill_1
XFILLER_8_1445 VPWR VGND sg13cmos5l_decap_8
XFILLER_4_1309 VPWR VGND sg13cmos5l_decap_8
XANTENNA__1284__A0 Tile_X3Y0_N2END[1] VPWR VGND sg13cmos5l_antennanp
XFILLER_2_1099 VPWR VGND sg13cmos5l_decap_8
XANTENNA__0761__X Tile_X3Y0_S1BEG[2] VPWR VGND sg13cmos5l_antennanp
XFILLER_15_1929 VPWR VGND sg13cmos5l_decap_8
XFILLER_13_2343 VPWR VGND sg13cmos5l_decap_8
XFILLER_6_645 VPWR VGND sg13cmos5l_fill_2
XFILLER_6_656 VPWR VGND sg13cmos5l_decap_8
XFILLER_13_1664 VPWR VGND sg13cmos5l_decap_8
XFILLER_5_166 VPWR VGND sg13cmos5l_decap_8
XFILLER_8_2691 VPWR VGND sg13cmos5l_decap_8
X_0200_ _0200_/Q Tile_X0Y0_FrameData[17] VGND VPWR Tile_X0Y0_FrameStrobe[3] latch
X_1180_ _1180_/X Tile_X1Y0_N2MID[1] Tile_X1Y0_N4END[14] Tile_X1Y0_NN4END[1] _0595_/Q
+ _0295_/Q _0294_/Q VPWR VGND sg13cmos5l_mux4_1
XANTENNA__0936__X Tile_X2Y0_FrameStrobe_O[1] VPWR VGND sg13cmos5l_antennanp
X_0131_ _0131_/Q Tile_X0Y0_FrameData[22] VGND VPWR Tile_X0Y0_FrameStrobe[1] latch
XFILLER_4_2577 VPWR VGND sg13cmos5l_decap_8
XFILLER_0_1729 VPWR VGND sg13cmos5l_fill_1
XANTENNA__1275__A0 Tile_X3Y0_N2END[0] VPWR VGND sg13cmos5l_antennanp
XFILLER_14_2129 VPWR VGND sg13cmos5l_decap_8
X_0964_ Tile_X1Y0_FrameStrobe_O[9] Tile_X1Y0_FrameStrobe[9] VPWR VGND sg13cmos5l_buf_1
X_0895_ Tile_X2Y0_S4BEG[12] _1231_/X VPWR VGND sg13cmos5l_buf_1
XFILLER_12_1196 VPWR VGND sg13cmos5l_decap_8
XFILLER_9_1732 VPWR VGND sg13cmos5l_fill_1
XFILLER_9_2466 VPWR VGND sg13cmos5l_decap_8
XANTENNA__1007__X Tile_X0Y0_S2BEGb[0] VPWR VGND sg13cmos5l_antennanp
XFILLER_9_1765 VPWR VGND sg13cmos5l_fill_2
XFILLER_3_2021 VPWR VGND sg13cmos5l_decap_4
XANTENNA__0846__X Tile_X4Y0_FrameStrobe_O[3] VPWR VGND sg13cmos5l_antennanp
X_0329_ _0329_/Q Tile_X0Y0_FrameData[16] VGND VPWR Tile_X2Y0_FrameStrobe[0] latch
XANTENNA__1266__A0 Tile_X3Y0_N2MID[7] VPWR VGND sg13cmos5l_antennanp
XANTENNA__0444__D Tile_X0Y0_FrameData[29] VPWR VGND sg13cmos5l_antennanp
XFILLER_14_2696 VPWR VGND sg13cmos5l_decap_8
XFILLER_14_1962 VPWR VGND sg13cmos5l_decap_8
XFILLER_10_1848 VPWR VGND sg13cmos5l_decap_8
XFILLER_10_1859 VPWR VGND sg13cmos5l_fill_2
XANTENNA__0530__Q NPU_WDATA6 VPWR VGND sg13cmos5l_antennanp
XFILLER_8_1264 VPWR VGND sg13cmos5l_decap_8
XFILLER_4_1106 VPWR VGND sg13cmos5l_decap_8
XANTENNA__0756__X Tile_X1Y0_S2BEG[5] VPWR VGND sg13cmos5l_antennanp
XFILLER_15_700 VPWR VGND sg13cmos5l_decap_4
XANTENNA__1257__A0 Tile_X3Y0_N1END[2] VPWR VGND sg13cmos5l_antennanp
XFILLER_15_744 VPWR VGND sg13cmos5l_decap_8
XFILLER_15_722 VPWR VGND sg13cmos5l_decap_8
XFILLER_14_221 VPWR VGND sg13cmos5l_decap_8
XFILLER_14_243 VPWR VGND sg13cmos5l_fill_2
XANTENNA__0354__D Tile_X0Y0_FrameData[23] VPWR VGND sg13cmos5l_antennanp
XFILLER_15_2449 VPWR VGND sg13cmos5l_decap_8
XFILLER_14_276 VPWR VGND sg13cmos5l_decap_8
XANTENNA__0932__A Tile_X3Y0_FrameStrobe[17] VPWR VGND sg13cmos5l_antennanp
XFILLER_15_1759 VPWR VGND sg13cmos5l_decap_8
X_0680_ _0680_/L_HI VPWR VGND sg13cmos5l_tiehi
XFILLER_7_998 VPWR VGND sg13cmos5l_decap_4
XFILLER_13_1494 VPWR VGND sg13cmos5l_fill_2
X_1232_ _1232_/X Tile_X2Y0_N2MID[5] Tile_X2Y0_N4END[2] Tile_X2Y0_NN4END[13] _0581_/Q
+ _0367_/Q _0366_/Q VPWR VGND sg13cmos5l_mux4_1
XFILLER_6_1938 VPWR VGND sg13cmos5l_fill_2
XFILLER_0_2216 VPWR VGND sg13cmos5l_fill_2
X_1163_ _1163_/X Tile_X0Y0_N2END[0] Tile_X0Y0_N4END[8] Tile_X0Y0_NN4END[7] _0599_/Q
+ _0137_/Q _0136_/Q VPWR VGND sg13cmos5l_mux4_1
X_0114_ _0114_/Q Tile_X0Y0_FrameData[7] VGND VPWR Tile_X0Y0_FrameStrobe[0] latch
X_1094_ _1094_/X Tile_X3Y0_N1END[2] Tile_X3Y0_N2MID[1] Tile_X3Y0_N2MID[6] Tile_X3Y0_N2END[1]
+ _0413_/Q _0412_/Q VPWR VGND sg13cmos5l_mux4_1
XFILLER_4_1684 VPWR VGND sg13cmos5l_decap_8
XANTENNA__1248__A0 Tile_X2Y0_N2END[5] VPWR VGND sg13cmos5l_antennanp
XANTENNA__0264__D Tile_X0Y0_FrameData[1] VPWR VGND sg13cmos5l_antennanp
XANTENNA__0842__A Tile_X0Y0_FrameData[31] VPWR VGND sg13cmos5l_antennanp
XFILLER_14_1214 VPWR VGND sg13cmos5l_decap_8
X_0947_ Tile_X2Y0_FrameStrobe_O[12] Tile_X2Y0_FrameStrobe[12] VPWR VGND sg13cmos5l_buf_1
X_0878_ Tile_X2Y0_S2BEGb[3] _1214_/X VPWR VGND sg13cmos5l_buf_1
XFILLER_9_2263 VPWR VGND sg13cmos5l_decap_8
XFILLER_5_2127 VPWR VGND sg13cmos5l_fill_1
XFILLER_5_2116 VPWR VGND sg13cmos5l_decap_8
XFILLER_9_1573 VPWR VGND sg13cmos5l_decap_8
XANTENNA__0439__D Tile_X0Y0_FrameData[2] VPWR VGND sg13cmos5l_antennanp
XANTENNA__1239__A0 Tile_X2Y0_N2END[4] VPWR VGND sg13cmos5l_antennanp
XFILLER_0_2783 VPWR VGND sg13cmos5l_fill_1
XFILLER_16_2725 VPWR VGND sg13cmos5l_decap_8
XANTENNA__0174__D Tile_X0Y0_FrameData[11] VPWR VGND sg13cmos5l_antennanp
XANTENNA__0525__Q NPU_WDATA1 VPWR VGND sg13cmos5l_antennanp
XFILLER_16_2747 VPWR VGND sg13cmos5l_decap_8
XANTENNA__0752__A Tile_X1Y0_N2MID[6] VPWR VGND sg13cmos5l_antennanp
XFILLER_12_758 VPWR VGND sg13cmos5l_fill_2
XFILLER_7_206 VPWR VGND sg13cmos5l_decap_8
XFILLER_10_2335 VPWR VGND sg13cmos5l_decap_8
XFILLER_14_2493 VPWR VGND sg13cmos5l_decap_8
XFILLER_10_1634 VPWR VGND sg13cmos5l_decap_8
XFILLER_14_1781 VPWR VGND sg13cmos5l_decap_8
XFILLER_3_467 VPWR VGND sg13cmos5l_decap_8
XANTENNA__1190__A2 Tile_X1Y0_NN4END[11] VPWR VGND sg13cmos5l_antennanp
XANTENNA__0349__D Tile_X0Y0_FrameData[28] VPWR VGND sg13cmos5l_antennanp
XFILLER_8_1094 VPWR VGND sg13cmos5l_decap_8
XANTENNA__0483__GATE Tile_X3Y0_FrameStrobe[2] VPWR VGND sg13cmos5l_antennanp
XANTENNA__0927__A Tile_X3Y0_FrameStrobe[12] VPWR VGND sg13cmos5l_antennanp
XFILLER_5_2683 VPWR VGND sg13cmos5l_decap_8
XFILLER_1_2547 VPWR VGND sg13cmos5l_fill_1
XFILLER_15_563 VPWR VGND sg13cmos5l_decap_8
XANTENNA__0498__GATE Tile_X3Y0_FrameStrobe[2] VPWR VGND sg13cmos5l_antennanp
XFILLER_15_2224 VPWR VGND sg13cmos5l_decap_8
XFILLER_15_1501 VPWR VGND sg13cmos5l_decap_8
X_0801_ Tile_X3Y0_SS4BEG[6] _1281_/X VPWR VGND sg13cmos5l_buf_1
XANTENNA__0421__GATE Tile_X3Y0_FrameStrobe[0] VPWR VGND sg13cmos5l_antennanp
X_0732_ Tile_X1Y0_SS4BEG[1] _1196_/X VPWR VGND sg13cmos5l_buf_1
XFILLER_6_250 VPWR VGND sg13cmos5l_fill_1
XFILLER_13_1280 VPWR VGND sg13cmos5l_decap_8
XFILLER_10_290 VPWR VGND sg13cmos5l_decap_8
X_0663_ _0663_/L_HI VPWR VGND sg13cmos5l_tiehi
XFILLER_6_294 VPWR VGND sg13cmos5l_decap_8
XANTENNA__0436__GATE Tile_X3Y0_FrameStrobe[0] VPWR VGND sg13cmos5l_antennanp
X_0594_ _0594_/Q Tile_X0Y0_UserCLK NPU_RDATA22 _0610_/L_HI VPWR VGND sg13cmos5l_dfrbpq_1
XANTENNA__1181__A2 Tile_X1Y0_NN4END[2] VPWR VGND sg13cmos5l_antennanp
XANTENNA__0259__D Tile_X0Y0_FrameData[6] VPWR VGND sg13cmos5l_antennanp
XFILLER_6_1746 VPWR VGND sg13cmos5l_decap_8
XANTENNA__0837__A Tile_X0Y0_FrameData[26] VPWR VGND sg13cmos5l_antennanp
X_1215_ _1215_/X Tile_X2Y0_N1END[0] Tile_X2Y0_N2MID[4] Tile_X2Y0_N2END[3] _0584_/Q
+ _0401_/Q _0400_/Q VPWR VGND sg13cmos5l_mux4_1
XFILLER_0_2057 VPWR VGND sg13cmos5l_decap_4
X_1146_ _1146_/X Tile_X0Y0_N2MID[7] Tile_X0Y0_N4END[8] Tile_X0Y0_NN4END[7] _0601_/Q
+ _0171_/Q _0170_/Q VPWR VGND sg13cmos5l_mux4_1
XFILLER_4_1470 VPWR VGND sg13cmos5l_decap_4
X_1077_ Tile_X4Y0_SS4BEG[14] Tile_X4Y0_NN4END[1] VPWR VGND sg13cmos5l_buf_1
XANTENNA__1020__X Tile_X0Y0_S2BEG[5] VPWR VGND sg13cmos5l_antennanp
XFILLER_11_2611 VPWR VGND sg13cmos5l_decap_8
XFILLER_14_1088 VPWR VGND sg13cmos5l_decap_8
XFILLER_14_1077 VPWR VGND sg13cmos5l_fill_1
XFILLER_11_2688 VPWR VGND sg13cmos5l_decap_8
XANTENNA__1172__A2 Tile_X1Y0_N2END[6] VPWR VGND sg13cmos5l_antennanp
XFILLER_9_1392 VPWR VGND sg13cmos5l_fill_1
XANTENNA__0169__D Tile_X0Y0_FrameData[16] VPWR VGND sg13cmos5l_antennanp
XANTENNA__0747__A Tile_X1Y0_N1END[3] VPWR VGND sg13cmos5l_antennanp
XFILLER_16_349 VPWR VGND sg13cmos5l_fill_2
XFILLER_16_2500 VPWR VGND sg13cmos5l_decap_8
XFILLER_12_511 VPWR VGND sg13cmos5l_decap_4
XFILLER_12_555 VPWR VGND sg13cmos5l_decap_8
XFILLER_8_537 VPWR VGND sg13cmos5l_decap_8
XFILLER_16_1843 VPWR VGND sg13cmos5l_fill_2
XFILLER_16_1898 VPWR VGND sg13cmos5l_decap_4
XFILLER_12_1707 VPWR VGND sg13cmos5l_decap_8
XANTENNA_9 Tile_X0Y0_FrameData[15] VPWR VGND sg13cmos5l_antennanp
XFILLER_10_1475 VPWR VGND sg13cmos5l_decap_4
XFILLER_7_2701 VPWR VGND sg13cmos5l_decap_8
XANTENNA__1163__A2 Tile_X0Y0_NN4END[7] VPWR VGND sg13cmos5l_antennanp
XFILLER_0_960 VPWR VGND sg13cmos5l_fill_2
XFILLER_7_2789 VPWR VGND sg13cmos5l_fill_2
XFILLER_7_2778 VPWR VGND sg13cmos5l_decap_8
XFILLER_5_2480 VPWR VGND sg13cmos5l_decap_8
X_1000_ Tile_X0Y0_S4BEG[9] _1148_/X VPWR VGND sg13cmos5l_buf_1
XFILLER_1_2388 VPWR VGND sg13cmos5l_fill_1
XFILLER_1_2377 VPWR VGND sg13cmos5l_decap_8
XFILLER_1_1632 VPWR VGND sg13cmos5l_decap_8
XANTENNA__0944__X Tile_X2Y0_FrameStrobe_O[9] VPWR VGND sg13cmos5l_antennanp
XFILLER_1_2399 VPWR VGND sg13cmos5l_fill_2
XFILLER_16_850 VPWR VGND sg13cmos5l_decap_8
XANTENNA__0360__GATE Tile_X2Y0_FrameStrobe[1] VPWR VGND sg13cmos5l_antennanp
XFILLER_15_1331 VPWR VGND sg13cmos5l_decap_8
XFILLER_15_2087 VPWR VGND sg13cmos5l_fill_1
XFILLER_15_1375 VPWR VGND sg13cmos5l_decap_8
XFILLER_11_1217 VPWR VGND sg13cmos5l_decap_8
X_0715_ Tile_X1Y0_S4BEG[0] _1179_/X VPWR VGND sg13cmos5l_buf_1
XANTENNA__0375__GATE Tile_X2Y0_FrameStrobe[1] VPWR VGND sg13cmos5l_antennanp
X_0646_ _0646_/L_HI VPWR VGND sg13cmos5l_tiehi
XANTENNA__1154__A2 Tile_X0Y0_NN4END[15] VPWR VGND sg13cmos5l_antennanp
X_0577_ _0577_/Q Tile_X0Y0_UserCLK NPU_RDATA5 _0644_/L_HI VPWR VGND sg13cmos5l_dfrbpq_1
XFILLER_6_2244 VPWR VGND sg13cmos5l_decap_8
XFILLER_6_1510 VPWR VGND sg13cmos5l_decap_8
XANTENNA__1015__X Tile_X0Y0_S2BEG[0] VPWR VGND sg13cmos5l_antennanp
XANTENNA__0313__GATE Tile_X1Y0_FrameStrobe[3] VPWR VGND sg13cmos5l_antennanp
XANTENNA__0854__X Tile_X4Y0_FrameStrobe_O[11] VPWR VGND sg13cmos5l_antennanp
X_1129_ _1129_/X Tile_X4Y0_N1END[1] Tile_X4Y0_N2MID[1] Tile_X4Y0_N2MID[6] Tile_X4Y0_N2END[6]
+ _0509_/Q _0508_/Q VPWR VGND sg13cmos5l_mux4_1
XFILLER_16_1117 VPWR VGND sg13cmos5l_decap_8
XANTENNA__0328__GATE Tile_X2Y0_FrameStrobe[0] VPWR VGND sg13cmos5l_antennanp
XANTENNA__1090__A1 Tile_X3Y0_N2MID[2] VPWR VGND sg13cmos5l_antennanp
XFILLER_13_2728 VPWR VGND sg13cmos5l_decap_8
XANTENNA__0452__D Tile_X0Y0_FrameData[21] VPWR VGND sg13cmos5l_antennanp
XFILLER_5_518 VPWR VGND sg13cmos5l_decap_8
XFILLER_11_2496 VPWR VGND sg13cmos5l_decap_8
XFILLER_11_1762 VPWR VGND sg13cmos5l_decap_8
XANTENNA__1145__A2 Tile_X0Y0_NN4END[6] VPWR VGND sg13cmos5l_antennanp
XFILLER_0_234 VPWR VGND sg13cmos5l_fill_2
XFILLER_0_278 VPWR VGND sg13cmos5l_fill_1
XFILLER_1_779 VPWR VGND sg13cmos5l_decap_8
XFILLER_5_1097 VPWR VGND sg13cmos5l_decap_8
XFILLER_16_102 VPWR VGND sg13cmos5l_fill_2
XANTENNA__0764__X Tile_X3Y0_S2BEG[1] VPWR VGND sg13cmos5l_antennanp
XFILLER_2_1963 VPWR VGND sg13cmos5l_decap_4
XFILLER_16_135 VPWR VGND sg13cmos5l_decap_8
XFILLER_16_2341 VPWR VGND sg13cmos5l_fill_2
XFILLER_8_301 VPWR VGND sg13cmos5l_decap_8
XFILLER_16_2374 VPWR VGND sg13cmos5l_decap_8
XFILLER_13_864 VPWR VGND sg13cmos5l_fill_1
XANTENNA__0362__D Tile_X0Y0_FrameData[15] VPWR VGND sg13cmos5l_antennanp
XANTENNA__1081__A1 Tile_X2Y0_N2MID[1] VPWR VGND sg13cmos5l_antennanp
XFILLER_8_323 VPWR VGND sg13cmos5l_fill_1
XFILLER_12_2249 VPWR VGND sg13cmos5l_decap_8
XFILLER_12_1504 VPWR VGND sg13cmos5l_decap_8
XANTENNA__0940__A Tile_X2Y0_FrameStrobe[5] VPWR VGND sg13cmos5l_antennanp
X_0500_ _0500_/Q Tile_X0Y0_FrameData[5] VGND VPWR Tile_X3Y0_FrameStrobe[2] latch
XFILLER_4_573 VPWR VGND sg13cmos5l_decap_8
XANTENNA__0939__X Tile_X2Y0_FrameStrobe_O[4] VPWR VGND sg13cmos5l_antennanp
X_0431_ _0431_/Q Tile_X0Y0_FrameData[10] VGND VPWR Tile_X3Y0_FrameStrobe[0] latch
XFILLER_7_2542 VPWR VGND sg13cmos5l_fill_2
XANTENNA__1136__A2 Tile_X0Y0_N2END[2] VPWR VGND sg13cmos5l_antennanp
X_0362_ _0362_/Q Tile_X0Y0_FrameData[15] VGND VPWR Tile_X2Y0_FrameStrobe[1] latch
XANTENNA__0543__CLK Tile_X0Y0_UserCLK VPWR VGND sg13cmos5l_antennanp
XFILLER_7_1863 VPWR VGND sg13cmos5l_fill_1
X_0293_ _0293_/Q Tile_X0Y0_FrameData[4] VGND VPWR Tile_X1Y0_FrameStrobe[2] latch
XFILLER_1_2174 VPWR VGND sg13cmos5l_decap_8
XANTENNA__0272__D Tile_X0Y0_FrameData[25] VPWR VGND sg13cmos5l_antennanp
XANTENNA__0850__A Tile_X4Y0_FrameStrobe[7] VPWR VGND sg13cmos5l_antennanp
XFILLER_12_2750 VPWR VGND sg13cmos5l_decap_8
XFILLER_7_81 VPWR VGND sg13cmos5l_fill_2
XANTENNA__0849__X Tile_X4Y0_FrameStrobe_O[6] VPWR VGND sg13cmos5l_antennanp
X_0629_ _0629_/L_HI VPWR VGND sg13cmos5l_tiehi
XFILLER_8_1605 VPWR VGND sg13cmos5l_decap_8
XANTENNA__1127__A2 Tile_X0Y0_NN4END[13] VPWR VGND sg13cmos5l_antennanp
XANTENNA__0252__GATE Tile_X1Y0_FrameStrobe[1] VPWR VGND sg13cmos5l_antennanp
XFILLER_2_1204 VPWR VGND sg13cmos5l_decap_4
XANTENNA__0447__D Tile_X0Y0_FrameData[26] VPWR VGND sg13cmos5l_antennanp
XANTENNA__0267__GATE Tile_X1Y0_FrameStrobe[2] VPWR VGND sg13cmos5l_antennanp
XANTENNA__0533__Q NPU_WDATA9 VPWR VGND sg13cmos5l_antennanp
XFILLER_13_2525 VPWR VGND sg13cmos5l_decap_8
XANTENNA__0182__D Tile_X0Y0_FrameData[3] VPWR VGND sg13cmos5l_antennanp
XANTENNA__0760__A Tile_X3Y0_N1END[2] VPWR VGND sg13cmos5l_antennanp
XFILLER_13_1835 VPWR VGND sg13cmos5l_decap_8
XFILLER_5_326 VPWR VGND sg13cmos5l_fill_1
XFILLER_11_2293 VPWR VGND sg13cmos5l_decap_8
XANTENNA__0205__GATE Tile_X1Y0_FrameStrobe[0] VPWR VGND sg13cmos5l_antennanp
XANTENNA__0566__CLK Tile_X0Y0_UserCLK VPWR VGND sg13cmos5l_antennanp
XANTENNA__0759__X Tile_X3Y0_S1BEG[0] VPWR VGND sg13cmos5l_antennanp
XANTENNA__1118__A2 Tile_X0Y0_NN4END[4] VPWR VGND sg13cmos5l_antennanp
XFILLER_1_554 VPWR VGND sg13cmos5l_decap_8
XFILLER_4_2748 VPWR VGND sg13cmos5l_decap_8
XFILLER_2_2472 VPWR VGND sg13cmos5l_decap_8
XANTENNA__0357__D Tile_X0Y0_FrameData[20] VPWR VGND sg13cmos5l_antennanp
XANTENNA__0935__A Tile_X2Y0_FrameStrobe[0] VPWR VGND sg13cmos5l_antennanp
X_0980_ Tile_X0Y0_SS4BEG[5] _1160_/X VPWR VGND sg13cmos5l_buf_1
XANTENNA__0092__D Tile_X0Y0_FrameData[29] VPWR VGND sg13cmos5l_antennanp
XFILLER_9_676 VPWR VGND sg13cmos5l_decap_8
XFILLER_16_1481 VPWR VGND sg13cmos5l_decap_8
XFILLER_12_2046 VPWR VGND sg13cmos5l_decap_8
XFILLER_12_182 VPWR VGND sg13cmos5l_decap_8
XFILLER_12_1301 VPWR VGND sg13cmos5l_decap_8
XFILLER_12_1367 VPWR VGND sg13cmos5l_decap_8
XFILLER_9_2648 VPWR VGND sg13cmos5l_decap_8
XANTENNA__1109__A2 Tile_X1Y0_NN4END[13] VPWR VGND sg13cmos5l_antennanp
X_0414_ _0414_/Q Tile_X0Y0_FrameData[27] VGND VPWR Tile_X3Y0_FrameStrobe[0] latch
XFILLER_7_2350 VPWR VGND sg13cmos5l_decap_8
X_0345_ _0345_/Q Tile_X0Y0_FrameData[0] VGND VPWR Tile_X2Y0_FrameStrobe[0] latch
XFILLER_3_2258 VPWR VGND sg13cmos5l_decap_8
X_0276_ _0276_/Q Tile_X0Y0_FrameData[21] VGND VPWR Tile_X1Y0_FrameStrobe[2] latch
XFILLER_3_1535 VPWR VGND sg13cmos5l_fill_1
XANTENNA__0267__D Tile_X0Y0_FrameData[30] VPWR VGND sg13cmos5l_antennanp
XANTENNA__0845__A Tile_X4Y0_FrameStrobe[2] VPWR VGND sg13cmos5l_antennanp
XFILLER_10_2709 VPWR VGND sg13cmos5l_decap_8
XANTENNA__0589__CLK Tile_X0Y0_UserCLK VPWR VGND sg13cmos5l_antennanp
XFILLER_2_318 VPWR VGND sg13cmos5l_decap_8
XFILLER_8_2136 VPWR VGND sg13cmos5l_fill_2
XANTENNA__0191__GATE Tile_X0Y0_FrameStrobe[3] VPWR VGND sg13cmos5l_antennanp
XANTENNA__0177__D Tile_X0Y0_FrameData[8] VPWR VGND sg13cmos5l_antennanp
XANTENNA__0528__Q NPU_WDATA4 VPWR VGND sg13cmos5l_antennanp
XANTENNA__0755__A Tile_X1Y0_N2MID[3] VPWR VGND sg13cmos5l_antennanp
XFILLER_2_1078 VPWR VGND sg13cmos5l_decap_8
XANTENNA__1284__A1 Tile_X3Y0_N4END[9] VPWR VGND sg13cmos5l_antennanp
XFILLER_15_2609 VPWR VGND sg13cmos5l_decap_8
XFILLER_15_1908 VPWR VGND sg13cmos5l_decap_8
XFILLER_13_2322 VPWR VGND sg13cmos5l_decap_8
XFILLER_6_635 VPWR VGND sg13cmos5l_fill_1
XFILLER_13_2399 VPWR VGND sg13cmos5l_decap_8
XFILLER_13_1643 VPWR VGND sg13cmos5l_decap_8
XFILLER_10_675 VPWR VGND sg13cmos5l_decap_8
XANTENNA__0144__GATE Tile_X0Y0_FrameStrobe[1] VPWR VGND sg13cmos5l_antennanp
XANTENNA__0159__GATE Tile_X0Y0_FrameStrobe[2] VPWR VGND sg13cmos5l_antennanp
XFILLER_8_2670 VPWR VGND sg13cmos5l_decap_8
XFILLER_4_2556 VPWR VGND sg13cmos5l_decap_8
X_0130_ _0130_/Q Tile_X0Y0_FrameData[23] VGND VPWR Tile_X0Y0_FrameStrobe[1] latch
XFILLER_4_1833 VPWR VGND sg13cmos5l_fill_1
XFILLER_4_1888 VPWR VGND sg13cmos5l_decap_4
XFILLER_2_2291 VPWR VGND sg13cmos5l_fill_2
XANTENNA__1275__A1 Tile_X3Y0_N4END[0] VPWR VGND sg13cmos5l_antennanp
XANTENNA__0952__X Tile_X2Y0_FrameStrobe_O[17] VPWR VGND sg13cmos5l_antennanp
X_0963_ Tile_X1Y0_FrameStrobe_O[8] Tile_X1Y0_FrameStrobe[8] VPWR VGND sg13cmos5l_buf_1
X_0894_ Tile_X2Y0_S4BEG[11] _1230_/X VPWR VGND sg13cmos5l_buf_1
XFILLER_12_1175 VPWR VGND sg13cmos5l_decap_8
XFILLER_9_1700 VPWR VGND sg13cmos5l_decap_4
XFILLER_9_1711 VPWR VGND sg13cmos5l_fill_2
XFILLER_9_2445 VPWR VGND sg13cmos5l_decap_8
XFILLER_4_60 VPWR VGND sg13cmos5l_fill_2
X_0328_ _0328_/Q Tile_X0Y0_FrameData[17] VGND VPWR Tile_X2Y0_FrameStrobe[0] latch
XANTENNA__1023__X Tile_X0Y0_S1BEG[0] VPWR VGND sg13cmos5l_antennanp
X_0259_ _0259_/Q Tile_X0Y0_FrameData[6] VGND VPWR Tile_X1Y0_FrameStrobe[1] latch
XFILLER_3_1398 VPWR VGND sg13cmos5l_fill_1
XANTENNA__1266__A1 Tile_X3Y0_N4END[8] VPWR VGND sg13cmos5l_antennanp
XANTENNA__0862__X Tile_X4Y0_FrameStrobe_O[19] VPWR VGND sg13cmos5l_antennanp
XFILLER_10_2517 VPWR VGND sg13cmos5l_decap_8
XFILLER_14_2675 VPWR VGND sg13cmos5l_decap_8
XFILLER_14_1941 VPWR VGND sg13cmos5l_decap_8
XFILLER_10_1827 VPWR VGND sg13cmos5l_decap_8
XANTENNA__0460__D Tile_X0Y0_FrameData[13] VPWR VGND sg13cmos5l_antennanp
XFILLER_3_649 VPWR VGND sg13cmos5l_decap_8
XFILLER_8_1243 VPWR VGND sg13cmos5l_decap_8
XANTENNA__1257__A1 Tile_X3Y0_N2MID[6] VPWR VGND sg13cmos5l_antennanp
XFILLER_14_200 VPWR VGND sg13cmos5l_decap_8
XANTENNA__0772__X Tile_X3Y0_S2BEGb[1] VPWR VGND sg13cmos5l_antennanp
XFILLER_15_2428 VPWR VGND sg13cmos5l_decap_8
XFILLER_15_1738 VPWR VGND sg13cmos5l_decap_8
XFILLER_13_2196 VPWR VGND sg13cmos5l_decap_8
XFILLER_10_472 VPWR VGND sg13cmos5l_fill_1
XANTENNA__0370__D Tile_X0Y0_FrameData[7] VPWR VGND sg13cmos5l_antennanp
XFILLER_13_1473 VPWR VGND sg13cmos5l_decap_4
XANTENNA__0098__GATE Tile_X0Y0_FrameStrobe[0] VPWR VGND sg13cmos5l_antennanp
XANTENNA__1193__A0 Tile_X1Y0_N2MID[6] VPWR VGND sg13cmos5l_antennanp
XANTENNA__0947__X Tile_X2Y0_FrameStrobe_O[12] VPWR VGND sg13cmos5l_antennanp
X_1231_ _1231_/X Tile_X2Y0_N2MID[4] Tile_X2Y0_N4END[3] Tile_X2Y0_NN4END[12] _0580_/Q
+ _0369_/Q _0368_/Q VPWR VGND sg13cmos5l_mux4_1
XFILLER_6_1917 VPWR VGND sg13cmos5l_decap_8
XFILLER_4_2353 VPWR VGND sg13cmos5l_fill_1
X_1162_ _1162_/X Tile_X0Y0_N2END[7] Tile_X0Y0_N4END[7] Tile_X0Y0_NN4END[8] _0600_/Q
+ _0139_/Q _0138_/Q VPWR VGND sg13cmos5l_mux4_1
XFILLER_4_1663 VPWR VGND sg13cmos5l_decap_8
X_0113_ _0113_/Q Tile_X0Y0_FrameData[8] VGND VPWR Tile_X0Y0_FrameStrobe[0] latch
X_1093_ _1093_/X Tile_X3Y0_N1END[1] Tile_X3Y0_N2MID[2] Tile_X3Y0_N2MID[5] Tile_X3Y0_N2END[2]
+ _0415_/Q _0414_/Q VPWR VGND sg13cmos5l_mux4_1
XANTENNA__1248__A1 Tile_X2Y0_N4END[13] VPWR VGND sg13cmos5l_antennanp
X_0946_ Tile_X2Y0_FrameStrobe_O[11] Tile_X2Y0_FrameStrobe[11] VPWR VGND sg13cmos5l_buf_1
XFILLER_9_281 VPWR VGND sg13cmos5l_fill_1
XANTENNA__0280__D Tile_X0Y0_FrameData[17] VPWR VGND sg13cmos5l_antennanp
X_0877_ Tile_X2Y0_S2BEGb[2] _1213_/X VPWR VGND sg13cmos5l_buf_1
XANTENNA__1018__X Tile_X0Y0_S2BEG[3] VPWR VGND sg13cmos5l_antennanp
XANTENNA__1184__A0 Tile_X1Y0_N2MID[5] VPWR VGND sg13cmos5l_antennanp
XFILLER_9_2242 VPWR VGND sg13cmos5l_decap_8
XANTENNA__0857__X Tile_X4Y0_FrameStrobe_O[14] VPWR VGND sg13cmos5l_antennanp
XFILLER_9_1552 VPWR VGND sg13cmos5l_decap_8
XFILLER_5_2139 VPWR VGND sg13cmos5l_decap_8
XFILLER_5_1427 VPWR VGND sg13cmos5l_fill_2
XFILLER_0_2740 VPWR VGND sg13cmos5l_fill_1
XANTENNA__1239__A1 Tile_X2Y0_N4END[4] VPWR VGND sg13cmos5l_antennanp
XFILLER_3_1195 VPWR VGND sg13cmos5l_decap_8
XANTENNA__0455__D Tile_X0Y0_FrameData[18] VPWR VGND sg13cmos5l_antennanp
XFILLER_16_2704 VPWR VGND sg13cmos5l_decap_8
XFILLER_12_737 VPWR VGND sg13cmos5l_decap_8
XFILLER_14_2472 VPWR VGND sg13cmos5l_decap_8
XFILLER_10_2314 VPWR VGND sg13cmos5l_decap_8
XFILLER_14_1760 VPWR VGND sg13cmos5l_decap_8
XANTENNA__0190__D Tile_X0Y0_FrameData[27] VPWR VGND sg13cmos5l_antennanp
XANTENNA__0541__Q NPU_WDATA17 VPWR VGND sg13cmos5l_antennanp
XFILLER_10_1613 VPWR VGND sg13cmos5l_decap_8
XFILLER_4_903 VPWR VGND sg13cmos5l_fill_2
XFILLER_4_958 VPWR VGND sg13cmos5l_fill_2
XANTENNA__1175__A0 Tile_X1Y0_N1END[0] VPWR VGND sg13cmos5l_antennanp
XANTENNA__0767__X Tile_X3Y0_S2BEG[4] VPWR VGND sg13cmos5l_antennanp
XFILLER_8_1073 VPWR VGND sg13cmos5l_decap_8
XFILLER_5_2662 VPWR VGND sg13cmos5l_decap_8
XFILLER_1_2504 VPWR VGND sg13cmos5l_fill_1
XANTENNA__0365__D Tile_X0Y0_FrameData[12] VPWR VGND sg13cmos5l_antennanp
XANTENNA__0943__A Tile_X2Y0_FrameStrobe[8] VPWR VGND sg13cmos5l_antennanp
XFILLER_15_542 VPWR VGND sg13cmos5l_decap_8
X_0800_ Tile_X3Y0_SS4BEG[5] _1280_/X VPWR VGND sg13cmos5l_buf_1
XFILLER_15_1557 VPWR VGND sg13cmos5l_decap_8
X_0731_ Tile_X1Y0_SS4BEG[0] _1195_/X VPWR VGND sg13cmos5l_buf_1
XFILLER_15_1579 VPWR VGND sg13cmos5l_decap_8
XFILLER_7_763 VPWR VGND sg13cmos5l_decap_8
XFILLER_6_240 VPWR VGND sg13cmos5l_decap_4
X_0662_ _0662_/L_HI VPWR VGND sg13cmos5l_tiehi
XANTENNA__1166__A0 Tile_X0Y0_N2END[3] VPWR VGND sg13cmos5l_antennanp
X_0593_ _0593_/Q Tile_X0Y0_UserCLK NPU_RDATA21 _0609_/L_HI VPWR VGND sg13cmos5l_dfrbpq_1
XFILLER_6_2448 VPWR VGND sg13cmos5l_decap_8
X_1214_ _1214_/X Tile_X2Y0_N1END[3] Tile_X2Y0_N2MID[3] Tile_X2Y0_N2END[4] _0583_/Q
+ _0403_/Q _0402_/Q VPWR VGND sg13cmos5l_mux4_1
X_1145_ _1145_/X Tile_X0Y0_N2MID[6] Tile_X0Y0_N4END[9] Tile_X0Y0_NN4END[6] _0600_/Q
+ _0173_/Q _0172_/Q VPWR VGND sg13cmos5l_mux4_1
XFILLER_1_61 VPWR VGND sg13cmos5l_fill_1
XFILLER_1_94 VPWR VGND sg13cmos5l_fill_2
XANTENNA__0275__D Tile_X0Y0_FrameData[22] VPWR VGND sg13cmos5l_antennanp
X_1076_ Tile_X4Y0_SS4BEG[13] Tile_X4Y0_NN4END[2] VPWR VGND sg13cmos5l_buf_1
XANTENNA__0853__A Tile_X4Y0_FrameStrobe[10] VPWR VGND sg13cmos5l_antennanp
XFILLER_15_2781 VPWR VGND sg13cmos5l_fill_1
XFILLER_14_1045 VPWR VGND sg13cmos5l_fill_1
X_0929_ Tile_X3Y0_FrameStrobe_O[14] Tile_X3Y0_FrameStrobe[14] VPWR VGND sg13cmos5l_buf_1
XFILLER_14_1067 VPWR VGND sg13cmos5l_decap_4
XFILLER_11_2667 VPWR VGND sg13cmos5l_decap_8
XFILLER_11_1944 VPWR VGND sg13cmos5l_decap_4
XANTENNA__1157__A0 Tile_X0Y0_N2END[2] VPWR VGND sg13cmos5l_antennanp
XFILLER_16_339 VPWR VGND sg13cmos5l_fill_2
XFILLER_16_328 VPWR VGND sg13cmos5l_decap_8
XANTENNA__0185__D Tile_X0Y0_FrameData[0] VPWR VGND sg13cmos5l_antennanp
XANTENNA__0536__Q NPU_WDATA12 VPWR VGND sg13cmos5l_antennanp
XANTENNA__0763__A Tile_X3Y0_N2MID[7] VPWR VGND sg13cmos5l_antennanp
XFILLER_16_2556 VPWR VGND sg13cmos5l_decap_8
XFILLER_16_1822 VPWR VGND sg13cmos5l_decap_8
XFILLER_12_534 VPWR VGND sg13cmos5l_decap_8
XFILLER_8_516 VPWR VGND sg13cmos5l_decap_8
XFILLER_16_1877 VPWR VGND sg13cmos5l_decap_8
XFILLER_10_1410 VPWR VGND sg13cmos5l_decap_8
XFILLER_10_2188 VPWR VGND sg13cmos5l_decap_8
XANTENNA__1148__A0 Tile_X0Y0_N2MID[1] VPWR VGND sg13cmos5l_antennanp
XFILLER_10_1454 VPWR VGND sg13cmos5l_decap_8
XFILLER_7_2757 VPWR VGND sg13cmos5l_decap_8
XANTENNA__0938__A Tile_X2Y0_FrameStrobe[3] VPWR VGND sg13cmos5l_antennanp
XFILLER_1_2312 VPWR VGND sg13cmos5l_decap_8
XFILLER_1_2356 VPWR VGND sg13cmos5l_decap_8
XFILLER_1_1611 VPWR VGND sg13cmos5l_decap_8
XFILLER_1_2367 VPWR VGND sg13cmos5l_fill_1
XANTENNA__0095__D Tile_X0Y0_FrameData[26] VPWR VGND sg13cmos5l_antennanp
XFILLER_1_1699 VPWR VGND sg13cmos5l_fill_1
XFILLER_1_1688 VPWR VGND sg13cmos5l_decap_8
XANTENNA__0960__X Tile_X1Y0_FrameStrobe_O[5] VPWR VGND sg13cmos5l_antennanp
XFILLER_15_2044 VPWR VGND sg13cmos5l_fill_2
XFILLER_15_1310 VPWR VGND sg13cmos5l_decap_8
X_0714_ Tile_X1Y0_S2BEGb[7] _1178_/X VPWR VGND sg13cmos5l_buf_1
XANTENNA__1139__A0 Tile_X0Y0_N2MID[0] VPWR VGND sg13cmos5l_antennanp
X_0645_ _0645_/L_HI VPWR VGND sg13cmos5l_tiehi
X_0576_ _0576_/Q Tile_X0Y0_UserCLK NPU_RDATA4 _0646_/L_HI VPWR VGND sg13cmos5l_dfrbpq_1
XFILLER_6_2223 VPWR VGND sg13cmos5l_decap_8
XANTENNA__0848__A Tile_X4Y0_FrameStrobe[5] VPWR VGND sg13cmos5l_antennanp
XFILLER_6_1599 VPWR VGND sg13cmos5l_fill_1
X_1128_ _1128_/X Tile_X4Y0_N1END[0] Tile_X4Y0_N2MID[0] Tile_X4Y0_N2MID[7] Tile_X4Y0_N2END[7]
+ _0511_/Q _0510_/Q VPWR VGND sg13cmos5l_mux4_1
XANTENNA__1031__X Tile_X4Y0_S2BEG[0] VPWR VGND sg13cmos5l_antennanp
X_1059_ Tile_X4Y0_S4BEG[12] Tile_X4Y0_N4END[3] VPWR VGND sg13cmos5l_buf_1
XFILLER_15_48 VPWR VGND sg13cmos5l_decap_8
XANTENNA__0870__X Tile_X2Y0_S2BEG[3] VPWR VGND sg13cmos5l_antennanp
XANTENNA__1090__A2 Tile_X3Y0_N2MID[5] VPWR VGND sg13cmos5l_antennanp
XANTENNA__0482__GATE Tile_X3Y0_FrameStrobe[2] VPWR VGND sg13cmos5l_antennanp
XFILLER_11_2475 VPWR VGND sg13cmos5l_decap_8
XFILLER_11_1741 VPWR VGND sg13cmos5l_decap_8
XANTENNA__0497__GATE Tile_X3Y0_FrameStrobe[2] VPWR VGND sg13cmos5l_antennanp
XANTENNA__0758__A Tile_X1Y0_N2MID[0] VPWR VGND sg13cmos5l_antennanp
XFILLER_0_268 VPWR VGND sg13cmos5l_fill_2
XFILLER_5_1032 VPWR VGND sg13cmos5l_fill_2
XFILLER_2_2621 VPWR VGND sg13cmos5l_decap_8
XANTENNA__0420__GATE Tile_X3Y0_FrameStrobe[0] VPWR VGND sg13cmos5l_antennanp
XFILLER_2_2643 VPWR VGND sg13cmos5l_fill_2
XFILLER_5_1076 VPWR VGND sg13cmos5l_decap_8
XFILLER_2_1942 VPWR VGND sg13cmos5l_decap_4
XFILLER_16_114 VPWR VGND sg13cmos5l_decap_8
XFILLER_2_2698 VPWR VGND sg13cmos5l_decap_8
XANTENNA__0435__GATE Tile_X3Y0_FrameStrobe[0] VPWR VGND sg13cmos5l_antennanp
XFILLER_16_2320 VPWR VGND sg13cmos5l_fill_1
XFILLER_13_843 VPWR VGND sg13cmos5l_fill_2
XANTENNA__0780__X Tile_X3Y0_S4BEG[1] VPWR VGND sg13cmos5l_antennanp
XFILLER_16_2353 VPWR VGND sg13cmos5l_decap_8
XFILLER_13_876 VPWR VGND sg13cmos5l_fill_1
XANTENNA__1081__A2 Tile_X2Y0_N2MID[6] VPWR VGND sg13cmos5l_antennanp
XFILLER_8_335 VPWR VGND sg13cmos5l_fill_1
XFILLER_12_2228 VPWR VGND sg13cmos5l_decap_8
XFILLER_16_1685 VPWR VGND sg13cmos5l_decap_8
XFILLER_4_552 VPWR VGND sg13cmos5l_decap_8
XFILLER_10_1295 VPWR VGND sg13cmos5l_decap_8
X_0430_ _0430_/Q Tile_X0Y0_FrameData[11] VGND VPWR Tile_X3Y0_FrameStrobe[0] latch
XFILLER_7_2521 VPWR VGND sg13cmos5l_decap_8
X_0361_ _0361_/Q Tile_X0Y0_FrameData[16] VGND VPWR Tile_X2Y0_FrameStrobe[1] latch
XFILLER_3_2407 VPWR VGND sg13cmos5l_decap_8
XFILLER_3_2429 VPWR VGND sg13cmos5l_decap_8
XANTENNA__0955__X Tile_X1Y0_FrameStrobe_O[0] VPWR VGND sg13cmos5l_antennanp
X_0292_ _0292_/Q Tile_X0Y0_FrameData[5] VGND VPWR Tile_X1Y0_FrameStrobe[2] latch
XFILLER_1_2120 VPWR VGND sg13cmos5l_fill_2
XFILLER_1_1496 VPWR VGND sg13cmos5l_decap_8
XFILLER_1_1463 VPWR VGND sg13cmos5l_decap_4
XFILLER_16_692 VPWR VGND sg13cmos5l_fill_1
XANTENNA__0690__X Tile_X0Y0_FrameStrobe_O[3] VPWR VGND sg13cmos5l_antennanp
XFILLER_11_1004 VPWR VGND sg13cmos5l_fill_1
XFILLER_15_1195 VPWR VGND sg13cmos5l_decap_8
X_0628_ _0628_/L_HI VPWR VGND sg13cmos5l_tiehi
XANTENNA__1127__A3 Tile_X0Y0_NN4END[15] VPWR VGND sg13cmos5l_antennanp
X_0559_ NPU_WE3 Tile_X0Y0_UserCLK _0559_/D _0668_/L_HI VPWR VGND sg13cmos5l_dfrbpq_1
XANTENNA__1026__X Tile_X0Y0_S1BEG[3] VPWR VGND sg13cmos5l_antennanp
XFILLER_6_2097 VPWR VGND sg13cmos5l_decap_8
XANTENNA__0865__X Tile_X2Y0_S1BEG[2] VPWR VGND sg13cmos5l_antennanp
XFILLER_13_117 VPWR VGND sg13cmos5l_fill_2
XANTENNA__0463__D Tile_X0Y0_FrameData[10] VPWR VGND sg13cmos5l_antennanp
XFILLER_13_2504 VPWR VGND sg13cmos5l_decap_8
XFILLER_10_835 VPWR VGND sg13cmos5l_decap_8
XFILLER_6_806 VPWR VGND sg13cmos5l_decap_8
XFILLER_13_1814 VPWR VGND sg13cmos5l_decap_8
XFILLER_11_2272 VPWR VGND sg13cmos5l_decap_8
XFILLER_1_533 VPWR VGND sg13cmos5l_decap_8
XANTENNA__1118__A3 Tile_X0Y0_NN4END[6] VPWR VGND sg13cmos5l_antennanp
XFILLER_1_577 VPWR VGND sg13cmos5l_fill_1
XFILLER_7_1138 VPWR VGND sg13cmos5l_decap_8
XFILLER_4_2727 VPWR VGND sg13cmos5l_decap_8
XANTENNA__0775__X Tile_X3Y0_S2BEGb[4] VPWR VGND sg13cmos5l_antennanp
XFILLER_2_2451 VPWR VGND sg13cmos5l_decap_8
XANTENNA__0374__GATE Tile_X2Y0_FrameStrobe[1] VPWR VGND sg13cmos5l_antennanp
XANTENNA__0373__D Tile_X0Y0_FrameData[4] VPWR VGND sg13cmos5l_antennanp
XFILLER_16_91 VPWR VGND sg13cmos5l_decap_8
XFILLER_16_2150 VPWR VGND sg13cmos5l_fill_2
XANTENNA__0951__A Tile_X2Y0_FrameStrobe[16] VPWR VGND sg13cmos5l_antennanp
XFILLER_13_695 VPWR VGND sg13cmos5l_decap_8
XFILLER_12_161 VPWR VGND sg13cmos5l_decap_8
XFILLER_12_150 VPWR VGND sg13cmos5l_fill_1
XANTENNA__0389__GATE Tile_X2Y0_FrameStrobe[2] VPWR VGND sg13cmos5l_antennanp
XFILLER_9_655 VPWR VGND sg13cmos5l_decap_8
XFILLER_16_1460 VPWR VGND sg13cmos5l_decap_8
XFILLER_9_688 VPWR VGND sg13cmos5l_fill_2
XFILLER_9_699 VPWR VGND sg13cmos5l_fill_2
XANTENNA__0312__GATE Tile_X1Y0_FrameStrobe[3] VPWR VGND sg13cmos5l_antennanp
XFILLER_9_2627 VPWR VGND sg13cmos5l_decap_8
XANTENNA__1109__A3 Tile_X1Y0_NN4END[15] VPWR VGND sg13cmos5l_antennanp
X_0413_ _0413_/Q Tile_X0Y0_FrameData[28] VGND VPWR Tile_X3Y0_FrameStrobe[0] latch
XANTENNA__0327__GATE Tile_X2Y0_FrameStrobe[0] VPWR VGND sg13cmos5l_antennanp
X_0344_ _0344_/Q Tile_X0Y0_FrameData[1] VGND VPWR Tile_X2Y0_FrameStrobe[0] latch
XFILLER_3_2237 VPWR VGND sg13cmos5l_decap_8
XFILLER_3_1503 VPWR VGND sg13cmos5l_decap_8
X_0275_ _0275_/Q Tile_X0Y0_FrameData[22] VGND VPWR Tile_X1Y0_FrameStrobe[2] latch
XFILLER_3_1525 VPWR VGND sg13cmos5l_fill_2
XANTENNA__1022__A Tile_X0Y0_N2MID[0] VPWR VGND sg13cmos5l_antennanp
XANTENNA__0283__D Tile_X0Y0_FrameData[14] VPWR VGND sg13cmos5l_antennanp
XANTENNA__0861__A Tile_X4Y0_FrameStrobe[18] VPWR VGND sg13cmos5l_antennanp
XFILLER_8_2115 VPWR VGND sg13cmos5l_decap_8
XANTENNA__0458__D Tile_X0Y0_FrameData[15] VPWR VGND sg13cmos5l_antennanp
XFILLER_3_2771 VPWR VGND sg13cmos5l_decap_8
XFILLER_6_1193 VPWR VGND sg13cmos5l_decap_8
XFILLER_2_1057 VPWR VGND sg13cmos5l_decap_8
XANTENNA__1284__A2 Tile_X3Y0_NN4END[6] VPWR VGND sg13cmos5l_antennanp
XANTENNA__0193__D Tile_X0Y0_FrameData[24] VPWR VGND sg13cmos5l_antennanp
XANTENNA__0544__Q NPU_WDATA20 VPWR VGND sg13cmos5l_antennanp
XFILLER_13_2301 VPWR VGND sg13cmos5l_decap_8
XANTENNA__0533__CLK Tile_X0Y0_UserCLK VPWR VGND sg13cmos5l_antennanp
XFILLER_6_603 VPWR VGND sg13cmos5l_fill_1
XFILLER_10_654 VPWR VGND sg13cmos5l_decap_8
XFILLER_6_614 VPWR VGND sg13cmos5l_decap_8
XFILLER_13_2378 VPWR VGND sg13cmos5l_decap_8
XFILLER_13_1622 VPWR VGND sg13cmos5l_decap_8
XFILLER_13_1699 VPWR VGND sg13cmos5l_decap_8
XFILLER_11_2091 VPWR VGND sg13cmos5l_fill_1
XFILLER_2_842 VPWR VGND sg13cmos5l_decap_8
XFILLER_2_864 VPWR VGND sg13cmos5l_decap_8
XFILLER_2_853 VPWR VGND sg13cmos5l_fill_1
XFILLER_1_341 VPWR VGND sg13cmos5l_decap_4
XFILLER_4_2502 VPWR VGND sg13cmos5l_fill_1
XFILLER_1_385 VPWR VGND sg13cmos5l_decap_4
XFILLER_8_1970 VPWR VGND sg13cmos5l_decap_8
XFILLER_4_2535 VPWR VGND sg13cmos5l_decap_8
XANTENNA__0368__D Tile_X0Y0_FrameData[9] VPWR VGND sg13cmos5l_antennanp
XANTENNA__0946__A Tile_X2Y0_FrameStrobe[11] VPWR VGND sg13cmos5l_antennanp
XFILLER_2_2270 VPWR VGND sg13cmos5l_decap_8
XANTENNA__1275__A2 Tile_X3Y0_NN4END[15] VPWR VGND sg13cmos5l_antennanp
XFILLER_2_1591 VPWR VGND sg13cmos5l_fill_1
X_0962_ Tile_X1Y0_FrameStrobe_O[7] Tile_X1Y0_FrameStrobe[7] VPWR VGND sg13cmos5l_buf_1
X_0893_ Tile_X2Y0_S4BEG[10] _1229_/X VPWR VGND sg13cmos5l_buf_1
XANTENNA__0251__GATE Tile_X1Y0_FrameStrobe[1] VPWR VGND sg13cmos5l_antennanp
XFILLER_12_1154 VPWR VGND sg13cmos5l_decap_8
XFILLER_9_2424 VPWR VGND sg13cmos5l_decap_8
XFILLER_5_680 VPWR VGND sg13cmos5l_decap_8
XANTENNA__0266__GATE Tile_X1Y0_FrameStrobe[2] VPWR VGND sg13cmos5l_antennanp
XANTENNA__1017__A Tile_X0Y0_N2MID[5] VPWR VGND sg13cmos5l_antennanp
XANTENNA__0278__D Tile_X0Y0_FrameData[19] VPWR VGND sg13cmos5l_antennanp
XANTENNA__0856__A Tile_X4Y0_FrameStrobe[13] VPWR VGND sg13cmos5l_antennanp
X_0327_ _0327_/Q Tile_X0Y0_FrameData[18] VGND VPWR Tile_X2Y0_FrameStrobe[0] latch
X_0258_ _0258_/Q Tile_X0Y0_FrameData[7] VGND VPWR Tile_X1Y0_FrameStrobe[1] latch
XANTENNA__1266__A2 Tile_X3Y0_NN4END[7] VPWR VGND sg13cmos5l_antennanp
X_0189_ _0189_/Q Tile_X0Y0_FrameData[28] VGND VPWR Tile_X0Y0_FrameStrobe[3] latch
XANTENNA__0204__GATE Tile_X1Y0_FrameStrobe[0] VPWR VGND sg13cmos5l_antennanp
XANTENNA__0556__CLK Tile_X0Y0_UserCLK VPWR VGND sg13cmos5l_antennanp
XFILLER_14_2654 VPWR VGND sg13cmos5l_decap_8
XFILLER_14_1920 VPWR VGND sg13cmos5l_decap_8
XANTENNA__0219__GATE Tile_X1Y0_FrameStrobe[0] VPWR VGND sg13cmos5l_antennanp
XFILLER_10_1806 VPWR VGND sg13cmos5l_decap_8
XFILLER_3_628 VPWR VGND sg13cmos5l_decap_8
XFILLER_14_1997 VPWR VGND sg13cmos5l_decap_8
XFILLER_2_138 VPWR VGND sg13cmos5l_decap_8
XANTENNA__0188__D Tile_X0Y0_FrameData[29] VPWR VGND sg13cmos5l_antennanp
XANTENNA__0539__Q NPU_WDATA15 VPWR VGND sg13cmos5l_antennanp
XANTENNA__0766__A Tile_X3Y0_N2MID[4] VPWR VGND sg13cmos5l_antennanp
XFILLER_3_2590 VPWR VGND sg13cmos5l_fill_2
XANTENNA__1257__A2 Tile_X3Y0_N2END[1] VPWR VGND sg13cmos5l_antennanp
XFILLER_15_779 VPWR VGND sg13cmos5l_decap_8
XFILLER_15_2407 VPWR VGND sg13cmos5l_decap_8
XFILLER_9_39 VPWR VGND sg13cmos5l_fill_2
XFILLER_15_1717 VPWR VGND sg13cmos5l_decap_8
XFILLER_13_2153 VPWR VGND sg13cmos5l_fill_2
XFILLER_6_433 VPWR VGND sg13cmos5l_fill_1
XFILLER_13_2175 VPWR VGND sg13cmos5l_decap_8
XFILLER_13_1452 VPWR VGND sg13cmos5l_decap_4
XFILLER_13_1496 VPWR VGND sg13cmos5l_fill_1
XANTENNA__1193__A1 Tile_X1Y0_N4END[1] VPWR VGND sg13cmos5l_antennanp
XFILLER_6_2619 VPWR VGND sg13cmos5l_decap_8
XFILLER_2_694 VPWR VGND sg13cmos5l_fill_2
XFILLER_1_160 VPWR VGND sg13cmos5l_decap_4
X_1230_ _1230_/X Tile_X2Y0_N2MID[3] Tile_X2Y0_N4END[4] Tile_X2Y0_NN4END[11] _0583_/Q
+ _0371_/Q _0370_/Q VPWR VGND sg13cmos5l_mux4_1
XANTENNA__0098__D Tile_X0Y0_FrameData[23] VPWR VGND sg13cmos5l_antennanp
X_1161_ _1161_/X Tile_X0Y0_N2END[6] Tile_X0Y0_N4END[6] Tile_X0Y0_NN4END[9] _0601_/Q
+ _0141_/Q _0140_/Q VPWR VGND sg13cmos5l_mux4_1
XFILLER_4_2365 VPWR VGND sg13cmos5l_decap_8
X_0112_ _0112_/Q Tile_X0Y0_FrameData[9] VGND VPWR Tile_X0Y0_FrameStrobe[0] latch
XFILLER_4_2376 VPWR VGND sg13cmos5l_decap_8
XFILLER_4_1642 VPWR VGND sg13cmos5l_decap_8
XANTENNA__0579__CLK Tile_X0Y0_UserCLK VPWR VGND sg13cmos5l_antennanp
X_1092_ _1092_/X Tile_X3Y0_N1END[0] Tile_X3Y0_N2MID[3] Tile_X3Y0_N2MID[4] Tile_X3Y0_N2END[3]
+ _0417_/Q _0416_/Q VPWR VGND sg13cmos5l_mux4_1
XANTENNA__0963__X Tile_X1Y0_FrameStrobe_O[8] VPWR VGND sg13cmos5l_antennanp
XANTENNA__1248__A2 Tile_X2Y0_NN4END[2] VPWR VGND sg13cmos5l_antennanp
XFILLER_14_790 VPWR VGND sg13cmos5l_fill_1
XANTENNA__0190__GATE Tile_X0Y0_FrameStrobe[3] VPWR VGND sg13cmos5l_antennanp
X_0945_ Tile_X2Y0_FrameStrobe_O[10] Tile_X2Y0_FrameStrobe[10] VPWR VGND sg13cmos5l_buf_1
XFILLER_14_1249 VPWR VGND sg13cmos5l_decap_8
X_0876_ Tile_X2Y0_S2BEGb[1] _1212_/X VPWR VGND sg13cmos5l_buf_1
XANTENNA__1184__A1 Tile_X1Y0_N4END[10] VPWR VGND sg13cmos5l_antennanp
XFILLER_9_2221 VPWR VGND sg13cmos5l_decap_8
XFILLER_9_1520 VPWR VGND sg13cmos5l_fill_2
XFILLER_9_2298 VPWR VGND sg13cmos5l_decap_8
XANTENNA__1034__X Tile_X4Y0_S2BEG[3] VPWR VGND sg13cmos5l_antennanp
XANTENNA__0143__GATE Tile_X0Y0_FrameStrobe[1] VPWR VGND sg13cmos5l_antennanp
XANTENNA__0873__X Tile_X2Y0_S2BEG[6] VPWR VGND sg13cmos5l_antennanp
XANTENNA__1239__A2 Tile_X2Y0_NN4END[11] VPWR VGND sg13cmos5l_antennanp
XFILLER_0_2763 VPWR VGND sg13cmos5l_fill_1
XFILLER_3_1174 VPWR VGND sg13cmos5l_decap_8
XFILLER_0_2796 VPWR VGND sg13cmos5l_fill_1
XFILLER_16_2738 VPWR VGND sg13cmos5l_fill_2
XFILLER_12_716 VPWR VGND sg13cmos5l_decap_8
XFILLER_11_204 VPWR VGND sg13cmos5l_decap_8
XFILLER_11_248 VPWR VGND sg13cmos5l_decap_4
XFILLER_11_237 VPWR VGND sg13cmos5l_fill_2
XFILLER_11_215 VPWR VGND sg13cmos5l_fill_2
XANTENNA__0158__GATE Tile_X0Y0_FrameStrobe[2] VPWR VGND sg13cmos5l_antennanp
XANTENNA__0471__D Tile_X0Y0_FrameData[2] VPWR VGND sg13cmos5l_antennanp
XFILLER_14_2451 VPWR VGND sg13cmos5l_decap_8
XFILLER_10_1669 VPWR VGND sg13cmos5l_decap_8
XFILLER_3_436 VPWR VGND sg13cmos5l_decap_8
XANTENNA__1175__A1 Tile_X1Y0_N2MID[4] VPWR VGND sg13cmos5l_antennanp
XFILLER_8_1052 VPWR VGND sg13cmos5l_decap_8
XFILLER_5_2641 VPWR VGND sg13cmos5l_decap_8
XANTENNA__0783__X Tile_X3Y0_S4BEG[4] VPWR VGND sg13cmos5l_antennanp
XFILLER_15_598 VPWR VGND sg13cmos5l_decap_8
XFILLER_15_2259 VPWR VGND sg13cmos5l_decap_8
XFILLER_15_1536 VPWR VGND sg13cmos5l_decap_8
XFILLER_11_760 VPWR VGND sg13cmos5l_fill_2
XANTENNA__0381__D Tile_X0Y0_FrameData[28] VPWR VGND sg13cmos5l_antennanp
X_0730_ Tile_X1Y0_S4BEG[15] _1194_/X VPWR VGND sg13cmos5l_buf_1
X_0661_ _0661_/L_HI VPWR VGND sg13cmos5l_tiehi
XANTENNA__1166__A1 Tile_X0Y0_N4END[11] VPWR VGND sg13cmos5l_antennanp
X_0592_ _0592_/Q Tile_X0Y0_UserCLK NPU_RDATA20 _0608_/L_HI VPWR VGND sg13cmos5l_dfrbpq_1
XANTENNA__0958__X Tile_X1Y0_FrameStrobe_O[3] VPWR VGND sg13cmos5l_antennanp
XFILLER_6_2405 VPWR VGND sg13cmos5l_decap_8
XFILLER_3_981 VPWR VGND sg13cmos5l_fill_1
XFILLER_6_2427 VPWR VGND sg13cmos5l_decap_8
XFILLER_6_1715 VPWR VGND sg13cmos5l_decap_8
XFILLER_2_491 VPWR VGND sg13cmos5l_decap_8
X_1213_ _1213_/X Tile_X2Y0_N1END[2] Tile_X2Y0_N2MID[2] Tile_X2Y0_N2END[5] _0582_/Q
+ _0405_/Q _0404_/Q VPWR VGND sg13cmos5l_mux4_1
XFILLER_4_2173 VPWR VGND sg13cmos5l_decap_8
X_1144_ _1144_/X Tile_X0Y0_N2MID[5] Tile_X0Y0_N4END[10] Tile_X0Y0_NN4END[5] _0601_/Q
+ _0175_/Q _0174_/Q VPWR VGND sg13cmos5l_mux4_1
XANTENNA__0693__X Tile_X0Y0_FrameStrobe_O[6] VPWR VGND sg13cmos5l_antennanp
X_1075_ Tile_X4Y0_SS4BEG[12] Tile_X4Y0_NN4END[3] VPWR VGND sg13cmos5l_buf_1
XFILLER_0_1369 VPWR VGND sg13cmos5l_decap_4
XANTENNA__1030__A Tile_X4Y0_N1END[0] VPWR VGND sg13cmos5l_antennanp
XANTENNA__0291__D Tile_X0Y0_FrameData[6] VPWR VGND sg13cmos5l_antennanp
XFILLER_11_2646 VPWR VGND sg13cmos5l_decap_8
X_0928_ Tile_X3Y0_FrameStrobe_O[13] Tile_X3Y0_FrameStrobe[13] VPWR VGND sg13cmos5l_buf_1
XANTENNA__1029__X Tile_X4Y0_S1BEG[2] VPWR VGND sg13cmos5l_antennanp
X_0859_ Tile_X4Y0_FrameStrobe_O[16] Tile_X4Y0_FrameStrobe[16] VPWR VGND sg13cmos5l_buf_1
XANTENNA__1157__A1 Tile_X0Y0_N4END[2] VPWR VGND sg13cmos5l_antennanp
XFILLER_11_1978 VPWR VGND sg13cmos5l_fill_1
XANTENNA__0868__X Tile_X2Y0_S2BEG[1] VPWR VGND sg13cmos5l_antennanp
XFILLER_9_2084 VPWR VGND sg13cmos5l_decap_8
XFILLER_9_2095 VPWR VGND sg13cmos5l_fill_1
XFILLER_9_1361 VPWR VGND sg13cmos5l_fill_1
XFILLER_5_1236 VPWR VGND sg13cmos5l_fill_2
XANTENNA__0466__D Tile_X0Y0_FrameData[7] VPWR VGND sg13cmos5l_antennanp
XFILLER_16_307 VPWR VGND sg13cmos5l_decap_8
XFILLER_0_2582 VPWR VGND sg13cmos5l_decap_4
XANTENNA__1093__A0 Tile_X3Y0_N1END[1] VPWR VGND sg13cmos5l_antennanp
XANTENNA__0097__GATE Tile_X0Y0_FrameStrobe[0] VPWR VGND sg13cmos5l_antennanp
XFILLER_16_2535 VPWR VGND sg13cmos5l_decap_8
XFILLER_16_1801 VPWR VGND sg13cmos5l_decap_8
XFILLER_16_2579 VPWR VGND sg13cmos5l_fill_2
XFILLER_16_1856 VPWR VGND sg13cmos5l_decap_8
XFILLER_16_1845 VPWR VGND sg13cmos5l_fill_1
XANTENNA__0552__Q NPU_WDATA28 VPWR VGND sg13cmos5l_antennanp
XFILLER_10_2123 VPWR VGND sg13cmos5l_fill_2
XFILLER_14_2292 VPWR VGND sg13cmos5l_decap_8
XFILLER_3_200 VPWR VGND sg13cmos5l_fill_2
XANTENNA__1148__A1 Tile_X0Y0_N4END[6] VPWR VGND sg13cmos5l_antennanp
XANTENNA__0778__X Tile_X3Y0_S2BEGb[7] VPWR VGND sg13cmos5l_antennanp
XFILLER_7_2736 VPWR VGND sg13cmos5l_decap_8
XFILLER_5_1770 VPWR VGND sg13cmos5l_fill_2
XFILLER_1_2335 VPWR VGND sg13cmos5l_decap_8
XANTENNA__0376__D Tile_X0Y0_FrameData[1] VPWR VGND sg13cmos5l_antennanp
XANTENNA__0954__A Tile_X2Y0_FrameStrobe[19] VPWR VGND sg13cmos5l_antennanp
XFILLER_1_1667 VPWR VGND sg13cmos5l_decap_8
XFILLER_16_874 VPWR VGND sg13cmos5l_fill_2
XFILLER_16_863 VPWR VGND sg13cmos5l_decap_8
XANTENNA__1084__A0 Tile_X2Y0_N1END[0] VPWR VGND sg13cmos5l_antennanp
XFILLER_15_2023 VPWR VGND sg13cmos5l_decap_8
XFILLER_15_2001 VPWR VGND sg13cmos5l_decap_8
XFILLER_15_2078 VPWR VGND sg13cmos5l_decap_8
X_0713_ Tile_X1Y0_S2BEGb[6] _1177_/X VPWR VGND sg13cmos5l_buf_1
XFILLER_7_594 VPWR VGND sg13cmos5l_decap_8
XANTENNA__1139__A1 Tile_X0Y0_N4END[15] VPWR VGND sg13cmos5l_antennanp
X_0644_ _0644_/L_HI VPWR VGND sg13cmos5l_tiehi
XANTENNA__0688__X Tile_X0Y0_FrameStrobe_O[1] VPWR VGND sg13cmos5l_antennanp
X_0575_ _0575_/Q Tile_X0Y0_UserCLK NPU_RDATA3 _0647_/L_HI VPWR VGND sg13cmos5l_dfrbpq_1
XFILLER_6_2202 VPWR VGND sg13cmos5l_decap_8
XFILLER_6_2279 VPWR VGND sg13cmos5l_decap_8
XANTENNA__1025__A Tile_X0Y0_N1END[1] VPWR VGND sg13cmos5l_antennanp
XFILLER_6_1589 VPWR VGND sg13cmos5l_fill_1
XFILLER_6_1578 VPWR VGND sg13cmos5l_decap_8
XANTENNA__0286__D Tile_X0Y0_FrameData[11] VPWR VGND sg13cmos5l_antennanp
XANTENNA__0864__A Tile_X2Y0_N1END[2] VPWR VGND sg13cmos5l_antennanp
X_1127_ _1127_/X Tile_X0Y0_N4END[12] Tile_X0Y0_N4END[15] Tile_X0Y0_NN4END[13] Tile_X0Y0_NN4END[15]
+ _0091_/Q _0202_/Q VPWR VGND sg13cmos5l_mux4_1
X_1058_ Tile_X4Y0_S4BEG[11] Tile_X4Y0_N4END[4] VPWR VGND sg13cmos5l_buf_1
XFILLER_15_38 VPWR VGND sg13cmos5l_fill_1
XANTENNA__1090__A3 Tile_X3Y0_N2END[5] VPWR VGND sg13cmos5l_antennanp
XFILLER_11_2454 VPWR VGND sg13cmos5l_decap_8
XFILLER_11_1720 VPWR VGND sg13cmos5l_decap_8
XFILLER_1_726 VPWR VGND sg13cmos5l_decap_4
XFILLER_11_1797 VPWR VGND sg13cmos5l_decap_8
XFILLER_1_748 VPWR VGND sg13cmos5l_decap_4
XFILLER_9_1180 VPWR VGND sg13cmos5l_decap_8
XFILLER_9_1191 VPWR VGND sg13cmos5l_fill_2
XFILLER_6_2780 VPWR VGND sg13cmos5l_decap_4
XFILLER_5_1055 VPWR VGND sg13cmos5l_decap_8
XANTENNA__0196__D Tile_X0Y0_FrameData[21] VPWR VGND sg13cmos5l_antennanp
XANTENNA__0547__Q NPU_WDATA23 VPWR VGND sg13cmos5l_antennanp
XFILLER_2_2677 VPWR VGND sg13cmos5l_decap_8
XFILLER_16_2332 VPWR VGND sg13cmos5l_fill_1
XFILLER_13_822 VPWR VGND sg13cmos5l_decap_8
XFILLER_9_826 VPWR VGND sg13cmos5l_fill_1
XFILLER_12_2207 VPWR VGND sg13cmos5l_decap_8
XANTENNA__1081__A3 Tile_X2Y0_N2END[6] VPWR VGND sg13cmos5l_antennanp
XFILLER_9_859 VPWR VGND sg13cmos5l_decap_4
XFILLER_16_1653 VPWR VGND sg13cmos5l_decap_8
XFILLER_16_1642 VPWR VGND sg13cmos5l_decap_8
XFILLER_12_1539 VPWR VGND sg13cmos5l_decap_8
XFILLER_4_531 VPWR VGND sg13cmos5l_decap_8
XFILLER_10_1274 VPWR VGND sg13cmos5l_decap_8
XANTENNA__0949__A Tile_X2Y0_FrameStrobe[14] VPWR VGND sg13cmos5l_antennanp
XFILLER_7_2500 VPWR VGND sg13cmos5l_decap_8
X_0360_ _0360_/Q Tile_X0Y0_FrameData[17] VGND VPWR Tile_X2Y0_FrameStrobe[1] latch
XFILLER_7_2544 VPWR VGND sg13cmos5l_fill_1
XFILLER_0_770 VPWR VGND sg13cmos5l_decap_8
X_0291_ _0291_/Q Tile_X0Y0_FrameData[6] VGND VPWR Tile_X1Y0_FrameStrobe[2] latch
XFILLER_3_1729 VPWR VGND sg13cmos5l_decap_8
XFILLER_1_2154 VPWR VGND sg13cmos5l_fill_1
XFILLER_1_1431 VPWR VGND sg13cmos5l_decap_4
XANTENNA__0971__X Tile_X1Y0_FrameStrobe_O[16] VPWR VGND sg13cmos5l_antennanp
XFILLER_15_192 VPWR VGND sg13cmos5l_decap_8
XFILLER_15_1174 VPWR VGND sg13cmos5l_decap_8
XFILLER_12_2785 VPWR VGND sg13cmos5l_decap_4
XFILLER_8_2319 VPWR VGND sg13cmos5l_decap_8
XANTENNA__0859__A Tile_X4Y0_FrameStrobe[16] VPWR VGND sg13cmos5l_antennanp
X_0627_ _0627_/L_HI VPWR VGND sg13cmos5l_tiehi
X_0558_ NPU_WE2 Tile_X0Y0_UserCLK _0558_/D _0669_/L_HI VPWR VGND sg13cmos5l_dfrbpq_1
X_0489_ _0489_/Q Tile_X0Y0_FrameData[16] VGND VPWR Tile_X3Y0_FrameStrobe[2] latch
XFILLER_2_1217 VPWR VGND sg13cmos5l_fill_1
XANTENNA__1042__X Tile_X4Y0_S2BEGb[3] VPWR VGND sg13cmos5l_antennanp
XANTENNA__0881__X Tile_X2Y0_S2BEGb[6] VPWR VGND sg13cmos5l_antennanp
XFILLER_10_814 VPWR VGND sg13cmos5l_decap_8
XFILLER_11_2251 VPWR VGND sg13cmos5l_decap_8
XANTENNA__1220__A0 Tile_X2Y0_N2MID[1] VPWR VGND sg13cmos5l_antennanp
XFILLER_11_1594 VPWR VGND sg13cmos5l_decap_8
XFILLER_11_1583 VPWR VGND sg13cmos5l_decap_8
XANTENNA__0769__A Tile_X3Y0_N2MID[1] VPWR VGND sg13cmos5l_antennanp
XFILLER_1_512 VPWR VGND sg13cmos5l_decap_8
XFILLER_7_1117 VPWR VGND sg13cmos5l_decap_8
XFILLER_4_2717 VPWR VGND sg13cmos5l_fill_1
XFILLER_1_589 VPWR VGND sg13cmos5l_fill_1
XFILLER_2_2430 VPWR VGND sg13cmos5l_decap_8
XANTENNA__1287__A0 Tile_X3Y0_N2END[4] VPWR VGND sg13cmos5l_antennanp
XFILLER_2_1762 VPWR VGND sg13cmos5l_decap_8
XANTENNA__0791__X Tile_X3Y0_S4BEG[12] VPWR VGND sg13cmos5l_antennanp
XFILLER_16_70 VPWR VGND sg13cmos5l_decap_8
XFILLER_9_634 VPWR VGND sg13cmos5l_decap_8
XFILLER_13_674 VPWR VGND sg13cmos5l_decap_8
XFILLER_12_2015 VPWR VGND sg13cmos5l_decap_8
XFILLER_16_1472 VPWR VGND sg13cmos5l_decap_4
XFILLER_8_155 VPWR VGND sg13cmos5l_decap_4
XFILLER_12_1336 VPWR VGND sg13cmos5l_decap_8
XANTENNA__1211__A0 Tile_X2Y0_N1END[0] VPWR VGND sg13cmos5l_antennanp
XFILLER_9_2606 VPWR VGND sg13cmos5l_decap_8
XFILLER_10_1093 VPWR VGND sg13cmos5l_decap_8
XFILLER_9_1905 VPWR VGND sg13cmos5l_fill_2
X_0412_ _0412_/Q Tile_X0Y0_FrameData[29] VGND VPWR Tile_X3Y0_FrameStrobe[0] latch
XANTENNA__0966__X Tile_X1Y0_FrameStrobe_O[11] VPWR VGND sg13cmos5l_antennanp
X_0343_ _0343_/Q Tile_X0Y0_FrameData[2] VGND VPWR Tile_X2Y0_FrameStrobe[0] latch
XFILLER_7_2385 VPWR VGND sg13cmos5l_decap_8
XFILLER_3_2216 VPWR VGND sg13cmos5l_decap_8
X_0274_ _0274_/Q Tile_X0Y0_FrameData[23] VGND VPWR Tile_X1Y0_FrameStrobe[2] latch
XFILLER_7_1695 VPWR VGND sg13cmos5l_decap_8
XANTENNA__0481__GATE Tile_X3Y0_FrameStrobe[2] VPWR VGND sg13cmos5l_antennanp
XANTENNA__1278__A0 Tile_X3Y0_N2END[3] VPWR VGND sg13cmos5l_antennanp
XFILLER_3_1559 VPWR VGND sg13cmos5l_decap_8
XANTENNA__0496__GATE Tile_X3Y0_FrameStrobe[2] VPWR VGND sg13cmos5l_antennanp
XANTENNA__1202__A0 Tile_X1Y0_N2END[7] VPWR VGND sg13cmos5l_antennanp
XANTENNA__1037__X Tile_X4Y0_S2BEG[6] VPWR VGND sg13cmos5l_antennanp
XFILLER_8_1415 VPWR VGND sg13cmos5l_fill_1
XANTENNA__0434__GATE Tile_X3Y0_FrameStrobe[0] VPWR VGND sg13cmos5l_antennanp
XANTENNA__0876__X Tile_X2Y0_S2BEGb[1] VPWR VGND sg13cmos5l_antennanp
XFILLER_6_1172 VPWR VGND sg13cmos5l_decap_8
XFILLER_3_2750 VPWR VGND sg13cmos5l_decap_8
XANTENNA__0449__GATE Tile_X3Y0_FrameStrobe[1] VPWR VGND sg13cmos5l_antennanp
XANTENNA__1269__A0 Tile_X3Y0_N2MID[2] VPWR VGND sg13cmos5l_antennanp
XANTENNA__0474__D Tile_X0Y0_FrameData[31] VPWR VGND sg13cmos5l_antennanp
XFILLER_10_633 VPWR VGND sg13cmos5l_decap_8
XFILLER_13_2357 VPWR VGND sg13cmos5l_decap_8
XANTENNA__0560__Q NPU_WE4 VPWR VGND sg13cmos5l_antennanp
XFILLER_13_1678 VPWR VGND sg13cmos5l_decap_8
XFILLER_5_158 VPWR VGND sg13cmos5l_fill_1
XFILLER_2_821 VPWR VGND sg13cmos5l_decap_8
XFILLER_4_2514 VPWR VGND sg13cmos5l_decap_8
XFILLER_2_887 VPWR VGND sg13cmos5l_decap_8
XANTENNA__0786__X Tile_X3Y0_S4BEG[7] VPWR VGND sg13cmos5l_antennanp
XFILLER_2_2293 VPWR VGND sg13cmos5l_fill_1
XANTENNA__0384__D Tile_X0Y0_FrameData[25] VPWR VGND sg13cmos5l_antennanp
XANTENNA__0962__A Tile_X1Y0_FrameStrobe[7] VPWR VGND sg13cmos5l_antennanp
X_0961_ Tile_X1Y0_FrameStrobe_O[6] Tile_X1Y0_FrameStrobe[6] VPWR VGND sg13cmos5l_buf_1
XFILLER_13_482 VPWR VGND sg13cmos5l_fill_2
XFILLER_9_464 VPWR VGND sg13cmos5l_decap_8
X_0892_ Tile_X2Y0_S4BEG[9] _1228_/X VPWR VGND sg13cmos5l_buf_1
XFILLER_9_497 VPWR VGND sg13cmos5l_decap_8
XFILLER_12_1133 VPWR VGND sg13cmos5l_decap_8
XFILLER_9_2403 VPWR VGND sg13cmos5l_decap_8
XFILLER_4_191 VPWR VGND sg13cmos5l_decap_4
XANTENNA__0696__X Tile_X0Y0_FrameStrobe_O[9] VPWR VGND sg13cmos5l_antennanp
XFILLER_9_1779 VPWR VGND sg13cmos5l_decap_8
XFILLER_7_2182 VPWR VGND sg13cmos5l_decap_8
X_0326_ _0326_/Q Tile_X0Y0_FrameData[19] VGND VPWR Tile_X2Y0_FrameStrobe[0] latch
XFILLER_3_1312 VPWR VGND sg13cmos5l_decap_4
X_0257_ _0257_/Q Tile_X0Y0_FrameData[8] VGND VPWR Tile_X1Y0_FrameStrobe[1] latch
XANTENNA__1033__A Tile_X4Y0_N2MID[5] VPWR VGND sg13cmos5l_antennanp
XANTENNA__0294__D Tile_X0Y0_FrameData[3] VPWR VGND sg13cmos5l_antennanp
X_0188_ _0188_/Q Tile_X0Y0_FrameData[29] VGND VPWR Tile_X0Y0_FrameStrobe[3] latch
XANTENNA__0872__A Tile_X2Y0_N2MID[2] VPWR VGND sg13cmos5l_antennanp
XFILLER_11_408 VPWR VGND sg13cmos5l_fill_2
XFILLER_14_2633 VPWR VGND sg13cmos5l_decap_8
XFILLER_14_1976 VPWR VGND sg13cmos5l_decap_8
XFILLER_3_607 VPWR VGND sg13cmos5l_decap_8
XFILLER_2_117 VPWR VGND sg13cmos5l_decap_8
XANTENNA__0373__GATE Tile_X2Y0_FrameStrobe[1] VPWR VGND sg13cmos5l_antennanp
XANTENNA__0469__D Tile_X0Y0_FrameData[4] VPWR VGND sg13cmos5l_antennanp
XFILLER_5_2801 VPWR VGND sg13cmos5l_fill_2
XANTENNA__0388__GATE Tile_X2Y0_FrameStrobe[2] VPWR VGND sg13cmos5l_antennanp
XFILLER_8_1278 VPWR VGND sg13cmos5l_decap_8
XFILLER_1_2709 VPWR VGND sg13cmos5l_fill_2
XANTENNA__0311__GATE Tile_X1Y0_FrameStrobe[3] VPWR VGND sg13cmos5l_antennanp
XANTENNA__0555__Q NPU_WDATA31 VPWR VGND sg13cmos5l_antennanp
XFILLER_15_758 VPWR VGND sg13cmos5l_decap_8
XFILLER_14_257 VPWR VGND sg13cmos5l_fill_2
XFILLER_13_2110 VPWR VGND sg13cmos5l_decap_4
XANTENNA__0326__GATE Tile_X2Y0_FrameStrobe[0] VPWR VGND sg13cmos5l_antennanp
XFILLER_7_946 VPWR VGND sg13cmos5l_decap_8
XFILLER_13_1431 VPWR VGND sg13cmos5l_decap_8
XANTENNA__1193__A2 Tile_X1Y0_NN4END[14] VPWR VGND sg13cmos5l_antennanp
XANTENNA__0379__D Tile_X0Y0_FrameData[30] VPWR VGND sg13cmos5l_antennanp
XFILLER_2_673 VPWR VGND sg13cmos5l_decap_8
XANTENNA__0957__A Tile_X1Y0_FrameStrobe[2] VPWR VGND sg13cmos5l_antennanp
XFILLER_8_2480 VPWR VGND sg13cmos5l_decap_8
XFILLER_1_194 VPWR VGND sg13cmos5l_decap_8
X_1160_ _1160_/X Tile_X0Y0_N2END[5] Tile_X0Y0_N4END[5] Tile_X0Y0_NN4END[10] _0600_/Q
+ _0143_/Q _0142_/Q VPWR VGND sg13cmos5l_mux4_1
XFILLER_4_2344 VPWR VGND sg13cmos5l_decap_8
XFILLER_4_1621 VPWR VGND sg13cmos5l_decap_8
XFILLER_0_2208 VPWR VGND sg13cmos5l_fill_1
X_0111_ _0111_/Q Tile_X0Y0_FrameData[10] VGND VPWR Tile_X0Y0_FrameStrobe[0] latch
XFILLER_4_2399 VPWR VGND sg13cmos5l_decap_8
XFILLER_4_2388 VPWR VGND sg13cmos5l_decap_8
X_1091_ _1091_/X Tile_X3Y0_N1END[3] Tile_X3Y0_N2MID[3] Tile_X3Y0_N2MID[4] Tile_X3Y0_N2END[4]
+ _0419_/Q _0418_/Q VPWR VGND sg13cmos5l_mux4_1
XFILLER_4_1698 VPWR VGND sg13cmos5l_decap_8
XANTENNA__0692__A Tile_X0Y0_FrameStrobe[5] VPWR VGND sg13cmos5l_antennanp
X_0944_ Tile_X2Y0_FrameStrobe_O[9] Tile_X2Y0_FrameStrobe[9] VPWR VGND sg13cmos5l_buf_1
XFILLER_14_1228 VPWR VGND sg13cmos5l_decap_8
X_0875_ Tile_X2Y0_S2BEGb[0] _1211_/X VPWR VGND sg13cmos5l_buf_1
XFILLER_9_2200 VPWR VGND sg13cmos5l_decap_8
XANTENNA__1028__A Tile_X4Y0_N1END[2] VPWR VGND sg13cmos5l_antennanp
XANTENNA__1184__A2 Tile_X1Y0_NN4END[5] VPWR VGND sg13cmos5l_antennanp
XFILLER_9_2277 VPWR VGND sg13cmos5l_decap_8
XANTENNA__0289__D Tile_X0Y0_FrameData[8] VPWR VGND sg13cmos5l_antennanp
XANTENNA__0867__A Tile_X2Y0_N2MID[7] VPWR VGND sg13cmos5l_antennanp
XFILLER_9_1587 VPWR VGND sg13cmos5l_fill_2
XANTENNA__0523__CLK Tile_X0Y0_UserCLK VPWR VGND sg13cmos5l_antennanp
X_0309_ _0309_/Q Tile_X0Y0_FrameData[20] VGND VPWR Tile_X1Y0_FrameStrobe[3] latch
X_1289_ _1289_/X Tile_X3Y0_N2END[6] Tile_X3Y0_N4END[14] Tile_X3Y0_NN4END[1] _0573_/Q
+ _0429_/Q _0428_/Q VPWR VGND sg13cmos5l_mux4_1
XFILLER_0_2775 VPWR VGND sg13cmos5l_fill_1
XANTENNA__1050__X Tile_X4Y0_S4BEG[3] VPWR VGND sg13cmos5l_antennanp
XFILLER_14_2430 VPWR VGND sg13cmos5l_decap_8
XFILLER_10_2349 VPWR VGND sg13cmos5l_decap_8
XFILLER_14_1795 VPWR VGND sg13cmos5l_decap_8
XFILLER_10_1648 VPWR VGND sg13cmos5l_decap_8
XANTENNA__1175__A2 Tile_X1Y0_N2END[3] VPWR VGND sg13cmos5l_antennanp
XANTENNA__0199__D Tile_X0Y0_FrameData[18] VPWR VGND sg13cmos5l_antennanp
XFILLER_8_1031 VPWR VGND sg13cmos5l_decap_8
XFILLER_5_2620 VPWR VGND sg13cmos5l_decap_8
XFILLER_5_2697 VPWR VGND sg13cmos5l_decap_8
XANTENNA__0250__GATE Tile_X1Y0_FrameStrobe[1] VPWR VGND sg13cmos5l_antennanp
XFILLER_15_511 VPWR VGND sg13cmos5l_decap_4
XFILLER_15_577 VPWR VGND sg13cmos5l_decap_8
XANTENNA__0265__GATE Tile_X1Y0_FrameStrobe[1] VPWR VGND sg13cmos5l_antennanp
XFILLER_15_2238 VPWR VGND sg13cmos5l_decap_8
XFILLER_15_1515 VPWR VGND sg13cmos5l_decap_8
XFILLER_11_794 VPWR VGND sg13cmos5l_decap_8
XFILLER_11_772 VPWR VGND sg13cmos5l_fill_2
XFILLER_6_231 VPWR VGND sg13cmos5l_fill_2
XFILLER_6_220 VPWR VGND sg13cmos5l_decap_8
X_0660_ _0660_/L_HI VPWR VGND sg13cmos5l_tiehi
XFILLER_7_798 VPWR VGND sg13cmos5l_decap_8
XFILLER_13_1294 VPWR VGND sg13cmos5l_decap_8
XANTENNA__1166__A2 Tile_X0Y0_NN4END[4] VPWR VGND sg13cmos5l_antennanp
X_0591_ _0591_/Q Tile_X0Y0_UserCLK NPU_RDATA19 _0607_/L_HI VPWR VGND sg13cmos5l_dfrbpq_1
XANTENNA__0203__GATE Tile_X1Y0_FrameStrobe[0] VPWR VGND sg13cmos5l_antennanp
XANTENNA__0546__CLK Tile_X0Y0_UserCLK VPWR VGND sg13cmos5l_antennanp
XANTENNA__0687__A Tile_X0Y0_FrameStrobe[0] VPWR VGND sg13cmos5l_antennanp
X_1212_ _1212_/X Tile_X2Y0_N1END[1] Tile_X2Y0_N2MID[1] Tile_X2Y0_N2END[6] _0581_/Q
+ _0407_/Q _0406_/Q VPWR VGND sg13cmos5l_mux4_1
XFILLER_0_2005 VPWR VGND sg13cmos5l_fill_2
XFILLER_4_2152 VPWR VGND sg13cmos5l_decap_8
XFILLER_1_30 VPWR VGND sg13cmos5l_fill_1
XANTENNA__0218__GATE Tile_X1Y0_FrameStrobe[0] VPWR VGND sg13cmos5l_antennanp
XANTENNA__0974__X Tile_X1Y0_FrameStrobe_O[19] VPWR VGND sg13cmos5l_antennanp
X_1143_ _1143_/X Tile_X0Y0_N2MID[4] Tile_X0Y0_N4END[11] Tile_X0Y0_NN4END[4] _0600_/Q
+ _0177_/Q _0176_/Q VPWR VGND sg13cmos5l_mux4_1
X_1074_ Tile_X4Y0_SS4BEG[11] Tile_X4Y0_NN4END[4] VPWR VGND sg13cmos5l_buf_1
XANTENNA__0572__D NPU_RDATA0 VPWR VGND sg13cmos5l_antennanp
XFILLER_15_2750 VPWR VGND sg13cmos5l_decap_4
X_0927_ Tile_X3Y0_FrameStrobe_O[12] Tile_X3Y0_FrameStrobe[12] VPWR VGND sg13cmos5l_buf_1
XFILLER_11_2625 VPWR VGND sg13cmos5l_decap_8
XFILLER_14_1058 VPWR VGND sg13cmos5l_fill_1
XFILLER_11_1902 VPWR VGND sg13cmos5l_decap_8
X_0858_ Tile_X4Y0_FrameStrobe_O[15] Tile_X4Y0_FrameStrobe[15] VPWR VGND sg13cmos5l_buf_1
XFILLER_11_1957 VPWR VGND sg13cmos5l_decap_8
XANTENNA__1157__A2 Tile_X0Y0_NN4END[13] VPWR VGND sg13cmos5l_antennanp
X_0789_ Tile_X3Y0_S4BEG[10] _1269_/X VPWR VGND sg13cmos5l_buf_1
XFILLER_0_407 VPWR VGND sg13cmos5l_fill_2
XFILLER_1_919 VPWR VGND sg13cmos5l_decap_8
XFILLER_0_429 VPWR VGND sg13cmos5l_fill_2
XFILLER_9_2063 VPWR VGND sg13cmos5l_decap_8
XANTENNA__1045__X Tile_X4Y0_S2BEGb[6] VPWR VGND sg13cmos5l_antennanp
XFILLER_5_1215 VPWR VGND sg13cmos5l_decap_8
XANTENNA__0884__X Tile_X2Y0_S4BEG[1] VPWR VGND sg13cmos5l_antennanp
XFILLER_0_2561 VPWR VGND sg13cmos5l_fill_2
XFILLER_0_2594 VPWR VGND sg13cmos5l_decap_4
XFILLER_16_2514 VPWR VGND sg13cmos5l_decap_8
XANTENNA__0482__D Tile_X0Y0_FrameData[23] VPWR VGND sg13cmos5l_antennanp
XANTENNA__1093__A1 Tile_X3Y0_N2MID[2] VPWR VGND sg13cmos5l_antennanp
XFILLER_12_569 VPWR VGND sg13cmos5l_decap_8
XFILLER_10_2113 VPWR VGND sg13cmos5l_fill_2
XFILLER_14_2271 VPWR VGND sg13cmos5l_decap_8
XFILLER_10_2135 VPWR VGND sg13cmos5l_decap_8
XFILLER_4_735 VPWR VGND sg13cmos5l_fill_1
XANTENNA__0569__CLK Tile_X0Y0_UserCLK VPWR VGND sg13cmos5l_antennanp
XFILLER_4_746 VPWR VGND sg13cmos5l_fill_1
XFILLER_3_234 VPWR VGND sg13cmos5l_decap_8
XANTENNA__1148__A2 Tile_X0Y0_NN4END[9] VPWR VGND sg13cmos5l_antennanp
XFILLER_7_2715 VPWR VGND sg13cmos5l_decap_8
XFILLER_10_61 VPWR VGND sg13cmos5l_fill_2
XFILLER_0_996 VPWR VGND sg13cmos5l_fill_1
XANTENNA__0794__X Tile_X3Y0_S4BEG[15] VPWR VGND sg13cmos5l_antennanp
XFILLER_5_2494 VPWR VGND sg13cmos5l_decap_8
XFILLER_1_1646 VPWR VGND sg13cmos5l_decap_8
XANTENNA__0392__D Tile_X0Y0_FrameData[17] VPWR VGND sg13cmos5l_antennanp
XANTENNA__1084__A1 Tile_X2Y0_N2MID[3] VPWR VGND sg13cmos5l_antennanp
XANTENNA__0970__A Tile_X1Y0_FrameStrobe[15] VPWR VGND sg13cmos5l_antennanp
XFILLER_15_2057 VPWR VGND sg13cmos5l_decap_8
XFILLER_15_1345 VPWR VGND sg13cmos5l_decap_8
XFILLER_11_591 VPWR VGND sg13cmos5l_decap_8
X_0712_ Tile_X1Y0_S2BEGb[5] _1176_/X VPWR VGND sg13cmos5l_buf_1
XFILLER_7_573 VPWR VGND sg13cmos5l_decap_8
XANTENNA__0969__X Tile_X1Y0_FrameStrobe_O[14] VPWR VGND sg13cmos5l_antennanp
X_0643_ _0643_/L_HI VPWR VGND sg13cmos5l_tiehi
XFILLER_13_1091 VPWR VGND sg13cmos5l_decap_8
XANTENNA__0142__GATE Tile_X0Y0_FrameStrobe[1] VPWR VGND sg13cmos5l_antennanp
XANTENNA__1139__A2 Tile_X0Y0_NN4END[0] VPWR VGND sg13cmos5l_antennanp
X_0574_ _0574_/Q Tile_X0Y0_UserCLK NPU_RDATA2 _0648_/L_HI VPWR VGND sg13cmos5l_dfrbpq_1
XFILLER_6_2258 VPWR VGND sg13cmos5l_decap_8
XANTENNA__0157__GATE Tile_X0Y0_FrameStrobe[2] VPWR VGND sg13cmos5l_antennanp
XFILLER_6_1557 VPWR VGND sg13cmos5l_decap_8
X_1126_ _1126_/X Tile_X0Y0_N4END[14] Tile_X0Y0_N4END[15] Tile_X0Y0_NN4END[12] Tile_X0Y0_NN4END[14]
+ _0093_/Q _0092_/Q VPWR VGND sg13cmos5l_mux4_1
XANTENNA__1041__A Tile_X4Y0_N2END[5] VPWR VGND sg13cmos5l_antennanp
X_1057_ Tile_X4Y0_S4BEG[10] Tile_X4Y0_N4END[5] VPWR VGND sg13cmos5l_buf_1
XFILLER_13_2709 VPWR VGND sg13cmos5l_fill_1
XFILLER_11_2433 VPWR VGND sg13cmos5l_decap_8
XANTENNA__0879__X Tile_X2Y0_S2BEGb[4] VPWR VGND sg13cmos5l_antennanp
XFILLER_11_1776 VPWR VGND sg13cmos5l_decap_8
XFILLER_0_204 VPWR VGND sg13cmos5l_fill_1
XFILLER_1_738 VPWR VGND sg13cmos5l_decap_4
XFILLER_0_259 VPWR VGND sg13cmos5l_fill_2
XANTENNA__0477__D Tile_X0Y0_FrameData[28] VPWR VGND sg13cmos5l_antennanp
XFILLER_2_2645 VPWR VGND sg13cmos5l_fill_1
XFILLER_2_2656 VPWR VGND sg13cmos5l_decap_8
XFILLER_2_1922 VPWR VGND sg13cmos5l_decap_4
XFILLER_2_1955 VPWR VGND sg13cmos5l_decap_4
XFILLER_16_149 VPWR VGND sg13cmos5l_decap_8
XFILLER_13_801 VPWR VGND sg13cmos5l_decap_8
XANTENNA__0563__Q NPU_WE7 VPWR VGND sg13cmos5l_antennanp
XFILLER_16_1621 VPWR VGND sg13cmos5l_decap_8
XFILLER_13_845 VPWR VGND sg13cmos5l_fill_1
XFILLER_12_333 VPWR VGND sg13cmos5l_decap_8
XFILLER_8_315 VPWR VGND sg13cmos5l_decap_4
XFILLER_16_2388 VPWR VGND sg13cmos5l_decap_8
XFILLER_12_1518 VPWR VGND sg13cmos5l_decap_8
XFILLER_4_510 VPWR VGND sg13cmos5l_decap_8
XANTENNA__0789__X Tile_X3Y0_S4BEG[10] VPWR VGND sg13cmos5l_antennanp
XFILLER_10_1253 VPWR VGND sg13cmos5l_decap_8
X_0290_ _0290_/Q Tile_X0Y0_FrameData[7] VGND VPWR Tile_X1Y0_FrameStrobe[2] latch
XFILLER_7_1855 VPWR VGND sg13cmos5l_fill_2
XANTENNA__0387__D Tile_X0Y0_FrameData[22] VPWR VGND sg13cmos5l_antennanp
XANTENNA__0965__A Tile_X1Y0_FrameStrobe[10] VPWR VGND sg13cmos5l_antennanp
XFILLER_3_1708 VPWR VGND sg13cmos5l_decap_8
XFILLER_1_2111 VPWR VGND sg13cmos5l_fill_1
XFILLER_1_2133 VPWR VGND sg13cmos5l_decap_8
XFILLER_1_2188 VPWR VGND sg13cmos5l_decap_8
XFILLER_1_1443 VPWR VGND sg13cmos5l_decap_4
XFILLER_16_683 VPWR VGND sg13cmos5l_decap_8
XFILLER_15_171 VPWR VGND sg13cmos5l_decap_8
XFILLER_15_1153 VPWR VGND sg13cmos5l_decap_8
XFILLER_7_73 VPWR VGND sg13cmos5l_fill_2
XFILLER_12_2764 VPWR VGND sg13cmos5l_decap_8
XANTENNA__0699__X Tile_X0Y0_FrameStrobe_O[12] VPWR VGND sg13cmos5l_antennanp
X_0626_ _0626_/L_HI VPWR VGND sg13cmos5l_tiehi
XANTENNA__1036__A Tile_X4Y0_N2MID[2] VPWR VGND sg13cmos5l_antennanp
X_0557_ NPU_WE1 Tile_X0Y0_UserCLK _0557_/D _0670_/L_HI VPWR VGND sg13cmos5l_dfrbpq_1
XFILLER_8_1619 VPWR VGND sg13cmos5l_decap_8
XANTENNA__0096__GATE Tile_X0Y0_FrameStrobe[0] VPWR VGND sg13cmos5l_antennanp
XANTENNA__0297__D Tile_X0Y0_FrameData[0] VPWR VGND sg13cmos5l_antennanp
X_0488_ _0488_/Q Tile_X0Y0_FrameData[17] VGND VPWR Tile_X3Y0_FrameStrobe[2] latch
XFILLER_6_2077 VPWR VGND sg13cmos5l_decap_4
XFILLER_6_1343 VPWR VGND sg13cmos5l_decap_4
X_1109_ _1109_/X Tile_X1Y0_N4END[13] Tile_X1Y0_N4END[14] Tile_X1Y0_NN4END[13] Tile_X1Y0_NN4END[15]
+ _0207_/Q _0206_/Q VPWR VGND sg13cmos5l_mux4_1
XFILLER_14_609 VPWR VGND sg13cmos5l_decap_8
XFILLER_13_2539 VPWR VGND sg13cmos5l_decap_8
XFILLER_13_1849 VPWR VGND sg13cmos5l_decap_8
XFILLER_11_2230 VPWR VGND sg13cmos5l_decap_8
XANTENNA__1220__A1 Tile_X2Y0_N4END[14] VPWR VGND sg13cmos5l_antennanp
XFILLER_1_568 VPWR VGND sg13cmos5l_fill_1
XANTENNA__0558__Q NPU_WE2 VPWR VGND sg13cmos5l_antennanp
XANTENNA__1287__A1 Tile_X3Y0_N4END[12] VPWR VGND sg13cmos5l_antennanp
XFILLER_2_2486 VPWR VGND sg13cmos5l_decap_4
XFILLER_2_1741 VPWR VGND sg13cmos5l_decap_8
XFILLER_16_2130 VPWR VGND sg13cmos5l_fill_2
XFILLER_13_653 VPWR VGND sg13cmos5l_decap_8
XFILLER_9_613 VPWR VGND sg13cmos5l_decap_8
XFILLER_16_2163 VPWR VGND sg13cmos5l_decap_8
XFILLER_16_2152 VPWR VGND sg13cmos5l_fill_1
XFILLER_12_130 VPWR VGND sg13cmos5l_decap_8
XFILLER_16_2185 VPWR VGND sg13cmos5l_decap_8
XFILLER_12_196 VPWR VGND sg13cmos5l_decap_4
XFILLER_16_1495 VPWR VGND sg13cmos5l_decap_8
XFILLER_12_1315 VPWR VGND sg13cmos5l_decap_8
XANTENNA__1211__A1 Tile_X2Y0_N2MID[0] VPWR VGND sg13cmos5l_antennanp
XFILLER_8_189 VPWR VGND sg13cmos5l_fill_2
XFILLER_10_1072 VPWR VGND sg13cmos5l_decap_8
X_0411_ _0411_/Q Tile_X0Y0_FrameData[30] VGND VPWR Tile_X3Y0_FrameStrobe[0] latch
X_0342_ _0342_/Q Tile_X0Y0_FrameData[3] VGND VPWR Tile_X2Y0_FrameStrobe[0] latch
XFILLER_7_2364 VPWR VGND sg13cmos5l_decap_8
XFILLER_7_1652 VPWR VGND sg13cmos5l_fill_2
XANTENNA__0695__A Tile_X0Y0_FrameStrobe[8] VPWR VGND sg13cmos5l_antennanp
X_0273_ _0273_/Q Tile_X0Y0_FrameData[24] VGND VPWR Tile_X1Y0_FrameStrobe[2] latch
XANTENNA__1278__A1 Tile_X3Y0_N4END[3] VPWR VGND sg13cmos5l_antennanp
XANTENNA__0982__X Tile_X0Y0_SS4BEG[7] VPWR VGND sg13cmos5l_antennanp
XANTENNA__0580__D NPU_RDATA8 VPWR VGND sg13cmos5l_antennanp
XANTENNA__1202__A1 Tile_X1Y0_N4END[7] VPWR VGND sg13cmos5l_antennanp
XFILLER_12_1882 VPWR VGND sg13cmos5l_decap_8
X_0609_ _0609_/L_HI VPWR VGND sg13cmos5l_tiehi
XANTENNA__1053__X Tile_X4Y0_S4BEG[6] VPWR VGND sg13cmos5l_antennanp
XFILLER_6_1151 VPWR VGND sg13cmos5l_decap_8
XANTENNA__1269__A1 Tile_X3Y0_N4END[5] VPWR VGND sg13cmos5l_antennanp
XANTENNA__0892__X Tile_X2Y0_S4BEG[9] VPWR VGND sg13cmos5l_antennanp
XFILLER_13_2336 VPWR VGND sg13cmos5l_decap_8
XFILLER_10_612 VPWR VGND sg13cmos5l_decap_8
XANTENNA__0490__D Tile_X0Y0_FrameData[15] VPWR VGND sg13cmos5l_antennanp
XFILLER_13_1657 VPWR VGND sg13cmos5l_decap_8
XFILLER_11_2082 VPWR VGND sg13cmos5l_decap_8
XFILLER_11_1392 VPWR VGND sg13cmos5l_fill_2
XFILLER_8_2684 VPWR VGND sg13cmos5l_decap_8
XFILLER_2_1582 VPWR VGND sg13cmos5l_decap_8
XFILLER_2_1571 VPWR VGND sg13cmos5l_fill_2
X_0960_ Tile_X1Y0_FrameStrobe_O[5] Tile_X1Y0_FrameStrobe[5] VPWR VGND sg13cmos5l_buf_1
X_0891_ Tile_X2Y0_S4BEG[8] _1227_/X VPWR VGND sg13cmos5l_buf_1
XFILLER_12_1112 VPWR VGND sg13cmos5l_decap_8
XANTENNA__1196__A0 Tile_X1Y0_N2END[1] VPWR VGND sg13cmos5l_antennanp
XANTENNA__0509__GATE Tile_X4Y0_FrameStrobe[0] VPWR VGND sg13cmos5l_antennanp
XFILLER_12_1189 VPWR VGND sg13cmos5l_decap_8
XANTENNA__0977__X Tile_X0Y0_SS4BEG[2] VPWR VGND sg13cmos5l_antennanp
XFILLER_9_2459 VPWR VGND sg13cmos5l_decap_8
XFILLER_4_170 VPWR VGND sg13cmos5l_fill_2
XFILLER_7_2150 VPWR VGND sg13cmos5l_fill_2
XFILLER_3_2014 VPWR VGND sg13cmos5l_decap_8
X_0325_ _0325_/Q Tile_X0Y0_FrameData[20] VGND VPWR Tile_X2Y0_FrameStrobe[0] latch
XFILLER_3_2025 VPWR VGND sg13cmos5l_fill_2
X_0256_ _0256_/Q Tile_X0Y0_FrameData[9] VGND VPWR Tile_X1Y0_FrameStrobe[1] latch
XANTENNA__0575__D NPU_RDATA3 VPWR VGND sg13cmos5l_antennanp
XANTENNA__1120__A0 Tile_X0Y0_N4END[8] VPWR VGND sg13cmos5l_antennanp
X_0187_ _0187_/Q Tile_X0Y0_FrameData[30] VGND VPWR Tile_X0Y0_FrameStrobe[3] latch
XFILLER_14_2612 VPWR VGND sg13cmos5l_decap_8
XFILLER_14_2689 VPWR VGND sg13cmos5l_decap_8
XFILLER_14_1955 VPWR VGND sg13cmos5l_decap_8
XANTENNA__1048__X Tile_X4Y0_S4BEG[1] VPWR VGND sg13cmos5l_antennanp
XANTENNA__1187__A0 Tile_X1Y0_N2MID[0] VPWR VGND sg13cmos5l_antennanp
XANTENNA__0887__X Tile_X2Y0_S4BEG[4] VPWR VGND sg13cmos5l_antennanp
XFILLER_8_1257 VPWR VGND sg13cmos5l_decap_8
XFILLER_3_2570 VPWR VGND sg13cmos5l_fill_2
XANTENNA__0485__D Tile_X0Y0_FrameData[20] VPWR VGND sg13cmos5l_antennanp
XANTENNA__1111__A0 Tile_X1Y0_N4END[12] VPWR VGND sg13cmos5l_antennanp
XFILLER_15_737 VPWR VGND sg13cmos5l_decap_8
XFILLER_15_715 VPWR VGND sg13cmos5l_decap_8
XFILLER_14_214 VPWR VGND sg13cmos5l_decap_8
XFILLER_14_269 VPWR VGND sg13cmos5l_decap_8
XFILLER_10_420 VPWR VGND sg13cmos5l_fill_2
XANTENNA__0571__Q NPU_ADDR7 VPWR VGND sg13cmos5l_antennanp
XFILLER_6_402 VPWR VGND sg13cmos5l_fill_2
XFILLER_13_61 VPWR VGND sg13cmos5l_fill_1
XANTENNA__1178__A0 Tile_X1Y0_N1END[3] VPWR VGND sg13cmos5l_antennanp
XFILLER_13_1487 VPWR VGND sg13cmos5l_decap_8
XANTENNA__0480__GATE Tile_X3Y0_FrameStrobe[2] VPWR VGND sg13cmos5l_antennanp
XFILLER_6_479 VPWR VGND sg13cmos5l_decap_4
XANTENNA__0797__X Tile_X3Y0_SS4BEG[2] VPWR VGND sg13cmos5l_antennanp
XFILLER_2_652 VPWR VGND sg13cmos5l_decap_8
XANTENNA__0495__GATE Tile_X3Y0_FrameStrobe[2] VPWR VGND sg13cmos5l_antennanp
XFILLER_4_1600 VPWR VGND sg13cmos5l_decap_8
X_0110_ _0110_/Q Tile_X0Y0_FrameData[11] VGND VPWR Tile_X0Y0_FrameStrobe[0] latch
XANTENNA__0395__D Tile_X0Y0_FrameData[14] VPWR VGND sg13cmos5l_antennanp
X_1090_ _1090_/X Tile_X3Y0_N1END[2] Tile_X3Y0_N2MID[2] Tile_X3Y0_N2MID[5] Tile_X3Y0_N2END[5]
+ _0421_/Q _0420_/Q VPWR VGND sg13cmos5l_mux4_1
XFILLER_4_1677 VPWR VGND sg13cmos5l_decap_8
XANTENNA__0973__A Tile_X1Y0_FrameStrobe[18] VPWR VGND sg13cmos5l_antennanp
XANTENNA__1102__A0 Tile_X1Y0_N4END[6] VPWR VGND sg13cmos5l_antennanp
XANTENNA__0433__GATE Tile_X3Y0_FrameStrobe[0] VPWR VGND sg13cmos5l_antennanp
XFILLER_14_781 VPWR VGND sg13cmos5l_decap_8
X_0943_ Tile_X2Y0_FrameStrobe_O[8] Tile_X2Y0_FrameStrobe[8] VPWR VGND sg13cmos5l_buf_1
XFILLER_14_1207 VPWR VGND sg13cmos5l_decap_8
XFILLER_13_280 VPWR VGND sg13cmos5l_fill_2
X_0874_ Tile_X2Y0_S2BEG[7] Tile_X2Y0_N2MID[0] VPWR VGND sg13cmos5l_buf_1
XANTENNA__1169__A0 Tile_X0Y0_N2END[6] VPWR VGND sg13cmos5l_antennanp
XANTENNA__0448__GATE Tile_X3Y0_FrameStrobe[1] VPWR VGND sg13cmos5l_antennanp
XFILLER_5_490 VPWR VGND sg13cmos5l_decap_8
XFILLER_9_2256 VPWR VGND sg13cmos5l_decap_8
XFILLER_5_2109 VPWR VGND sg13cmos5l_decap_8
XFILLER_9_1566 VPWR VGND sg13cmos5l_decap_8
XANTENNA__1044__A Tile_X4Y0_N2END[2] VPWR VGND sg13cmos5l_antennanp
XFILLER_0_2710 VPWR VGND sg13cmos5l_fill_1
X_0308_ _0308_/Q Tile_X0Y0_FrameData[21] VGND VPWR Tile_X1Y0_FrameStrobe[3] latch
XFILLER_0_2721 VPWR VGND sg13cmos5l_fill_1
X_1288_ _1288_/X Tile_X3Y0_N2END[5] Tile_X3Y0_N4END[13] Tile_X3Y0_NN4END[2] _0572_/Q
+ _0431_/Q _0430_/Q VPWR VGND sg13cmos5l_mux4_1
XFILLER_3_1143 VPWR VGND sg13cmos5l_fill_2
X_0239_ _0239_/Q Tile_X0Y0_FrameData[26] VGND VPWR Tile_X1Y0_FrameStrobe[1] latch
XFILLER_0_2787 VPWR VGND sg13cmos5l_fill_1
XFILLER_16_2718 VPWR VGND sg13cmos5l_decap_8
XFILLER_10_2328 VPWR VGND sg13cmos5l_decap_8
XFILLER_14_2486 VPWR VGND sg13cmos5l_decap_8
XFILLER_10_1627 VPWR VGND sg13cmos5l_decap_8
XFILLER_14_1774 VPWR VGND sg13cmos5l_decap_8
XFILLER_8_1087 VPWR VGND sg13cmos5l_decap_8
XFILLER_5_2676 VPWR VGND sg13cmos5l_decap_8
XFILLER_5_1953 VPWR VGND sg13cmos5l_decap_4
XANTENNA__0566__Q NPU_ADDR2 VPWR VGND sg13cmos5l_antennanp
XFILLER_15_556 VPWR VGND sg13cmos5l_decap_8
XFILLER_15_2217 VPWR VGND sg13cmos5l_fill_2
XFILLER_7_700 VPWR VGND sg13cmos5l_fill_1
XFILLER_7_733 VPWR VGND sg13cmos5l_fill_2
XFILLER_11_784 VPWR VGND sg13cmos5l_decap_4
XFILLER_10_283 VPWR VGND sg13cmos5l_decap_8
XFILLER_7_788 VPWR VGND sg13cmos5l_fill_2
XFILLER_6_287 VPWR VGND sg13cmos5l_decap_4
XFILLER_6_276 VPWR VGND sg13cmos5l_decap_8
XFILLER_6_265 VPWR VGND sg13cmos5l_decap_4
XFILLER_13_1273 VPWR VGND sg13cmos5l_decap_8
X_0590_ _0590_/Q Tile_X0Y0_UserCLK NPU_RDATA18 _0606_/L_HI VPWR VGND sg13cmos5l_dfrbpq_1
XANTENNA__0968__A Tile_X1Y0_FrameStrobe[13] VPWR VGND sg13cmos5l_antennanp
XFILLER_2_482 VPWR VGND sg13cmos5l_fill_2
X_1211_ _1211_/X Tile_X2Y0_N1END[0] Tile_X2Y0_N2MID[0] Tile_X2Y0_N2END[7] _0580_/Q
+ _0409_/Q _0408_/Q VPWR VGND sg13cmos5l_mux4_1
XFILLER_6_1739 VPWR VGND sg13cmos5l_decap_8
XFILLER_4_2131 VPWR VGND sg13cmos5l_decap_8
X_1142_ _1142_/X Tile_X0Y0_N2MID[3] Tile_X0Y0_N4END[12] Tile_X0Y0_NN4END[3] _0603_/Q
+ _0179_/Q _0178_/Q VPWR VGND sg13cmos5l_mux4_1
XFILLER_4_1463 VPWR VGND sg13cmos5l_decap_4
X_1073_ Tile_X4Y0_SS4BEG[10] Tile_X4Y0_NN4END[5] VPWR VGND sg13cmos5l_buf_1
XFILLER_4_1474 VPWR VGND sg13cmos5l_fill_2
XANTENNA__0372__GATE Tile_X2Y0_FrameStrobe[1] VPWR VGND sg13cmos5l_antennanp
XANTENNA__0990__X Tile_X0Y0_SS4BEG[15] VPWR VGND sg13cmos5l_antennanp
X_0926_ Tile_X3Y0_FrameStrobe_O[11] Tile_X3Y0_FrameStrobe[11] VPWR VGND sg13cmos5l_buf_1
XFILLER_11_2604 VPWR VGND sg13cmos5l_decap_8
XANTENNA__0387__GATE Tile_X2Y0_FrameStrobe[2] VPWR VGND sg13cmos5l_antennanp
XANTENNA__1039__A Tile_X4Y0_N2END[7] VPWR VGND sg13cmos5l_antennanp
X_0857_ Tile_X4Y0_FrameStrobe_O[14] Tile_X4Y0_FrameStrobe[14] VPWR VGND sg13cmos5l_buf_1
X_0788_ Tile_X3Y0_S4BEG[9] _1268_/X VPWR VGND sg13cmos5l_buf_1
XANTENNA__0310__GATE Tile_X1Y0_FrameStrobe[3] VPWR VGND sg13cmos5l_antennanp
XFILLER_9_2042 VPWR VGND sg13cmos5l_decap_8
XANTENNA__0325__GATE Tile_X2Y0_FrameStrobe[0] VPWR VGND sg13cmos5l_antennanp
XANTENNA__1061__X Tile_X4Y0_S4BEG[14] VPWR VGND sg13cmos5l_antennanp
XFILLER_0_2540 VPWR VGND sg13cmos5l_decap_8
XFILLER_0_1850 VPWR VGND sg13cmos5l_fill_1
XFILLER_0_2573 VPWR VGND sg13cmos5l_decap_4
XANTENNA__1093__A2 Tile_X3Y0_N2MID[5] VPWR VGND sg13cmos5l_antennanp
XFILLER_12_515 VPWR VGND sg13cmos5l_fill_1
XFILLER_12_504 VPWR VGND sg13cmos5l_decap_8
XFILLER_16_1836 VPWR VGND sg13cmos5l_decap_8
XFILLER_12_548 VPWR VGND sg13cmos5l_decap_8
XFILLER_14_2250 VPWR VGND sg13cmos5l_decap_8
XFILLER_10_1468 VPWR VGND sg13cmos5l_decap_8
XFILLER_10_1479 VPWR VGND sg13cmos5l_fill_1
XFILLER_10_51 VPWR VGND sg13cmos5l_decap_4
XFILLER_3_279 VPWR VGND sg13cmos5l_decap_4
XFILLER_0_942 VPWR VGND sg13cmos5l_fill_1
XFILLER_5_2473 VPWR VGND sg13cmos5l_decap_8
XFILLER_1_2304 VPWR VGND sg13cmos5l_decap_4
XFILLER_1_1625 VPWR VGND sg13cmos5l_decap_8
XFILLER_16_843 VPWR VGND sg13cmos5l_decap_8
XANTENNA__1084__A2 Tile_X2Y0_N2MID[4] VPWR VGND sg13cmos5l_antennanp
XFILLER_15_1324 VPWR VGND sg13cmos5l_decap_8
X_0711_ Tile_X1Y0_S2BEGb[4] _1175_/X VPWR VGND sg13cmos5l_buf_1
XFILLER_15_1368 VPWR VGND sg13cmos5l_decap_8
XFILLER_11_570 VPWR VGND sg13cmos5l_decap_8
XFILLER_7_552 VPWR VGND sg13cmos5l_decap_8
X_0642_ _0642_/L_HI VPWR VGND sg13cmos5l_tiehi
XFILLER_10_2681 VPWR VGND sg13cmos5l_decap_8
XANTENNA__0698__A Tile_X0Y0_FrameStrobe[11] VPWR VGND sg13cmos5l_antennanp
X_0573_ _0573_/Q Tile_X0Y0_UserCLK NPU_RDATA1 _0649_/L_HI VPWR VGND sg13cmos5l_dfrbpq_1
XFILLER_6_2237 VPWR VGND sg13cmos5l_decap_8
XANTENNA__0985__X Tile_X0Y0_SS4BEG[10] VPWR VGND sg13cmos5l_antennanp
X_1125_ _1125_/X Tile_X0Y0_N4END[13] Tile_X0Y0_N4END[14] Tile_X0Y0_NN4END[13] Tile_X0Y0_NN4END[15]
+ _0095_/Q _0094_/Q VPWR VGND sg13cmos5l_mux4_1
XANTENNA__0583__D NPU_RDATA11 VPWR VGND sg13cmos5l_antennanp
X_1056_ Tile_X4Y0_S4BEG[9] Tile_X4Y0_N4END[6] VPWR VGND sg13cmos5l_buf_1
XFILLER_11_2412 VPWR VGND sg13cmos5l_decap_8
X_0909_ Tile_X2Y0_SS4BEG[10] _1245_/X VPWR VGND sg13cmos5l_buf_1
XFILLER_11_2489 VPWR VGND sg13cmos5l_decap_8
XFILLER_11_1755 VPWR VGND sg13cmos5l_decap_8
XFILLER_1_706 VPWR VGND sg13cmos5l_fill_2
XANTENNA__1056__X Tile_X4Y0_S4BEG[9] VPWR VGND sg13cmos5l_antennanp
XANTENNA__0264__GATE Tile_X1Y0_FrameStrobe[1] VPWR VGND sg13cmos5l_antennanp
XANTENNA__0895__X Tile_X2Y0_S4BEG[12] VPWR VGND sg13cmos5l_antennanp
XFILLER_2_2602 VPWR VGND sg13cmos5l_decap_8
XFILLER_2_2635 VPWR VGND sg13cmos5l_decap_4
XANTENNA__0279__GATE Tile_X1Y0_FrameStrobe[2] VPWR VGND sg13cmos5l_antennanp
XFILLER_16_128 VPWR VGND sg13cmos5l_decap_8
XANTENNA__0493__D Tile_X0Y0_FrameData[12] VPWR VGND sg13cmos5l_antennanp
XFILLER_16_2312 VPWR VGND sg13cmos5l_fill_1
XFILLER_12_312 VPWR VGND sg13cmos5l_decap_8
XANTENNA__0202__GATE Tile_X0Y0_FrameStrobe[0] VPWR VGND sg13cmos5l_antennanp
XANTENNA__0536__CLK Tile_X0Y0_UserCLK VPWR VGND sg13cmos5l_antennanp
XFILLER_13_857 VPWR VGND sg13cmos5l_fill_2
XFILLER_16_2367 VPWR VGND sg13cmos5l_decap_8
XANTENNA_90 Tile_X0Y0_FrameData[14] VPWR VGND sg13cmos5l_antennanp
XFILLER_16_1699 VPWR VGND sg13cmos5l_decap_8
XANTENNA__0217__GATE Tile_X1Y0_FrameStrobe[0] VPWR VGND sg13cmos5l_antennanp
XFILLER_10_1232 VPWR VGND sg13cmos5l_decap_8
XFILLER_4_566 VPWR VGND sg13cmos5l_decap_8
XFILLER_7_2535 VPWR VGND sg13cmos5l_decap_8
XFILLER_7_1812 VPWR VGND sg13cmos5l_decap_8
XFILLER_0_761 VPWR VGND sg13cmos5l_fill_2
XFILLER_1_2167 VPWR VGND sg13cmos5l_decap_8
XFILLER_16_662 VPWR VGND sg13cmos5l_decap_8
XFILLER_15_150 VPWR VGND sg13cmos5l_decap_8
XFILLER_12_2710 VPWR VGND sg13cmos5l_decap_8
XFILLER_15_1132 VPWR VGND sg13cmos5l_decap_8
XFILLER_12_2743 VPWR VGND sg13cmos5l_decap_8
XFILLER_8_883 VPWR VGND sg13cmos5l_decap_4
XFILLER_7_371 VPWR VGND sg13cmos5l_fill_2
XFILLER_12_2798 VPWR VGND sg13cmos5l_fill_2
X_0625_ _0625_/L_HI VPWR VGND sg13cmos5l_tiehi
X_0556_ NPU_WE0 Tile_X0Y0_UserCLK _0556_/D _0671_/L_HI VPWR VGND sg13cmos5l_dfrbpq_1
XANTENNA__0578__D NPU_RDATA6 VPWR VGND sg13cmos5l_antennanp
X_0487_ _0487_/Q Tile_X0Y0_FrameData[18] VGND VPWR Tile_X3Y0_FrameStrobe[2] latch
XFILLER_6_1322 VPWR VGND sg13cmos5l_decap_8
XFILLER_6_1377 VPWR VGND sg13cmos5l_fill_2
XFILLER_2_1208 VPWR VGND sg13cmos5l_fill_2
XANTENNA__1052__A Tile_X4Y0_N4END[10] VPWR VGND sg13cmos5l_antennanp
XANTENNA__0559__CLK Tile_X0Y0_UserCLK VPWR VGND sg13cmos5l_antennanp
X_1108_ _1108_/X Tile_X1Y0_N4END[12] Tile_X1Y0_N4END[13] Tile_X1Y0_NN4END[12] Tile_X1Y0_NN4END[14]
+ _0209_/Q _0208_/Q VPWR VGND sg13cmos5l_mux4_1
XFILLER_1_2690 VPWR VGND sg13cmos5l_fill_2
X_1039_ Tile_X4Y0_S2BEGb[0] Tile_X4Y0_N2END[7] VPWR VGND sg13cmos5l_buf_1
XFILLER_13_2518 VPWR VGND sg13cmos5l_decap_8
XFILLER_13_1828 VPWR VGND sg13cmos5l_decap_8
XFILLER_10_849 VPWR VGND sg13cmos5l_fill_2
XANTENNA__1220__A2 Tile_X2Y0_NN4END[1] VPWR VGND sg13cmos5l_antennanp
XFILLER_11_2286 VPWR VGND sg13cmos5l_decap_8
XFILLER_11_1530 VPWR VGND sg13cmos5l_decap_8
XFILLER_1_547 VPWR VGND sg13cmos5l_decap_8
XANTENNA__0488__D Tile_X0Y0_FrameData[17] VPWR VGND sg13cmos5l_antennanp
XANTENNA__1287__A2 Tile_X3Y0_NN4END[3] VPWR VGND sg13cmos5l_antennanp
XFILLER_2_2465 VPWR VGND sg13cmos5l_decap_8
XFILLER_2_1720 VPWR VGND sg13cmos5l_decap_8
XANTENNA__0141__GATE Tile_X0Y0_FrameStrobe[1] VPWR VGND sg13cmos5l_antennanp
XFILLER_2_1797 VPWR VGND sg13cmos5l_fill_2
XFILLER_13_632 VPWR VGND sg13cmos5l_decap_8
XFILLER_8_102 VPWR VGND sg13cmos5l_fill_2
XFILLER_9_669 VPWR VGND sg13cmos5l_decap_8
XFILLER_12_2039 VPWR VGND sg13cmos5l_decap_8
XFILLER_12_175 VPWR VGND sg13cmos5l_decap_8
XANTENNA__0156__GATE Tile_X0Y0_FrameStrobe[2] VPWR VGND sg13cmos5l_antennanp
XANTENNA__1211__A2 Tile_X2Y0_N2END[7] VPWR VGND sg13cmos5l_antennanp
XFILLER_10_1051 VPWR VGND sg13cmos5l_decap_8
XFILLER_4_374 VPWR VGND sg13cmos5l_decap_8
X_0410_ _0410_/Q Tile_X0Y0_FrameData[31] VGND VPWR Tile_X2Y0_FrameStrobe[0] latch
XANTENNA__0398__D Tile_X0Y0_FrameData[11] VPWR VGND sg13cmos5l_antennanp
X_0341_ _0341_/Q Tile_X0Y0_FrameData[4] VGND VPWR Tile_X2Y0_FrameStrobe[0] latch
XFILLER_7_2343 VPWR VGND sg13cmos5l_decap_8
XFILLER_7_1631 VPWR VGND sg13cmos5l_decap_8
X_0272_ _0272_/Q Tile_X0Y0_FrameData[25] VGND VPWR Tile_X1Y0_FrameStrobe[2] latch
XANTENNA__1278__A2 Tile_X3Y0_NN4END[12] VPWR VGND sg13cmos5l_antennanp
XANTENNA__0109__GATE Tile_X0Y0_FrameStrobe[0] VPWR VGND sg13cmos5l_antennanp
XFILLER_1_1285 VPWR VGND sg13cmos5l_fill_2
XFILLER_16_492 VPWR VGND sg13cmos5l_decap_8
XFILLER_12_2540 VPWR VGND sg13cmos5l_fill_1
XANTENNA__1202__A2 Tile_X1Y0_NN4END[8] VPWR VGND sg13cmos5l_antennanp
XFILLER_12_1861 VPWR VGND sg13cmos5l_decap_8
XANTENNA__1047__A Tile_X4Y0_N4END[15] VPWR VGND sg13cmos5l_antennanp
X_0608_ _0608_/L_HI VPWR VGND sg13cmos5l_tiehi
X_0539_ NPU_WDATA15 Tile_X0Y0_UserCLK _1111_/X _0662_/L_HI VPWR VGND sg13cmos5l_dfrbpq_1
XANTENNA__0101__D Tile_X0Y0_FrameData[20] VPWR VGND sg13cmos5l_antennanp
XFILLER_6_1130 VPWR VGND sg13cmos5l_decap_8
XANTENNA__1269__A2 Tile_X3Y0_NN4END[10] VPWR VGND sg13cmos5l_antennanp
XFILLER_13_2315 VPWR VGND sg13cmos5l_decap_8
XFILLER_13_1636 VPWR VGND sg13cmos5l_decap_8
XFILLER_10_668 VPWR VGND sg13cmos5l_decap_8
XFILLER_6_628 VPWR VGND sg13cmos5l_decap_8
XFILLER_2_812 VPWR VGND sg13cmos5l_decap_4
XFILLER_11_1371 VPWR VGND sg13cmos5l_decap_8
XFILLER_1_333 VPWR VGND sg13cmos5l_decap_4
XANTENNA__0569__Q NPU_ADDR5 VPWR VGND sg13cmos5l_antennanp
XFILLER_8_2663 VPWR VGND sg13cmos5l_decap_8
XFILLER_4_2549 VPWR VGND sg13cmos5l_decap_8
XFILLER_2_2284 VPWR VGND sg13cmos5l_decap_8
XFILLER_14_930 VPWR VGND sg13cmos5l_decap_4
XANTENNA__0095__GATE Tile_X0Y0_FrameStrobe[0] VPWR VGND sg13cmos5l_antennanp
X_0890_ Tile_X2Y0_S4BEG[7] _1226_/X VPWR VGND sg13cmos5l_buf_1
XFILLER_13_495 VPWR VGND sg13cmos5l_fill_1
XFILLER_13_484 VPWR VGND sg13cmos5l_fill_1
XFILLER_16_1293 VPWR VGND sg13cmos5l_decap_8
XANTENNA__1196__A1 Tile_X1Y0_N4END[1] VPWR VGND sg13cmos5l_antennanp
XFILLER_12_1168 VPWR VGND sg13cmos5l_decap_8
XFILLER_9_2438 VPWR VGND sg13cmos5l_decap_8
XFILLER_5_694 VPWR VGND sg13cmos5l_decap_8
XFILLER_9_1748 VPWR VGND sg13cmos5l_fill_1
XFILLER_4_53 VPWR VGND sg13cmos5l_fill_1
X_0324_ _0324_/Q Tile_X0Y0_FrameData[21] VGND VPWR Tile_X2Y0_FrameStrobe[0] latch
XANTENNA__0993__X Tile_X0Y0_S4BEG[2] VPWR VGND sg13cmos5l_antennanp
X_0255_ _0255_/Q Tile_X0Y0_FrameData[10] VGND VPWR Tile_X1Y0_FrameStrobe[1] latch
XANTENNA__1120__A1 Tile_X0Y0_N4END[9] VPWR VGND sg13cmos5l_antennanp
X_0186_ _0186_/Q Tile_X0Y0_FrameData[31] VGND VPWR Tile_X0Y0_FrameStrobe[3] latch
XFILLER_1_1060 VPWR VGND sg13cmos5l_decap_8
XFILLER_1_1071 VPWR VGND sg13cmos5l_decap_8
XANTENNA__0591__D NPU_RDATA19 VPWR VGND sg13cmos5l_antennanp
XFILLER_14_2668 VPWR VGND sg13cmos5l_decap_8
XFILLER_14_1934 VPWR VGND sg13cmos5l_decap_8
XANTENNA__1187__A1 Tile_X1Y0_N4END[7] VPWR VGND sg13cmos5l_antennanp
XANTENNA__1064__X Tile_X4Y0_SS4BEG[1] VPWR VGND sg13cmos5l_antennanp
XFILLER_8_1236 VPWR VGND sg13cmos5l_decap_8
XANTENNA__1111__A1 Tile_X1Y0_N4END[15] VPWR VGND sg13cmos5l_antennanp
XFILLER_11_922 VPWR VGND sg13cmos5l_fill_2
XFILLER_10_410 VPWR VGND sg13cmos5l_fill_2
XFILLER_13_2189 VPWR VGND sg13cmos5l_decap_8
XANTENNA__1178__A1 Tile_X1Y0_N2MID[7] VPWR VGND sg13cmos5l_antennanp
XFILLER_13_1466 VPWR VGND sg13cmos5l_decap_8
XFILLER_2_631 VPWR VGND sg13cmos5l_decap_8
XFILLER_1_130 VPWR VGND sg13cmos5l_fill_2
XFILLER_8_1792 VPWR VGND sg13cmos5l_decap_8
XFILLER_4_1656 VPWR VGND sg13cmos5l_decap_8
XANTENNA__1102__A1 Tile_X1Y0_N4END[7] VPWR VGND sg13cmos5l_antennanp
X_0942_ Tile_X2Y0_FrameStrobe_O[7] Tile_X2Y0_FrameStrobe[7] VPWR VGND sg13cmos5l_buf_1
XFILLER_13_292 VPWR VGND sg13cmos5l_decap_8
XFILLER_11_2808 VPWR VGND sg13cmos5l_fill_1
X_0873_ Tile_X2Y0_S2BEG[6] Tile_X2Y0_N2MID[1] VPWR VGND sg13cmos5l_buf_1
XANTENNA__1169__A1 Tile_X0Y0_N4END[14] VPWR VGND sg13cmos5l_antennanp
XFILLER_16_1090 VPWR VGND sg13cmos5l_fill_2
XANTENNA__0988__X Tile_X0Y0_SS4BEG[13] VPWR VGND sg13cmos5l_antennanp
XFILLER_9_2235 VPWR VGND sg13cmos5l_decap_8
XFILLER_6_992 VPWR VGND sg13cmos5l_decap_8
XFILLER_9_1589 VPWR VGND sg13cmos5l_fill_1
XANTENNA__0586__D NPU_RDATA14 VPWR VGND sg13cmos5l_antennanp
X_0307_ _0307_/Q Tile_X0Y0_FrameData[22] VGND VPWR Tile_X1Y0_FrameStrobe[3] latch
X_1287_ _1287_/X Tile_X3Y0_N2END[4] Tile_X3Y0_N4END[12] Tile_X3Y0_NN4END[3] _0573_/Q
+ _0433_/Q _0432_/Q VPWR VGND sg13cmos5l_mux4_1
XFILLER_3_1122 VPWR VGND sg13cmos5l_decap_8
XFILLER_0_2744 VPWR VGND sg13cmos5l_fill_1
XFILLER_0_2755 VPWR VGND sg13cmos5l_decap_4
X_0238_ _0238_/Q Tile_X0Y0_FrameData[27] VGND VPWR Tile_X1Y0_FrameStrobe[1] latch
XFILLER_3_1188 VPWR VGND sg13cmos5l_decap_8
XANTENNA__1060__A Tile_X4Y0_N4END[2] VPWR VGND sg13cmos5l_antennanp
X_0169_ _0169_/Q Tile_X0Y0_FrameData[16] VGND VPWR Tile_X0Y0_FrameStrobe[2] latch
XANTENNA__1059__X Tile_X4Y0_S4BEG[12] VPWR VGND sg13cmos5l_antennanp
XFILLER_10_2307 VPWR VGND sg13cmos5l_decap_8
XFILLER_14_2465 VPWR VGND sg13cmos5l_decap_8
XFILLER_14_1753 VPWR VGND sg13cmos5l_decap_8
XFILLER_10_1606 VPWR VGND sg13cmos5l_decap_8
XANTENNA__0898__X Tile_X2Y0_S4BEG[15] VPWR VGND sg13cmos5l_antennanp
XFILLER_8_1011 VPWR VGND sg13cmos5l_fill_2
XFILLER_8_1066 VPWR VGND sg13cmos5l_decap_8
XFILLER_5_2655 VPWR VGND sg13cmos5l_decap_8
XFILLER_5_1910 VPWR VGND sg13cmos5l_decap_8
XANTENNA__0496__D Tile_X0Y0_FrameData[9] VPWR VGND sg13cmos5l_antennanp
XFILLER_1_2519 VPWR VGND sg13cmos5l_fill_2
XFILLER_1_2508 VPWR VGND sg13cmos5l_decap_8
XFILLER_1_1829 VPWR VGND sg13cmos5l_decap_4
XANTENNA__1096__A0 Tile_X1Y0_N4END[0] VPWR VGND sg13cmos5l_antennanp
XANTENNA__0508__GATE Tile_X4Y0_FrameStrobe[0] VPWR VGND sg13cmos5l_antennanp
XFILLER_10_262 VPWR VGND sg13cmos5l_decap_8
XFILLER_13_1252 VPWR VGND sg13cmos5l_decap_8
XFILLER_6_2419 VPWR VGND sg13cmos5l_fill_1
X_1210_ _1210_/X Tile_X1Y0_N2END[7] Tile_X1Y0_N4END[15] Tile_X1Y0_NN4END[0] _0588_/Q
+ _0235_/Q _0234_/Q VPWR VGND sg13cmos5l_mux4_1
X_1141_ _1141_/X Tile_X0Y0_N2MID[2] Tile_X0Y0_N4END[13] Tile_X0Y0_NN4END[2] _0602_/Q
+ _0181_/Q _0180_/Q VPWR VGND sg13cmos5l_mux4_1
XFILLER_4_1420 VPWR VGND sg13cmos5l_decap_4
XFILLER_0_2007 VPWR VGND sg13cmos5l_fill_1
XFILLER_0_2018 VPWR VGND sg13cmos5l_fill_1
XFILLER_4_2187 VPWR VGND sg13cmos5l_decap_4
XFILLER_4_1431 VPWR VGND sg13cmos5l_decap_8
XFILLER_1_65 VPWR VGND sg13cmos5l_fill_1
X_1072_ Tile_X4Y0_SS4BEG[9] Tile_X4Y0_NN4END[6] VPWR VGND sg13cmos5l_buf_1
XANTENNA__1087__A0 Tile_X2Y0_N1END[3] VPWR VGND sg13cmos5l_antennanp
XFILLER_0_1339 VPWR VGND sg13cmos5l_decap_8
XANTENNA__0592__CLK Tile_X0Y0_UserCLK VPWR VGND sg13cmos5l_antennanp
X_0925_ Tile_X3Y0_FrameStrobe_O[10] Tile_X3Y0_FrameStrobe[10] VPWR VGND sg13cmos5l_buf_1
XFILLER_15_2774 VPWR VGND sg13cmos5l_decap_8
X_0856_ Tile_X4Y0_FrameStrobe_O[13] Tile_X4Y0_FrameStrobe[13] VPWR VGND sg13cmos5l_buf_1
XFILLER_11_1948 VPWR VGND sg13cmos5l_fill_2
XFILLER_11_1937 VPWR VGND sg13cmos5l_decap_8
X_0787_ Tile_X3Y0_S4BEG[8] _1267_/X VPWR VGND sg13cmos5l_buf_1
XFILLER_0_409 VPWR VGND sg13cmos5l_fill_1
XFILLER_9_2021 VPWR VGND sg13cmos5l_decap_8
XANTENNA__1055__A Tile_X4Y0_N4END[7] VPWR VGND sg13cmos5l_antennanp
XFILLER_0_1840 VPWR VGND sg13cmos5l_fill_1
XANTENNA__1093__A3 Tile_X3Y0_N2END[2] VPWR VGND sg13cmos5l_antennanp
XFILLER_16_2549 VPWR VGND sg13cmos5l_decap_8
XFILLER_8_509 VPWR VGND sg13cmos5l_decap_8
XFILLER_16_1815 VPWR VGND sg13cmos5l_decap_4
XANTENNA__0494__GATE Tile_X3Y0_FrameStrobe[2] VPWR VGND sg13cmos5l_antennanp
XANTENNA__1250__A0 Tile_X2Y0_N2END[7] VPWR VGND sg13cmos5l_antennanp
XFILLER_10_2115 VPWR VGND sg13cmos5l_fill_1
XFILLER_10_1403 VPWR VGND sg13cmos5l_decap_8
XFILLER_10_1447 VPWR VGND sg13cmos5l_decap_8
XFILLER_0_921 VPWR VGND sg13cmos5l_fill_2
XFILLER_5_2430 VPWR VGND sg13cmos5l_decap_8
XANTENNA__0432__GATE Tile_X3Y0_FrameStrobe[0] VPWR VGND sg13cmos5l_antennanp
XFILLER_0_976 VPWR VGND sg13cmos5l_fill_1
XFILLER_0_987 VPWR VGND sg13cmos5l_fill_2
XFILLER_5_2452 VPWR VGND sg13cmos5l_decap_8
XFILLER_5_1784 VPWR VGND sg13cmos5l_fill_1
XFILLER_1_1604 VPWR VGND sg13cmos5l_decap_8
XANTENNA__0447__GATE Tile_X3Y0_FrameStrobe[1] VPWR VGND sg13cmos5l_antennanp
XFILLER_16_822 VPWR VGND sg13cmos5l_decap_8
XFILLER_15_332 VPWR VGND sg13cmos5l_fill_2
XANTENNA__1084__A3 Tile_X2Y0_N2END[3] VPWR VGND sg13cmos5l_antennanp
XFILLER_15_2015 VPWR VGND sg13cmos5l_decap_4
XFILLER_15_2037 VPWR VGND sg13cmos5l_decap_8
XFILLER_15_1303 VPWR VGND sg13cmos5l_decap_8
XANTENNA__1241__A0 Tile_X2Y0_N2END[6] VPWR VGND sg13cmos5l_antennanp
X_0710_ Tile_X1Y0_S2BEGb[3] _1174_/X VPWR VGND sg13cmos5l_buf_1
XFILLER_7_531 VPWR VGND sg13cmos5l_decap_8
X_0641_ _0641_/L_HI VPWR VGND sg13cmos5l_tiehi
XFILLER_10_2660 VPWR VGND sg13cmos5l_decap_8
XFILLER_10_1981 VPWR VGND sg13cmos5l_decap_4
X_0572_ _0572_/Q Tile_X0Y0_UserCLK NPU_RDATA0 _0650_/L_HI VPWR VGND sg13cmos5l_dfrbpq_1
XFILLER_6_2216 VPWR VGND sg13cmos5l_decap_8
X_1124_ _1124_/X Tile_X0Y0_N4END[12] Tile_X0Y0_N4END[13] Tile_X0Y0_NN4END[12] Tile_X0Y0_NN4END[14]
+ _0097_/Q _0096_/Q VPWR VGND sg13cmos5l_mux4_1
XFILLER_4_1250 VPWR VGND sg13cmos5l_fill_1
XFILLER_0_1114 VPWR VGND sg13cmos5l_decap_4
X_1055_ Tile_X4Y0_S4BEG[8] Tile_X4Y0_N4END[7] VPWR VGND sg13cmos5l_buf_1
XFILLER_4_1283 VPWR VGND sg13cmos5l_fill_2
XFILLER_4_1272 VPWR VGND sg13cmos5l_fill_1
XANTENNA__1232__A0 Tile_X2Y0_N2MID[5] VPWR VGND sg13cmos5l_antennanp
X_0908_ Tile_X2Y0_SS4BEG[9] _1244_/X VPWR VGND sg13cmos5l_buf_1
XFILLER_11_2468 VPWR VGND sg13cmos5l_decap_8
XFILLER_11_1734 VPWR VGND sg13cmos5l_decap_8
X_0839_ Tile_X4Y0_FrameData_O[28] Tile_X0Y0_FrameData[28] VPWR VGND sg13cmos5l_buf_1
XANTENNA__0104__D Tile_X0Y0_FrameData[17] VPWR VGND sg13cmos5l_antennanp
XANTENNA__1072__X Tile_X4Y0_SS4BEG[9] VPWR VGND sg13cmos5l_antennanp
XFILLER_5_1069 VPWR VGND sg13cmos5l_decap_8
XFILLER_2_1935 VPWR VGND sg13cmos5l_decap_8
XFILLER_2_1946 VPWR VGND sg13cmos5l_fill_2
XFILLER_16_107 VPWR VGND sg13cmos5l_decap_8
XFILLER_0_2393 VPWR VGND sg13cmos5l_decap_8
XFILLER_16_2324 VPWR VGND sg13cmos5l_fill_1
XFILLER_16_2302 VPWR VGND sg13cmos5l_fill_2
XFILLER_16_2346 VPWR VGND sg13cmos5l_decap_8
XFILLER_13_836 VPWR VGND sg13cmos5l_decap_8
XFILLER_8_328 VPWR VGND sg13cmos5l_decap_8
XANTENNA__1223__A0 Tile_X2Y0_N2MID[4] VPWR VGND sg13cmos5l_antennanp
XFILLER_16_1678 VPWR VGND sg13cmos5l_decap_8
XFILLER_16_1667 VPWR VGND sg13cmos5l_fill_1
XANTENNA_80 Tile_X0Y0_FrameData[3] VPWR VGND sg13cmos5l_antennanp
XANTENNA_91 Tile_X0Y0_FrameData[15] VPWR VGND sg13cmos5l_antennanp
XFILLER_14_2092 VPWR VGND sg13cmos5l_decap_8
XFILLER_10_1211 VPWR VGND sg13cmos5l_decap_8
XFILLER_4_545 VPWR VGND sg13cmos5l_decap_8
XFILLER_10_1288 VPWR VGND sg13cmos5l_decap_8
XFILLER_7_2514 VPWR VGND sg13cmos5l_decap_8
XANTENNA__0371__GATE Tile_X2Y0_FrameStrobe[1] VPWR VGND sg13cmos5l_antennanp
XFILLER_0_795 VPWR VGND sg13cmos5l_decap_8
XFILLER_5_2293 VPWR VGND sg13cmos5l_decap_8
XANTENNA__0386__GATE Tile_X2Y0_FrameStrobe[2] VPWR VGND sg13cmos5l_antennanp
XFILLER_5_1592 VPWR VGND sg13cmos5l_decap_8
XFILLER_1_1467 VPWR VGND sg13cmos5l_fill_1
XFILLER_16_696 VPWR VGND sg13cmos5l_decap_8
XFILLER_15_1111 VPWR VGND sg13cmos5l_decap_8
XANTENNA__1214__A0 Tile_X2Y0_N1END[3] VPWR VGND sg13cmos5l_antennanp
XFILLER_12_2722 VPWR VGND sg13cmos5l_decap_8
XANTENNA__0324__GATE Tile_X2Y0_FrameStrobe[0] VPWR VGND sg13cmos5l_antennanp
XFILLER_8_873 VPWR VGND sg13cmos5l_fill_2
XFILLER_15_1188 VPWR VGND sg13cmos5l_decap_8
XFILLER_7_86 VPWR VGND sg13cmos5l_fill_2
X_0624_ _0624_/L_HI VPWR VGND sg13cmos5l_tiehi
XFILLER_7_394 VPWR VGND sg13cmos5l_decap_8
XANTENNA__0996__X Tile_X0Y0_S4BEG[5] VPWR VGND sg13cmos5l_antennanp
XANTENNA__0339__GATE Tile_X2Y0_FrameStrobe[0] VPWR VGND sg13cmos5l_antennanp
X_0555_ NPU_WDATA31 Tile_X0Y0_UserCLK _1127_/X _0678_/L_HI VPWR VGND sg13cmos5l_dfrbpq_1
X_0486_ _0486_/Q Tile_X0Y0_FrameData[19] VGND VPWR Tile_X3Y0_FrameStrobe[2] latch
XANTENNA__0594__D NPU_RDATA22 VPWR VGND sg13cmos5l_antennanp
X_1107_ _1107_/X Tile_X1Y0_N4END[8] Tile_X1Y0_N4END[11] Tile_X1Y0_NN4END[9] Tile_X1Y0_NN4END[11]
+ _0211_/Q _0210_/Q VPWR VGND sg13cmos5l_mux4_1
X_1038_ Tile_X4Y0_S2BEG[7] Tile_X4Y0_N2MID[0] VPWR VGND sg13cmos5l_buf_1
XANTENNA__1205__A0 Tile_X1Y0_N2END[2] VPWR VGND sg13cmos5l_antennanp
XFILLER_13_1807 VPWR VGND sg13cmos5l_decap_8
XFILLER_10_828 VPWR VGND sg13cmos5l_decap_8
XFILLER_11_2265 VPWR VGND sg13cmos5l_decap_8
XANTENNA__1067__X Tile_X4Y0_SS4BEG[4] VPWR VGND sg13cmos5l_antennanp
XFILLER_1_526 VPWR VGND sg13cmos5l_decap_8
XFILLER_6_2591 VPWR VGND sg13cmos5l_decap_8
XFILLER_2_2444 VPWR VGND sg13cmos5l_decap_8
XFILLER_13_600 VPWR VGND sg13cmos5l_decap_8
XFILLER_16_84 VPWR VGND sg13cmos5l_decap_8
XFILLER_16_2132 VPWR VGND sg13cmos5l_fill_1
XFILLER_16_2121 VPWR VGND sg13cmos5l_fill_2
XFILLER_13_611 VPWR VGND sg13cmos5l_decap_8
XFILLER_16_2143 VPWR VGND sg13cmos5l_decap_8
XFILLER_12_154 VPWR VGND sg13cmos5l_decap_8
XFILLER_9_648 VPWR VGND sg13cmos5l_decap_8
XFILLER_16_1453 VPWR VGND sg13cmos5l_decap_8
XFILLER_13_688 VPWR VGND sg13cmos5l_decap_8
XFILLER_12_2029 VPWR VGND sg13cmos5l_decap_8
XFILLER_5_854 VPWR VGND sg13cmos5l_fill_2
XFILLER_4_364 VPWR VGND sg13cmos5l_fill_2
XFILLER_7_2322 VPWR VGND sg13cmos5l_decap_8
X_0340_ _0340_/Q Tile_X0Y0_FrameData[5] VGND VPWR Tile_X2Y0_FrameStrobe[0] latch
XFILLER_7_1610 VPWR VGND sg13cmos5l_decap_8
X_0271_ _0271_/Q Tile_X0Y0_FrameData[26] VGND VPWR Tile_X1Y0_FrameStrobe[2] latch
XFILLER_7_2399 VPWR VGND sg13cmos5l_decap_8
XFILLER_3_1518 VPWR VGND sg13cmos5l_decap_8
XANTENNA__0263__GATE Tile_X1Y0_FrameStrobe[1] VPWR VGND sg13cmos5l_antennanp
XFILLER_8_670 VPWR VGND sg13cmos5l_decap_4
XFILLER_12_1840 VPWR VGND sg13cmos5l_decap_8
XANTENNA__0278__GATE Tile_X1Y0_FrameStrobe[2] VPWR VGND sg13cmos5l_antennanp
XANTENNA__0589__D NPU_RDATA17 VPWR VGND sg13cmos5l_antennanp
XFILLER_8_2108 VPWR VGND sg13cmos5l_decap_8
X_0607_ _0607_/L_HI VPWR VGND sg13cmos5l_tiehi
X_0538_ NPU_WDATA14 Tile_X0Y0_UserCLK _1110_/X _0663_/L_HI VPWR VGND sg13cmos5l_dfrbpq_1
XANTENNA__0201__GATE Tile_X0Y0_FrameStrobe[3] VPWR VGND sg13cmos5l_antennanp
XANTENNA__0526__CLK Tile_X0Y0_UserCLK VPWR VGND sg13cmos5l_antennanp
XANTENNA__1063__A Tile_X4Y0_NN4END[15] VPWR VGND sg13cmos5l_antennanp
X_0469_ _0469_/Q Tile_X0Y0_FrameData[4] VGND VPWR Tile_X3Y0_FrameStrobe[1] latch
XFILLER_6_1186 VPWR VGND sg13cmos5l_decap_8
XFILLER_3_2764 VPWR VGND sg13cmos5l_decap_8
XFILLER_2_1006 VPWR VGND sg13cmos5l_decap_4
XANTENNA__0216__GATE Tile_X1Y0_FrameStrobe[0] VPWR VGND sg13cmos5l_antennanp
XFILLER_6_607 VPWR VGND sg13cmos5l_decap_8
XFILLER_13_1615 VPWR VGND sg13cmos5l_decap_8
XFILLER_10_647 VPWR VGND sg13cmos5l_decap_8
XFILLER_11_2062 VPWR VGND sg13cmos5l_decap_8
XFILLER_11_2095 VPWR VGND sg13cmos5l_fill_2
XFILLER_11_1350 VPWR VGND sg13cmos5l_decap_8
XFILLER_2_802 VPWR VGND sg13cmos5l_fill_2
XFILLER_1_301 VPWR VGND sg13cmos5l_decap_4
XANTENNA__0499__D Tile_X0Y0_FrameData[6] VPWR VGND sg13cmos5l_antennanp
XFILLER_2_835 VPWR VGND sg13cmos5l_decap_8
XFILLER_1_323 VPWR VGND sg13cmos5l_fill_2
XFILLER_8_2642 VPWR VGND sg13cmos5l_decap_8
XFILLER_1_345 VPWR VGND sg13cmos5l_fill_2
XFILLER_8_1941 VPWR VGND sg13cmos5l_fill_2
XFILLER_4_2528 VPWR VGND sg13cmos5l_decap_8
XFILLER_4_1838 VPWR VGND sg13cmos5l_decap_4
XFILLER_2_2263 VPWR VGND sg13cmos5l_decap_8
XFILLER_2_1573 VPWR VGND sg13cmos5l_fill_1
XFILLER_16_1272 VPWR VGND sg13cmos5l_decap_8
XFILLER_9_478 VPWR VGND sg13cmos5l_decap_4
XANTENNA__1196__A2 Tile_X1Y0_NN4END[14] VPWR VGND sg13cmos5l_antennanp
XFILLER_12_1147 VPWR VGND sg13cmos5l_decap_8
XFILLER_9_2417 VPWR VGND sg13cmos5l_decap_8
XFILLER_5_673 VPWR VGND sg13cmos5l_decap_8
XFILLER_5_651 VPWR VGND sg13cmos5l_fill_2
XANTENNA__0549__CLK Tile_X0Y0_UserCLK VPWR VGND sg13cmos5l_antennanp
XFILLER_4_183 VPWR VGND sg13cmos5l_fill_1
XANTENNA__0202__D Tile_X0Y0_FrameData[31] VPWR VGND sg13cmos5l_antennanp
XFILLER_7_2152 VPWR VGND sg13cmos5l_fill_1
X_0323_ _0323_/Q Tile_X0Y0_FrameData[22] VGND VPWR Tile_X2Y0_FrameStrobe[0] latch
XFILLER_7_2196 VPWR VGND sg13cmos5l_decap_8
XFILLER_7_1451 VPWR VGND sg13cmos5l_decap_8
XFILLER_3_1304 VPWR VGND sg13cmos5l_decap_4
X_0254_ _0254_/Q Tile_X0Y0_FrameData[11] VGND VPWR Tile_X1Y0_FrameStrobe[1] latch
X_0185_ _0185_/Q Tile_X0Y0_FrameData[0] VGND VPWR Tile_X0Y0_FrameStrobe[2] latch
XANTENNA__1120__A2 Tile_X0Y0_NN4END[8] VPWR VGND sg13cmos5l_antennanp
XFILLER_14_2647 VPWR VGND sg13cmos5l_decap_8
XFILLER_14_1913 VPWR VGND sg13cmos5l_decap_8
XANTENNA__1058__A Tile_X4Y0_N4END[4] VPWR VGND sg13cmos5l_antennanp
XANTENNA__1187__A2 Tile_X1Y0_NN4END[8] VPWR VGND sg13cmos5l_antennanp
XFILLER_12_2382 VPWR VGND sg13cmos5l_decap_8
XANTENNA__0112__D Tile_X0Y0_FrameData[9] VPWR VGND sg13cmos5l_antennanp
XANTENNA__0140__GATE Tile_X0Y0_FrameStrobe[1] VPWR VGND sg13cmos5l_antennanp
XANTENNA__0155__GATE Tile_X0Y0_FrameStrobe[2] VPWR VGND sg13cmos5l_antennanp
XFILLER_3_2583 VPWR VGND sg13cmos5l_decap_8
XANTENNA__1111__A2 Tile_X1Y0_NN4END[13] VPWR VGND sg13cmos5l_antennanp
XFILLER_3_1893 VPWR VGND sg13cmos5l_fill_2
XFILLER_11_901 VPWR VGND sg13cmos5l_fill_2
XFILLER_13_2102 VPWR VGND sg13cmos5l_fill_2
XFILLER_11_934 VPWR VGND sg13cmos5l_decap_4
XFILLER_13_2146 VPWR VGND sg13cmos5l_decap_8
XFILLER_10_422 VPWR VGND sg13cmos5l_fill_1
XFILLER_6_404 VPWR VGND sg13cmos5l_fill_1
XFILLER_13_2168 VPWR VGND sg13cmos5l_decap_8
XFILLER_13_1445 VPWR VGND sg13cmos5l_decap_8
XANTENNA__1178__A2 Tile_X1Y0_N2END[0] VPWR VGND sg13cmos5l_antennanp
XFILLER_2_610 VPWR VGND sg13cmos5l_decap_8
XANTENNA__0108__GATE Tile_X0Y0_FrameStrobe[0] VPWR VGND sg13cmos5l_antennanp
XFILLER_4_2314 VPWR VGND sg13cmos5l_fill_1
XFILLER_2_687 VPWR VGND sg13cmos5l_decap_8
XFILLER_1_164 VPWR VGND sg13cmos5l_fill_2
XFILLER_1_153 VPWR VGND sg13cmos5l_decap_8
XFILLER_8_2494 VPWR VGND sg13cmos5l_decap_8
XFILLER_4_2336 VPWR VGND sg13cmos5l_decap_4
XFILLER_8_1782 VPWR VGND sg13cmos5l_decap_4
XFILLER_4_2358 VPWR VGND sg13cmos5l_decap_4
XFILLER_4_1635 VPWR VGND sg13cmos5l_decap_8
XANTENNA__1102__A2 Tile_X1Y0_NN4END[4] VPWR VGND sg13cmos5l_antennanp
X_0941_ Tile_X2Y0_FrameStrobe_O[6] Tile_X2Y0_FrameStrobe[6] VPWR VGND sg13cmos5l_buf_1
XFILLER_14_794 VPWR VGND sg13cmos5l_decap_4
X_0872_ Tile_X2Y0_S2BEG[5] Tile_X2Y0_N2MID[2] VPWR VGND sg13cmos5l_buf_1
XFILLER_13_2691 VPWR VGND sg13cmos5l_decap_8
XANTENNA__1169__A2 Tile_X0Y0_NN4END[1] VPWR VGND sg13cmos5l_antennanp
XFILLER_9_2214 VPWR VGND sg13cmos5l_decap_8
XFILLER_9_1513 VPWR VGND sg13cmos5l_decap_8
X_0306_ _0306_/Q Tile_X0Y0_FrameData[23] VGND VPWR Tile_X1Y0_FrameStrobe[3] latch
XFILLER_3_1101 VPWR VGND sg13cmos5l_decap_8
X_1286_ _1286_/X Tile_X3Y0_N2END[3] Tile_X3Y0_N4END[11] Tile_X3Y0_NN4END[4] _0574_/Q
+ _0435_/Q _0434_/Q VPWR VGND sg13cmos5l_mux4_1
XFILLER_0_2767 VPWR VGND sg13cmos5l_fill_1
X_0237_ _0237_/Q Tile_X0Y0_FrameData[28] VGND VPWR Tile_X1Y0_FrameStrobe[1] latch
XFILLER_3_1167 VPWR VGND sg13cmos5l_decap_8
X_0168_ _0168_/Q Tile_X0Y0_FrameData[17] VGND VPWR Tile_X0Y0_FrameStrobe[2] latch
XFILLER_12_709 VPWR VGND sg13cmos5l_decap_8
X_0099_ _0099_/Q Tile_X0Y0_FrameData[22] VGND VPWR Tile_X0Y0_FrameStrobe[0] latch
XANTENNA__0107__D Tile_X0Y0_FrameData[14] VPWR VGND sg13cmos5l_antennanp
XFILLER_14_2444 VPWR VGND sg13cmos5l_decap_8
XFILLER_14_1732 VPWR VGND sg13cmos5l_decap_8
XFILLER_3_429 VPWR VGND sg13cmos5l_decap_8
XANTENNA__1075__X Tile_X4Y0_SS4BEG[12] VPWR VGND sg13cmos5l_antennanp
XFILLER_8_1023 VPWR VGND sg13cmos5l_decap_4
XFILLER_8_1045 VPWR VGND sg13cmos5l_decap_8
XFILLER_5_2634 VPWR VGND sg13cmos5l_decap_8
XANTENNA__0094__GATE Tile_X0Y0_FrameStrobe[0] VPWR VGND sg13cmos5l_antennanp
XANTENNA__1096__A1 Tile_X1Y0_N4END[1] VPWR VGND sg13cmos5l_antennanp
XFILLER_15_2219 VPWR VGND sg13cmos5l_fill_1
XFILLER_15_2208 VPWR VGND sg13cmos5l_decap_4
XFILLER_15_1529 VPWR VGND sg13cmos5l_decap_8
XFILLER_11_753 VPWR VGND sg13cmos5l_decap_8
XFILLER_13_1231 VPWR VGND sg13cmos5l_decap_8
XFILLER_3_952 VPWR VGND sg13cmos5l_decap_4
XFILLER_2_484 VPWR VGND sg13cmos5l_fill_1
XFILLER_2_473 VPWR VGND sg13cmos5l_fill_2
XFILLER_8_2291 VPWR VGND sg13cmos5l_decap_8
XFILLER_6_1708 VPWR VGND sg13cmos5l_decap_8
X_1140_ _1140_/X Tile_X0Y0_N2MID[1] Tile_X0Y0_N4END[14] Tile_X0Y0_NN4END[1] _0603_/Q
+ _0183_/Q _0182_/Q VPWR VGND sg13cmos5l_mux4_1
XFILLER_4_2166 VPWR VGND sg13cmos5l_decap_8
X_1071_ Tile_X4Y0_SS4BEG[8] Tile_X4Y0_NN4END[7] VPWR VGND sg13cmos5l_buf_1
XANTENNA__1087__A1 Tile_X2Y0_N2MID[0] VPWR VGND sg13cmos5l_antennanp
X_0924_ Tile_X3Y0_FrameStrobe_O[9] Tile_X3Y0_FrameStrobe[9] VPWR VGND sg13cmos5l_buf_1
XANTENNA__0999__X Tile_X0Y0_S4BEG[8] VPWR VGND sg13cmos5l_antennanp
X_0855_ Tile_X4Y0_FrameStrobe_O[12] Tile_X4Y0_FrameStrobe[12] VPWR VGND sg13cmos5l_buf_1
XFILLER_11_2639 VPWR VGND sg13cmos5l_decap_8
XFILLER_11_1916 VPWR VGND sg13cmos5l_decap_8
X_0786_ Tile_X3Y0_S4BEG[7] _1266_/X VPWR VGND sg13cmos5l_buf_1
XFILLER_9_2077 VPWR VGND sg13cmos5l_decap_8
XANTENNA__0597__D NPU_RDATA25 VPWR VGND sg13cmos5l_antennanp
XFILLER_5_1229 VPWR VGND sg13cmos5l_decap_8
XANTENNA__1071__A Tile_X4Y0_NN4END[7] VPWR VGND sg13cmos5l_antennanp
X_1269_ _1269_/X Tile_X3Y0_N2MID[2] Tile_X3Y0_N4END[5] Tile_X3Y0_NN4END[10] _0574_/Q
+ _0469_/Q _0468_/Q VPWR VGND sg13cmos5l_mux4_1
XFILLER_16_2528 VPWR VGND sg13cmos5l_decap_8
XFILLER_16_1849 VPWR VGND sg13cmos5l_decap_8
XANTENNA__1250__A1 Tile_X2Y0_N4END[15] VPWR VGND sg13cmos5l_antennanp
XFILLER_14_2285 VPWR VGND sg13cmos5l_decap_8
XFILLER_14_1540 VPWR VGND sg13cmos5l_fill_1
XANTENNA__0702__X Tile_X0Y0_FrameStrobe_O[15] VPWR VGND sg13cmos5l_antennanp
XFILLER_10_2149 VPWR VGND sg13cmos5l_decap_8
XFILLER_4_705 VPWR VGND sg13cmos5l_fill_1
XFILLER_14_1573 VPWR VGND sg13cmos5l_fill_1
XFILLER_4_727 VPWR VGND sg13cmos5l_decap_4
XFILLER_7_2729 VPWR VGND sg13cmos5l_decap_8
XFILLER_0_966 VPWR VGND sg13cmos5l_fill_1
XANTENNA__0300__D Tile_X0Y0_FrameData[29] VPWR VGND sg13cmos5l_antennanp
XFILLER_5_1763 VPWR VGND sg13cmos5l_decap_8
XFILLER_16_801 VPWR VGND sg13cmos5l_fill_2
XFILLER_15_322 VPWR VGND sg13cmos5l_fill_2
XANTENNA__1241__A1 Tile_X2Y0_N4END[6] VPWR VGND sg13cmos5l_antennanp
XFILLER_7_510 VPWR VGND sg13cmos5l_decap_8
XFILLER_15_1359 VPWR VGND sg13cmos5l_decap_4
X_0640_ _0640_/L_HI VPWR VGND sg13cmos5l_tiehi
XFILLER_7_587 VPWR VGND sg13cmos5l_decap_8
XFILLER_10_1960 VPWR VGND sg13cmos5l_decap_8
X_0571_ NPU_ADDR7 Tile_X0Y0_UserCLK _1087_/X _0658_/L_HI VPWR VGND sg13cmos5l_dfrbpq_1
XFILLER_3_782 VPWR VGND sg13cmos5l_decap_8
XFILLER_3_793 VPWR VGND sg13cmos5l_fill_1
XANTENNA__0210__D Tile_X0Y0_FrameData[23] VPWR VGND sg13cmos5l_antennanp
X_1123_ _1123_/X Tile_X0Y0_N4END[8] Tile_X0Y0_N4END[11] Tile_X0Y0_NN4END[9] Tile_X0Y0_NN4END[11]
+ _0099_/Q _0098_/Q VPWR VGND sg13cmos5l_mux4_1
X_1054_ Tile_X4Y0_S4BEG[7] Tile_X4Y0_N4END[8] VPWR VGND sg13cmos5l_buf_1
XFILLER_15_2550 VPWR VGND sg13cmos5l_decap_8
XANTENNA__1232__A1 Tile_X2Y0_N4END[2] VPWR VGND sg13cmos5l_antennanp
X_0907_ Tile_X2Y0_SS4BEG[8] _1243_/X VPWR VGND sg13cmos5l_buf_1
XFILLER_15_1860 VPWR VGND sg13cmos5l_decap_8
XFILLER_11_2447 VPWR VGND sg13cmos5l_decap_8
XFILLER_11_1713 VPWR VGND sg13cmos5l_decap_8
X_0838_ Tile_X4Y0_FrameData_O[27] Tile_X0Y0_FrameData[27] VPWR VGND sg13cmos5l_buf_1
X_0769_ Tile_X3Y0_S2BEG[6] Tile_X3Y0_N2MID[1] VPWR VGND sg13cmos5l_buf_1
XANTENNA__1066__A Tile_X4Y0_NN4END[12] VPWR VGND sg13cmos5l_antennanp
XFILLER_1_719 VPWR VGND sg13cmos5l_decap_8
XANTENNA__0507__GATE Tile_X4Y0_FrameStrobe[0] VPWR VGND sg13cmos5l_antennanp
XANTENNA__0120__D Tile_X0Y0_FrameData[1] VPWR VGND sg13cmos5l_antennanp
XFILLER_9_1173 VPWR VGND sg13cmos5l_decap_8
XFILLER_6_2784 VPWR VGND sg13cmos5l_fill_1
XFILLER_6_2773 VPWR VGND sg13cmos5l_decap_8
XFILLER_5_1048 VPWR VGND sg13cmos5l_decap_8
XFILLER_5_1015 VPWR VGND sg13cmos5l_fill_2
XFILLER_0_2372 VPWR VGND sg13cmos5l_decap_8
XFILLER_16_2336 VPWR VGND sg13cmos5l_fill_2
XFILLER_16_1602 VPWR VGND sg13cmos5l_decap_8
XFILLER_16_1635 VPWR VGND sg13cmos5l_decap_8
XFILLER_12_347 VPWR VGND sg13cmos5l_decap_4
XANTENNA__1223__A1 Tile_X2Y0_N4END[11] VPWR VGND sg13cmos5l_antennanp
XANTENNA_70 Tile_X0Y0_FrameData[22] VPWR VGND sg13cmos5l_antennanp
XANTENNA_81 Tile_X0Y0_FrameData[3] VPWR VGND sg13cmos5l_antennanp
XANTENNA_92 Tile_X0Y0_FrameData[1] VPWR VGND sg13cmos5l_antennanp
XFILLER_4_524 VPWR VGND sg13cmos5l_decap_8
XFILLER_10_1267 VPWR VGND sg13cmos5l_decap_8
XANTENNA__0582__CLK Tile_X0Y0_UserCLK VPWR VGND sg13cmos5l_antennanp
XFILLER_0_785 VPWR VGND sg13cmos5l_fill_2
XFILLER_5_2272 VPWR VGND sg13cmos5l_fill_1
XFILLER_5_2261 VPWR VGND sg13cmos5l_decap_8
XFILLER_5_1560 VPWR VGND sg13cmos5l_fill_1
XFILLER_5_1571 VPWR VGND sg13cmos5l_decap_8
XFILLER_1_2147 VPWR VGND sg13cmos5l_decap_8
XFILLER_1_1435 VPWR VGND sg13cmos5l_fill_1
XFILLER_1_1402 VPWR VGND sg13cmos5l_decap_4
XFILLER_1_1457 VPWR VGND sg13cmos5l_fill_2
XFILLER_16_653 VPWR VGND sg13cmos5l_decap_4
XFILLER_15_185 VPWR VGND sg13cmos5l_decap_8
XANTENNA__1214__A1 Tile_X2Y0_N2MID[3] VPWR VGND sg13cmos5l_antennanp
XANTENNA__0205__D Tile_X0Y0_FrameData[28] VPWR VGND sg13cmos5l_antennanp
XFILLER_15_1167 VPWR VGND sg13cmos5l_decap_8
XFILLER_12_2778 VPWR VGND sg13cmos5l_decap_8
XFILLER_12_2789 VPWR VGND sg13cmos5l_fill_1
X_0623_ _0623_/L_HI VPWR VGND sg13cmos5l_tiehi
X_0554_ NPU_WDATA30 Tile_X0Y0_UserCLK _1126_/X _0679_/L_HI VPWR VGND sg13cmos5l_dfrbpq_1
XFILLER_6_2014 VPWR VGND sg13cmos5l_fill_1
X_0485_ _0485_/Q Tile_X0Y0_FrameData[20] VGND VPWR Tile_X3Y0_FrameStrobe[2] latch
XANTENNA__0493__GATE Tile_X3Y0_FrameStrobe[2] VPWR VGND sg13cmos5l_antennanp
XFILLER_16_0 VPWR VGND sg13cmos5l_fill_1
XANTENNA__1150__A0 Tile_X0Y0_N2MID[3] VPWR VGND sg13cmos5l_antennanp
X_1106_ _1106_/X Tile_X1Y0_N4END[10] Tile_X1Y0_N4END[11] Tile_X1Y0_NN4END[8] Tile_X1Y0_NN4END[10]
+ _0213_/Q _0212_/Q VPWR VGND sg13cmos5l_mux4_1
XFILLER_4_1092 VPWR VGND sg13cmos5l_decap_8
X_1037_ Tile_X4Y0_S2BEG[6] Tile_X4Y0_N2MID[1] VPWR VGND sg13cmos5l_buf_1
XFILLER_10_807 VPWR VGND sg13cmos5l_decap_8
XANTENNA__0431__GATE Tile_X3Y0_FrameStrobe[0] VPWR VGND sg13cmos5l_antennanp
XANTENNA__1205__A1 Tile_X1Y0_N4END[10] VPWR VGND sg13cmos5l_antennanp
XANTENNA__0115__D Tile_X0Y0_FrameData[6] VPWR VGND sg13cmos5l_antennanp
XFILLER_11_2244 VPWR VGND sg13cmos5l_decap_8
XANTENNA__0446__GATE Tile_X3Y0_FrameStrobe[1] VPWR VGND sg13cmos5l_antennanp
XFILLER_1_505 VPWR VGND sg13cmos5l_decap_8
XFILLER_2_2423 VPWR VGND sg13cmos5l_decap_8
XANTENNA__1141__A0 Tile_X0Y0_N2MID[2] VPWR VGND sg13cmos5l_antennanp
XFILLER_2_1755 VPWR VGND sg13cmos5l_decap_8
XFILLER_2_1799 VPWR VGND sg13cmos5l_fill_1
XFILLER_16_63 VPWR VGND sg13cmos5l_decap_8
XFILLER_13_667 VPWR VGND sg13cmos5l_decap_8
XFILLER_12_144 VPWR VGND sg13cmos5l_fill_1
XFILLER_9_627 VPWR VGND sg13cmos5l_decap_8
XFILLER_8_104 VPWR VGND sg13cmos5l_fill_1
XFILLER_16_2199 VPWR VGND sg13cmos5l_decap_8
XFILLER_16_2177 VPWR VGND sg13cmos5l_decap_4
XFILLER_12_2008 VPWR VGND sg13cmos5l_decap_8
XFILLER_8_159 VPWR VGND sg13cmos5l_fill_1
XFILLER_8_148 VPWR VGND sg13cmos5l_decap_8
XFILLER_16_1476 VPWR VGND sg13cmos5l_fill_2
XFILLER_12_1329 VPWR VGND sg13cmos5l_decap_8
XFILLER_5_844 VPWR VGND sg13cmos5l_fill_2
XFILLER_4_332 VPWR VGND sg13cmos5l_decap_8
XFILLER_4_310 VPWR VGND sg13cmos5l_fill_2
XFILLER_10_1086 VPWR VGND sg13cmos5l_decap_8
XFILLER_7_2301 VPWR VGND sg13cmos5l_decap_8
X_0270_ _0270_/Q Tile_X0Y0_FrameData[27] VGND VPWR Tile_X1Y0_FrameStrobe[2] latch
XFILLER_7_2378 VPWR VGND sg13cmos5l_decap_8
XFILLER_3_2209 VPWR VGND sg13cmos5l_decap_8
XFILLER_7_1688 VPWR VGND sg13cmos5l_decap_8
XANTENNA__1132__A0 Tile_X0Y0_N1END[1] VPWR VGND sg13cmos5l_antennanp
XFILLER_16_461 VPWR VGND sg13cmos5l_decap_8
XANTENNA__1199__A0 Tile_X1Y0_N2END[4] VPWR VGND sg13cmos5l_antennanp
XFILLER_8_660 VPWR VGND sg13cmos5l_decap_4
XFILLER_12_1896 VPWR VGND sg13cmos5l_decap_8
XANTENNA__0800__X Tile_X3Y0_SS4BEG[5] VPWR VGND sg13cmos5l_antennanp
X_0606_ _0606_/L_HI VPWR VGND sg13cmos5l_tiehi
X_0537_ NPU_WDATA13 Tile_X0Y0_UserCLK _1109_/X _0664_/L_HI VPWR VGND sg13cmos5l_dfrbpq_1
X_0468_ _0468_/Q Tile_X0Y0_FrameData[5] VGND VPWR Tile_X3Y0_FrameStrobe[1] latch
XFILLER_3_2743 VPWR VGND sg13cmos5l_decap_8
XANTENNA__1123__A0 Tile_X0Y0_N4END[8] VPWR VGND sg13cmos5l_antennanp
X_0399_ _0399_/Q Tile_X0Y0_FrameData[10] VGND VPWR Tile_X2Y0_FrameStrobe[2] latch
XFILLER_6_1165 VPWR VGND sg13cmos5l_decap_8
XANTENNA__0370__GATE Tile_X2Y0_FrameStrobe[1] VPWR VGND sg13cmos5l_antennanp
XFILLER_10_626 VPWR VGND sg13cmos5l_decap_8
XANTENNA__1078__X Tile_X4Y0_SS4BEG[15] VPWR VGND sg13cmos5l_antennanp
XFILLER_5_118 VPWR VGND sg13cmos5l_fill_2
XFILLER_11_2041 VPWR VGND sg13cmos5l_decap_8
XANTENNA__0385__GATE Tile_X2Y0_FrameStrobe[2] VPWR VGND sg13cmos5l_antennanp
XANTENNA__0710__X Tile_X1Y0_S2BEGb[3] VPWR VGND sg13cmos5l_antennanp
XFILLER_8_2621 VPWR VGND sg13cmos5l_decap_8
XFILLER_8_2698 VPWR VGND sg13cmos5l_decap_8
XFILLER_4_2507 VPWR VGND sg13cmos5l_decap_8
XANTENNA__1114__A0 Tile_X0Y0_N4END[2] VPWR VGND sg13cmos5l_antennanp
XFILLER_2_2242 VPWR VGND sg13cmos5l_decap_8
XANTENNA__0323__GATE Tile_X2Y0_FrameStrobe[0] VPWR VGND sg13cmos5l_antennanp
XANTENNA__0338__GATE Tile_X2Y0_FrameStrobe[0] VPWR VGND sg13cmos5l_antennanp
XFILLER_9_457 VPWR VGND sg13cmos5l_decap_4
XFILLER_12_1126 VPWR VGND sg13cmos5l_decap_8
XFILLER_5_630 VPWR VGND sg13cmos5l_decap_8
XFILLER_9_1728 VPWR VGND sg13cmos5l_decap_4
XFILLER_4_195 VPWR VGND sg13cmos5l_fill_1
X_0322_ _0322_/Q Tile_X0Y0_FrameData[23] VGND VPWR Tile_X2Y0_FrameStrobe[0] latch
XFILLER_7_2175 VPWR VGND sg13cmos5l_decap_8
XANTENNA__1105__A0 Tile_X1Y0_N4END[9] VPWR VGND sg13cmos5l_antennanp
X_0253_ _0253_/Q Tile_X0Y0_FrameData[12] VGND VPWR Tile_X1Y0_FrameStrobe[1] latch
X_0184_ _0184_/Q Tile_X0Y0_FrameData[1] VGND VPWR Tile_X0Y0_FrameStrobe[2] latch
XANTENNA__1120__A3 Tile_X0Y0_NN4END[10] VPWR VGND sg13cmos5l_antennanp
XFILLER_1_1040 VPWR VGND sg13cmos5l_fill_2
XFILLER_14_2626 VPWR VGND sg13cmos5l_decap_8
XFILLER_9_980 VPWR VGND sg13cmos5l_decap_4
XFILLER_14_1969 VPWR VGND sg13cmos5l_decap_8
XFILLER_12_2361 VPWR VGND sg13cmos5l_decap_8
XFILLER_9_991 VPWR VGND sg13cmos5l_fill_1
XFILLER_12_1693 VPWR VGND sg13cmos5l_decap_8
XFILLER_8_1216 VPWR VGND sg13cmos5l_decap_8
XANTENNA__1074__A Tile_X4Y0_NN4END[4] VPWR VGND sg13cmos5l_antennanp
XANTENNA__1111__A3 Tile_X1Y0_NN4END[15] VPWR VGND sg13cmos5l_antennanp
XFILLER_15_729 VPWR VGND sg13cmos5l_decap_4
XANTENNA__0705__X Tile_X0Y0_FrameStrobe_O[18] VPWR VGND sg13cmos5l_antennanp
XFILLER_13_2114 VPWR VGND sg13cmos5l_fill_2
XFILLER_10_412 VPWR VGND sg13cmos5l_fill_1
XANTENNA__0303__D Tile_X0Y0_FrameData[26] VPWR VGND sg13cmos5l_antennanp
XFILLER_2_666 VPWR VGND sg13cmos5l_decap_8
XFILLER_1_121 VPWR VGND sg13cmos5l_fill_2
XFILLER_8_2473 VPWR VGND sg13cmos5l_decap_8
XFILLER_4_2304 VPWR VGND sg13cmos5l_decap_8
XANTENNA__0262__GATE Tile_X1Y0_FrameStrobe[1] VPWR VGND sg13cmos5l_antennanp
XFILLER_4_1614 VPWR VGND sg13cmos5l_decap_8
XANTENNA__1102__A3 Tile_X1Y0_NN4END[6] VPWR VGND sg13cmos5l_antennanp
XANTENNA__0277__GATE Tile_X1Y0_FrameStrobe[2] VPWR VGND sg13cmos5l_antennanp
XFILLER_2_1382 VPWR VGND sg13cmos5l_decap_8
X_0940_ Tile_X2Y0_FrameStrobe_O[5] Tile_X2Y0_FrameStrobe[5] VPWR VGND sg13cmos5l_buf_1
XFILLER_13_261 VPWR VGND sg13cmos5l_fill_2
XFILLER_13_250 VPWR VGND sg13cmos5l_decap_4
XANTENNA__0200__GATE Tile_X0Y0_FrameStrobe[3] VPWR VGND sg13cmos5l_antennanp
X_0871_ Tile_X2Y0_S2BEG[4] Tile_X2Y0_N2MID[3] VPWR VGND sg13cmos5l_buf_1
XFILLER_16_1092 VPWR VGND sg13cmos5l_fill_1
XFILLER_13_2670 VPWR VGND sg13cmos5l_decap_8
XANTENNA__0213__D Tile_X0Y0_FrameData[20] VPWR VGND sg13cmos5l_antennanp
XANTENNA__0215__GATE Tile_X1Y0_FrameStrobe[0] VPWR VGND sg13cmos5l_antennanp
X_0305_ _0305_/Q Tile_X0Y0_FrameData[24] VGND VPWR Tile_X1Y0_FrameStrobe[3] latch
X_1285_ _1285_/X Tile_X3Y0_N2END[2] Tile_X3Y0_N4END[10] Tile_X3Y0_NN4END[5] _0575_/Q
+ _0437_/Q _0436_/Q VPWR VGND sg13cmos5l_mux4_1
X_0236_ _0236_/Q Tile_X0Y0_FrameData[29] VGND VPWR Tile_X1Y0_FrameStrobe[1] latch
XFILLER_7_1282 VPWR VGND sg13cmos5l_decap_4
XFILLER_0_2779 VPWR VGND sg13cmos5l_fill_1
X_0167_ _0167_/Q Tile_X0Y0_FrameData[18] VGND VPWR Tile_X0Y0_FrameStrobe[2] latch
X_0098_ _0098_/Q Tile_X0Y0_FrameData[23] VGND VPWR Tile_X0Y0_FrameStrobe[0] latch
XFILLER_14_2423 VPWR VGND sg13cmos5l_decap_8
XANTENNA__1069__A Tile_X4Y0_NN4END[9] VPWR VGND sg13cmos5l_antennanp
XFILLER_14_1711 VPWR VGND sg13cmos5l_decap_8
XFILLER_14_1788 VPWR VGND sg13cmos5l_decap_8
XANTENNA__0123__D Tile_X0Y0_FrameData[30] VPWR VGND sg13cmos5l_antennanp
XANTENNA__0701__A Tile_X0Y0_FrameStrobe[14] VPWR VGND sg13cmos5l_antennanp
XFILLER_12_1490 VPWR VGND sg13cmos5l_decap_8
XFILLER_9_2760 VPWR VGND sg13cmos5l_decap_8
XFILLER_5_2613 VPWR VGND sg13cmos5l_decap_8
XFILLER_3_2381 VPWR VGND sg13cmos5l_fill_2
XANTENNA__1096__A2 Tile_X1Y0_NN4END[0] VPWR VGND sg13cmos5l_antennanp
XFILLER_3_1680 VPWR VGND sg13cmos5l_decap_8
XFILLER_15_504 VPWR VGND sg13cmos5l_fill_2
XANTENNA__0539__CLK Tile_X0Y0_UserCLK VPWR VGND sg13cmos5l_antennanp
XFILLER_15_1508 VPWR VGND sg13cmos5l_decap_8
XFILLER_11_732 VPWR VGND sg13cmos5l_decap_8
XFILLER_7_714 VPWR VGND sg13cmos5l_fill_2
XFILLER_13_1210 VPWR VGND sg13cmos5l_decap_8
XFILLER_6_213 VPWR VGND sg13cmos5l_decap_8
XFILLER_13_1287 VPWR VGND sg13cmos5l_decap_8
XFILLER_10_297 VPWR VGND sg13cmos5l_fill_2
XFILLER_3_920 VPWR VGND sg13cmos5l_decap_4
XFILLER_3_964 VPWR VGND sg13cmos5l_decap_8
XFILLER_2_452 VPWR VGND sg13cmos5l_decap_8
XFILLER_8_2270 VPWR VGND sg13cmos5l_decap_8
XFILLER_4_2145 VPWR VGND sg13cmos5l_decap_8
XFILLER_4_1411 VPWR VGND sg13cmos5l_fill_2
XFILLER_8_1591 VPWR VGND sg13cmos5l_fill_1
X_1070_ Tile_X4Y0_SS4BEG[7] Tile_X4Y0_NN4END[8] VPWR VGND sg13cmos5l_buf_1
XFILLER_1_78 VPWR VGND sg13cmos5l_fill_1
XANTENNA__1087__A2 Tile_X2Y0_N2MID[7] VPWR VGND sg13cmos5l_antennanp
XFILLER_2_1190 VPWR VGND sg13cmos5l_decap_8
XANTENNA__0208__D Tile_X0Y0_FrameData[25] VPWR VGND sg13cmos5l_antennanp
XFILLER_15_2754 VPWR VGND sg13cmos5l_fill_1
XFILLER_15_2743 VPWR VGND sg13cmos5l_decap_8
XFILLER_15_2721 VPWR VGND sg13cmos5l_decap_8
X_0923_ Tile_X3Y0_FrameStrobe_O[8] Tile_X3Y0_FrameStrobe[8] VPWR VGND sg13cmos5l_buf_1
XFILLER_11_2618 VPWR VGND sg13cmos5l_decap_8
X_0854_ Tile_X4Y0_FrameStrobe_O[11] Tile_X4Y0_FrameStrobe[11] VPWR VGND sg13cmos5l_buf_1
XANTENNA__0154__GATE Tile_X0Y0_FrameStrobe[2] VPWR VGND sg13cmos5l_antennanp
X_0785_ Tile_X3Y0_S4BEG[6] _1265_/X VPWR VGND sg13cmos5l_buf_1
XFILLER_9_1300 VPWR VGND sg13cmos5l_decap_8
XFILLER_9_2056 VPWR VGND sg13cmos5l_decap_8
XANTENNA__0169__GATE Tile_X0Y0_FrameStrobe[2] VPWR VGND sg13cmos5l_antennanp
XFILLER_5_1208 VPWR VGND sg13cmos5l_decap_8
X_1268_ _1268_/X Tile_X3Y0_N2MID[1] Tile_X3Y0_N4END[6] Tile_X3Y0_NN4END[9] _0575_/Q
+ _0471_/Q _0470_/Q VPWR VGND sg13cmos5l_mux4_1
XFILLER_0_2554 VPWR VGND sg13cmos5l_decap_8
X_0219_ _0219_/Q Tile_X0Y0_FrameData[14] VGND VPWR Tile_X1Y0_FrameStrobe[0] latch
X_1199_ _1199_/X Tile_X1Y0_N2END[4] Tile_X1Y0_N4END[4] Tile_X1Y0_NN4END[11] _0593_/Q
+ _0257_/Q _0256_/Q VPWR VGND sg13cmos5l_mux4_1
XANTENNA__0107__GATE Tile_X0Y0_FrameStrobe[0] VPWR VGND sg13cmos5l_antennanp
XANTENNA__0118__D Tile_X0Y0_FrameData[3] VPWR VGND sg13cmos5l_antennanp
XFILLER_16_2507 VPWR VGND sg13cmos5l_decap_8
XANTENNA__1250__A2 Tile_X2Y0_NN4END[0] VPWR VGND sg13cmos5l_antennanp
XFILLER_10_2106 VPWR VGND sg13cmos5l_decap_8
XFILLER_10_2128 VPWR VGND sg13cmos5l_decap_8
XFILLER_14_2264 VPWR VGND sg13cmos5l_decap_8
XFILLER_4_739 VPWR VGND sg13cmos5l_decap_8
XFILLER_3_227 VPWR VGND sg13cmos5l_decap_8
XFILLER_3_216 VPWR VGND sg13cmos5l_decap_4
XFILLER_7_2708 VPWR VGND sg13cmos5l_decap_8
XFILLER_5_2487 VPWR VGND sg13cmos5l_decap_8
XFILLER_5_1731 VPWR VGND sg13cmos5l_decap_4
XFILLER_1_2329 VPWR VGND sg13cmos5l_fill_2
XFILLER_1_1639 VPWR VGND sg13cmos5l_decap_8
XFILLER_15_301 VPWR VGND sg13cmos5l_decap_8
XFILLER_16_857 VPWR VGND sg13cmos5l_fill_2
XFILLER_16_879 VPWR VGND sg13cmos5l_fill_1
XFILLER_15_1338 VPWR VGND sg13cmos5l_decap_8
XANTENNA__1241__A2 Tile_X2Y0_NN4END[9] VPWR VGND sg13cmos5l_antennanp
XFILLER_11_584 VPWR VGND sg13cmos5l_decap_8
XFILLER_7_566 VPWR VGND sg13cmos5l_decap_8
XFILLER_13_1084 VPWR VGND sg13cmos5l_decap_8
X_0570_ NPU_ADDR6 Tile_X0Y0_UserCLK _1086_/X _0632_/L_HI VPWR VGND sg13cmos5l_dfrbpq_1
XFILLER_10_2695 VPWR VGND sg13cmos5l_decap_8
XFILLER_2_260 VPWR VGND sg13cmos5l_fill_2
XFILLER_6_1517 VPWR VGND sg13cmos5l_fill_2
X_1122_ _1122_/X Tile_X0Y0_N4END[10] Tile_X0Y0_N4END[11] Tile_X0Y0_NN4END[8] Tile_X0Y0_NN4END[10]
+ _0101_/Q _0100_/Q VPWR VGND sg13cmos5l_mux4_1
X_1053_ Tile_X4Y0_S4BEG[6] Tile_X4Y0_N4END[9] VPWR VGND sg13cmos5l_buf_1
XANTENNA__0093__GATE Tile_X0Y0_FrameStrobe[0] VPWR VGND sg13cmos5l_antennanp
XANTENNA__0803__X Tile_X3Y0_SS4BEG[8] VPWR VGND sg13cmos5l_antennanp
XANTENNA__1232__A2 Tile_X2Y0_NN4END[13] VPWR VGND sg13cmos5l_antennanp
X_0906_ Tile_X2Y0_SS4BEG[7] _1242_/X VPWR VGND sg13cmos5l_buf_1
XFILLER_15_2595 VPWR VGND sg13cmos5l_decap_8
XFILLER_11_2426 VPWR VGND sg13cmos5l_decap_8
X_0837_ Tile_X4Y0_FrameData_O[26] Tile_X0Y0_FrameData[26] VPWR VGND sg13cmos5l_buf_1
X_0768_ Tile_X3Y0_S2BEG[5] Tile_X3Y0_N2MID[2] VPWR VGND sg13cmos5l_buf_1
XFILLER_11_1769 VPWR VGND sg13cmos5l_decap_8
XFILLER_0_219 VPWR VGND sg13cmos5l_fill_1
XANTENNA__0401__D Tile_X0Y0_FrameData[8] VPWR VGND sg13cmos5l_antennanp
XFILLER_9_1130 VPWR VGND sg13cmos5l_decap_8
X_0699_ Tile_X0Y0_FrameStrobe_O[12] Tile_X0Y0_FrameStrobe[12] VPWR VGND sg13cmos5l_buf_1
XFILLER_6_2752 VPWR VGND sg13cmos5l_decap_8
XFILLER_9_1196 VPWR VGND sg13cmos5l_decap_8
XFILLER_2_2616 VPWR VGND sg13cmos5l_fill_2
XFILLER_2_2649 VPWR VGND sg13cmos5l_decap_8
XFILLER_2_1926 VPWR VGND sg13cmos5l_fill_2
XFILLER_2_1915 VPWR VGND sg13cmos5l_decap_8
XFILLER_0_2351 VPWR VGND sg13cmos5l_decap_4
XFILLER_0_1650 VPWR VGND sg13cmos5l_fill_1
XFILLER_0_1672 VPWR VGND sg13cmos5l_fill_2
XFILLER_16_2304 VPWR VGND sg13cmos5l_fill_1
XFILLER_13_849 VPWR VGND sg13cmos5l_decap_4
XFILLER_12_326 VPWR VGND sg13cmos5l_decap_8
XFILLER_8_319 VPWR VGND sg13cmos5l_fill_1
XFILLER_8_308 VPWR VGND sg13cmos5l_decap_4
XANTENNA__0713__X Tile_X1Y0_S2BEGb[6] VPWR VGND sg13cmos5l_antennanp
XANTENNA__1223__A2 Tile_X2Y0_NN4END[4] VPWR VGND sg13cmos5l_antennanp
XFILLER_14_2072 VPWR VGND sg13cmos5l_decap_8
XANTENNA_60 Tile_X0Y0_FrameData[9] VPWR VGND sg13cmos5l_antennanp
XANTENNA_71 Tile_X0Y0_FrameData[22] VPWR VGND sg13cmos5l_antennanp
XANTENNA_82 Tile_X0Y0_FrameData[3] VPWR VGND sg13cmos5l_antennanp
XANTENNA_93 Tile_X0Y0_FrameData[1] VPWR VGND sg13cmos5l_antennanp
XFILLER_4_503 VPWR VGND sg13cmos5l_decap_8
XFILLER_14_1393 VPWR VGND sg13cmos5l_fill_2
XFILLER_10_1246 VPWR VGND sg13cmos5l_decap_8
XANTENNA__0311__D Tile_X0Y0_FrameData[18] VPWR VGND sg13cmos5l_antennanp
XFILLER_0_753 VPWR VGND sg13cmos5l_fill_1
XFILLER_5_2240 VPWR VGND sg13cmos5l_decap_8
XFILLER_1_2126 VPWR VGND sg13cmos5l_decap_8
XFILLER_1_1425 VPWR VGND sg13cmos5l_fill_2
XFILLER_1_1447 VPWR VGND sg13cmos5l_fill_2
XFILLER_16_632 VPWR VGND sg13cmos5l_decap_8
XFILLER_16_676 VPWR VGND sg13cmos5l_decap_8
XFILLER_15_164 VPWR VGND sg13cmos5l_decap_8
XFILLER_8_831 VPWR VGND sg13cmos5l_decap_4
XFILLER_15_1146 VPWR VGND sg13cmos5l_decap_8
XANTENNA__1214__A2 Tile_X2Y0_N2END[4] VPWR VGND sg13cmos5l_antennanp
XFILLER_12_2757 VPWR VGND sg13cmos5l_decap_8
XFILLER_11_370 VPWR VGND sg13cmos5l_fill_1
XFILLER_8_875 VPWR VGND sg13cmos5l_fill_1
X_0622_ _0622_/L_HI VPWR VGND sg13cmos5l_tiehi
X_0553_ NPU_WDATA29 Tile_X0Y0_UserCLK _1125_/X _0634_/L_HI VPWR VGND sg13cmos5l_dfrbpq_1
XANTENNA__0221__D Tile_X0Y0_FrameData[12] VPWR VGND sg13cmos5l_antennanp
X_0484_ _0484_/Q Tile_X0Y0_FrameData[21] VGND VPWR Tile_X3Y0_FrameStrobe[2] latch
XFILLER_6_1347 VPWR VGND sg13cmos5l_fill_2
XFILLER_6_1336 VPWR VGND sg13cmos5l_decap_8
XANTENNA__1150__A1 Tile_X0Y0_N4END[4] VPWR VGND sg13cmos5l_antennanp
X_1105_ _1105_/X Tile_X1Y0_N4END[9] Tile_X1Y0_N4END[10] Tile_X1Y0_NN4END[9] Tile_X1Y0_NN4END[11]
+ _0215_/Q _0214_/Q VPWR VGND sg13cmos5l_mux4_1
XFILLER_4_1071 VPWR VGND sg13cmos5l_decap_8
X_1036_ Tile_X4Y0_S2BEG[5] Tile_X4Y0_N2MID[2] VPWR VGND sg13cmos5l_buf_1
XANTENNA__1205__A2 Tile_X1Y0_NN4END[5] VPWR VGND sg13cmos5l_antennanp
XFILLER_11_2223 VPWR VGND sg13cmos5l_decap_8
XANTENNA__1077__A Tile_X4Y0_NN4END[1] VPWR VGND sg13cmos5l_antennanp
XFILLER_11_1544 VPWR VGND sg13cmos5l_decap_8
XANTENNA__0131__D Tile_X0Y0_FrameData[22] VPWR VGND sg13cmos5l_antennanp
XANTENNA__1141__A1 Tile_X0Y0_N4END[13] VPWR VGND sg13cmos5l_antennanp
XFILLER_6_1870 VPWR VGND sg13cmos5l_fill_2
XFILLER_2_2479 VPWR VGND sg13cmos5l_decap_8
XFILLER_2_1734 VPWR VGND sg13cmos5l_decap_8
XANTENNA__0708__X Tile_X1Y0_S2BEGb[1] VPWR VGND sg13cmos5l_antennanp
XFILLER_16_42 VPWR VGND sg13cmos5l_decap_8
XFILLER_16_2101 VPWR VGND sg13cmos5l_decap_8
XFILLER_12_101 VPWR VGND sg13cmos5l_decap_4
XFILLER_9_606 VPWR VGND sg13cmos5l_decap_8
XFILLER_16_2156 VPWR VGND sg13cmos5l_decap_8
XFILLER_13_646 VPWR VGND sg13cmos5l_decap_8
XFILLER_12_123 VPWR VGND sg13cmos5l_decap_8
XANTENNA__0306__D Tile_X0Y0_FrameData[23] VPWR VGND sg13cmos5l_antennanp
XFILLER_16_1488 VPWR VGND sg13cmos5l_decap_8
XFILLER_12_189 VPWR VGND sg13cmos5l_decap_8
XFILLER_12_1308 VPWR VGND sg13cmos5l_decap_8
XFILLER_10_1065 VPWR VGND sg13cmos5l_decap_8
XFILLER_4_366 VPWR VGND sg13cmos5l_fill_1
XFILLER_7_2357 VPWR VGND sg13cmos5l_decap_8
XFILLER_7_1645 VPWR VGND sg13cmos5l_decap_8
XFILLER_5_2070 VPWR VGND sg13cmos5l_fill_1
XANTENNA__1132__A1 Tile_X0Y0_N2MID[1] VPWR VGND sg13cmos5l_antennanp
XFILLER_16_451 VPWR VGND sg13cmos5l_decap_8
XFILLER_16_473 VPWR VGND sg13cmos5l_fill_1
XANTENNA__0506__GATE Tile_X3Y0_FrameStrobe[0] VPWR VGND sg13cmos5l_antennanp
XANTENNA__0216__D Tile_X0Y0_FrameData[17] VPWR VGND sg13cmos5l_antennanp
XANTENNA__1199__A1 Tile_X1Y0_N4END[4] VPWR VGND sg13cmos5l_antennanp
XFILLER_16_2690 VPWR VGND sg13cmos5l_decap_8
XFILLER_12_1875 VPWR VGND sg13cmos5l_decap_8
X_0605_ _0605_/L_HI VPWR VGND sg13cmos5l_tiehi
X_0536_ NPU_WDATA12 Tile_X0Y0_UserCLK _1108_/X _0635_/L_HI VPWR VGND sg13cmos5l_dfrbpq_1
X_0467_ _0467_/Q Tile_X0Y0_FrameData[6] VGND VPWR Tile_X3Y0_FrameStrobe[1] latch
XFILLER_6_1144 VPWR VGND sg13cmos5l_decap_8
XFILLER_3_2722 VPWR VGND sg13cmos5l_decap_8
XANTENNA__1123__A1 Tile_X0Y0_N4END[11] VPWR VGND sg13cmos5l_antennanp
X_0398_ _0398_/Q Tile_X0Y0_FrameData[11] VGND VPWR Tile_X2Y0_FrameStrobe[2] latch
X_1019_ Tile_X0Y0_S2BEG[4] Tile_X0Y0_N2MID[3] VPWR VGND sg13cmos5l_buf_1
XANTENNA__0126__D Tile_X0Y0_FrameData[27] VPWR VGND sg13cmos5l_antennanp
XANTENNA__0572__CLK Tile_X0Y0_UserCLK VPWR VGND sg13cmos5l_antennanp
XFILLER_13_2329 VPWR VGND sg13cmos5l_decap_8
XFILLER_10_605 VPWR VGND sg13cmos5l_decap_8
XANTENNA__0704__A Tile_X0Y0_FrameStrobe[17] VPWR VGND sg13cmos5l_antennanp
XFILLER_11_2020 VPWR VGND sg13cmos5l_decap_8
XFILLER_2_804 VPWR VGND sg13cmos5l_fill_1
XFILLER_8_2600 VPWR VGND sg13cmos5l_decap_8
XFILLER_1_325 VPWR VGND sg13cmos5l_fill_1
XFILLER_11_1385 VPWR VGND sg13cmos5l_decap_8
XFILLER_8_1910 VPWR VGND sg13cmos5l_decap_8
XFILLER_8_2677 VPWR VGND sg13cmos5l_decap_8
XFILLER_8_1932 VPWR VGND sg13cmos5l_decap_4
XANTENNA__1114__A1 Tile_X0Y0_N4END[3] VPWR VGND sg13cmos5l_antennanp
XFILLER_4_1829 VPWR VGND sg13cmos5l_decap_4
XFILLER_2_2221 VPWR VGND sg13cmos5l_decap_8
XFILLER_2_1564 VPWR VGND sg13cmos5l_decap_8
XFILLER_14_900 VPWR VGND sg13cmos5l_fill_2
XFILLER_16_1252 VPWR VGND sg13cmos5l_fill_2
XANTENNA__0492__GATE Tile_X3Y0_FrameStrobe[2] VPWR VGND sg13cmos5l_antennanp
XFILLER_12_1105 VPWR VGND sg13cmos5l_decap_8
XANTENNA__0901__X Tile_X2Y0_SS4BEG[2] VPWR VGND sg13cmos5l_antennanp
XFILLER_5_653 VPWR VGND sg13cmos5l_fill_1
XFILLER_4_141 VPWR VGND sg13cmos5l_decap_8
XFILLER_9_1707 VPWR VGND sg13cmos5l_decap_4
XFILLER_4_45 VPWR VGND sg13cmos5l_fill_2
X_0321_ _0321_/Q Tile_X0Y0_FrameData[24] VGND VPWR Tile_X2Y0_FrameStrobe[0] latch
XFILLER_7_2143 VPWR VGND sg13cmos5l_decap_8
XANTENNA__0430__GATE Tile_X3Y0_FrameStrobe[0] VPWR VGND sg13cmos5l_antennanp
XANTENNA__1105__A1 Tile_X1Y0_N4END[10] VPWR VGND sg13cmos5l_antennanp
X_0252_ _0252_/Q Tile_X0Y0_FrameData[13] VGND VPWR Tile_X1Y0_FrameStrobe[1] latch
X_0183_ _0183_/Q Tile_X0Y0_FrameData[2] VGND VPWR Tile_X0Y0_FrameStrobe[2] latch
XANTENNA__0445__GATE Tile_X3Y0_FrameStrobe[1] VPWR VGND sg13cmos5l_antennanp
XANTENNA__0595__CLK Tile_X0Y0_UserCLK VPWR VGND sg13cmos5l_antennanp
XFILLER_1_1085 VPWR VGND sg13cmos5l_decap_4
XFILLER_14_2605 VPWR VGND sg13cmos5l_decap_8
XFILLER_14_1948 VPWR VGND sg13cmos5l_decap_8
XFILLER_12_2340 VPWR VGND sg13cmos5l_decap_8
XANTENNA__0811__X Tile_X4Y0_FrameData_O[0] VPWR VGND sg13cmos5l_antennanp
XFILLER_12_1672 VPWR VGND sg13cmos5l_decap_8
X_0519_ _0519_/Q Tile_X0Y0_FrameData[24] VGND VPWR Tile_X4Y0_FrameStrobe[0] latch
XFILLER_3_2552 VPWR VGND sg13cmos5l_decap_8
XFILLER_3_1884 VPWR VGND sg13cmos5l_fill_2
XFILLER_15_708 VPWR VGND sg13cmos5l_decap_8
XFILLER_3_1895 VPWR VGND sg13cmos5l_fill_1
XFILLER_14_207 VPWR VGND sg13cmos5l_decap_8
XFILLER_11_903 VPWR VGND sg13cmos5l_fill_1
XANTENNA__1280__A0 Tile_X3Y0_N2END[5] VPWR VGND sg13cmos5l_antennanp
XFILLER_13_10 VPWR VGND sg13cmos5l_fill_2
XANTENNA__0721__X Tile_X1Y0_S4BEG[6] VPWR VGND sg13cmos5l_antennanp
XFILLER_11_1182 VPWR VGND sg13cmos5l_decap_8
XFILLER_2_645 VPWR VGND sg13cmos5l_decap_8
XFILLER_8_2452 VPWR VGND sg13cmos5l_decap_8
XFILLER_8_1762 VPWR VGND sg13cmos5l_fill_1
XANTENNA__1099__A0 Tile_X1Y0_N4END[0] VPWR VGND sg13cmos5l_antennanp
XFILLER_2_2051 VPWR VGND sg13cmos5l_fill_2
XFILLER_14_763 VPWR VGND sg13cmos5l_fill_2
XFILLER_14_752 VPWR VGND sg13cmos5l_decap_4
XANTENNA__1271__A0 Tile_X3Y0_N2MID[4] VPWR VGND sg13cmos5l_antennanp
XFILLER_13_273 VPWR VGND sg13cmos5l_decap_8
XFILLER_9_277 VPWR VGND sg13cmos5l_decap_4
X_0870_ Tile_X2Y0_S2BEG[3] Tile_X2Y0_N2MID[4] VPWR VGND sg13cmos5l_buf_1
XFILLER_16_1071 VPWR VGND sg13cmos5l_fill_2
XFILLER_9_2249 VPWR VGND sg13cmos5l_decap_8
XFILLER_9_1559 VPWR VGND sg13cmos5l_decap_8
X_0304_ _0304_/Q Tile_X0Y0_FrameData[25] VGND VPWR Tile_X1Y0_FrameStrobe[3] latch
X_1284_ _1284_/X Tile_X3Y0_N2END[1] Tile_X3Y0_N4END[9] Tile_X3Y0_NN4END[6] _0574_/Q
+ _0439_/Q _0438_/Q VPWR VGND sg13cmos5l_mux4_1
XFILLER_7_1261 VPWR VGND sg13cmos5l_decap_8
X_0235_ _0235_/Q Tile_X0Y0_FrameData[30] VGND VPWR Tile_X1Y0_FrameStrobe[1] latch
XFILLER_3_1136 VPWR VGND sg13cmos5l_decap_8
XANTENNA__0384__GATE Tile_X2Y0_FrameStrobe[2] VPWR VGND sg13cmos5l_antennanp
X_0166_ _0166_/Q Tile_X0Y0_FrameData[19] VGND VPWR Tile_X0Y0_FrameStrobe[2] latch
XANTENNA__0806__X Tile_X3Y0_SS4BEG[11] VPWR VGND sg13cmos5l_antennanp
X_0097_ _0097_/Q Tile_X0Y0_FrameData[24] VGND VPWR Tile_X0Y0_FrameStrobe[0] latch
XFILLER_14_2402 VPWR VGND sg13cmos5l_decap_8
XANTENNA__0399__GATE Tile_X2Y0_FrameStrobe[2] VPWR VGND sg13cmos5l_antennanp
XANTENNA__1262__A0 Tile_X3Y0_N2MID[3] VPWR VGND sg13cmos5l_antennanp
XFILLER_14_2479 VPWR VGND sg13cmos5l_decap_8
XANTENNA__0404__D Tile_X0Y0_FrameData[5] VPWR VGND sg13cmos5l_antennanp
X_0999_ Tile_X0Y0_S4BEG[8] _1147_/X VPWR VGND sg13cmos5l_buf_1
XFILLER_14_1767 VPWR VGND sg13cmos5l_decap_8
XANTENNA__0322__GATE Tile_X2Y0_FrameStrobe[0] VPWR VGND sg13cmos5l_antennanp
XANTENNA__0337__GATE Tile_X2Y0_FrameStrobe[0] VPWR VGND sg13cmos5l_antennanp
XFILLER_5_1902 VPWR VGND sg13cmos5l_fill_1
XFILLER_5_2669 VPWR VGND sg13cmos5l_decap_8
XFILLER_5_1924 VPWR VGND sg13cmos5l_fill_1
XFILLER_3_2360 VPWR VGND sg13cmos5l_decap_8
XFILLER_3_2393 VPWR VGND sg13cmos5l_decap_8
XANTENNA__1096__A3 Tile_X1Y0_NN4END[2] VPWR VGND sg13cmos5l_antennanp
XFILLER_15_527 VPWR VGND sg13cmos5l_fill_2
XANTENNA__0716__X Tile_X1Y0_S4BEG[1] VPWR VGND sg13cmos5l_antennanp
XFILLER_15_549 VPWR VGND sg13cmos5l_fill_2
XANTENNA__1253__A0 Tile_X3Y0_N1END[2] VPWR VGND sg13cmos5l_antennanp
XFILLER_11_711 VPWR VGND sg13cmos5l_decap_8
XFILLER_7_726 VPWR VGND sg13cmos5l_decap_8
XFILLER_11_788 VPWR VGND sg13cmos5l_fill_2
XFILLER_11_777 VPWR VGND sg13cmos5l_decap_8
XFILLER_10_276 VPWR VGND sg13cmos5l_decap_8
XANTENNA__0314__D Tile_X0Y0_FrameData[31] VPWR VGND sg13cmos5l_antennanp
XFILLER_6_258 VPWR VGND sg13cmos5l_decap_8
XFILLER_13_1266 VPWR VGND sg13cmos5l_decap_8
XFILLER_4_2102 VPWR VGND sg13cmos5l_decap_8
XFILLER_4_2124 VPWR VGND sg13cmos5l_decap_8
XFILLER_8_1581 VPWR VGND sg13cmos5l_decap_8
XFILLER_4_1456 VPWR VGND sg13cmos5l_decap_8
XANTENNA__1087__A3 Tile_X2Y0_N2END[0] VPWR VGND sg13cmos5l_antennanp
XFILLER_15_2700 VPWR VGND sg13cmos5l_decap_8
XANTENNA__1244__A0 Tile_X2Y0_N2END[1] VPWR VGND sg13cmos5l_antennanp
X_0922_ Tile_X3Y0_FrameStrobe_O[7] Tile_X3Y0_FrameStrobe[7] VPWR VGND sg13cmos5l_buf_1
X_0853_ Tile_X4Y0_FrameStrobe_O[10] Tile_X4Y0_FrameStrobe[10] VPWR VGND sg13cmos5l_buf_1
XANTENNA__0224__D Tile_X0Y0_FrameData[9] VPWR VGND sg13cmos5l_antennanp
XFILLER_13_2490 VPWR VGND sg13cmos5l_decap_8
X_0784_ Tile_X3Y0_S4BEG[5] _1264_/X VPWR VGND sg13cmos5l_buf_1
XFILLER_9_2035 VPWR VGND sg13cmos5l_decap_8
XFILLER_0_2533 VPWR VGND sg13cmos5l_decap_4
X_1267_ _1267_/X Tile_X3Y0_N2MID[0] Tile_X3Y0_N4END[7] Tile_X3Y0_NN4END[8] _0574_/Q
+ _0473_/Q _0472_/Q VPWR VGND sg13cmos5l_mux4_1
XFILLER_0_2566 VPWR VGND sg13cmos5l_decap_8
X_0218_ _0218_/Q Tile_X0Y0_FrameData[15] VGND VPWR Tile_X1Y0_FrameStrobe[0] latch
X_1198_ _1198_/X Tile_X1Y0_N2END[3] Tile_X1Y0_N4END[3] Tile_X1Y0_NN4END[12] _0594_/Q
+ _0259_/Q _0258_/Q VPWR VGND sg13cmos5l_mux4_1
XFILLER_0_2577 VPWR VGND sg13cmos5l_fill_2
X_0149_ _0149_/Q Tile_X0Y0_FrameData[4] VGND VPWR Tile_X0Y0_FrameStrobe[1] latch
XFILLER_0_1887 VPWR VGND sg13cmos5l_fill_1
XFILLER_0_1898 VPWR VGND sg13cmos5l_fill_1
XFILLER_12_519 VPWR VGND sg13cmos5l_decap_8
XANTENNA__1235__A0 Tile_X2Y0_N2END[0] VPWR VGND sg13cmos5l_antennanp
XFILLER_16_1829 VPWR VGND sg13cmos5l_decap_8
XFILLER_14_2243 VPWR VGND sg13cmos5l_decap_8
XANTENNA__0261__GATE Tile_X1Y0_FrameStrobe[1] VPWR VGND sg13cmos5l_antennanp
XANTENNA__0134__D Tile_X0Y0_FrameData[19] VPWR VGND sg13cmos5l_antennanp
XFILLER_10_1417 VPWR VGND sg13cmos5l_fill_2
XFILLER_10_22 VPWR VGND sg13cmos5l_decap_4
XANTENNA__0276__GATE Tile_X1Y0_FrameStrobe[2] VPWR VGND sg13cmos5l_antennanp
XFILLER_0_946 VPWR VGND sg13cmos5l_decap_4
XFILLER_5_2466 VPWR VGND sg13cmos5l_decap_8
XFILLER_1_2319 VPWR VGND sg13cmos5l_decap_8
XFILLER_1_2308 VPWR VGND sg13cmos5l_fill_1
XFILLER_1_1618 VPWR VGND sg13cmos5l_decap_8
XFILLER_16_814 VPWR VGND sg13cmos5l_decap_4
XFILLER_16_803 VPWR VGND sg13cmos5l_fill_1
XANTENNA__0214__GATE Tile_X1Y0_FrameStrobe[0] VPWR VGND sg13cmos5l_antennanp
XANTENNA__0309__D Tile_X0Y0_FrameData[20] VPWR VGND sg13cmos5l_antennanp
XFILLER_16_836 VPWR VGND sg13cmos5l_decap_8
XFILLER_15_324 VPWR VGND sg13cmos5l_fill_1
XANTENNA__1226__A0 Tile_X2Y0_N2MID[7] VPWR VGND sg13cmos5l_antennanp
XFILLER_15_1317 VPWR VGND sg13cmos5l_decap_8
XANTENNA__0229__GATE Tile_X1Y0_FrameStrobe[0] VPWR VGND sg13cmos5l_antennanp
XFILLER_11_563 VPWR VGND sg13cmos5l_decap_8
XFILLER_7_545 VPWR VGND sg13cmos5l_decap_8
XFILLER_10_2674 VPWR VGND sg13cmos5l_decap_8
XFILLER_3_740 VPWR VGND sg13cmos5l_decap_8
X_1121_ _1121_/X Tile_X0Y0_N4END[9] Tile_X0Y0_N4END[10] Tile_X0Y0_NN4END[9] Tile_X0Y0_NN4END[11]
+ _0103_/Q _0102_/Q VPWR VGND sg13cmos5l_mux4_1
X_1052_ Tile_X4Y0_S4BEG[5] Tile_X4Y0_N4END[10] VPWR VGND sg13cmos5l_buf_1
XANTENNA__0219__D Tile_X0Y0_FrameData[14] VPWR VGND sg13cmos5l_antennanp
XANTENNA__1217__A0 Tile_X2Y0_N1END[2] VPWR VGND sg13cmos5l_antennanp
X_0905_ Tile_X2Y0_SS4BEG[6] _1241_/X VPWR VGND sg13cmos5l_buf_1
XFILLER_11_2405 VPWR VGND sg13cmos5l_decap_8
X_0836_ Tile_X4Y0_FrameData_O[25] Tile_X0Y0_FrameData[25] VPWR VGND sg13cmos5l_buf_1
XFILLER_11_1748 VPWR VGND sg13cmos5l_decap_8
X_0767_ Tile_X3Y0_S2BEG[4] Tile_X3Y0_N2MID[3] VPWR VGND sg13cmos5l_buf_1
XANTENNA__0529__CLK Tile_X0Y0_UserCLK VPWR VGND sg13cmos5l_antennanp
X_0698_ Tile_X0Y0_FrameStrobe_O[11] Tile_X0Y0_FrameStrobe[11] VPWR VGND sg13cmos5l_buf_1
XFILLER_6_2731 VPWR VGND sg13cmos5l_decap_8
XFILLER_5_1017 VPWR VGND sg13cmos5l_fill_1
XFILLER_2_2628 VPWR VGND sg13cmos5l_decap_8
XANTENNA__0129__D Tile_X0Y0_FrameData[24] VPWR VGND sg13cmos5l_antennanp
XFILLER_0_1662 VPWR VGND sg13cmos5l_fill_1
XANTENNA__1208__A0 Tile_X1Y0_N2END[5] VPWR VGND sg13cmos5l_antennanp
XFILLER_0_1684 VPWR VGND sg13cmos5l_decap_4
XFILLER_16_2316 VPWR VGND sg13cmos5l_decap_4
XFILLER_12_305 VPWR VGND sg13cmos5l_decap_8
XANTENNA_50 Tile_X0Y0_FrameData[6] VPWR VGND sg13cmos5l_antennanp
XANTENNA_61 Tile_X0Y0_FrameData[9] VPWR VGND sg13cmos5l_antennanp
XANTENNA_72 Tile_X0Y0_FrameData[27] VPWR VGND sg13cmos5l_antennanp
XANTENNA_83 Tile_X0Y0_FrameData[4] VPWR VGND sg13cmos5l_antennanp
XANTENNA_94 Tile_X0Y0_FrameData[1] VPWR VGND sg13cmos5l_antennanp
XFILLER_10_1225 VPWR VGND sg13cmos5l_decap_8
XFILLER_4_559 VPWR VGND sg13cmos5l_decap_8
XFILLER_7_2528 VPWR VGND sg13cmos5l_decap_8
XFILLER_7_1805 VPWR VGND sg13cmos5l_decap_8
XFILLER_0_787 VPWR VGND sg13cmos5l_fill_1
XFILLER_1_2116 VPWR VGND sg13cmos5l_decap_4
XANTENNA__0153__GATE Tile_X0Y0_FrameStrobe[1] VPWR VGND sg13cmos5l_antennanp
XFILLER_1_1459 VPWR VGND sg13cmos5l_fill_1
XFILLER_16_611 VPWR VGND sg13cmos5l_decap_8
XFILLER_15_132 VPWR VGND sg13cmos5l_decap_8
XANTENNA__0168__GATE Tile_X0Y0_FrameStrobe[2] VPWR VGND sg13cmos5l_antennanp
XANTENNA__0904__X Tile_X2Y0_SS4BEG[5] VPWR VGND sg13cmos5l_antennanp
XFILLER_15_1125 VPWR VGND sg13cmos5l_decap_8
XFILLER_12_2703 VPWR VGND sg13cmos5l_decap_8
XFILLER_7_320 VPWR VGND sg13cmos5l_decap_8
XFILLER_12_2736 VPWR VGND sg13cmos5l_decap_8
XFILLER_7_364 VPWR VGND sg13cmos5l_decap_8
XFILLER_10_2482 VPWR VGND sg13cmos5l_decap_8
X_0621_ _0621_/L_HI VPWR VGND sg13cmos5l_tiehi
XANTENNA__0502__D Tile_X0Y0_FrameData[3] VPWR VGND sg13cmos5l_antennanp
X_0552_ NPU_WDATA28 Tile_X0Y0_UserCLK _1124_/X _0645_/L_HI VPWR VGND sg13cmos5l_dfrbpq_1
XFILLER_10_1792 VPWR VGND sg13cmos5l_decap_8
XANTENNA__0106__GATE Tile_X0Y0_FrameStrobe[0] VPWR VGND sg13cmos5l_antennanp
X_0483_ _0483_/Q Tile_X0Y0_FrameData[22] VGND VPWR Tile_X3Y0_FrameStrobe[2] latch
XANTENNA__1150__A2 Tile_X0Y0_NN4END[11] VPWR VGND sg13cmos5l_antennanp
X_1104_ _1104_/X Tile_X1Y0_N4END[8] Tile_X1Y0_N4END[9] Tile_X1Y0_NN4END[8] Tile_X1Y0_NN4END[10]
+ _0217_/Q _0216_/Q VPWR VGND sg13cmos5l_mux4_1
XFILLER_4_1050 VPWR VGND sg13cmos5l_decap_8
X_1035_ Tile_X4Y0_S2BEG[4] Tile_X4Y0_N2MID[3] VPWR VGND sg13cmos5l_buf_1
XANTENNA__0814__X Tile_X4Y0_FrameData_O[3] VPWR VGND sg13cmos5l_antennanp
XFILLER_11_2202 VPWR VGND sg13cmos5l_decap_8
XFILLER_15_2393 VPWR VGND sg13cmos5l_decap_8
XFILLER_11_1523 VPWR VGND sg13cmos5l_decap_8
X_0819_ Tile_X4Y0_FrameData_O[8] Tile_X0Y0_FrameData[8] VPWR VGND sg13cmos5l_buf_1
XFILLER_11_2279 VPWR VGND sg13cmos5l_decap_8
XANTENNA__0412__D Tile_X0Y0_FrameData[29] VPWR VGND sg13cmos5l_antennanp
XFILLER_11_1578 VPWR VGND sg13cmos5l_fill_2
XANTENNA__1141__A2 Tile_X0Y0_NN4END[2] VPWR VGND sg13cmos5l_antennanp
XFILLER_2_2458 VPWR VGND sg13cmos5l_decap_8
XFILLER_2_1713 VPWR VGND sg13cmos5l_decap_8
XFILLER_0_2193 VPWR VGND sg13cmos5l_fill_1
XFILLER_13_625 VPWR VGND sg13cmos5l_decap_8
XANTENNA__0724__X Tile_X1Y0_S4BEG[9] VPWR VGND sg13cmos5l_antennanp
XFILLER_16_98 VPWR VGND sg13cmos5l_decap_4
XFILLER_12_168 VPWR VGND sg13cmos5l_decap_8
XFILLER_16_1467 VPWR VGND sg13cmos5l_fill_2
XFILLER_10_1033 VPWR VGND sg13cmos5l_fill_1
XFILLER_5_846 VPWR VGND sg13cmos5l_fill_1
XFILLER_4_323 VPWR VGND sg13cmos5l_fill_1
XANTENNA__0322__D Tile_X0Y0_FrameData[23] VPWR VGND sg13cmos5l_antennanp
XFILLER_10_1044 VPWR VGND sg13cmos5l_decap_8
XFILLER_4_356 VPWR VGND sg13cmos5l_fill_1
XFILLER_7_2336 VPWR VGND sg13cmos5l_decap_8
XFILLER_0_551 VPWR VGND sg13cmos5l_decap_8
XFILLER_7_1624 VPWR VGND sg13cmos5l_decap_8
XANTENNA__0092__GATE Tile_X0Y0_FrameStrobe[0] VPWR VGND sg13cmos5l_antennanp
XANTENNA__1132__A2 Tile_X0Y0_N2END[6] VPWR VGND sg13cmos5l_antennanp
XANTENNA__1199__A2 Tile_X1Y0_NN4END[11] VPWR VGND sg13cmos5l_antennanp
XFILLER_12_2522 VPWR VGND sg13cmos5l_decap_8
XFILLER_11_190 VPWR VGND sg13cmos5l_decap_8
XFILLER_12_1854 VPWR VGND sg13cmos5l_decap_8
XANTENNA__0232__D Tile_X0Y0_FrameData[1] VPWR VGND sg13cmos5l_antennanp
X_0604_ _0604_/L_HI VPWR VGND sg13cmos5l_tiehi
X_0535_ NPU_WDATA11 Tile_X0Y0_UserCLK _1107_/X _0636_/L_HI VPWR VGND sg13cmos5l_dfrbpq_1
X_0466_ _0466_/Q Tile_X0Y0_FrameData[7] VGND VPWR Tile_X3Y0_FrameStrobe[1] latch
XFILLER_3_2701 VPWR VGND sg13cmos5l_decap_8
XANTENNA__0809__X Tile_X3Y0_SS4BEG[14] VPWR VGND sg13cmos5l_antennanp
XFILLER_6_1123 VPWR VGND sg13cmos5l_decap_8
XANTENNA__1123__A2 Tile_X0Y0_NN4END[9] VPWR VGND sg13cmos5l_antennanp
X_0397_ _0397_/Q Tile_X0Y0_FrameData[12] VGND VPWR Tile_X2Y0_FrameStrobe[2] latch
X_1018_ Tile_X0Y0_S2BEG[3] Tile_X0Y0_N2MID[4] VPWR VGND sg13cmos5l_buf_1
XANTENNA__0407__D Tile_X0Y0_FrameData[2] VPWR VGND sg13cmos5l_antennanp
XFILLER_13_2308 VPWR VGND sg13cmos5l_decap_8
XFILLER_13_1629 VPWR VGND sg13cmos5l_decap_8
XFILLER_11_2076 VPWR VGND sg13cmos5l_fill_2
XANTENNA__0142__D Tile_X0Y0_FrameData[11] VPWR VGND sg13cmos5l_antennanp
XFILLER_2_816 VPWR VGND sg13cmos5l_fill_1
XFILLER_11_1364 VPWR VGND sg13cmos5l_decap_8
XFILLER_2_849 VPWR VGND sg13cmos5l_decap_4
XFILLER_8_2656 VPWR VGND sg13cmos5l_decap_8
XFILLER_1_337 VPWR VGND sg13cmos5l_fill_1
XANTENNA__0719__X Tile_X1Y0_S4BEG[4] VPWR VGND sg13cmos5l_antennanp
XFILLER_8_1977 VPWR VGND sg13cmos5l_fill_2
XFILLER_2_2200 VPWR VGND sg13cmos5l_decap_8
XANTENNA__1114__A2 Tile_X0Y0_NN4END[0] VPWR VGND sg13cmos5l_antennanp
XFILLER_6_2391 VPWR VGND sg13cmos5l_decap_8
XFILLER_2_2277 VPWR VGND sg13cmos5l_decap_8
XANTENNA__0317__D Tile_X0Y0_FrameData[28] VPWR VGND sg13cmos5l_antennanp
XFILLER_14_934 VPWR VGND sg13cmos5l_fill_1
XFILLER_16_1231 VPWR VGND sg13cmos5l_decap_8
XFILLER_13_488 VPWR VGND sg13cmos5l_decap_8
XFILLER_16_1286 VPWR VGND sg13cmos5l_decap_8
XFILLER_4_120 VPWR VGND sg13cmos5l_fill_2
XFILLER_5_687 VPWR VGND sg13cmos5l_decap_8
X_0320_ _0320_/Q Tile_X0Y0_FrameData[25] VGND VPWR Tile_X2Y0_FrameStrobe[0] latch
XFILLER_7_1410 VPWR VGND sg13cmos5l_fill_1
XFILLER_7_1443 VPWR VGND sg13cmos5l_fill_1
XANTENNA__1105__A2 Tile_X1Y0_NN4END[9] VPWR VGND sg13cmos5l_antennanp
X_0251_ _0251_/Q Tile_X0Y0_FrameData[14] VGND VPWR Tile_X1Y0_FrameStrobe[1] latch
X_0182_ _0182_/Q Tile_X0Y0_FrameData[3] VGND VPWR Tile_X0Y0_FrameStrobe[2] latch
XFILLER_1_1053 VPWR VGND sg13cmos5l_decap_8
XANTENNA__0227__D Tile_X0Y0_FrameData[6] VPWR VGND sg13cmos5l_antennanp
XFILLER_16_293 VPWR VGND sg13cmos5l_decap_4
XFILLER_14_1927 VPWR VGND sg13cmos5l_decap_8
XFILLER_12_2396 VPWR VGND sg13cmos5l_decap_8
XFILLER_12_1651 VPWR VGND sg13cmos5l_decap_8
X_0518_ _0518_/Q Tile_X0Y0_FrameData[23] VGND VPWR Tile_X4Y0_FrameStrobe[0] latch
XFILLER_8_1229 VPWR VGND sg13cmos5l_decap_8
X_0449_ _0449_/Q Tile_X0Y0_FrameData[24] VGND VPWR Tile_X3Y0_FrameStrobe[1] latch
XFILLER_3_2542 VPWR VGND sg13cmos5l_fill_2
XANTENNA__0137__D Tile_X0Y0_FrameData[16] VPWR VGND sg13cmos5l_antennanp
XANTENNA__1280__A1 Tile_X3Y0_N4END[5] VPWR VGND sg13cmos5l_antennanp
XFILLER_10_403 VPWR VGND sg13cmos5l_decap_8
XFILLER_13_1426 VPWR VGND sg13cmos5l_fill_2
XFILLER_10_458 VPWR VGND sg13cmos5l_fill_2
XFILLER_13_77 VPWR VGND sg13cmos5l_fill_1
XFILLER_13_1459 VPWR VGND sg13cmos5l_decap_8
XFILLER_2_624 VPWR VGND sg13cmos5l_decap_8
XFILLER_11_1161 VPWR VGND sg13cmos5l_decap_8
XFILLER_8_2431 VPWR VGND sg13cmos5l_decap_8
XANTENNA__0600__D NPU_RDATA28 VPWR VGND sg13cmos5l_antennanp
XANTENNA__0505__GATE Tile_X3Y0_FrameStrobe[2] VPWR VGND sg13cmos5l_antennanp
XANTENNA__1099__A1 Tile_X1Y0_N4END[3] VPWR VGND sg13cmos5l_antennanp
XFILLER_4_1649 VPWR VGND sg13cmos5l_decap_8
XFILLER_2_1373 VPWR VGND sg13cmos5l_fill_2
XANTENNA__1271__A1 Tile_X3Y0_N4END[3] VPWR VGND sg13cmos5l_antennanp
XFILLER_13_285 VPWR VGND sg13cmos5l_decap_8
XANTENNA__0912__X Tile_X2Y0_SS4BEG[13] VPWR VGND sg13cmos5l_antennanp
XFILLER_16_1050 VPWR VGND sg13cmos5l_decap_8
XFILLER_13_1982 VPWR VGND sg13cmos5l_decap_8
XFILLER_9_2228 VPWR VGND sg13cmos5l_decap_8
XANTENNA__0510__D Tile_X0Y0_FrameData[27] VPWR VGND sg13cmos5l_antennanp
XANTENNA__0562__CLK Tile_X0Y0_UserCLK VPWR VGND sg13cmos5l_antennanp
X_0303_ _0303_/Q Tile_X0Y0_FrameData[26] VGND VPWR Tile_X1Y0_FrameStrobe[3] latch
X_1283_ _1283_/X Tile_X3Y0_N2END[0] Tile_X3Y0_N4END[8] Tile_X3Y0_NN4END[7] _0575_/Q
+ _0441_/Q _0440_/Q VPWR VGND sg13cmos5l_mux4_1
XFILLER_7_1240 VPWR VGND sg13cmos5l_decap_8
X_0234_ _0234_/Q Tile_X0Y0_FrameData[31] VGND VPWR Tile_X1Y0_FrameStrobe[1] latch
XFILLER_3_1115 VPWR VGND sg13cmos5l_decap_8
XFILLER_0_2748 VPWR VGND sg13cmos5l_decap_8
XFILLER_0_2759 VPWR VGND sg13cmos5l_fill_1
X_0165_ _0165_/Q Tile_X0Y0_FrameData[20] VGND VPWR Tile_X0Y0_FrameStrobe[2] latch
X_0096_ _0096_/Q Tile_X0Y0_FrameData[25] VGND VPWR Tile_X0Y0_FrameStrobe[0] latch
XANTENNA__1262__A1 Tile_X3Y0_N4END[12] VPWR VGND sg13cmos5l_antennanp
XANTENNA__0822__X Tile_X4Y0_FrameData_O[11] VPWR VGND sg13cmos5l_antennanp
XFILLER_14_2458 VPWR VGND sg13cmos5l_decap_8
X_0998_ Tile_X0Y0_S4BEG[7] _1146_/X VPWR VGND sg13cmos5l_buf_1
XFILLER_14_1746 VPWR VGND sg13cmos5l_decap_8
XFILLER_12_2193 VPWR VGND sg13cmos5l_decap_8
XANTENNA__0420__D Tile_X0Y0_FrameData[21] VPWR VGND sg13cmos5l_antennanp
XFILLER_8_1059 VPWR VGND sg13cmos5l_decap_8
XFILLER_5_2648 VPWR VGND sg13cmos5l_decap_8
XANTENNA__0491__GATE Tile_X3Y0_FrameStrobe[2] VPWR VGND sg13cmos5l_antennanp
XFILLER_15_506 VPWR VGND sg13cmos5l_fill_1
XANTENNA__1253__A1 Tile_X3Y0_N2MID[2] VPWR VGND sg13cmos5l_antennanp
XANTENNA__0732__X Tile_X1Y0_SS4BEG[1] VPWR VGND sg13cmos5l_antennanp
XFILLER_10_255 VPWR VGND sg13cmos5l_decap_8
XFILLER_6_248 VPWR VGND sg13cmos5l_fill_2
XFILLER_13_1245 VPWR VGND sg13cmos5l_decap_8
XANTENNA__0585__CLK Tile_X0Y0_UserCLK VPWR VGND sg13cmos5l_antennanp
XANTENNA__0330__D Tile_X0Y0_FrameData[15] VPWR VGND sg13cmos5l_antennanp
XANTENNA__0444__GATE Tile_X3Y0_FrameStrobe[1] VPWR VGND sg13cmos5l_antennanp
XFILLER_2_498 VPWR VGND sg13cmos5l_decap_8
XANTENNA__0459__GATE Tile_X3Y0_FrameStrobe[1] VPWR VGND sg13cmos5l_antennanp
XANTENNA__0907__X Tile_X2Y0_SS4BEG[8] VPWR VGND sg13cmos5l_antennanp
XFILLER_14_550 VPWR VGND sg13cmos5l_fill_2
XANTENNA__1244__A1 Tile_X2Y0_N4END[9] VPWR VGND sg13cmos5l_antennanp
X_0921_ Tile_X3Y0_FrameStrobe_O[6] Tile_X3Y0_FrameStrobe[6] VPWR VGND sg13cmos5l_buf_1
XFILLER_14_583 VPWR VGND sg13cmos5l_fill_2
XANTENNA__0505__D Tile_X0Y0_FrameData[0] VPWR VGND sg13cmos5l_antennanp
XFILLER_15_2767 VPWR VGND sg13cmos5l_decap_8
X_0852_ Tile_X4Y0_FrameStrobe_O[9] Tile_X4Y0_FrameStrobe[9] VPWR VGND sg13cmos5l_buf_1
X_0783_ Tile_X3Y0_S4BEG[4] _1263_/X VPWR VGND sg13cmos5l_buf_1
XFILLER_6_771 VPWR VGND sg13cmos5l_fill_2
XFILLER_13_1790 VPWR VGND sg13cmos5l_decap_4
XFILLER_9_2014 VPWR VGND sg13cmos5l_decap_4
XANTENNA__0240__D Tile_X0Y0_FrameData[25] VPWR VGND sg13cmos5l_antennanp
XFILLER_5_292 VPWR VGND sg13cmos5l_fill_2
XFILLER_9_1357 VPWR VGND sg13cmos5l_decap_4
XANTENNA__1180__A0 Tile_X1Y0_N2MID[1] VPWR VGND sg13cmos5l_antennanp
XFILLER_0_2512 VPWR VGND sg13cmos5l_decap_8
X_1266_ _1266_/X Tile_X3Y0_N2MID[7] Tile_X3Y0_N4END[8] Tile_X3Y0_NN4END[7] _0577_/Q
+ _0475_/Q _0474_/Q VPWR VGND sg13cmos5l_mux4_1
XANTENNA__0817__X Tile_X4Y0_FrameData_O[6] VPWR VGND sg13cmos5l_antennanp
X_0217_ _0217_/Q Tile_X0Y0_FrameData[16] VGND VPWR Tile_X1Y0_FrameStrobe[0] latch
X_1197_ _1197_/X Tile_X1Y0_N2END[2] Tile_X1Y0_N4END[2] Tile_X1Y0_NN4END[13] _0595_/Q
+ _0261_/Q _0260_/Q VPWR VGND sg13cmos5l_mux4_1
XFILLER_0_2589 VPWR VGND sg13cmos5l_fill_2
X_0148_ _0148_/Q Tile_X0Y0_FrameData[5] VGND VPWR Tile_X0Y0_FrameStrobe[1] latch
XANTENNA__1235__A1 Tile_X2Y0_N4END[0] VPWR VGND sg13cmos5l_antennanp
XFILLER_16_1808 VPWR VGND sg13cmos5l_decap_8
XANTENNA__0415__D Tile_X0Y0_FrameData[26] VPWR VGND sg13cmos5l_antennanp
XFILLER_14_2222 VPWR VGND sg13cmos5l_decap_8
XFILLER_10_2119 VPWR VGND sg13cmos5l_decap_4
XFILLER_14_1521 VPWR VGND sg13cmos5l_decap_8
XFILLER_14_2299 VPWR VGND sg13cmos5l_fill_1
XANTENNA__0150__D Tile_X0Y0_FrameData[3] VPWR VGND sg13cmos5l_antennanp
XFILLER_5_2401 VPWR VGND sg13cmos5l_fill_1
XFILLER_9_2592 VPWR VGND sg13cmos5l_decap_8
XFILLER_5_2445 VPWR VGND sg13cmos5l_decap_8
XANTENNA__1171__A0 Tile_X1Y0_N1END[0] VPWR VGND sg13cmos5l_antennanp
XANTENNA__0727__X Tile_X1Y0_S4BEG[12] VPWR VGND sg13cmos5l_antennanp
XFILLER_16_859 VPWR VGND sg13cmos5l_fill_1
XANTENNA__1226__A1 Tile_X2Y0_N4END[8] VPWR VGND sg13cmos5l_antennanp
XFILLER_15_2008 VPWR VGND sg13cmos5l_decap_8
XANTENNA__0325__D Tile_X0Y0_FrameData[20] VPWR VGND sg13cmos5l_antennanp
XFILLER_11_542 VPWR VGND sg13cmos5l_decap_8
XFILLER_7_524 VPWR VGND sg13cmos5l_decap_8
XFILLER_10_2653 VPWR VGND sg13cmos5l_decap_8
XANTENNA__0383__GATE Tile_X2Y0_FrameStrobe[2] VPWR VGND sg13cmos5l_antennanp
XFILLER_10_1974 VPWR VGND sg13cmos5l_decap_8
XFILLER_10_1985 VPWR VGND sg13cmos5l_fill_2
XFILLER_6_2209 VPWR VGND sg13cmos5l_decap_8
XFILLER_8_2080 VPWR VGND sg13cmos5l_decap_8
XANTENNA__0398__GATE Tile_X2Y0_FrameStrobe[2] VPWR VGND sg13cmos5l_antennanp
XANTENNA__1162__A0 Tile_X0Y0_N2END[7] VPWR VGND sg13cmos5l_antennanp
X_1120_ _1120_/X Tile_X0Y0_N4END[8] Tile_X0Y0_N4END[9] Tile_X0Y0_NN4END[8] Tile_X0Y0_NN4END[10]
+ _0105_/Q _0104_/Q VPWR VGND sg13cmos5l_mux4_1
XFILLER_0_1107 VPWR VGND sg13cmos5l_decap_4
X_1051_ Tile_X4Y0_S4BEG[4] Tile_X4Y0_N4END[11] VPWR VGND sg13cmos5l_buf_1
XFILLER_4_1265 VPWR VGND sg13cmos5l_decap_8
XANTENNA__0321__GATE Tile_X2Y0_FrameStrobe[0] VPWR VGND sg13cmos5l_antennanp
XANTENNA__0600__CLK Tile_X0Y0_UserCLK VPWR VGND sg13cmos5l_antennanp
XFILLER_15_870 VPWR VGND sg13cmos5l_decap_8
XANTENNA__0336__GATE Tile_X2Y0_FrameStrobe[0] VPWR VGND sg13cmos5l_antennanp
XANTENNA__1217__A1 Tile_X2Y0_N2MID[6] VPWR VGND sg13cmos5l_antennanp
XANTENNA__0235__D Tile_X0Y0_FrameData[30] VPWR VGND sg13cmos5l_antennanp
XANTENNA__0813__A Tile_X0Y0_FrameData[2] VPWR VGND sg13cmos5l_antennanp
X_0904_ Tile_X2Y0_SS4BEG[5] _1240_/X VPWR VGND sg13cmos5l_buf_1
X_0835_ Tile_X4Y0_FrameData_O[24] Tile_X0Y0_FrameData[24] VPWR VGND sg13cmos5l_buf_1
XFILLER_15_1874 VPWR VGND sg13cmos5l_fill_2
XFILLER_11_1727 VPWR VGND sg13cmos5l_decap_8
X_0766_ Tile_X3Y0_S2BEG[3] Tile_X3Y0_N2MID[4] VPWR VGND sg13cmos5l_buf_1
X_0697_ Tile_X0Y0_FrameStrobe_O[10] Tile_X0Y0_FrameStrobe[10] VPWR VGND sg13cmos5l_buf_1
XFILLER_6_2710 VPWR VGND sg13cmos5l_decap_8
XANTENNA__1153__A0 Tile_X0Y0_N2MID[6] VPWR VGND sg13cmos5l_antennanp
XFILLER_9_1187 VPWR VGND sg13cmos5l_decap_4
XFILLER_0_2331 VPWR VGND sg13cmos5l_decap_8
XFILLER_0_2342 VPWR VGND sg13cmos5l_fill_2
X_1249_ _1249_/X Tile_X2Y0_N2END[6] Tile_X2Y0_N4END[14] Tile_X2Y0_NN4END[1] _0581_/Q
+ _0333_/Q _0332_/Q VPWR VGND sg13cmos5l_mux4_1
XFILLER_0_1630 VPWR VGND sg13cmos5l_fill_1
XFILLER_0_2386 VPWR VGND sg13cmos5l_decap_8
XFILLER_16_2328 VPWR VGND sg13cmos5l_fill_1
XFILLER_13_829 VPWR VGND sg13cmos5l_decap_8
XFILLER_13_818 VPWR VGND sg13cmos5l_fill_1
XANTENNA__1208__A1 Tile_X1Y0_N4END[13] VPWR VGND sg13cmos5l_antennanp
XFILLER_16_1616 VPWR VGND sg13cmos5l_fill_2
XANTENNA_40 Tile_X0Y0_FrameData[4] VPWR VGND sg13cmos5l_antennanp
XANTENNA__0145__D Tile_X0Y0_FrameData[8] VPWR VGND sg13cmos5l_antennanp
XFILLER_16_1649 VPWR VGND sg13cmos5l_fill_1
XANTENNA_51 Tile_X0Y0_FrameData[6] VPWR VGND sg13cmos5l_antennanp
XANTENNA_62 Tile_X0Y0_FrameData[9] VPWR VGND sg13cmos5l_antennanp
XANTENNA_73 Tile_X0Y0_FrameData[30] VPWR VGND sg13cmos5l_antennanp
XANTENNA_84 Tile_X0Y0_FrameData[7] VPWR VGND sg13cmos5l_antennanp
XFILLER_14_1351 VPWR VGND sg13cmos5l_decap_8
XANTENNA_95 Tile_X0Y0_FrameData[1] VPWR VGND sg13cmos5l_antennanp
XFILLER_10_1204 VPWR VGND sg13cmos5l_decap_8
XFILLER_4_538 VPWR VGND sg13cmos5l_decap_8
XFILLER_14_1395 VPWR VGND sg13cmos5l_fill_1
XFILLER_7_2507 VPWR VGND sg13cmos5l_decap_8
XANTENNA__1144__A0 Tile_X0Y0_N2MID[5] VPWR VGND sg13cmos5l_antennanp
XFILLER_0_777 VPWR VGND sg13cmos5l_fill_1
XFILLER_5_2286 VPWR VGND sg13cmos5l_decap_8
XFILLER_5_1541 VPWR VGND sg13cmos5l_fill_1
XFILLER_5_1585 VPWR VGND sg13cmos5l_decap_8
XFILLER_1_1416 VPWR VGND sg13cmos5l_fill_2
XFILLER_1_1427 VPWR VGND sg13cmos5l_fill_1
XFILLER_15_122 VPWR VGND sg13cmos5l_fill_1
XFILLER_15_199 VPWR VGND sg13cmos5l_decap_8
XFILLER_15_1104 VPWR VGND sg13cmos5l_decap_8
XFILLER_8_855 VPWR VGND sg13cmos5l_decap_4
XFILLER_7_35 VPWR VGND sg13cmos5l_fill_2
XFILLER_8_866 VPWR VGND sg13cmos5l_decap_8
XANTENNA__0920__X Tile_X3Y0_FrameStrobe_O[5] VPWR VGND sg13cmos5l_antennanp
XFILLER_10_2461 VPWR VGND sg13cmos5l_decap_8
X_0620_ _0620_/L_HI VPWR VGND sg13cmos5l_tiehi
XFILLER_10_1771 VPWR VGND sg13cmos5l_decap_8
X_0551_ NPU_WDATA27 Tile_X0Y0_UserCLK _1123_/X _0656_/L_HI VPWR VGND sg13cmos5l_dfrbpq_1
X_0482_ _0482_/Q Tile_X0Y0_FrameData[23] VGND VPWR Tile_X3Y0_FrameStrobe[2] latch
XFILLER_3_593 VPWR VGND sg13cmos5l_decap_8
XANTENNA__1135__A0 Tile_X0Y0_N1END[0] VPWR VGND sg13cmos5l_antennanp
XANTENNA__0260__GATE Tile_X1Y0_FrameStrobe[1] VPWR VGND sg13cmos5l_antennanp
X_1103_ _1103_/X Tile_X1Y0_N4END[4] Tile_X1Y0_N4END[7] Tile_X1Y0_NN4END[5] Tile_X1Y0_NN4END[7]
+ _0219_/Q _0218_/Q VPWR VGND sg13cmos5l_mux4_1
X_1034_ Tile_X4Y0_S2BEG[3] Tile_X4Y0_N2MID[4] VPWR VGND sg13cmos5l_buf_1
XFILLER_1_2695 VPWR VGND sg13cmos5l_fill_1
XANTENNA__0275__GATE Tile_X1Y0_FrameStrobe[2] VPWR VGND sg13cmos5l_antennanp
XFILLER_15_2372 VPWR VGND sg13cmos5l_decap_8
XFILLER_15_1682 VPWR VGND sg13cmos5l_decap_8
XFILLER_11_2258 VPWR VGND sg13cmos5l_decap_8
XFILLER_11_1502 VPWR VGND sg13cmos5l_decap_8
XANTENNA__0830__X Tile_X4Y0_FrameData_O[19] VPWR VGND sg13cmos5l_antennanp
X_0818_ Tile_X4Y0_FrameData_O[7] Tile_X0Y0_FrameData[7] VPWR VGND sg13cmos5l_buf_1
XANTENNA__0213__GATE Tile_X1Y0_FrameStrobe[0] VPWR VGND sg13cmos5l_antennanp
X_0749_ Tile_X1Y0_S1BEG[2] Tile_X1Y0_N1END[1] VPWR VGND sg13cmos5l_buf_1
XFILLER_1_519 VPWR VGND sg13cmos5l_decap_8
XANTENNA__1126__A0 Tile_X0Y0_N4END[14] VPWR VGND sg13cmos5l_antennanp
XFILLER_6_2584 VPWR VGND sg13cmos5l_decap_8
XFILLER_2_2404 VPWR VGND sg13cmos5l_fill_2
XANTENNA__0228__GATE Tile_X1Y0_FrameStrobe[0] VPWR VGND sg13cmos5l_antennanp
XFILLER_2_2437 VPWR VGND sg13cmos5l_decap_8
XFILLER_2_1769 VPWR VGND sg13cmos5l_fill_1
XFILLER_16_77 VPWR VGND sg13cmos5l_decap_8
XFILLER_16_2136 VPWR VGND sg13cmos5l_decap_8
XANTENNA__0603__D NPU_RDATA31 VPWR VGND sg13cmos5l_antennanp
XANTENNA__0740__X Tile_X1Y0_SS4BEG[9] VPWR VGND sg13cmos5l_antennanp
XFILLER_10_1012 VPWR VGND sg13cmos5l_decap_8
XFILLER_7_2315 VPWR VGND sg13cmos5l_decap_8
XFILLER_7_1603 VPWR VGND sg13cmos5l_decap_8
XANTENNA__1117__A0 Tile_X0Y0_N4END[5] VPWR VGND sg13cmos5l_antennanp
XFILLER_5_1393 VPWR VGND sg13cmos5l_fill_2
XFILLER_1_1213 VPWR VGND sg13cmos5l_fill_2
XFILLER_1_1202 VPWR VGND sg13cmos5l_decap_4
XANTENNA__0915__X Tile_X3Y0_FrameStrobe_O[0] VPWR VGND sg13cmos5l_antennanp
XFILLER_12_2501 VPWR VGND sg13cmos5l_decap_8
XFILLER_12_681 VPWR VGND sg13cmos5l_decap_8
XFILLER_8_674 VPWR VGND sg13cmos5l_fill_1
XANTENNA__0513__D Tile_X0Y0_FrameData[18] VPWR VGND sg13cmos5l_antennanp
XFILLER_8_696 VPWR VGND sg13cmos5l_fill_1
XFILLER_12_1833 VPWR VGND sg13cmos5l_decap_8
X_0603_ _0603_/Q Tile_X0Y0_UserCLK NPU_RDATA31 _0619_/L_HI VPWR VGND sg13cmos5l_dfrbpq_1
X_0534_ NPU_WDATA10 Tile_X0Y0_UserCLK _1106_/X _0637_/L_HI VPWR VGND sg13cmos5l_dfrbpq_1
XANTENNA__1108__A0 Tile_X1Y0_N4END[12] VPWR VGND sg13cmos5l_antennanp
X_0465_ _0465_/Q Tile_X0Y0_FrameData[8] VGND VPWR Tile_X3Y0_FrameStrobe[1] latch
XFILLER_6_1102 VPWR VGND sg13cmos5l_decap_8
XANTENNA__1123__A3 Tile_X0Y0_NN4END[11] VPWR VGND sg13cmos5l_antennanp
X_0396_ _0396_/Q Tile_X0Y0_FrameData[13] VGND VPWR Tile_X2Y0_FrameStrobe[2] latch
XFILLER_6_1179 VPWR VGND sg13cmos5l_decap_8
XFILLER_3_2757 VPWR VGND sg13cmos5l_decap_8
XFILLER_1_2492 VPWR VGND sg13cmos5l_decap_4
XANTENNA__0825__X Tile_X4Y0_FrameData_O[14] VPWR VGND sg13cmos5l_antennanp
X_1017_ Tile_X0Y0_S2BEG[2] Tile_X0Y0_N2MID[5] VPWR VGND sg13cmos5l_buf_1
XFILLER_13_1608 VPWR VGND sg13cmos5l_decap_8
XANTENNA__0423__D Tile_X0Y0_FrameData[18] VPWR VGND sg13cmos5l_antennanp
XFILLER_11_2055 VPWR VGND sg13cmos5l_decap_8
XANTENNA__0152__GATE Tile_X0Y0_FrameStrobe[1] VPWR VGND sg13cmos5l_antennanp
XFILLER_2_828 VPWR VGND sg13cmos5l_decap_8
XFILLER_1_316 VPWR VGND sg13cmos5l_decap_8
XFILLER_8_2635 VPWR VGND sg13cmos5l_decap_8
XANTENNA__0167__GATE Tile_X0Y0_FrameStrobe[2] VPWR VGND sg13cmos5l_antennanp
XFILLER_8_1956 VPWR VGND sg13cmos5l_decap_8
XFILLER_6_2370 VPWR VGND sg13cmos5l_decap_8
XANTENNA__1114__A3 Tile_X0Y0_NN4END[2] VPWR VGND sg13cmos5l_antennanp
XFILLER_6_1680 VPWR VGND sg13cmos5l_decap_8
XFILLER_2_2256 VPWR VGND sg13cmos5l_decap_8
XANTENNA__0735__X Tile_X1Y0_SS4BEG[4] VPWR VGND sg13cmos5l_antennanp
XFILLER_2_1577 VPWR VGND sg13cmos5l_fill_2
XANTENNA__0105__GATE Tile_X0Y0_FrameStrobe[0] VPWR VGND sg13cmos5l_antennanp
XFILLER_16_1254 VPWR VGND sg13cmos5l_fill_1
XFILLER_16_1265 VPWR VGND sg13cmos5l_decap_8
XANTENNA__0333__D Tile_X0Y0_FrameData[12] VPWR VGND sg13cmos5l_antennanp
XFILLER_5_666 VPWR VGND sg13cmos5l_decap_8
XFILLER_5_644 VPWR VGND sg13cmos5l_decap_8
XFILLER_4_176 VPWR VGND sg13cmos5l_decap_8
XFILLER_7_2123 VPWR VGND sg13cmos5l_fill_2
X_0250_ _0250_/Q Tile_X0Y0_FrameData[15] VGND VPWR Tile_X1Y0_FrameStrobe[1] latch
XFILLER_7_2189 VPWR VGND sg13cmos5l_decap_8
XFILLER_1_883 VPWR VGND sg13cmos5l_fill_1
XANTENNA__1105__A3 Tile_X1Y0_NN4END[11] VPWR VGND sg13cmos5l_antennanp
XFILLER_7_1466 VPWR VGND sg13cmos5l_decap_4
X_0181_ _0181_/Q Tile_X0Y0_FrameData[4] VGND VPWR Tile_X0Y0_FrameStrobe[2] latch
XFILLER_1_1010 VPWR VGND sg13cmos5l_decap_4
XANTENNA__0508__D Tile_X0Y0_FrameData[29] VPWR VGND sg13cmos5l_antennanp
XFILLER_16_272 VPWR VGND sg13cmos5l_decap_8
XFILLER_14_1906 VPWR VGND sg13cmos5l_decap_8
XFILLER_9_950 VPWR VGND sg13cmos5l_fill_2
XANTENNA__0243__D Tile_X0Y0_FrameData[22] VPWR VGND sg13cmos5l_antennanp
XANTENNA__0821__A Tile_X0Y0_FrameData[10] VPWR VGND sg13cmos5l_antennanp
XFILLER_12_2375 VPWR VGND sg13cmos5l_decap_8
XFILLER_12_1630 VPWR VGND sg13cmos5l_decap_8
X_0517_ _0517_/Q Tile_X0Y0_FrameData[22] VGND VPWR Tile_X4Y0_FrameStrobe[0] latch
X_0448_ _0448_/Q Tile_X0Y0_FrameData[25] VGND VPWR Tile_X3Y0_FrameStrobe[1] latch
X_0379_ _0379_/Q Tile_X0Y0_FrameData[30] VGND VPWR Tile_X2Y0_FrameStrobe[2] latch
XFILLER_3_2576 VPWR VGND sg13cmos5l_decap_8
XANTENNA__0418__D Tile_X0Y0_FrameData[23] VPWR VGND sg13cmos5l_antennanp
XANTENNA__1280__A2 Tile_X3Y0_NN4END[10] VPWR VGND sg13cmos5l_antennanp
XFILLER_11_938 VPWR VGND sg13cmos5l_fill_2
XFILLER_11_927 VPWR VGND sg13cmos5l_decap_8
XANTENNA__0153__D Tile_X0Y0_FrameData[0] VPWR VGND sg13cmos5l_antennanp
XFILLER_13_1438 VPWR VGND sg13cmos5l_decap_8
XANTENNA__0091__GATE Tile_X0Y0_FrameStrobe[0] VPWR VGND sg13cmos5l_antennanp
XFILLER_11_1140 VPWR VGND sg13cmos5l_decap_8
XFILLER_2_603 VPWR VGND sg13cmos5l_decap_8
XFILLER_8_2410 VPWR VGND sg13cmos5l_decap_8
XFILLER_8_2487 VPWR VGND sg13cmos5l_decap_8
XFILLER_8_1731 VPWR VGND sg13cmos5l_fill_1
XFILLER_8_1775 VPWR VGND sg13cmos5l_decap_8
XANTENNA__1099__A2 Tile_X1Y0_NN4END[1] VPWR VGND sg13cmos5l_antennanp
XFILLER_4_1628 VPWR VGND sg13cmos5l_decap_8
XANTENNA__0328__D Tile_X0Y0_FrameData[17] VPWR VGND sg13cmos5l_antennanp
XFILLER_2_1363 VPWR VGND sg13cmos5l_fill_2
XFILLER_2_1396 VPWR VGND sg13cmos5l_decap_8
XFILLER_14_732 VPWR VGND sg13cmos5l_fill_2
XFILLER_14_721 VPWR VGND sg13cmos5l_decap_8
XFILLER_13_242 VPWR VGND sg13cmos5l_fill_1
XFILLER_13_231 VPWR VGND sg13cmos5l_decap_4
XANTENNA__1271__A2 Tile_X3Y0_NN4END[12] VPWR VGND sg13cmos5l_antennanp
XFILLER_9_213 VPWR VGND sg13cmos5l_fill_2
XFILLER_9_246 VPWR VGND sg13cmos5l_fill_2
XFILLER_13_2684 VPWR VGND sg13cmos5l_decap_8
XFILLER_13_1961 VPWR VGND sg13cmos5l_decap_8
XFILLER_9_2207 VPWR VGND sg13cmos5l_decap_8
XFILLER_9_1506 VPWR VGND sg13cmos5l_decap_8
X_0302_ _0302_/Q Tile_X0Y0_FrameData[27] VGND VPWR Tile_X1Y0_FrameStrobe[3] latch
XFILLER_1_680 VPWR VGND sg13cmos5l_decap_4
X_1282_ _1282_/X Tile_X3Y0_N2END[7] Tile_X3Y0_N4END[7] Tile_X3Y0_NN4END[8] _0576_/Q
+ _0443_/Q _0442_/Q VPWR VGND sg13cmos5l_mux4_1
X_0233_ _0233_/Q Tile_X0Y0_FrameData[0] VGND VPWR Tile_X1Y0_FrameStrobe[0] latch
X_0164_ _0164_/Q Tile_X0Y0_FrameData[21] VGND VPWR Tile_X0Y0_FrameStrobe[2] latch
XANTENNA__0238__D Tile_X0Y0_FrameData[27] VPWR VGND sg13cmos5l_antennanp
XANTENNA__0816__A Tile_X0Y0_FrameData[5] VPWR VGND sg13cmos5l_antennanp
X_0095_ _0095_/Q Tile_X0Y0_FrameData[26] VGND VPWR Tile_X0Y0_FrameStrobe[0] latch
XANTENNA__1262__A2 Tile_X3Y0_NN4END[3] VPWR VGND sg13cmos5l_antennanp
XFILLER_14_2437 VPWR VGND sg13cmos5l_decap_8
XFILLER_14_1725 VPWR VGND sg13cmos5l_decap_8
X_0997_ Tile_X0Y0_S4BEG[6] _1145_/X VPWR VGND sg13cmos5l_buf_1
XFILLER_12_2172 VPWR VGND sg13cmos5l_decap_8
XFILLER_5_90 VPWR VGND sg13cmos5l_fill_2
XFILLER_9_2774 VPWR VGND sg13cmos5l_decap_4
XFILLER_8_1038 VPWR VGND sg13cmos5l_decap_4
XFILLER_8_1027 VPWR VGND sg13cmos5l_fill_1
XFILLER_8_1016 VPWR VGND sg13cmos5l_decap_8
XFILLER_5_2627 VPWR VGND sg13cmos5l_decap_8
XANTENNA__0148__D Tile_X0Y0_FrameData[5] VPWR VGND sg13cmos5l_antennanp
XFILLER_3_1694 VPWR VGND sg13cmos5l_decap_8
XFILLER_15_529 VPWR VGND sg13cmos5l_fill_1
XANTENNA__1253__A2 Tile_X3Y0_N2END[5] VPWR VGND sg13cmos5l_antennanp
XFILLER_10_234 VPWR VGND sg13cmos5l_fill_2
XFILLER_11_746 VPWR VGND sg13cmos5l_decap_8
XFILLER_13_1224 VPWR VGND sg13cmos5l_decap_8
XFILLER_6_227 VPWR VGND sg13cmos5l_decap_4
XFILLER_3_956 VPWR VGND sg13cmos5l_fill_1
XFILLER_2_422 VPWR VGND sg13cmos5l_fill_2
XFILLER_2_466 VPWR VGND sg13cmos5l_decap_8
XFILLER_8_2284 VPWR VGND sg13cmos5l_decap_8
XFILLER_4_2159 VPWR VGND sg13cmos5l_decap_8
XANTENNA__0923__X Tile_X3Y0_FrameStrobe_O[8] VPWR VGND sg13cmos5l_antennanp
XANTENNA__1244__A2 Tile_X2Y0_NN4END[6] VPWR VGND sg13cmos5l_antennanp
X_0920_ Tile_X3Y0_FrameStrobe_O[5] Tile_X3Y0_FrameStrobe[5] VPWR VGND sg13cmos5l_buf_1
XFILLER_14_595 VPWR VGND sg13cmos5l_decap_8
X_0851_ Tile_X4Y0_FrameStrobe_O[8] Tile_X4Y0_FrameStrobe[8] VPWR VGND sg13cmos5l_buf_1
X_0782_ Tile_X3Y0_S4BEG[3] _1262_/X VPWR VGND sg13cmos5l_buf_1
XFILLER_11_1909 VPWR VGND sg13cmos5l_decap_8
XFILLER_6_761 VPWR VGND sg13cmos5l_decap_4
XFILLER_9_1325 VPWR VGND sg13cmos5l_decap_4
XANTENNA__1180__A1 Tile_X1Y0_N4END[14] VPWR VGND sg13cmos5l_antennanp
X_1265_ _1265_/X Tile_X3Y0_N2MID[6] Tile_X3Y0_N4END[9] Tile_X3Y0_NN4END[6] _0576_/Q
+ _0477_/Q _0476_/Q VPWR VGND sg13cmos5l_mux4_1
XFILLER_7_1082 VPWR VGND sg13cmos5l_decap_8
XFILLER_4_2682 VPWR VGND sg13cmos5l_decap_8
X_0216_ _0216_/Q Tile_X0Y0_FrameData[17] VGND VPWR Tile_X1Y0_FrameStrobe[0] latch
X_1196_ _1196_/X Tile_X1Y0_N2END[1] Tile_X1Y0_N4END[1] Tile_X1Y0_NN4END[14] _0594_/Q
+ _0263_/Q _0262_/Q VPWR VGND sg13cmos5l_mux4_1
X_0147_ _0147_/Q Tile_X0Y0_FrameData[6] VGND VPWR Tile_X0Y0_FrameStrobe[1] latch
XANTENNA__0833__X Tile_X4Y0_FrameData_O[22] VPWR VGND sg13cmos5l_antennanp
XANTENNA__0504__GATE Tile_X3Y0_FrameStrobe[2] VPWR VGND sg13cmos5l_antennanp
XANTENNA__1235__A2 Tile_X2Y0_NN4END[15] VPWR VGND sg13cmos5l_antennanp
XFILLER_14_1500 VPWR VGND sg13cmos5l_decap_8
XFILLER_14_2278 VPWR VGND sg13cmos5l_decap_8
XFILLER_14_1544 VPWR VGND sg13cmos5l_fill_1
XANTENNA__0431__D Tile_X0Y0_FrameData[10] VPWR VGND sg13cmos5l_antennanp
XANTENNA__0519__GATE Tile_X4Y0_FrameStrobe[0] VPWR VGND sg13cmos5l_antennanp
XANTENNA__1171__A1 Tile_X1Y0_N2MID[0] VPWR VGND sg13cmos5l_antennanp
XFILLER_5_1756 VPWR VGND sg13cmos5l_decap_8
XFILLER_3_2181 VPWR VGND sg13cmos5l_decap_8
XFILLER_15_315 VPWR VGND sg13cmos5l_decap_8
XFILLER_15_337 VPWR VGND sg13cmos5l_fill_2
XANTENNA__0743__X Tile_X1Y0_SS4BEG[12] VPWR VGND sg13cmos5l_antennanp
XANTENNA__1226__A2 Tile_X2Y0_NN4END[7] VPWR VGND sg13cmos5l_antennanp
XFILLER_11_521 VPWR VGND sg13cmos5l_decap_8
XANTENNA__0552__CLK Tile_X0Y0_UserCLK VPWR VGND sg13cmos5l_antennanp
XFILLER_7_503 VPWR VGND sg13cmos5l_decap_8
XFILLER_11_598 VPWR VGND sg13cmos5l_decap_8
XFILLER_10_2632 VPWR VGND sg13cmos5l_decap_8
XANTENNA__0341__D Tile_X0Y0_FrameData[4] VPWR VGND sg13cmos5l_antennanp
XFILLER_3_731 VPWR VGND sg13cmos5l_fill_2
XFILLER_13_1098 VPWR VGND sg13cmos5l_decap_8
XFILLER_2_230 VPWR VGND sg13cmos5l_fill_2
XANTENNA__1162__A1 Tile_X0Y0_N4END[7] VPWR VGND sg13cmos5l_antennanp
XANTENNA__0918__X Tile_X3Y0_FrameStrobe_O[3] VPWR VGND sg13cmos5l_antennanp
X_1050_ Tile_X4Y0_S4BEG[3] Tile_X4Y0_N4END[12] VPWR VGND sg13cmos5l_buf_1
XANTENNA__0516__D Tile_X0Y0_FrameData[21] VPWR VGND sg13cmos5l_antennanp
XANTENNA__1217__A2 Tile_X2Y0_N2END[1] VPWR VGND sg13cmos5l_antennanp
XFILLER_15_2543 VPWR VGND sg13cmos5l_decap_8
X_0903_ Tile_X2Y0_SS4BEG[4] _1239_/X VPWR VGND sg13cmos5l_buf_1
X_0834_ Tile_X4Y0_FrameData_O[23] Tile_X0Y0_FrameData[23] VPWR VGND sg13cmos5l_buf_1
XFILLER_15_1853 VPWR VGND sg13cmos5l_decap_8
XFILLER_11_1706 VPWR VGND sg13cmos5l_decap_8
XANTENNA__0490__GATE Tile_X3Y0_FrameStrobe[2] VPWR VGND sg13cmos5l_antennanp
XANTENNA__0251__D Tile_X0Y0_FrameData[14] VPWR VGND sg13cmos5l_antennanp
X_0765_ Tile_X3Y0_S2BEG[2] Tile_X3Y0_N2MID[5] VPWR VGND sg13cmos5l_buf_1
XFILLER_6_580 VPWR VGND sg13cmos5l_decap_8
X_0696_ Tile_X0Y0_FrameStrobe_O[9] Tile_X0Y0_FrameStrobe[9] VPWR VGND sg13cmos5l_buf_1
XFILLER_9_1144 VPWR VGND sg13cmos5l_decap_8
XANTENNA__1153__A1 Tile_X0Y0_N4END[1] VPWR VGND sg13cmos5l_antennanp
XFILLER_9_1166 VPWR VGND sg13cmos5l_decap_8
XFILLER_6_2766 VPWR VGND sg13cmos5l_decap_8
XANTENNA__0828__X Tile_X4Y0_FrameData_O[17] VPWR VGND sg13cmos5l_antennanp
X_1248_ _1248_/X Tile_X2Y0_N2END[5] Tile_X2Y0_N4END[13] Tile_X2Y0_NN4END[2] _0580_/Q
+ _0335_/Q _0334_/Q VPWR VGND sg13cmos5l_mux4_1
XFILLER_0_2365 VPWR VGND sg13cmos5l_decap_8
X_1179_ _1179_/X Tile_X1Y0_N2MID[0] Tile_X1Y0_N4END[15] Tile_X1Y0_NN4END[0] _0594_/Q
+ _0297_/Q _0296_/Q VPWR VGND sg13cmos5l_mux4_1
XFILLER_13_808 VPWR VGND sg13cmos5l_decap_8
XANTENNA__0426__D Tile_X0Y0_FrameData[15] VPWR VGND sg13cmos5l_antennanp
XANTENNA__0575__CLK Tile_X0Y0_UserCLK VPWR VGND sg13cmos5l_antennanp
XANTENNA__0443__GATE Tile_X3Y0_FrameStrobe[1] VPWR VGND sg13cmos5l_antennanp
XANTENNA__1208__A2 Tile_X1Y0_NN4END[2] VPWR VGND sg13cmos5l_antennanp
XFILLER_16_1628 VPWR VGND sg13cmos5l_decap_8
XANTENNA_30 Tile_X0Y0_FrameData[2] VPWR VGND sg13cmos5l_antennanp
XANTENNA_41 Tile_X0Y0_FrameData[5] VPWR VGND sg13cmos5l_antennanp
XANTENNA_52 Tile_X0Y0_FrameData[6] VPWR VGND sg13cmos5l_antennanp
XANTENNA_63 Tile_X0Y0_FrameData[9] VPWR VGND sg13cmos5l_antennanp
XANTENNA_74 Tile_X0Y0_FrameData[30] VPWR VGND sg13cmos5l_antennanp
XFILLER_14_2086 VPWR VGND sg13cmos5l_fill_2
XFILLER_14_1330 VPWR VGND sg13cmos5l_decap_8
XANTENNA_85 Tile_X0Y0_FrameData[10] VPWR VGND sg13cmos5l_antennanp
XANTENNA_96 Tile_X0Y0_FrameData[20] VPWR VGND sg13cmos5l_antennanp
XANTENNA__0458__GATE Tile_X3Y0_FrameStrobe[1] VPWR VGND sg13cmos5l_antennanp
XANTENNA__0161__D Tile_X0Y0_FrameData[24] VPWR VGND sg13cmos5l_antennanp
XFILLER_4_517 VPWR VGND sg13cmos5l_decap_8
XFILLER_0_745 VPWR VGND sg13cmos5l_decap_4
XANTENNA__1144__A1 Tile_X0Y0_N4END[10] VPWR VGND sg13cmos5l_antennanp
XFILLER_5_2254 VPWR VGND sg13cmos5l_fill_1
XANTENNA__0738__X Tile_X1Y0_SS4BEG[7] VPWR VGND sg13cmos5l_antennanp
XFILLER_5_1520 VPWR VGND sg13cmos5l_decap_8
XFILLER_16_657 VPWR VGND sg13cmos5l_fill_2
XFILLER_16_646 VPWR VGND sg13cmos5l_decap_8
XANTENNA__0336__D Tile_X0Y0_FrameData[9] VPWR VGND sg13cmos5l_antennanp
XFILLER_15_178 VPWR VGND sg13cmos5l_decap_8
XFILLER_8_801 VPWR VGND sg13cmos5l_decap_8
XANTENNA__1080__A0 Tile_X2Y0_N1END[0] VPWR VGND sg13cmos5l_antennanp
XFILLER_10_2440 VPWR VGND sg13cmos5l_decap_8
X_0550_ NPU_WDATA26 Tile_X0Y0_UserCLK _1122_/X _0659_/L_HI VPWR VGND sg13cmos5l_dfrbpq_1
XFILLER_3_572 VPWR VGND sg13cmos5l_decap_8
X_0481_ _0481_/Q Tile_X0Y0_FrameData[24] VGND VPWR Tile_X3Y0_FrameStrobe[2] latch
XANTENNA__1135__A1 Tile_X0Y0_N2MID[4] VPWR VGND sg13cmos5l_antennanp
X_1102_ _1102_/X Tile_X1Y0_N4END[6] Tile_X1Y0_N4END[7] Tile_X1Y0_NN4END[4] Tile_X1Y0_NN4END[6]
+ _0221_/Q _0220_/Q VPWR VGND sg13cmos5l_mux4_1
XANTENNA__0598__CLK Tile_X0Y0_UserCLK VPWR VGND sg13cmos5l_antennanp
X_1033_ Tile_X4Y0_S2BEG[2] Tile_X4Y0_N2MID[5] VPWR VGND sg13cmos5l_buf_1
XFILLER_4_1085 VPWR VGND sg13cmos5l_decap_8
XFILLER_1_1951 VPWR VGND sg13cmos5l_fill_1
XANTENNA__0246__D Tile_X0Y0_FrameData[19] VPWR VGND sg13cmos5l_antennanp
XANTENNA__0824__A Tile_X0Y0_FrameData[13] VPWR VGND sg13cmos5l_antennanp
XFILLER_11_2237 VPWR VGND sg13cmos5l_decap_8
X_0817_ Tile_X4Y0_FrameData_O[6] Tile_X0Y0_FrameData[6] VPWR VGND sg13cmos5l_buf_1
X_0748_ Tile_X1Y0_S1BEG[1] Tile_X1Y0_N1END[2] VPWR VGND sg13cmos5l_buf_1
X_0679_ _0679_/L_HI VPWR VGND sg13cmos5l_tiehi
XANTENNA__1126__A1 Tile_X0Y0_N4END[15] VPWR VGND sg13cmos5l_antennanp
XFILLER_6_2552 VPWR VGND sg13cmos5l_decap_4
XFILLER_2_2416 VPWR VGND sg13cmos5l_decap_8
XFILLER_2_1748 VPWR VGND sg13cmos5l_decap_8
XFILLER_0_2184 VPWR VGND sg13cmos5l_fill_1
XANTENNA__0382__GATE Tile_X2Y0_FrameStrobe[2] VPWR VGND sg13cmos5l_antennanp
XFILLER_0_1472 VPWR VGND sg13cmos5l_decap_8
XFILLER_16_56 VPWR VGND sg13cmos5l_decap_8
XANTENNA__0156__D Tile_X0Y0_FrameData[29] VPWR VGND sg13cmos5l_antennanp
XFILLER_16_2115 VPWR VGND sg13cmos5l_fill_2
XFILLER_12_148 VPWR VGND sg13cmos5l_fill_2
XFILLER_12_137 VPWR VGND sg13cmos5l_decap_8
XANTENNA__0397__GATE Tile_X2Y0_FrameStrobe[2] VPWR VGND sg13cmos5l_antennanp
XFILLER_5_837 VPWR VGND sg13cmos5l_decap_8
XFILLER_4_303 VPWR VGND sg13cmos5l_decap_8
XFILLER_14_1193 VPWR VGND sg13cmos5l_decap_8
XANTENNA__0320__GATE Tile_X2Y0_FrameStrobe[0] VPWR VGND sg13cmos5l_antennanp
XFILLER_4_347 VPWR VGND sg13cmos5l_fill_2
XFILLER_10_1079 VPWR VGND sg13cmos5l_decap_8
XFILLER_0_520 VPWR VGND sg13cmos5l_fill_1
XANTENNA__1117__A1 Tile_X0Y0_N4END[6] VPWR VGND sg13cmos5l_antennanp
XANTENNA__0335__GATE Tile_X2Y0_FrameStrobe[0] VPWR VGND sg13cmos5l_antennanp
XFILLER_5_1350 VPWR VGND sg13cmos5l_fill_1
XFILLER_5_1361 VPWR VGND sg13cmos5l_fill_1
XFILLER_12_660 VPWR VGND sg13cmos5l_decap_8
XANTENNA__0931__X Tile_X3Y0_FrameStrobe_O[16] VPWR VGND sg13cmos5l_antennanp
XFILLER_8_653 VPWR VGND sg13cmos5l_decap_8
XFILLER_8_664 VPWR VGND sg13cmos5l_fill_2
XFILLER_12_1812 VPWR VGND sg13cmos5l_decap_8
X_0602_ _0602_/Q Tile_X0Y0_UserCLK NPU_RDATA30 _0618_/L_HI VPWR VGND sg13cmos5l_dfrbpq_1
XFILLER_12_1889 VPWR VGND sg13cmos5l_decap_8
X_0533_ NPU_WDATA9 Tile_X0Y0_UserCLK _1105_/X _0638_/L_HI VPWR VGND sg13cmos5l_dfrbpq_1
XFILLER_4_892 VPWR VGND sg13cmos5l_decap_8
XANTENNA__1108__A1 Tile_X1Y0_N4END[13] VPWR VGND sg13cmos5l_antennanp
X_0464_ _0464_/Q Tile_X0Y0_FrameData[9] VGND VPWR Tile_X3Y0_FrameStrobe[1] latch
XANTENNA__0819__A Tile_X0Y0_FrameData[8] VPWR VGND sg13cmos5l_antennanp
X_0395_ _0395_/Q Tile_X0Y0_FrameData[14] VGND VPWR Tile_X2Y0_FrameStrobe[2] latch
XFILLER_6_1158 VPWR VGND sg13cmos5l_decap_8
XFILLER_3_2736 VPWR VGND sg13cmos5l_decap_8
XFILLER_1_2471 VPWR VGND sg13cmos5l_fill_2
X_1016_ Tile_X0Y0_S2BEG[1] Tile_X0Y0_N2MID[6] VPWR VGND sg13cmos5l_buf_1
XFILLER_1_1770 VPWR VGND sg13cmos5l_decap_4
XANTENNA__1002__X Tile_X0Y0_S4BEG[11] VPWR VGND sg13cmos5l_antennanp
XFILLER_10_619 VPWR VGND sg13cmos5l_decap_8
XANTENNA__0841__X Tile_X4Y0_FrameData_O[30] VPWR VGND sg13cmos5l_antennanp
XFILLER_11_2034 VPWR VGND sg13cmos5l_decap_8
XFILLER_11_2078 VPWR VGND sg13cmos5l_fill_1
XFILLER_11_2089 VPWR VGND sg13cmos5l_fill_2
XFILLER_8_2614 VPWR VGND sg13cmos5l_decap_8
XFILLER_8_1924 VPWR VGND sg13cmos5l_fill_1
XFILLER_8_1979 VPWR VGND sg13cmos5l_fill_1
XFILLER_2_2235 VPWR VGND sg13cmos5l_decap_8
XFILLER_2_1545 VPWR VGND sg13cmos5l_decap_4
XFILLER_2_1589 VPWR VGND sg13cmos5l_fill_2
XFILLER_14_914 VPWR VGND sg13cmos5l_fill_2
XANTENNA__1283__A0 Tile_X3Y0_N2END[0] VPWR VGND sg13cmos5l_antennanp
XFILLER_16_1222 VPWR VGND sg13cmos5l_decap_4
XANTENNA__0751__X Tile_X1Y0_S2BEG[0] VPWR VGND sg13cmos5l_antennanp
XFILLER_12_1119 VPWR VGND sg13cmos5l_decap_8
XFILLER_5_623 VPWR VGND sg13cmos5l_decap_8
XFILLER_4_100 VPWR VGND sg13cmos5l_fill_2
XFILLER_11_2590 VPWR VGND sg13cmos5l_decap_8
XFILLER_7_2102 VPWR VGND sg13cmos5l_decap_8
XANTENNA__0274__GATE Tile_X1Y0_FrameStrobe[2] VPWR VGND sg13cmos5l_antennanp
XFILLER_7_2168 VPWR VGND sg13cmos5l_decap_8
X_0180_ _0180_/Q Tile_X0Y0_FrameData[5] VGND VPWR Tile_X0Y0_FrameStrobe[2] latch
XANTENNA__0289__GATE Tile_X1Y0_FrameStrobe[2] VPWR VGND sg13cmos5l_antennanp
XANTENNA__0926__X Tile_X3Y0_FrameStrobe_O[11] VPWR VGND sg13cmos5l_antennanp
XFILLER_2_2780 VPWR VGND sg13cmos5l_fill_1
XFILLER_16_251 VPWR VGND sg13cmos5l_decap_8
XANTENNA__1274__A0 Tile_X3Y0_N2MID[7] VPWR VGND sg13cmos5l_antennanp
XANTENNA__0212__GATE Tile_X1Y0_FrameStrobe[0] VPWR VGND sg13cmos5l_antennanp
XFILLER_14_2619 VPWR VGND sg13cmos5l_decap_8
XFILLER_9_940 VPWR VGND sg13cmos5l_fill_2
XFILLER_12_490 VPWR VGND sg13cmos5l_decap_8
XANTENNA__0227__GATE Tile_X1Y0_FrameStrobe[0] VPWR VGND sg13cmos5l_antennanp
XFILLER_12_2354 VPWR VGND sg13cmos5l_decap_8
XFILLER_12_1686 VPWR VGND sg13cmos5l_decap_8
X_0516_ _0516_/Q Tile_X0Y0_FrameData[21] VGND VPWR Tile_X4Y0_FrameStrobe[0] latch
X_0447_ _0447_/Q Tile_X0Y0_FrameData[26] VGND VPWR Tile_X3Y0_FrameStrobe[1] latch
XFILLER_7_2680 VPWR VGND sg13cmos5l_decap_8
XFILLER_3_2511 VPWR VGND sg13cmos5l_decap_8
X_0378_ _0378_/Q Tile_X0Y0_FrameData[31] VGND VPWR Tile_X2Y0_FrameStrobe[2] latch
XFILLER_3_2566 VPWR VGND sg13cmos5l_decap_4
XFILLER_3_2544 VPWR VGND sg13cmos5l_fill_1
XFILLER_3_1832 VPWR VGND sg13cmos5l_decap_4
XANTENNA__0836__X Tile_X4Y0_FrameData_O[25] VPWR VGND sg13cmos5l_antennanp
XFILLER_3_2599 VPWR VGND sg13cmos5l_decap_8
XFILLER_1_2290 VPWR VGND sg13cmos5l_decap_8
XANTENNA__1265__A0 Tile_X3Y0_N2MID[6] VPWR VGND sg13cmos5l_antennanp
XANTENNA__0434__D Tile_X0Y0_FrameData[7] VPWR VGND sg13cmos5l_antennanp
XFILLER_13_57 VPWR VGND sg13cmos5l_decap_4
XFILLER_11_1196 VPWR VGND sg13cmos5l_decap_8
XFILLER_2_659 VPWR VGND sg13cmos5l_decap_8
XFILLER_8_2466 VPWR VGND sg13cmos5l_decap_8
XFILLER_4_1607 VPWR VGND sg13cmos5l_decap_8
XFILLER_2_2010 VPWR VGND sg13cmos5l_decap_4
XANTENNA__1099__A3 Tile_X1Y0_NN4END[3] VPWR VGND sg13cmos5l_antennanp
XANTENNA__0746__X Tile_X1Y0_SS4BEG[15] VPWR VGND sg13cmos5l_antennanp
XFILLER_2_2076 VPWR VGND sg13cmos5l_decap_8
XFILLER_2_1342 VPWR VGND sg13cmos5l_decap_8
XFILLER_2_1320 VPWR VGND sg13cmos5l_decap_8
XFILLER_2_2087 VPWR VGND sg13cmos5l_decap_8
XANTENNA__1256__A0 Tile_X3Y0_N1END[1] VPWR VGND sg13cmos5l_antennanp
XFILLER_14_700 VPWR VGND sg13cmos5l_decap_8
XFILLER_13_210 VPWR VGND sg13cmos5l_decap_8
XFILLER_9_225 VPWR VGND sg13cmos5l_decap_8
XFILLER_14_788 VPWR VGND sg13cmos5l_fill_2
XFILLER_14_777 VPWR VGND sg13cmos5l_fill_1
XANTENNA__0344__D Tile_X0Y0_FrameData[1] VPWR VGND sg13cmos5l_antennanp
XANTENNA__0922__A Tile_X3Y0_FrameStrobe[7] VPWR VGND sg13cmos5l_antennanp
XFILLER_16_1096 VPWR VGND sg13cmos5l_decap_8
XFILLER_13_2663 VPWR VGND sg13cmos5l_decap_8
XFILLER_13_1940 VPWR VGND sg13cmos5l_decap_8
XFILLER_10_961 VPWR VGND sg13cmos5l_fill_1
XFILLER_10_994 VPWR VGND sg13cmos5l_decap_4
XFILLER_5_497 VPWR VGND sg13cmos5l_decap_8
X_0301_ _0301_/Q Tile_X0Y0_FrameData[28] VGND VPWR Tile_X1Y0_FrameStrobe[3] latch
X_1281_ _1281_/X Tile_X3Y0_N2END[6] Tile_X3Y0_N4END[6] Tile_X3Y0_NN4END[9] _0577_/Q
+ _0445_/Q _0444_/Q VPWR VGND sg13cmos5l_mux4_1
XFILLER_0_191 VPWR VGND sg13cmos5l_decap_4
X_0232_ _0232_/Q Tile_X0Y0_FrameData[1] VGND VPWR Tile_X1Y0_FrameStrobe[0] latch
XFILLER_7_1286 VPWR VGND sg13cmos5l_fill_1
XFILLER_7_1275 VPWR VGND sg13cmos5l_decap_8
XANTENNA__0519__D Tile_X0Y0_FrameData[24] VPWR VGND sg13cmos5l_antennanp
X_0163_ _0163_/Q Tile_X0Y0_FrameData[22] VGND VPWR Tile_X0Y0_FrameStrobe[2] latch
XANTENNA__0151__GATE Tile_X0Y0_FrameStrobe[1] VPWR VGND sg13cmos5l_antennanp
XANTENNA__1247__A0 Tile_X2Y0_N2END[4] VPWR VGND sg13cmos5l_antennanp
X_0094_ _0094_/Q Tile_X0Y0_FrameData[27] VGND VPWR Tile_X0Y0_FrameStrobe[0] latch
XFILLER_14_2416 VPWR VGND sg13cmos5l_decap_8
XANTENNA__0166__GATE Tile_X0Y0_FrameStrobe[2] VPWR VGND sg13cmos5l_antennanp
XANTENNA__0254__D Tile_X0Y0_FrameData[11] VPWR VGND sg13cmos5l_antennanp
XANTENNA__0832__A Tile_X0Y0_FrameData[21] VPWR VGND sg13cmos5l_antennanp
XFILLER_14_1704 VPWR VGND sg13cmos5l_decap_8
XFILLER_9_770 VPWR VGND sg13cmos5l_fill_1
X_0996_ Tile_X0Y0_S4BEG[5] _1144_/X VPWR VGND sg13cmos5l_buf_1
XFILLER_12_1483 VPWR VGND sg13cmos5l_decap_8
XFILLER_9_2753 VPWR VGND sg13cmos5l_decap_8
XFILLER_5_2606 VPWR VGND sg13cmos5l_decap_8
XANTENNA__0104__GATE Tile_X0Y0_FrameStrobe[0] VPWR VGND sg13cmos5l_antennanp
XANTENNA__0429__D Tile_X0Y0_FrameData[12] VPWR VGND sg13cmos5l_antennanp
XFILLER_3_2374 VPWR VGND sg13cmos5l_decap_8
XFILLER_3_1673 VPWR VGND sg13cmos5l_decap_8
XANTENNA__0119__GATE Tile_X0Y0_FrameStrobe[0] VPWR VGND sg13cmos5l_antennanp
XANTENNA__1238__A0 Tile_X2Y0_N2END[3] VPWR VGND sg13cmos5l_antennanp
XFILLER_11_725 VPWR VGND sg13cmos5l_decap_8
XANTENNA__0164__D Tile_X0Y0_FrameData[21] VPWR VGND sg13cmos5l_antennanp
XFILLER_6_206 VPWR VGND sg13cmos5l_decap_8
XFILLER_13_1203 VPWR VGND sg13cmos5l_decap_8
XFILLER_3_913 VPWR VGND sg13cmos5l_decap_8
XFILLER_3_935 VPWR VGND sg13cmos5l_fill_2
XFILLER_3_979 VPWR VGND sg13cmos5l_fill_2
XFILLER_8_2263 VPWR VGND sg13cmos5l_decap_8
XFILLER_8_1562 VPWR VGND sg13cmos5l_decap_8
XFILLER_4_2138 VPWR VGND sg13cmos5l_decap_8
XFILLER_8_1595 VPWR VGND sg13cmos5l_decap_8
XFILLER_4_1404 VPWR VGND sg13cmos5l_decap_8
XANTENNA__0339__D Tile_X0Y0_FrameData[6] VPWR VGND sg13cmos5l_antennanp
XANTENNA__0917__A Tile_X3Y0_FrameStrobe[2] VPWR VGND sg13cmos5l_antennanp
XANTENNA__1229__A0 Tile_X2Y0_N2MID[2] VPWR VGND sg13cmos5l_antennanp
XFILLER_2_1183 VPWR VGND sg13cmos5l_decap_8
XFILLER_15_2714 VPWR VGND sg13cmos5l_decap_8
X_0850_ Tile_X4Y0_FrameStrobe_O[7] Tile_X4Y0_FrameStrobe[7] VPWR VGND sg13cmos5l_buf_1
X_0781_ Tile_X3Y0_S4BEG[2] _1261_/X VPWR VGND sg13cmos5l_buf_1
XFILLER_9_2049 VPWR VGND sg13cmos5l_decap_8
XANTENNA__1180__A2 Tile_X1Y0_NN4END[1] VPWR VGND sg13cmos5l_antennanp
X_1264_ _1264_/X Tile_X3Y0_N2MID[5] Tile_X3Y0_N4END[10] Tile_X3Y0_NN4END[5] _0577_/Q
+ _0479_/Q _0478_/Q VPWR VGND sg13cmos5l_mux4_1
XFILLER_7_1061 VPWR VGND sg13cmos5l_decap_8
XANTENNA__0249__D Tile_X0Y0_FrameData[16] VPWR VGND sg13cmos5l_antennanp
X_0215_ _0215_/Q Tile_X0Y0_FrameData[18] VGND VPWR Tile_X1Y0_FrameStrobe[0] latch
XFILLER_4_2661 VPWR VGND sg13cmos5l_decap_8
XANTENNA__0827__A Tile_X0Y0_FrameData[16] VPWR VGND sg13cmos5l_antennanp
XFILLER_0_2547 VPWR VGND sg13cmos5l_decap_8
X_1195_ _1195_/X Tile_X1Y0_N2END[0] Tile_X1Y0_N4END[0] Tile_X1Y0_NN4END[15] _0595_/Q
+ _0265_/Q _0264_/Q VPWR VGND sg13cmos5l_mux4_1
X_0146_ _0146_/Q Tile_X0Y0_FrameData[7] VGND VPWR Tile_X0Y0_FrameStrobe[1] latch
XANTENNA__1010__X Tile_X0Y0_S2BEGb[3] VPWR VGND sg13cmos5l_antennanp
XFILLER_14_2257 VPWR VGND sg13cmos5l_decap_8
X_0979_ Tile_X0Y0_SS4BEG[4] _1159_/X VPWR VGND sg13cmos5l_buf_1
XFILLER_3_209 VPWR VGND sg13cmos5l_decap_8
XFILLER_12_1280 VPWR VGND sg13cmos5l_decap_8
XANTENNA__1171__A2 Tile_X1Y0_N2END[7] VPWR VGND sg13cmos5l_antennanp
XFILLER_9_1871 VPWR VGND sg13cmos5l_fill_2
XFILLER_5_1735 VPWR VGND sg13cmos5l_fill_2
XFILLER_5_1724 VPWR VGND sg13cmos5l_decap_8
XANTENNA__0159__D Tile_X0Y0_FrameData[26] VPWR VGND sg13cmos5l_antennanp
XFILLER_3_2160 VPWR VGND sg13cmos5l_decap_8
XFILLER_11_500 VPWR VGND sg13cmos5l_decap_8
XFILLER_13_1044 VPWR VGND sg13cmos5l_fill_2
XFILLER_11_577 VPWR VGND sg13cmos5l_decap_8
XFILLER_10_2611 VPWR VGND sg13cmos5l_decap_8
XFILLER_7_559 VPWR VGND sg13cmos5l_decap_8
XFILLER_13_1077 VPWR VGND sg13cmos5l_decap_8
XFILLER_10_2688 VPWR VGND sg13cmos5l_decap_8
XFILLER_2_242 VPWR VGND sg13cmos5l_decap_8
XANTENNA__1162__A2 Tile_X0Y0_NN4END[8] VPWR VGND sg13cmos5l_antennanp
XFILLER_4_1201 VPWR VGND sg13cmos5l_decap_4
XANTENNA__0934__X Tile_X3Y0_FrameStrobe_O[19] VPWR VGND sg13cmos5l_antennanp
X_0902_ Tile_X2Y0_SS4BEG[3] _1238_/X VPWR VGND sg13cmos5l_buf_1
XFILLER_15_1832 VPWR VGND sg13cmos5l_decap_8
X_0833_ Tile_X4Y0_FrameData_O[22] Tile_X0Y0_FrameData[22] VPWR VGND sg13cmos5l_buf_1
XFILLER_11_2419 VPWR VGND sg13cmos5l_decap_8
X_0764_ Tile_X3Y0_S2BEG[1] Tile_X3Y0_N2MID[6] VPWR VGND sg13cmos5l_buf_1
X_0695_ Tile_X0Y0_FrameStrobe_O[8] Tile_X0Y0_FrameStrobe[8] VPWR VGND sg13cmos5l_buf_1
XFILLER_9_1123 VPWR VGND sg13cmos5l_decap_8
XFILLER_6_2745 VPWR VGND sg13cmos5l_decap_8
XANTENNA__1153__A2 Tile_X0Y0_NN4END[14] VPWR VGND sg13cmos5l_antennanp
XFILLER_2_2609 VPWR VGND sg13cmos5l_decap_8
XANTENNA__1005__X Tile_X0Y0_S4BEG[14] VPWR VGND sg13cmos5l_antennanp
X_1247_ _1247_/X Tile_X2Y0_N2END[4] Tile_X2Y0_N4END[12] Tile_X2Y0_NN4END[3] _0581_/Q
+ _0337_/Q _0336_/Q VPWR VGND sg13cmos5l_mux4_1
XFILLER_2_1908 VPWR VGND sg13cmos5l_decap_8
XFILLER_0_2355 VPWR VGND sg13cmos5l_fill_1
X_1178_ _1178_/X Tile_X1Y0_N1END[3] Tile_X1Y0_N2MID[7] Tile_X1Y0_N2END[0] _0595_/Q
+ _0299_/Q _0298_/Q VPWR VGND sg13cmos5l_mux4_1
XANTENNA__0844__X Tile_X4Y0_FrameStrobe_O[1] VPWR VGND sg13cmos5l_antennanp
XFILLER_0_1654 VPWR VGND sg13cmos5l_fill_1
X_0129_ _0129_/Q Tile_X0Y0_FrameData[24] VGND VPWR Tile_X0Y0_FrameStrobe[1] latch
XFILLER_16_2308 VPWR VGND sg13cmos5l_fill_1
XFILLER_12_319 VPWR VGND sg13cmos5l_decap_8
XANTENNA_20 Tile_X0Y0_FrameData[17] VPWR VGND sg13cmos5l_antennanp
XANTENNA_31 Tile_X0Y0_FrameData[2] VPWR VGND sg13cmos5l_antennanp
XFILLER_14_2054 VPWR VGND sg13cmos5l_fill_1
XFILLER_14_2032 VPWR VGND sg13cmos5l_decap_8
XANTENNA_42 Tile_X0Y0_FrameData[5] VPWR VGND sg13cmos5l_antennanp
XANTENNA_53 Tile_X0Y0_FrameData[6] VPWR VGND sg13cmos5l_antennanp
XANTENNA_64 Tile_X0Y0_FrameData[9] VPWR VGND sg13cmos5l_antennanp
XANTENNA_75 Tile_X0Y0_FrameData[30] VPWR VGND sg13cmos5l_antennanp
XFILLER_14_2065 VPWR VGND sg13cmos5l_decap_8
XANTENNA_86 Tile_X0Y0_FrameData[17] VPWR VGND sg13cmos5l_antennanp
XANTENNA_97 Tile_X0Y0_FrameData[23] VPWR VGND sg13cmos5l_antennanp
XANTENNA__0442__D Tile_X0Y0_FrameData[31] VPWR VGND sg13cmos5l_antennanp
XFILLER_10_1239 VPWR VGND sg13cmos5l_decap_8
XFILLER_7_1819 VPWR VGND sg13cmos5l_fill_2
XANTENNA__1144__A2 Tile_X0Y0_NN4END[5] VPWR VGND sg13cmos5l_antennanp
XFILLER_5_2233 VPWR VGND sg13cmos5l_decap_8
XFILLER_5_2222 VPWR VGND sg13cmos5l_fill_1
XFILLER_5_1565 VPWR VGND sg13cmos5l_fill_2
XFILLER_16_625 VPWR VGND sg13cmos5l_decap_8
XANTENNA__0754__X Tile_X1Y0_S2BEG[3] VPWR VGND sg13cmos5l_antennanp
XFILLER_16_669 VPWR VGND sg13cmos5l_decap_8
XFILLER_15_157 VPWR VGND sg13cmos5l_decap_8
XFILLER_15_146 VPWR VGND sg13cmos5l_fill_1
XFILLER_12_2717 VPWR VGND sg13cmos5l_fill_2
XANTENNA__1080__A1 Tile_X2Y0_N2MID[0] VPWR VGND sg13cmos5l_antennanp
XFILLER_8_824 VPWR VGND sg13cmos5l_decap_8
XFILLER_8_835 VPWR VGND sg13cmos5l_fill_1
XFILLER_8_846 VPWR VGND sg13cmos5l_fill_2
XFILLER_15_1139 VPWR VGND sg13cmos5l_decap_4
XANTENNA__0352__D Tile_X0Y0_FrameData[25] VPWR VGND sg13cmos5l_antennanp
XANTENNA__0930__A Tile_X3Y0_FrameStrobe[15] VPWR VGND sg13cmos5l_antennanp
XFILLER_10_2496 VPWR VGND sg13cmos5l_decap_8
X_0480_ _0480_/Q Tile_X0Y0_FrameData[25] VGND VPWR Tile_X3Y0_FrameStrobe[2] latch
XFILLER_3_551 VPWR VGND sg13cmos5l_decap_8
XANTENNA__0929__X Tile_X3Y0_FrameStrobe_O[14] VPWR VGND sg13cmos5l_antennanp
XANTENNA__1135__A2 Tile_X0Y0_N2END[3] VPWR VGND sg13cmos5l_antennanp
XFILLER_6_1329 VPWR VGND sg13cmos5l_decap_8
XFILLER_6_1307 VPWR VGND sg13cmos5l_decap_4
XANTENNA__0503__GATE Tile_X3Y0_FrameStrobe[2] VPWR VGND sg13cmos5l_antennanp
X_1101_ _1101_/X Tile_X1Y0_N4END[5] Tile_X1Y0_N4END[6] Tile_X1Y0_NN4END[5] Tile_X1Y0_NN4END[7]
+ _0223_/Q _0222_/Q VPWR VGND sg13cmos5l_mux4_1
X_1032_ Tile_X4Y0_S2BEG[1] Tile_X4Y0_N2MID[6] VPWR VGND sg13cmos5l_buf_1
XFILLER_4_1064 VPWR VGND sg13cmos5l_decap_8
XFILLER_1_2653 VPWR VGND sg13cmos5l_decap_4
XFILLER_1_1963 VPWR VGND sg13cmos5l_fill_2
XANTENNA__0518__GATE Tile_X4Y0_FrameStrobe[0] VPWR VGND sg13cmos5l_antennanp
XFILLER_11_2216 VPWR VGND sg13cmos5l_decap_8
XANTENNA__0262__D Tile_X0Y0_FrameData[3] VPWR VGND sg13cmos5l_antennanp
XFILLER_15_1662 VPWR VGND sg13cmos5l_decap_8
XANTENNA__0840__A Tile_X0Y0_FrameData[29] VPWR VGND sg13cmos5l_antennanp
X_0816_ Tile_X4Y0_FrameData_O[5] Tile_X0Y0_FrameData[5] VPWR VGND sg13cmos5l_buf_1
XFILLER_11_1537 VPWR VGND sg13cmos5l_decap_8
X_0747_ Tile_X1Y0_S1BEG[0] Tile_X1Y0_N1END[3] VPWR VGND sg13cmos5l_buf_1
X_0678_ _0678_/L_HI VPWR VGND sg13cmos5l_tiehi
XANTENNA__0839__X Tile_X4Y0_FrameData_O[28] VPWR VGND sg13cmos5l_antennanp
XANTENNA__1126__A2 Tile_X0Y0_NN4END[12] VPWR VGND sg13cmos5l_antennanp
XANTENNA__0542__CLK Tile_X0Y0_UserCLK VPWR VGND sg13cmos5l_antennanp
XFILLER_2_1727 VPWR VGND sg13cmos5l_decap_8
XANTENNA__0437__D Tile_X0Y0_FrameData[4] VPWR VGND sg13cmos5l_antennanp
XFILLER_16_35 VPWR VGND sg13cmos5l_decap_8
XFILLER_0_1451 VPWR VGND sg13cmos5l_fill_2
XFILLER_13_639 VPWR VGND sg13cmos5l_decap_8
XANTENNA__0172__D Tile_X0Y0_FrameData[13] VPWR VGND sg13cmos5l_antennanp
XANTENNA__0523__Q NPU_READ_BANK_SEL2 VPWR VGND sg13cmos5l_antennanp
XANTENNA__0750__A Tile_X1Y0_N1END[0] VPWR VGND sg13cmos5l_antennanp
XFILLER_5_827 VPWR VGND sg13cmos5l_fill_2
XFILLER_14_1172 VPWR VGND sg13cmos5l_decap_8
XFILLER_11_2772 VPWR VGND sg13cmos5l_decap_8
XFILLER_10_1058 VPWR VGND sg13cmos5l_decap_8
XANTENNA__0749__X Tile_X1Y0_S1BEG[2] VPWR VGND sg13cmos5l_antennanp
XANTENNA__1117__A2 Tile_X0Y0_NN4END[5] VPWR VGND sg13cmos5l_antennanp
XFILLER_7_1638 VPWR VGND sg13cmos5l_decap_8
XFILLER_5_2030 VPWR VGND sg13cmos5l_fill_2
XFILLER_1_1215 VPWR VGND sg13cmos5l_fill_1
XANTENNA__0347__D Tile_X0Y0_FrameData[30] VPWR VGND sg13cmos5l_antennanp
XFILLER_1_1237 VPWR VGND sg13cmos5l_fill_1
XANTENNA__0925__A Tile_X3Y0_FrameStrobe[10] VPWR VGND sg13cmos5l_antennanp
XFILLER_16_444 VPWR VGND sg13cmos5l_decap_8
XFILLER_16_499 VPWR VGND sg13cmos5l_decap_8
XFILLER_16_477 VPWR VGND sg13cmos5l_fill_1
XFILLER_16_2683 VPWR VGND sg13cmos5l_decap_8
XFILLER_8_632 VPWR VGND sg13cmos5l_decap_8
XFILLER_7_131 VPWR VGND sg13cmos5l_fill_2
XFILLER_12_2536 VPWR VGND sg13cmos5l_decap_4
XFILLER_11_182 VPWR VGND sg13cmos5l_decap_4
XFILLER_7_164 VPWR VGND sg13cmos5l_decap_4
XFILLER_7_142 VPWR VGND sg13cmos5l_decap_4
X_0601_ _0601_/Q Tile_X0Y0_UserCLK NPU_RDATA29 _0617_/L_HI VPWR VGND sg13cmos5l_dfrbpq_1
XFILLER_12_1868 VPWR VGND sg13cmos5l_decap_8
XFILLER_10_2293 VPWR VGND sg13cmos5l_decap_8
X_0532_ NPU_WDATA8 Tile_X0Y0_UserCLK _1104_/X _0639_/L_HI VPWR VGND sg13cmos5l_dfrbpq_1
XANTENNA__0565__CLK Tile_X0Y0_UserCLK VPWR VGND sg13cmos5l_antennanp
XFILLER_10_1592 VPWR VGND sg13cmos5l_fill_1
XANTENNA__0442__GATE Tile_X3Y0_FrameStrobe[1] VPWR VGND sg13cmos5l_antennanp
XANTENNA__1108__A2 Tile_X1Y0_NN4END[12] VPWR VGND sg13cmos5l_antennanp
X_0463_ _0463_/Q Tile_X0Y0_FrameData[10] VGND VPWR Tile_X3Y0_FrameStrobe[1] latch
X_0394_ _0394_/Q Tile_X0Y0_FrameData[15] VGND VPWR Tile_X2Y0_FrameStrobe[2] latch
XFILLER_6_1137 VPWR VGND sg13cmos5l_decap_8
XFILLER_3_2715 VPWR VGND sg13cmos5l_decap_8
XANTENNA__0257__D Tile_X0Y0_FrameData[8] VPWR VGND sg13cmos5l_antennanp
XANTENNA__0457__GATE Tile_X3Y0_FrameStrobe[1] VPWR VGND sg13cmos5l_antennanp
XANTENNA__0835__A Tile_X0Y0_FrameData[24] VPWR VGND sg13cmos5l_antennanp
X_1015_ Tile_X0Y0_S2BEG[0] Tile_X0Y0_N2MID[7] VPWR VGND sg13cmos5l_buf_1
XFILLER_11_2013 VPWR VGND sg13cmos5l_decap_8
XFILLER_11_1301 VPWR VGND sg13cmos5l_decap_8
XFILLER_11_1378 VPWR VGND sg13cmos5l_decap_8
XFILLER_8_1936 VPWR VGND sg13cmos5l_fill_1
XFILLER_2_2214 VPWR VGND sg13cmos5l_decap_8
XANTENNA__0167__D Tile_X0Y0_FrameData[18] VPWR VGND sg13cmos5l_antennanp
XFILLER_2_1535 VPWR VGND sg13cmos5l_fill_1
XANTENNA__1283__A1 Tile_X3Y0_N4END[8] VPWR VGND sg13cmos5l_antennanp
XFILLER_0_1281 VPWR VGND sg13cmos5l_fill_1
XFILLER_16_1201 VPWR VGND sg13cmos5l_decap_8
XFILLER_16_1245 VPWR VGND sg13cmos5l_decap_8
XFILLER_5_602 VPWR VGND sg13cmos5l_decap_8
XANTENNA__0588__CLK Tile_X0Y0_UserCLK VPWR VGND sg13cmos5l_antennanp
XFILLER_4_134 VPWR VGND sg13cmos5l_decap_8
XFILLER_7_2136 VPWR VGND sg13cmos5l_decap_8
XFILLER_5_1192 VPWR VGND sg13cmos5l_fill_1
XANTENNA__1274__A1 Tile_X3Y0_N4END[0] VPWR VGND sg13cmos5l_antennanp
XFILLER_1_1089 VPWR VGND sg13cmos5l_fill_1
XFILLER_1_1078 VPWR VGND sg13cmos5l_decap_8
XANTENNA__0942__X Tile_X2Y0_FrameStrobe_O[7] VPWR VGND sg13cmos5l_antennanp
XFILLER_12_2333 VPWR VGND sg13cmos5l_decap_8
XFILLER_12_1665 VPWR VGND sg13cmos5l_decap_8
XANTENNA__0381__GATE Tile_X2Y0_FrameStrobe[2] VPWR VGND sg13cmos5l_antennanp
X_0515_ _0515_/Q Tile_X0Y0_FrameData[20] VGND VPWR Tile_X4Y0_FrameStrobe[0] latch
XFILLER_4_690 VPWR VGND sg13cmos5l_decap_8
X_0446_ _0446_/Q Tile_X0Y0_FrameData[27] VGND VPWR Tile_X3Y0_FrameStrobe[1] latch
XANTENNA__0396__GATE Tile_X2Y0_FrameStrobe[2] VPWR VGND sg13cmos5l_antennanp
X_0377_ _0377_/Q Tile_X0Y0_FrameData[0] VGND VPWR Tile_X2Y0_FrameStrobe[1] latch
XANTENNA__1013__X Tile_X0Y0_S2BEGb[6] VPWR VGND sg13cmos5l_antennanp
XANTENNA__1265__A1 Tile_X3Y0_N4END[9] VPWR VGND sg13cmos5l_antennanp
XANTENNA__0852__X Tile_X4Y0_FrameStrobe_O[9] VPWR VGND sg13cmos5l_antennanp
XFILLER_11_918 VPWR VGND sg13cmos5l_decap_4
XANTENNA__0334__GATE Tile_X2Y0_FrameStrobe[0] VPWR VGND sg13cmos5l_antennanp
XANTENNA__0450__D Tile_X0Y0_FrameData[23] VPWR VGND sg13cmos5l_antennanp
XFILLER_11_1175 VPWR VGND sg13cmos5l_decap_8
XANTENNA__0349__GATE Tile_X2Y0_FrameStrobe[1] VPWR VGND sg13cmos5l_antennanp
XFILLER_2_638 VPWR VGND sg13cmos5l_decap_8
XFILLER_8_2445 VPWR VGND sg13cmos5l_decap_8
XFILLER_8_1799 VPWR VGND sg13cmos5l_decap_8
XFILLER_2_1365 VPWR VGND sg13cmos5l_fill_1
XANTENNA__1256__A1 Tile_X3Y0_N2MID[5] VPWR VGND sg13cmos5l_antennanp
XANTENNA__0762__X Tile_X3Y0_S1BEG[3] VPWR VGND sg13cmos5l_antennanp
XFILLER_16_1020 VPWR VGND sg13cmos5l_decap_8
XFILLER_13_266 VPWR VGND sg13cmos5l_decap_8
XFILLER_9_248 VPWR VGND sg13cmos5l_fill_1
XFILLER_16_1031 VPWR VGND sg13cmos5l_fill_1
XFILLER_13_299 VPWR VGND sg13cmos5l_decap_8
XFILLER_13_2642 VPWR VGND sg13cmos5l_decap_8
XFILLER_16_1086 VPWR VGND sg13cmos5l_fill_1
XFILLER_16_1064 VPWR VGND sg13cmos5l_decap_8
XANTENNA__0360__D Tile_X0Y0_FrameData[17] VPWR VGND sg13cmos5l_antennanp
XFILLER_5_443 VPWR VGND sg13cmos5l_fill_2
XFILLER_13_1996 VPWR VGND sg13cmos5l_decap_8
XANTENNA__1192__A0 Tile_X1Y0_N2MID[5] VPWR VGND sg13cmos5l_antennanp
X_0300_ _0300_/Q Tile_X0Y0_FrameData[29] VGND VPWR Tile_X1Y0_FrameStrobe[3] latch
XFILLER_7_1210 VPWR VGND sg13cmos5l_decap_8
X_1280_ _1280_/X Tile_X3Y0_N2END[5] Tile_X3Y0_N4END[5] Tile_X3Y0_NN4END[10] _0576_/Q
+ _0447_/Q _0446_/Q VPWR VGND sg13cmos5l_mux4_1
XFILLER_7_1254 VPWR VGND sg13cmos5l_decap_8
XANTENNA__0937__X Tile_X2Y0_FrameStrobe_O[2] VPWR VGND sg13cmos5l_antennanp
X_0231_ _0231_/Q Tile_X0Y0_FrameData[2] VGND VPWR Tile_X1Y0_FrameStrobe[0] latch
XANTENNA__0603__CLK Tile_X0Y0_UserCLK VPWR VGND sg13cmos5l_antennanp
X_0162_ _0162_/Q Tile_X0Y0_FrameData[23] VGND VPWR Tile_X0Y0_FrameStrobe[2] latch
XFILLER_3_1129 VPWR VGND sg13cmos5l_decap_8
XANTENNA__1247__A1 Tile_X2Y0_N4END[12] VPWR VGND sg13cmos5l_antennanp
X_0093_ _0093_/Q Tile_X0Y0_FrameData[28] VGND VPWR Tile_X0Y0_FrameStrobe[0] latch
X_0995_ Tile_X0Y0_S4BEG[4] _1143_/X VPWR VGND sg13cmos5l_buf_1
XFILLER_12_2130 VPWR VGND sg13cmos5l_decap_8
XANTENNA__0270__D Tile_X0Y0_FrameData[27] VPWR VGND sg13cmos5l_antennanp
XFILLER_8_292 VPWR VGND sg13cmos5l_fill_2
XFILLER_12_1462 VPWR VGND sg13cmos5l_decap_8
XFILLER_9_2732 VPWR VGND sg13cmos5l_decap_8
XANTENNA__1008__X Tile_X0Y0_S2BEGb[1] VPWR VGND sg13cmos5l_antennanp
XANTENNA__1183__A0 Tile_X1Y0_N2MID[4] VPWR VGND sg13cmos5l_antennanp
XFILLER_5_92 VPWR VGND sg13cmos5l_fill_1
XFILLER_5_1917 VPWR VGND sg13cmos5l_decap_8
XANTENNA__0847__X Tile_X4Y0_FrameStrobe_O[4] VPWR VGND sg13cmos5l_antennanp
X_0429_ _0429_/Q Tile_X0Y0_FrameData[12] VGND VPWR Tile_X3Y0_FrameStrobe[0] latch
XFILLER_3_2353 VPWR VGND sg13cmos5l_decap_8
XFILLER_3_2386 VPWR VGND sg13cmos5l_decap_8
XANTENNA__1238__A1 Tile_X2Y0_N4END[3] VPWR VGND sg13cmos5l_antennanp
XANTENNA__0445__D Tile_X0Y0_FrameData[28] VPWR VGND sg13cmos5l_antennanp
XFILLER_11_704 VPWR VGND sg13cmos5l_decap_8
XANTENNA__0273__GATE Tile_X1Y0_FrameStrobe[2] VPWR VGND sg13cmos5l_antennanp
XFILLER_10_203 VPWR VGND sg13cmos5l_decap_4
XFILLER_13_1259 VPWR VGND sg13cmos5l_decap_8
XFILLER_10_269 VPWR VGND sg13cmos5l_decap_8
XANTENNA__0180__D Tile_X0Y0_FrameData[5] VPWR VGND sg13cmos5l_antennanp
XANTENNA__0288__GATE Tile_X1Y0_FrameStrobe[2] VPWR VGND sg13cmos5l_antennanp
XANTENNA__0531__Q NPU_WDATA7 VPWR VGND sg13cmos5l_antennanp
XFILLER_3_903 VPWR VGND sg13cmos5l_fill_2
XANTENNA__0211__GATE Tile_X1Y0_FrameStrobe[0] VPWR VGND sg13cmos5l_antennanp
XANTENNA__1174__A0 Tile_X1Y0_N1END[3] VPWR VGND sg13cmos5l_antennanp
XFILLER_8_2242 VPWR VGND sg13cmos5l_decap_8
XFILLER_8_1541 VPWR VGND sg13cmos5l_decap_8
XFILLER_4_2117 VPWR VGND sg13cmos5l_decap_8
XANTENNA__0757__X Tile_X1Y0_S2BEG[6] VPWR VGND sg13cmos5l_antennanp
XFILLER_8_1574 VPWR VGND sg13cmos5l_decap_8
XFILLER_4_1449 VPWR VGND sg13cmos5l_decap_8
XFILLER_4_1438 VPWR VGND sg13cmos5l_fill_1
XANTENNA__0226__GATE Tile_X1Y0_FrameStrobe[0] VPWR VGND sg13cmos5l_antennanp
XANTENNA_110 Tile_X0Y0_FrameData[19] VPWR VGND sg13cmos5l_antennanp
XFILLER_2_1162 VPWR VGND sg13cmos5l_decap_8
XANTENNA__1229__A1 Tile_X2Y0_N4END[5] VPWR VGND sg13cmos5l_antennanp
XANTENNA__0355__D Tile_X0Y0_FrameData[22] VPWR VGND sg13cmos5l_antennanp
XANTENNA__0933__A Tile_X3Y0_FrameStrobe[18] VPWR VGND sg13cmos5l_antennanp
X_0780_ Tile_X3Y0_S4BEG[1] _1260_/X VPWR VGND sg13cmos5l_buf_1
XFILLER_13_2483 VPWR VGND sg13cmos5l_decap_8
XFILLER_9_2028 VPWR VGND sg13cmos5l_decap_8
XANTENNA__1165__A0 Tile_X0Y0_N2END[2] VPWR VGND sg13cmos5l_antennanp
X_1263_ _1263_/X Tile_X3Y0_N2MID[4] Tile_X3Y0_N4END[11] Tile_X3Y0_NN4END[4] _0576_/Q
+ _0481_/Q _0480_/Q VPWR VGND sg13cmos5l_mux4_1
XFILLER_4_2640 VPWR VGND sg13cmos5l_decap_8
X_0214_ _0214_/Q Tile_X0Y0_FrameData[19] VGND VPWR Tile_X1Y0_FrameStrobe[0] latch
XFILLER_0_1803 VPWR VGND sg13cmos5l_fill_1
XFILLER_0_2526 VPWR VGND sg13cmos5l_decap_8
X_1194_ _1194_/X Tile_X1Y0_N2MID[7] Tile_X1Y0_N4END[0] Tile_X1Y0_NN4END[15] _0589_/Q
+ _0267_/Q _0266_/Q VPWR VGND sg13cmos5l_mux4_1
X_0145_ _0145_/Q Tile_X0Y0_FrameData[8] VGND VPWR Tile_X0Y0_FrameStrobe[1] latch
XFILLER_0_1858 VPWR VGND sg13cmos5l_fill_2
XANTENNA__0265__D Tile_X0Y0_FrameData[0] VPWR VGND sg13cmos5l_antennanp
XANTENNA__0843__A Tile_X4Y0_FrameStrobe[0] VPWR VGND sg13cmos5l_antennanp
XFILLER_14_2236 VPWR VGND sg13cmos5l_decap_8
X_0978_ Tile_X0Y0_SS4BEG[3] _1158_/X VPWR VGND sg13cmos5l_buf_1
XFILLER_14_1535 VPWR VGND sg13cmos5l_fill_2
XANTENNA__1156__A0 Tile_X0Y0_N2END[1] VPWR VGND sg13cmos5l_antennanp
XFILLER_5_2437 VPWR VGND sg13cmos5l_decap_4
XFILLER_5_2459 VPWR VGND sg13cmos5l_decap_8
XFILLER_16_807 VPWR VGND sg13cmos5l_decap_8
XFILLER_16_829 VPWR VGND sg13cmos5l_decap_4
XFILLER_16_818 VPWR VGND sg13cmos5l_fill_1
XFILLER_15_328 VPWR VGND sg13cmos5l_decap_4
XANTENNA__0175__D Tile_X0Y0_FrameData[10] VPWR VGND sg13cmos5l_antennanp
XANTENNA__0526__Q NPU_WDATA2 VPWR VGND sg13cmos5l_antennanp
XANTENNA__0753__A Tile_X1Y0_N2MID[5] VPWR VGND sg13cmos5l_antennanp
XFILLER_11_556 VPWR VGND sg13cmos5l_decap_8
XFILLER_7_538 VPWR VGND sg13cmos5l_decap_8
XFILLER_13_1034 VPWR VGND sg13cmos5l_fill_1
XFILLER_10_2667 VPWR VGND sg13cmos5l_decap_8
XANTENNA__0150__GATE Tile_X0Y0_FrameStrobe[1] VPWR VGND sg13cmos5l_antennanp
XFILLER_2_232 VPWR VGND sg13cmos5l_fill_1
XANTENNA__1147__A0 Tile_X0Y0_N2MID[0] VPWR VGND sg13cmos5l_antennanp
XANTENNA__0928__A Tile_X3Y0_FrameStrobe[13] VPWR VGND sg13cmos5l_antennanp
XFILLER_8_2094 VPWR VGND sg13cmos5l_decap_8
XANTENNA__0165__GATE Tile_X0Y0_FrameStrobe[2] VPWR VGND sg13cmos5l_antennanp
XFILLER_8_1393 VPWR VGND sg13cmos5l_decap_4
XFILLER_4_1224 VPWR VGND sg13cmos5l_fill_2
XFILLER_4_1246 VPWR VGND sg13cmos5l_decap_4
XFILLER_15_2512 VPWR VGND sg13cmos5l_decap_4
X_0901_ Tile_X2Y0_SS4BEG[2] _1237_/X VPWR VGND sg13cmos5l_buf_1
XFILLER_15_1811 VPWR VGND sg13cmos5l_decap_8
XANTENNA__0103__GATE Tile_X0Y0_FrameStrobe[0] VPWR VGND sg13cmos5l_antennanp
XANTENNA__0950__X Tile_X2Y0_FrameStrobe_O[15] VPWR VGND sg13cmos5l_antennanp
X_0832_ Tile_X4Y0_FrameData_O[21] Tile_X0Y0_FrameData[21] VPWR VGND sg13cmos5l_buf_1
XFILLER_13_2280 VPWR VGND sg13cmos5l_decap_8
X_0763_ Tile_X3Y0_S2BEG[0] Tile_X3Y0_N2MID[7] VPWR VGND sg13cmos5l_buf_1
XANTENNA__0118__GATE Tile_X0Y0_FrameStrobe[0] VPWR VGND sg13cmos5l_antennanp
X_0694_ Tile_X0Y0_FrameStrobe_O[7] Tile_X0Y0_FrameStrobe[7] VPWR VGND sg13cmos5l_buf_1
XANTENNA__1138__A0 Tile_X0Y0_N1END[3] VPWR VGND sg13cmos5l_antennanp
XFILLER_9_1102 VPWR VGND sg13cmos5l_decap_8
XFILLER_6_2724 VPWR VGND sg13cmos5l_decap_8
XANTENNA__0838__A Tile_X0Y0_FrameData[27] VPWR VGND sg13cmos5l_antennanp
X_1246_ _1246_/X Tile_X2Y0_N2END[3] Tile_X2Y0_N4END[11] Tile_X2Y0_NN4END[4] _0582_/Q
+ _0339_/Q _0338_/Q VPWR VGND sg13cmos5l_mux4_1
XFILLER_4_2470 VPWR VGND sg13cmos5l_decap_8
XFILLER_0_1622 VPWR VGND sg13cmos5l_fill_1
X_1177_ _1177_/X Tile_X1Y0_N1END[2] Tile_X1Y0_N2MID[6] Tile_X1Y0_N2END[1] _0594_/Q
+ _0301_/Q _0300_/Q VPWR VGND sg13cmos5l_mux4_1
XFILLER_0_1644 VPWR VGND sg13cmos5l_fill_1
X_0128_ _0128_/Q Tile_X0Y0_FrameData[25] VGND VPWR Tile_X0Y0_FrameStrobe[1] latch
XFILLER_0_1677 VPWR VGND sg13cmos5l_decap_8
XFILLER_0_1688 VPWR VGND sg13cmos5l_fill_1
XANTENNA__1021__X Tile_X0Y0_S2BEG[6] VPWR VGND sg13cmos5l_antennanp
XFILLER_14_2011 VPWR VGND sg13cmos5l_decap_8
XANTENNA_10 Tile_X0Y0_FrameData[15] VPWR VGND sg13cmos5l_antennanp
XANTENNA_21 Tile_X0Y0_FrameData[17] VPWR VGND sg13cmos5l_antennanp
XANTENNA_32 Tile_X0Y0_FrameData[2] VPWR VGND sg13cmos5l_antennanp
XANTENNA_43 Tile_X0Y0_FrameData[5] VPWR VGND sg13cmos5l_antennanp
XANTENNA_54 Tile_X0Y0_FrameData[7] VPWR VGND sg13cmos5l_antennanp
XANTENNA_65 _1090_/X VPWR VGND sg13cmos5l_antennanp
XANTENNA__0860__X Tile_X4Y0_FrameStrobe_O[17] VPWR VGND sg13cmos5l_antennanp
XANTENNA_76 Tile_X0Y0_FrameData[30] VPWR VGND sg13cmos5l_antennanp
XANTENNA_87 Tile_X0Y0_FrameData[21] VPWR VGND sg13cmos5l_antennanp
XANTENNA_98 Tile_X0Y0_FrameData[23] VPWR VGND sg13cmos5l_antennanp
XFILLER_14_2088 VPWR VGND sg13cmos5l_fill_1
XFILLER_14_1365 VPWR VGND sg13cmos5l_fill_1
XFILLER_10_1218 VPWR VGND sg13cmos5l_decap_8
XANTENNA__1129__A0 Tile_X4Y0_N1END[1] VPWR VGND sg13cmos5l_antennanp
XFILLER_0_703 VPWR VGND sg13cmos5l_decap_8
XANTENNA__0748__A Tile_X1Y0_N1END[2] VPWR VGND sg13cmos5l_antennanp
XFILLER_5_1599 VPWR VGND sg13cmos5l_decap_8
XFILLER_16_604 VPWR VGND sg13cmos5l_decap_8
XFILLER_15_1118 VPWR VGND sg13cmos5l_decap_8
XFILLER_12_832 VPWR VGND sg13cmos5l_decap_8
XANTENNA__0770__X Tile_X3Y0_S2BEG[7] VPWR VGND sg13cmos5l_antennanp
XANTENNA__1080__A2 Tile_X2Y0_N2MID[7] VPWR VGND sg13cmos5l_antennanp
XFILLER_12_2729 VPWR VGND sg13cmos5l_decap_8
XFILLER_10_1752 VPWR VGND sg13cmos5l_decap_8
XFILLER_10_2475 VPWR VGND sg13cmos5l_decap_8
XFILLER_3_530 VPWR VGND sg13cmos5l_decap_8
XFILLER_10_1785 VPWR VGND sg13cmos5l_decap_8
X_1100_ _1100_/X Tile_X1Y0_N4END[4] Tile_X1Y0_N4END[5] Tile_X1Y0_NN4END[4] Tile_X1Y0_NN4END[6]
+ _0225_/Q _0224_/Q VPWR VGND sg13cmos5l_mux4_1
XFILLER_4_1043 VPWR VGND sg13cmos5l_decap_8
XFILLER_4_1021 VPWR VGND sg13cmos5l_fill_1
XANTENNA__0945__X Tile_X2Y0_FrameStrobe_O[10] VPWR VGND sg13cmos5l_antennanp
X_1031_ Tile_X4Y0_S2BEG[0] Tile_X4Y0_N2MID[7] VPWR VGND sg13cmos5l_buf_1
XFILLER_1_2643 VPWR VGND sg13cmos5l_decap_8
XFILLER_1_1942 VPWR VGND sg13cmos5l_fill_1
XFILLER_14_191 VPWR VGND sg13cmos5l_decap_4
XFILLER_15_2386 VPWR VGND sg13cmos5l_decap_8
X_0815_ Tile_X4Y0_FrameData_O[4] Tile_X0Y0_FrameData[4] VPWR VGND sg13cmos5l_buf_1
XFILLER_15_1696 VPWR VGND sg13cmos5l_decap_8
XFILLER_11_1516 VPWR VGND sg13cmos5l_decap_8
X_0746_ Tile_X1Y0_SS4BEG[15] _1210_/X VPWR VGND sg13cmos5l_buf_1
X_0677_ _0677_/L_HI VPWR VGND sg13cmos5l_tiehi
XANTENNA__1126__A3 Tile_X0Y0_NN4END[14] VPWR VGND sg13cmos5l_antennanp
XANTENNA__1016__X Tile_X0Y0_S2BEG[1] VPWR VGND sg13cmos5l_antennanp
XFILLER_6_1820 VPWR VGND sg13cmos5l_fill_2
XFILLER_6_2598 VPWR VGND sg13cmos5l_decap_8
XFILLER_2_1706 VPWR VGND sg13cmos5l_decap_8
XANTENNA__0855__X Tile_X4Y0_FrameStrobe_O[12] VPWR VGND sg13cmos5l_antennanp
X_1229_ _1229_/X Tile_X2Y0_N2MID[2] Tile_X2Y0_N4END[5] Tile_X2Y0_NN4END[10] _0582_/Q
+ _0373_/Q _0372_/Q VPWR VGND sg13cmos5l_mux4_1
XFILLER_6_1886 VPWR VGND sg13cmos5l_fill_2
XFILLER_0_2197 VPWR VGND sg13cmos5l_fill_1
XFILLER_13_607 VPWR VGND sg13cmos5l_fill_1
XFILLER_16_2117 VPWR VGND sg13cmos5l_fill_1
XFILLER_13_618 VPWR VGND sg13cmos5l_decap_8
XANTENNA__0453__D Tile_X0Y0_FrameData[20] VPWR VGND sg13cmos5l_antennanp
XFILLER_16_1449 VPWR VGND sg13cmos5l_fill_1
XFILLER_14_1151 VPWR VGND sg13cmos5l_decap_8
XFILLER_11_2751 VPWR VGND sg13cmos5l_decap_8
XFILLER_10_1026 VPWR VGND sg13cmos5l_decap_8
XFILLER_10_1037 VPWR VGND sg13cmos5l_decap_8
XFILLER_7_2329 VPWR VGND sg13cmos5l_decap_8
XANTENNA__1117__A3 Tile_X0Y0_NN4END[7] VPWR VGND sg13cmos5l_antennanp
XFILLER_7_1617 VPWR VGND sg13cmos5l_decap_8
XFILLER_5_2053 VPWR VGND sg13cmos5l_fill_2
XANTENNA__0765__X Tile_X3Y0_S2BEG[2] VPWR VGND sg13cmos5l_antennanp
XFILLER_16_423 VPWR VGND sg13cmos5l_fill_2
XANTENNA__0363__D Tile_X0Y0_FrameData[14] VPWR VGND sg13cmos5l_antennanp
XANTENNA__0941__A Tile_X2Y0_FrameStrobe[6] VPWR VGND sg13cmos5l_antennanp
XFILLER_8_600 VPWR VGND sg13cmos5l_decap_4
XFILLER_16_2662 VPWR VGND sg13cmos5l_decap_8
XFILLER_12_2515 VPWR VGND sg13cmos5l_decap_8
XFILLER_16_1983 VPWR VGND sg13cmos5l_fill_2
XFILLER_16_1972 VPWR VGND sg13cmos5l_fill_1
XFILLER_12_695 VPWR VGND sg13cmos5l_decap_8
XFILLER_12_1847 VPWR VGND sg13cmos5l_decap_8
XFILLER_10_2272 VPWR VGND sg13cmos5l_decap_8
X_0600_ _0600_/Q Tile_X0Y0_UserCLK NPU_RDATA28 _0616_/L_HI VPWR VGND sg13cmos5l_dfrbpq_1
XFILLER_10_1560 VPWR VGND sg13cmos5l_decap_8
XFILLER_10_1571 VPWR VGND sg13cmos5l_decap_8
X_0531_ NPU_WDATA7 Tile_X0Y0_UserCLK _1103_/X _0640_/L_HI VPWR VGND sg13cmos5l_dfrbpq_1
X_0462_ _0462_/Q Tile_X0Y0_FrameData[11] VGND VPWR Tile_X3Y0_FrameStrobe[1] latch
XFILLER_3_393 VPWR VGND sg13cmos5l_decap_8
XANTENNA__1108__A3 Tile_X1Y0_NN4END[14] VPWR VGND sg13cmos5l_antennanp
X_0393_ _0393_/Q Tile_X0Y0_FrameData[16] VGND VPWR Tile_X2Y0_FrameStrobe[2] latch
XFILLER_6_1116 VPWR VGND sg13cmos5l_decap_8
XFILLER_1_2473 VPWR VGND sg13cmos5l_fill_1
X_1014_ Tile_X0Y0_S2BEGb[7] _1138_/X VPWR VGND sg13cmos5l_buf_1
XANTENNA__0273__D Tile_X0Y0_FrameData[24] VPWR VGND sg13cmos5l_antennanp
XANTENNA__0851__A Tile_X4Y0_FrameStrobe[8] VPWR VGND sg13cmos5l_antennanp
XFILLER_15_1482 VPWR VGND sg13cmos5l_fill_1
XFILLER_11_2069 VPWR VGND sg13cmos5l_decap_8
XFILLER_11_1357 VPWR VGND sg13cmos5l_decap_8
X_0729_ Tile_X1Y0_S4BEG[14] _1193_/X VPWR VGND sg13cmos5l_buf_1
XFILLER_8_2649 VPWR VGND sg13cmos5l_decap_8
XFILLER_6_2384 VPWR VGND sg13cmos5l_decap_8
XANTENNA__0448__D Tile_X0Y0_FrameData[25] VPWR VGND sg13cmos5l_antennanp
XFILLER_6_1694 VPWR VGND sg13cmos5l_decap_8
XANTENNA__1283__A2 Tile_X3Y0_NN4END[7] VPWR VGND sg13cmos5l_antennanp
XANTENNA__0183__D Tile_X0Y0_FrameData[2] VPWR VGND sg13cmos5l_antennanp
XANTENNA__0534__Q NPU_WDATA10 VPWR VGND sg13cmos5l_antennanp
XANTENNA__0502__GATE Tile_X3Y0_FrameStrobe[2] VPWR VGND sg13cmos5l_antennanp
XANTENNA__0761__A Tile_X3Y0_N1END[1] VPWR VGND sg13cmos5l_antennanp
XFILLER_16_1279 VPWR VGND sg13cmos5l_decap_4
XANTENNA__0517__GATE Tile_X4Y0_FrameStrobe[0] VPWR VGND sg13cmos5l_antennanp
XFILLER_7_1403 VPWR VGND sg13cmos5l_decap_8
XFILLER_7_1436 VPWR VGND sg13cmos5l_decap_8
XFILLER_7_1425 VPWR VGND sg13cmos5l_decap_4
XFILLER_7_1458 VPWR VGND sg13cmos5l_fill_1
XANTENNA__0358__D Tile_X0Y0_FrameData[19] VPWR VGND sg13cmos5l_antennanp
XANTENNA__0936__A Tile_X2Y0_FrameStrobe[1] VPWR VGND sg13cmos5l_antennanp
XFILLER_5_1171 VPWR VGND sg13cmos5l_decap_8
XFILLER_1_1046 VPWR VGND sg13cmos5l_decap_8
XANTENNA__1274__A2 Tile_X3Y0_NN4END[15] VPWR VGND sg13cmos5l_antennanp
XFILLER_16_286 VPWR VGND sg13cmos5l_decap_8
XANTENNA__0093__D Tile_X0Y0_FrameData[28] VPWR VGND sg13cmos5l_antennanp
XFILLER_9_942 VPWR VGND sg13cmos5l_fill_1
XFILLER_12_2312 VPWR VGND sg13cmos5l_decap_8
XANTENNA__0532__CLK Tile_X0Y0_UserCLK VPWR VGND sg13cmos5l_antennanp
XFILLER_16_1780 VPWR VGND sg13cmos5l_decap_8
XFILLER_12_2389 VPWR VGND sg13cmos5l_decap_8
XFILLER_12_1644 VPWR VGND sg13cmos5l_decap_8
X_0514_ _0514_/Q Tile_X0Y0_FrameData[19] VGND VPWR Tile_X4Y0_FrameStrobe[0] latch
X_0445_ _0445_/Q Tile_X0Y0_FrameData[28] VGND VPWR Tile_X3Y0_FrameStrobe[1] latch
XFILLER_3_2524 VPWR VGND sg13cmos5l_fill_1
XANTENNA__0268__D Tile_X0Y0_FrameData[29] VPWR VGND sg13cmos5l_antennanp
X_0376_ _0376_/Q Tile_X0Y0_FrameData[1] VGND VPWR Tile_X2Y0_FrameStrobe[1] latch
XFILLER_3_2535 VPWR VGND sg13cmos5l_decap_8
XFILLER_12_0 VPWR VGND sg13cmos5l_fill_2
XANTENNA__0846__A Tile_X4Y0_FrameStrobe[3] VPWR VGND sg13cmos5l_antennanp
XANTENNA__1265__A2 Tile_X3Y0_NN4END[6] VPWR VGND sg13cmos5l_antennanp
XFILLER_11_1154 VPWR VGND sg13cmos5l_decap_8
XFILLER_2_617 VPWR VGND sg13cmos5l_fill_1
XFILLER_1_105 VPWR VGND sg13cmos5l_decap_4
XFILLER_8_2424 VPWR VGND sg13cmos5l_decap_8
XANTENNA__0178__D Tile_X0Y0_FrameData[7] VPWR VGND sg13cmos5l_antennanp
XANTENNA__0529__Q NPU_WDATA5 VPWR VGND sg13cmos5l_antennanp
XFILLER_6_2181 VPWR VGND sg13cmos5l_decap_8
XFILLER_2_2023 VPWR VGND sg13cmos5l_decap_8
XANTENNA__0756__A Tile_X1Y0_N2MID[2] VPWR VGND sg13cmos5l_antennanp
XANTENNA__1256__A2 Tile_X3Y0_N2END[2] VPWR VGND sg13cmos5l_antennanp
XANTENNA__0555__CLK Tile_X0Y0_UserCLK VPWR VGND sg13cmos5l_antennanp
XANTENNA__0441__GATE Tile_X3Y0_FrameStrobe[0] VPWR VGND sg13cmos5l_antennanp
XFILLER_13_2621 VPWR VGND sg13cmos5l_decap_8
XFILLER_10_941 VPWR VGND sg13cmos5l_decap_8
XFILLER_13_2698 VPWR VGND sg13cmos5l_decap_8
XFILLER_10_985 VPWR VGND sg13cmos5l_fill_2
XANTENNA__0456__GATE Tile_X3Y0_FrameStrobe[1] VPWR VGND sg13cmos5l_antennanp
XFILLER_13_1975 VPWR VGND sg13cmos5l_decap_8
XFILLER_5_477 VPWR VGND sg13cmos5l_decap_8
XANTENNA__1192__A1 Tile_X1Y0_N4END[2] VPWR VGND sg13cmos5l_antennanp
XFILLER_7_1233 VPWR VGND sg13cmos5l_decap_8
X_0230_ _0230_/Q Tile_X0Y0_FrameData[3] VGND VPWR Tile_X1Y0_FrameStrobe[0] latch
XFILLER_3_1108 VPWR VGND sg13cmos5l_decap_8
X_0161_ _0161_/Q Tile_X0Y0_FrameData[24] VGND VPWR Tile_X0Y0_FrameStrobe[2] latch
X_0092_ _0092_/Q Tile_X0Y0_FrameData[29] VGND VPWR Tile_X0Y0_FrameStrobe[0] latch
XANTENNA__0953__X Tile_X2Y0_FrameStrobe_O[18] VPWR VGND sg13cmos5l_antennanp
XANTENNA__1247__A2 Tile_X2Y0_NN4END[3] VPWR VGND sg13cmos5l_antennanp
XANTENNA__0409__GATE Tile_X2Y0_FrameStrobe[2] VPWR VGND sg13cmos5l_antennanp
XFILLER_9_761 VPWR VGND sg13cmos5l_fill_1
X_0994_ Tile_X0Y0_S4BEG[3] _1142_/X VPWR VGND sg13cmos5l_buf_1
XFILLER_14_1739 VPWR VGND sg13cmos5l_decap_8
XFILLER_12_2164 VPWR VGND sg13cmos5l_fill_2
XFILLER_12_2186 VPWR VGND sg13cmos5l_decap_8
XFILLER_9_2711 VPWR VGND sg13cmos5l_decap_8
XANTENNA__1183__A1 Tile_X1Y0_N4END[11] VPWR VGND sg13cmos5l_antennanp
X_0428_ _0428_/Q Tile_X0Y0_FrameData[13] VGND VPWR Tile_X3Y0_FrameStrobe[0] latch
X_0359_ _0359_/Q Tile_X0Y0_FrameData[18] VGND VPWR Tile_X2Y0_FrameStrobe[1] latch
XANTENNA__1024__X Tile_X0Y0_S1BEG[1] VPWR VGND sg13cmos5l_antennanp
XANTENNA__0578__CLK Tile_X0Y0_UserCLK VPWR VGND sg13cmos5l_antennanp
XANTENNA__0863__X Tile_X2Y0_S1BEG[0] VPWR VGND sg13cmos5l_antennanp
XANTENNA__1238__A2 Tile_X2Y0_NN4END[12] VPWR VGND sg13cmos5l_antennanp
XFILLER_10_248 VPWR VGND sg13cmos5l_decap_8
XANTENNA__0461__D Tile_X0Y0_FrameData[12] VPWR VGND sg13cmos5l_antennanp
XFILLER_13_1238 VPWR VGND sg13cmos5l_decap_8
XFILLER_3_937 VPWR VGND sg13cmos5l_fill_1
XFILLER_8_2221 VPWR VGND sg13cmos5l_decap_8
XANTENNA__1174__A1 Tile_X1Y0_N2MID[3] VPWR VGND sg13cmos5l_antennanp
XFILLER_8_2298 VPWR VGND sg13cmos5l_decap_8
XANTENNA_100 Tile_X0Y0_FrameData[4] VPWR VGND sg13cmos5l_antennanp
XFILLER_2_1141 VPWR VGND sg13cmos5l_decap_8
XANTENNA_111 Tile_X0Y0_FrameData[23] VPWR VGND sg13cmos5l_antennanp
XANTENNA__0773__X Tile_X3Y0_S2BEGb[2] VPWR VGND sg13cmos5l_antennanp
XANTENNA__1229__A2 Tile_X2Y0_NN4END[10] VPWR VGND sg13cmos5l_antennanp
XFILLER_14_510 VPWR VGND sg13cmos5l_fill_1
XANTENNA__0380__GATE Tile_X2Y0_FrameStrobe[2] VPWR VGND sg13cmos5l_antennanp
XFILLER_14_543 VPWR VGND sg13cmos5l_decap_8
XANTENNA__0371__D Tile_X0Y0_FrameData[6] VPWR VGND sg13cmos5l_antennanp
XFILLER_13_2462 VPWR VGND sg13cmos5l_decap_8
XANTENNA__0395__GATE Tile_X2Y0_FrameStrobe[2] VPWR VGND sg13cmos5l_antennanp
XFILLER_6_753 VPWR VGND sg13cmos5l_fill_1
XFILLER_10_793 VPWR VGND sg13cmos5l_decap_8
XFILLER_13_1794 VPWR VGND sg13cmos5l_fill_2
XFILLER_13_1783 VPWR VGND sg13cmos5l_decap_8
XANTENNA__1165__A1 Tile_X0Y0_N4END[10] VPWR VGND sg13cmos5l_antennanp
XANTENNA__0948__X Tile_X2Y0_FrameStrobe_O[13] VPWR VGND sg13cmos5l_antennanp
XFILLER_1_480 VPWR VGND sg13cmos5l_fill_2
X_1262_ _1262_/X Tile_X3Y0_N2MID[3] Tile_X3Y0_N4END[12] Tile_X3Y0_NN4END[3] _0579_/Q
+ _0483_/Q _0482_/Q VPWR VGND sg13cmos5l_mux4_1
XFILLER_1_491 VPWR VGND sg13cmos5l_decap_8
XANTENNA__0333__GATE Tile_X2Y0_FrameStrobe[0] VPWR VGND sg13cmos5l_antennanp
XFILLER_0_2505 VPWR VGND sg13cmos5l_decap_8
X_0213_ _0213_/Q Tile_X0Y0_FrameData[20] VGND VPWR Tile_X1Y0_FrameStrobe[0] latch
XFILLER_7_1096 VPWR VGND sg13cmos5l_decap_8
X_1193_ _1193_/X Tile_X1Y0_N2MID[6] Tile_X1Y0_N4END[1] Tile_X1Y0_NN4END[14] _0588_/Q
+ _0269_/Q _0268_/Q VPWR VGND sg13cmos5l_mux4_1
XFILLER_4_2696 VPWR VGND sg13cmos5l_decap_8
X_0144_ _0144_/Q Tile_X0Y0_FrameData[9] VGND VPWR Tile_X0Y0_FrameStrobe[1] latch
XANTENNA__0348__GATE Tile_X2Y0_FrameStrobe[1] VPWR VGND sg13cmos5l_antennanp
XFILLER_14_2215 VPWR VGND sg13cmos5l_decap_8
XANTENNA__1020__A Tile_X0Y0_N2MID[2] VPWR VGND sg13cmos5l_antennanp
XFILLER_14_1514 VPWR VGND sg13cmos5l_decap_8
XANTENNA__0281__D Tile_X0Y0_FrameData[16] VPWR VGND sg13cmos5l_antennanp
X_0977_ Tile_X0Y0_SS4BEG[2] _1157_/X VPWR VGND sg13cmos5l_buf_1
XFILLER_14_1569 VPWR VGND sg13cmos5l_fill_1
XANTENNA__1019__X Tile_X0Y0_S2BEG[4] VPWR VGND sg13cmos5l_antennanp
XANTENNA__1156__A1 Tile_X0Y0_N4END[1] VPWR VGND sg13cmos5l_antennanp
XFILLER_9_2552 VPWR VGND sg13cmos5l_decap_8
XANTENNA__0858__X Tile_X4Y0_FrameStrobe_O[15] VPWR VGND sg13cmos5l_antennanp
XFILLER_9_2585 VPWR VGND sg13cmos5l_decap_8
XFILLER_5_1704 VPWR VGND sg13cmos5l_decap_4
XANTENNA__0456__D Tile_X0Y0_FrameData[17] VPWR VGND sg13cmos5l_antennanp
XFILLER_3_2195 VPWR VGND sg13cmos5l_decap_8
XANTENNA__1092__A0 Tile_X3Y0_N1END[0] VPWR VGND sg13cmos5l_antennanp
XFILLER_11_535 VPWR VGND sg13cmos5l_decap_8
XANTENNA__0191__D Tile_X0Y0_FrameData[26] VPWR VGND sg13cmos5l_antennanp
XANTENNA__0542__Q NPU_WDATA18 VPWR VGND sg13cmos5l_antennanp
XFILLER_7_517 VPWR VGND sg13cmos5l_decap_8
XFILLER_14_2771 VPWR VGND sg13cmos5l_decap_8
XFILLER_10_1901 VPWR VGND sg13cmos5l_fill_2
XFILLER_10_2646 VPWR VGND sg13cmos5l_decap_8
XFILLER_3_701 VPWR VGND sg13cmos5l_decap_8
XFILLER_10_1967 VPWR VGND sg13cmos5l_decap_8
XANTENNA__1147__A1 Tile_X0Y0_N4END[7] VPWR VGND sg13cmos5l_antennanp
XFILLER_3_789 VPWR VGND sg13cmos5l_decap_4
XANTENNA__0768__X Tile_X3Y0_S2BEG[5] VPWR VGND sg13cmos5l_antennanp
XFILLER_4_1258 VPWR VGND sg13cmos5l_decap_8
XANTENNA__0366__D Tile_X0Y0_FrameData[11] VPWR VGND sg13cmos5l_antennanp
XANTENNA__0944__A Tile_X2Y0_FrameStrobe[9] VPWR VGND sg13cmos5l_antennanp
XFILLER_15_863 VPWR VGND sg13cmos5l_decap_8
XANTENNA__1083__A0 Tile_X2Y0_N1END[3] VPWR VGND sg13cmos5l_antennanp
X_0900_ Tile_X2Y0_SS4BEG[1] _1236_/X VPWR VGND sg13cmos5l_buf_1
XFILLER_15_2557 VPWR VGND sg13cmos5l_decap_8
X_0831_ Tile_X4Y0_FrameData_O[20] Tile_X0Y0_FrameData[20] VPWR VGND sg13cmos5l_buf_1
XFILLER_15_1867 VPWR VGND sg13cmos5l_decap_8
X_0762_ Tile_X3Y0_S1BEG[3] Tile_X3Y0_N1END[0] VPWR VGND sg13cmos5l_buf_1
XFILLER_6_550 VPWR VGND sg13cmos5l_decap_8
XFILLER_13_1580 VPWR VGND sg13cmos5l_fill_1
X_0693_ Tile_X0Y0_FrameStrobe_O[6] Tile_X0Y0_FrameStrobe[6] VPWR VGND sg13cmos5l_buf_1
XANTENNA__1138__A1 Tile_X0Y0_N2MID[7] VPWR VGND sg13cmos5l_antennanp
XFILLER_6_2703 VPWR VGND sg13cmos5l_decap_8
XANTENNA__0272__GATE Tile_X1Y0_FrameStrobe[2] VPWR VGND sg13cmos5l_antennanp
XANTENNA__1015__A Tile_X0Y0_N2MID[7] VPWR VGND sg13cmos5l_antennanp
X_1245_ _1245_/X Tile_X2Y0_N2END[2] Tile_X2Y0_N4END[10] Tile_X2Y0_NN4END[5] _0583_/Q
+ _0341_/Q _0340_/Q VPWR VGND sg13cmos5l_mux4_1
X_1176_ _1176_/X Tile_X1Y0_N1END[1] Tile_X1Y0_N2MID[5] Tile_X1Y0_N2END[2] _0593_/Q
+ _0303_/Q _0302_/Q VPWR VGND sg13cmos5l_mux4_1
XANTENNA__0276__D Tile_X0Y0_FrameData[21] VPWR VGND sg13cmos5l_antennanp
XANTENNA__0287__GATE Tile_X1Y0_FrameStrobe[2] VPWR VGND sg13cmos5l_antennanp
XANTENNA__0854__A Tile_X4Y0_FrameStrobe[11] VPWR VGND sg13cmos5l_antennanp
XFILLER_0_1634 VPWR VGND sg13cmos5l_fill_1
XFILLER_0_2379 VPWR VGND sg13cmos5l_decap_8
X_0127_ _0127_/Q Tile_X0Y0_FrameData[26] VGND VPWR Tile_X0Y0_FrameStrobe[1] latch
XFILLER_16_1609 VPWR VGND sg13cmos5l_decap_8
XANTENNA_11 Tile_X0Y0_FrameData[15] VPWR VGND sg13cmos5l_antennanp
XANTENNA_22 Tile_X0Y0_FrameData[29] VPWR VGND sg13cmos5l_antennanp
XANTENNA__0210__GATE Tile_X1Y0_FrameStrobe[0] VPWR VGND sg13cmos5l_antennanp
XANTENNA_33 Tile_X0Y0_FrameData[2] VPWR VGND sg13cmos5l_antennanp
XANTENNA_44 Tile_X0Y0_FrameData[5] VPWR VGND sg13cmos5l_antennanp
XANTENNA_55 Tile_X0Y0_FrameData[8] VPWR VGND sg13cmos5l_antennanp
XANTENNA_66 Tile_X0Y0_FrameData[10] VPWR VGND sg13cmos5l_antennanp
XANTENNA_77 Tile_X0Y0_FrameData[31] VPWR VGND sg13cmos5l_antennanp
XANTENNA_88 Tile_X0Y0_FrameData[22] VPWR VGND sg13cmos5l_antennanp
XANTENNA_99 Tile_X0Y0_FrameData[3] VPWR VGND sg13cmos5l_antennanp
XFILLER_14_1344 VPWR VGND sg13cmos5l_decap_8
XANTENNA__0225__GATE Tile_X1Y0_FrameStrobe[0] VPWR VGND sg13cmos5l_antennanp
XANTENNA__1129__A1 Tile_X4Y0_N2MID[1] VPWR VGND sg13cmos5l_antennanp
XFILLER_5_2202 VPWR VGND sg13cmos5l_decap_8
XFILLER_9_2382 VPWR VGND sg13cmos5l_decap_8
XFILLER_5_2213 VPWR VGND sg13cmos5l_fill_1
XFILLER_5_2279 VPWR VGND sg13cmos5l_decap_8
XFILLER_5_2268 VPWR VGND sg13cmos5l_decap_4
XFILLER_5_1534 VPWR VGND sg13cmos5l_decap_8
XFILLER_5_1556 VPWR VGND sg13cmos5l_decap_4
XANTENNA__0537__Q NPU_WDATA13 VPWR VGND sg13cmos5l_antennanp
XFILLER_5_1578 VPWR VGND sg13cmos5l_decap_8
XFILLER_1_1409 VPWR VGND sg13cmos5l_decap_8
XANTENNA__0186__D Tile_X0Y0_FrameData[31] VPWR VGND sg13cmos5l_antennanp
XANTENNA__0764__A Tile_X3Y0_N2MID[6] VPWR VGND sg13cmos5l_antennanp
XFILLER_15_115 VPWR VGND sg13cmos5l_decap_4
XANTENNA__1080__A3 Tile_X2Y0_N2END[7] VPWR VGND sg13cmos5l_antennanp
XFILLER_8_815 VPWR VGND sg13cmos5l_fill_2
XFILLER_10_2454 VPWR VGND sg13cmos5l_decap_8
XFILLER_10_1764 VPWR VGND sg13cmos5l_decap_8
XANTENNA__0939__A Tile_X2Y0_FrameStrobe[4] VPWR VGND sg13cmos5l_antennanp
XFILLER_3_586 VPWR VGND sg13cmos5l_decap_8
X_1030_ Tile_X4Y0_S1BEG[3] Tile_X4Y0_N1END[0] VPWR VGND sg13cmos5l_buf_1
XFILLER_1_1921 VPWR VGND sg13cmos5l_decap_8
XANTENNA__0096__D Tile_X0Y0_FrameData[25] VPWR VGND sg13cmos5l_antennanp
XFILLER_4_1099 VPWR VGND sg13cmos5l_decap_8
XFILLER_15_682 VPWR VGND sg13cmos5l_decap_8
XANTENNA__0961__X Tile_X1Y0_FrameStrobe_O[6] VPWR VGND sg13cmos5l_antennanp
XFILLER_14_170 VPWR VGND sg13cmos5l_decap_8
XFILLER_15_2365 VPWR VGND sg13cmos5l_decap_8
X_0814_ Tile_X4Y0_FrameData_O[3] Tile_X0Y0_FrameData[3] VPWR VGND sg13cmos5l_buf_1
XFILLER_15_1653 VPWR VGND sg13cmos5l_fill_1
XFILLER_15_1642 VPWR VGND sg13cmos5l_fill_2
X_0745_ Tile_X1Y0_SS4BEG[14] _1209_/X VPWR VGND sg13cmos5l_buf_1
X_0676_ _0676_/L_HI VPWR VGND sg13cmos5l_tiehi
XANTENNA__0849__A Tile_X4Y0_FrameStrobe[6] VPWR VGND sg13cmos5l_antennanp
XFILLER_6_2533 VPWR VGND sg13cmos5l_decap_8
XFILLER_6_2577 VPWR VGND sg13cmos5l_decap_8
XFILLER_6_1832 VPWR VGND sg13cmos5l_decap_8
XFILLER_6_1843 VPWR VGND sg13cmos5l_fill_2
X_1228_ _1228_/X Tile_X2Y0_N2MID[1] Tile_X2Y0_N4END[6] Tile_X2Y0_NN4END[9] _0583_/Q
+ _0375_/Q _0374_/Q VPWR VGND sg13cmos5l_mux4_1
XFILLER_4_2290 VPWR VGND sg13cmos5l_decap_8
XANTENNA__1032__X Tile_X4Y0_S2BEG[1] VPWR VGND sg13cmos5l_antennanp
X_1159_ _1159_/X Tile_X0Y0_N2END[4] Tile_X0Y0_N4END[4] Tile_X0Y0_NN4END[11] _0601_/Q
+ _0145_/Q _0144_/Q VPWR VGND sg13cmos5l_mux4_1
XANTENNA__0871__X Tile_X2Y0_S2BEG[4] VPWR VGND sg13cmos5l_antennanp
XFILLER_16_1439 VPWR VGND sg13cmos5l_decap_8
XFILLER_14_1130 VPWR VGND sg13cmos5l_decap_8
XFILLER_11_2730 VPWR VGND sg13cmos5l_decap_8
XANTENNA__0164__GATE Tile_X0Y0_FrameStrobe[2] VPWR VGND sg13cmos5l_antennanp
XFILLER_5_829 VPWR VGND sg13cmos5l_fill_1
XFILLER_4_339 VPWR VGND sg13cmos5l_fill_1
XFILLER_4_328 VPWR VGND sg13cmos5l_fill_1
XANTENNA__0179__GATE Tile_X0Y0_FrameStrobe[2] VPWR VGND sg13cmos5l_antennanp
XANTENNA__0759__A Tile_X3Y0_N1END[3] VPWR VGND sg13cmos5l_antennanp
XFILLER_0_512 VPWR VGND sg13cmos5l_fill_1
XFILLER_7_2308 VPWR VGND sg13cmos5l_decap_8
XANTENNA__0102__GATE Tile_X0Y0_FrameStrobe[0] VPWR VGND sg13cmos5l_antennanp
XFILLER_5_1342 VPWR VGND sg13cmos5l_fill_1
XANTENNA__1286__A0 Tile_X3Y0_N2END[3] VPWR VGND sg13cmos5l_antennanp
XFILLER_16_435 VPWR VGND sg13cmos5l_fill_1
XANTENNA__0117__GATE Tile_X0Y0_FrameStrobe[0] VPWR VGND sg13cmos5l_antennanp
XFILLER_16_468 VPWR VGND sg13cmos5l_fill_2
XANTENNA__0781__X Tile_X3Y0_S4BEG[2] VPWR VGND sg13cmos5l_antennanp
XFILLER_16_2641 VPWR VGND sg13cmos5l_decap_8
XFILLER_16_1962 VPWR VGND sg13cmos5l_fill_2
XFILLER_12_674 VPWR VGND sg13cmos5l_decap_8
XFILLER_16_1995 VPWR VGND sg13cmos5l_decap_8
XFILLER_12_1826 VPWR VGND sg13cmos5l_decap_8
XFILLER_10_2251 VPWR VGND sg13cmos5l_decap_8
XANTENNA__1210__A0 Tile_X1Y0_N2END[7] VPWR VGND sg13cmos5l_antennanp
X_0530_ NPU_WDATA6 Tile_X0Y0_UserCLK _1102_/X _0641_/L_HI VPWR VGND sg13cmos5l_dfrbpq_1
XFILLER_4_862 VPWR VGND sg13cmos5l_decap_8
XFILLER_4_873 VPWR VGND sg13cmos5l_fill_2
XFILLER_3_361 VPWR VGND sg13cmos5l_decap_8
X_0461_ _0461_/Q Tile_X0Y0_FrameData[12] VGND VPWR Tile_X3Y0_FrameStrobe[1] latch
X_0392_ _0392_/Q Tile_X0Y0_FrameData[17] VGND VPWR Tile_X2Y0_FrameStrobe[2] latch
XANTENNA__0956__X Tile_X1Y0_FrameStrobe_O[1] VPWR VGND sg13cmos5l_antennanp
XANTENNA__1277__A0 Tile_X3Y0_N2END[2] VPWR VGND sg13cmos5l_antennanp
X_1013_ Tile_X0Y0_S2BEGb[6] _1137_/X VPWR VGND sg13cmos5l_buf_1
XFILLER_1_2485 VPWR VGND sg13cmos5l_decap_8
XANTENNA__0691__X Tile_X0Y0_FrameStrobe_O[4] VPWR VGND sg13cmos5l_antennanp
XFILLER_15_2184 VPWR VGND sg13cmos5l_fill_1
XFILLER_15_2162 VPWR VGND sg13cmos5l_decap_4
XFILLER_8_82 VPWR VGND sg13cmos5l_fill_1
XFILLER_11_2048 VPWR VGND sg13cmos5l_decap_8
XFILLER_15_1494 VPWR VGND sg13cmos5l_decap_8
XANTENNA__1201__A0 Tile_X1Y0_N2END[6] VPWR VGND sg13cmos5l_antennanp
X_0728_ Tile_X1Y0_S4BEG[13] _1192_/X VPWR VGND sg13cmos5l_buf_1
XFILLER_8_2628 VPWR VGND sg13cmos5l_decap_8
XANTENNA__1027__X Tile_X4Y0_S1BEG[0] VPWR VGND sg13cmos5l_antennanp
X_0659_ _0659_/L_HI VPWR VGND sg13cmos5l_tiehi
XANTENNA__0866__X Tile_X2Y0_S1BEG[3] VPWR VGND sg13cmos5l_antennanp
XFILLER_6_2363 VPWR VGND sg13cmos5l_decap_8
XFILLER_6_1673 VPWR VGND sg13cmos5l_decap_8
XFILLER_2_2249 VPWR VGND sg13cmos5l_decap_8
XFILLER_2_1515 VPWR VGND sg13cmos5l_decap_4
XANTENNA__1268__A0 Tile_X3Y0_N2MID[1] VPWR VGND sg13cmos5l_antennanp
XANTENNA__0464__D Tile_X0Y0_FrameData[9] VPWR VGND sg13cmos5l_antennanp
XFILLER_13_449 VPWR VGND sg13cmos5l_fill_2
XFILLER_16_1258 VPWR VGND sg13cmos5l_decap_8
XANTENNA__0550__Q NPU_WDATA26 VPWR VGND sg13cmos5l_antennanp
XFILLER_5_637 VPWR VGND sg13cmos5l_decap_8
XFILLER_1_810 VPWR VGND sg13cmos5l_fill_2
XFILLER_11_1881 VPWR VGND sg13cmos5l_decap_8
XFILLER_7_2116 VPWR VGND sg13cmos5l_decap_8
XANTENNA__0776__X Tile_X3Y0_S2BEGb[5] VPWR VGND sg13cmos5l_antennanp
XFILLER_0_386 VPWR VGND sg13cmos5l_fill_2
XANTENNA__1259__A0 Tile_X3Y0_N2MID[0] VPWR VGND sg13cmos5l_antennanp
XFILLER_1_1014 VPWR VGND sg13cmos5l_fill_1
XFILLER_1_1036 VPWR VGND sg13cmos5l_decap_4
XFILLER_16_265 VPWR VGND sg13cmos5l_decap_8
XANTENNA__0374__D Tile_X0Y0_FrameData[3] VPWR VGND sg13cmos5l_antennanp
XANTENNA__0952__A Tile_X2Y0_FrameStrobe[17] VPWR VGND sg13cmos5l_antennanp
XFILLER_9_932 VPWR VGND sg13cmos5l_fill_1
XFILLER_8_431 VPWR VGND sg13cmos5l_decap_8
XFILLER_16_2493 VPWR VGND sg13cmos5l_decap_8
XFILLER_8_442 VPWR VGND sg13cmos5l_fill_1
XFILLER_12_1623 VPWR VGND sg13cmos5l_decap_8
XFILLER_12_2368 VPWR VGND sg13cmos5l_decap_8
XFILLER_10_1380 VPWR VGND sg13cmos5l_fill_1
X_0513_ _0513_/Q Tile_X0Y0_FrameData[18] VGND VPWR Tile_X4Y0_FrameStrobe[0] latch
X_0444_ _0444_/Q Tile_X0Y0_FrameData[29] VGND VPWR Tile_X3Y0_FrameStrobe[1] latch
XFILLER_7_2694 VPWR VGND sg13cmos5l_decap_8
X_0375_ _0375_/Q Tile_X0Y0_FrameData[2] VGND VPWR Tile_X2Y0_FrameStrobe[1] latch
XANTENNA__1023__A Tile_X0Y0_N1END[3] VPWR VGND sg13cmos5l_antennanp
XFILLER_1_1570 VPWR VGND sg13cmos5l_decap_8
XANTENNA__0284__D Tile_X0Y0_FrameData[13] VPWR VGND sg13cmos5l_antennanp
XANTENNA__0862__A Tile_X4Y0_FrameStrobe[19] VPWR VGND sg13cmos5l_antennanp
XFILLER_11_1133 VPWR VGND sg13cmos5l_decap_8
XFILLER_8_2403 VPWR VGND sg13cmos5l_decap_8
XFILLER_1_117 VPWR VGND sg13cmos5l_decap_4
XANTENNA__0459__D Tile_X0Y0_FrameData[14] VPWR VGND sg13cmos5l_antennanp
XFILLER_6_2160 VPWR VGND sg13cmos5l_decap_8
XFILLER_2_2057 VPWR VGND sg13cmos5l_fill_2
XFILLER_2_1356 VPWR VGND sg13cmos5l_decap_8
XFILLER_14_714 VPWR VGND sg13cmos5l_decap_8
XANTENNA__0194__D Tile_X0Y0_FrameData[23] VPWR VGND sg13cmos5l_antennanp
XANTENNA__0545__Q NPU_WDATA21 VPWR VGND sg13cmos5l_antennanp
XFILLER_13_224 VPWR VGND sg13cmos5l_decap_8
XFILLER_0_1091 VPWR VGND sg13cmos5l_fill_1
XFILLER_13_257 VPWR VGND sg13cmos5l_decap_4
XFILLER_13_246 VPWR VGND sg13cmos5l_fill_1
XFILLER_13_235 VPWR VGND sg13cmos5l_fill_1
XFILLER_9_239 VPWR VGND sg13cmos5l_decap_8
XFILLER_13_2600 VPWR VGND sg13cmos5l_decap_8
XFILLER_13_2677 VPWR VGND sg13cmos5l_decap_8
XFILLER_13_1954 VPWR VGND sg13cmos5l_decap_8
XANTENNA__1192__A2 Tile_X1Y0_NN4END[13] VPWR VGND sg13cmos5l_antennanp
XANTENNA__0369__D Tile_X0Y0_FrameData[8] VPWR VGND sg13cmos5l_antennanp
XFILLER_0_161 VPWR VGND sg13cmos5l_fill_2
XFILLER_1_684 VPWR VGND sg13cmos5l_fill_1
XANTENNA__0947__A Tile_X2Y0_FrameStrobe[12] VPWR VGND sg13cmos5l_antennanp
X_0160_ _0160_/Q Tile_X0Y0_FrameData[25] VGND VPWR Tile_X0Y0_FrameStrobe[2] latch
X_0091_ _0091_/Q Tile_X0Y0_FrameData[30] VGND VPWR Tile_X0Y0_FrameStrobe[0] latch
X_0993_ Tile_X0Y0_S4BEG[2] _1141_/X VPWR VGND sg13cmos5l_buf_1
XFILLER_13_780 VPWR VGND sg13cmos5l_decap_8
XFILLER_14_1718 VPWR VGND sg13cmos5l_decap_8
XFILLER_8_261 VPWR VGND sg13cmos5l_decap_4
XFILLER_12_1497 VPWR VGND sg13cmos5l_decap_8
XANTENNA__1018__A Tile_X0Y0_N2MID[4] VPWR VGND sg13cmos5l_antennanp
XANTENNA__1183__A2 Tile_X1Y0_NN4END[4] VPWR VGND sg13cmos5l_antennanp
XFILLER_9_2767 VPWR VGND sg13cmos5l_decap_8
XFILLER_9_2778 VPWR VGND sg13cmos5l_fill_1
XFILLER_5_83 VPWR VGND sg13cmos5l_decap_8
XANTENNA__0279__D Tile_X0Y0_FrameData[18] VPWR VGND sg13cmos5l_antennanp
XANTENNA__0857__A Tile_X4Y0_FrameStrobe[14] VPWR VGND sg13cmos5l_antennanp
X_0427_ _0427_/Q Tile_X0Y0_FrameData[14] VGND VPWR Tile_X3Y0_FrameStrobe[0] latch
XFILLER_3_2322 VPWR VGND sg13cmos5l_fill_1
XANTENNA__0501__GATE Tile_X3Y0_FrameStrobe[2] VPWR VGND sg13cmos5l_antennanp
X_0358_ _0358_/Q Tile_X0Y0_FrameData[19] VGND VPWR Tile_X2Y0_FrameStrobe[1] latch
XFILLER_3_1632 VPWR VGND sg13cmos5l_decap_8
X_0289_ _0289_/Q Tile_X0Y0_FrameData[8] VGND VPWR Tile_X1Y0_FrameStrobe[2] latch
XFILLER_3_1687 VPWR VGND sg13cmos5l_decap_8
XANTENNA__0516__GATE Tile_X4Y0_FrameStrobe[0] VPWR VGND sg13cmos5l_antennanp
XANTENNA__1040__X Tile_X4Y0_S2BEGb[1] VPWR VGND sg13cmos5l_antennanp
XFILLER_11_739 VPWR VGND sg13cmos5l_decap_8
XFILLER_13_1217 VPWR VGND sg13cmos5l_decap_8
XFILLER_3_905 VPWR VGND sg13cmos5l_fill_1
XFILLER_8_2200 VPWR VGND sg13cmos5l_decap_8
XANTENNA__1174__A2 Tile_X1Y0_N2END[4] VPWR VGND sg13cmos5l_antennanp
XFILLER_2_459 VPWR VGND sg13cmos5l_decap_8
XANTENNA__0189__D Tile_X0Y0_FrameData[28] VPWR VGND sg13cmos5l_antennanp
XFILLER_8_2277 VPWR VGND sg13cmos5l_decap_8
XANTENNA__0767__A Tile_X3Y0_N2MID[3] VPWR VGND sg13cmos5l_antennanp
XANTENNA__0522__CLK Tile_X0Y0_UserCLK VPWR VGND sg13cmos5l_antennanp
XFILLER_2_1120 VPWR VGND sg13cmos5l_decap_8
XANTENNA_101 Tile_X0Y0_FrameData[0] VPWR VGND sg13cmos5l_antennanp
XFILLER_2_1197 VPWR VGND sg13cmos5l_decap_8
XFILLER_14_522 VPWR VGND sg13cmos5l_decap_8
XFILLER_15_2728 VPWR VGND sg13cmos5l_decap_8
XFILLER_14_588 VPWR VGND sg13cmos5l_decap_8
XFILLER_13_2441 VPWR VGND sg13cmos5l_decap_8
XFILLER_13_1762 VPWR VGND sg13cmos5l_decap_8
XFILLER_6_776 VPWR VGND sg13cmos5l_fill_2
XFILLER_6_765 VPWR VGND sg13cmos5l_fill_2
XANTENNA__1165__A2 Tile_X0Y0_NN4END[5] VPWR VGND sg13cmos5l_antennanp
XFILLER_9_1307 VPWR VGND sg13cmos5l_decap_4
XFILLER_9_1318 VPWR VGND sg13cmos5l_decap_8
XANTENNA__0099__D Tile_X0Y0_FrameData[22] VPWR VGND sg13cmos5l_antennanp
XFILLER_2_993 VPWR VGND sg13cmos5l_fill_2
X_1261_ _1261_/X Tile_X3Y0_N2MID[2] Tile_X3Y0_N4END[13] Tile_X3Y0_NN4END[2] _0578_/Q
+ _0485_/Q _0484_/Q VPWR VGND sg13cmos5l_mux4_1
X_0212_ _0212_/Q Tile_X0Y0_FrameData[21] VGND VPWR Tile_X1Y0_FrameStrobe[0] latch
X_1192_ _1192_/X Tile_X1Y0_N2MID[5] Tile_X1Y0_N4END[2] Tile_X1Y0_NN4END[13] _0589_/Q
+ _0271_/Q _0270_/Q VPWR VGND sg13cmos5l_mux4_1
XFILLER_7_1075 VPWR VGND sg13cmos5l_decap_8
XFILLER_4_2675 VPWR VGND sg13cmos5l_decap_8
XANTENNA__0964__X Tile_X1Y0_FrameStrobe_O[9] VPWR VGND sg13cmos5l_antennanp
X_0143_ _0143_/Q Tile_X0Y0_FrameData[10] VGND VPWR Tile_X0Y0_FrameStrobe[1] latch
X_0976_ Tile_X0Y0_SS4BEG[1] _1156_/X VPWR VGND sg13cmos5l_buf_1
XFILLER_9_592 VPWR VGND sg13cmos5l_decap_8
XFILLER_12_1294 VPWR VGND sg13cmos5l_decap_8
XANTENNA__1156__A2 Tile_X0Y0_NN4END[14] VPWR VGND sg13cmos5l_antennanp
XANTENNA__0545__CLK Tile_X0Y0_UserCLK VPWR VGND sg13cmos5l_antennanp
XANTENNA__0440__GATE Tile_X3Y0_FrameStrobe[0] VPWR VGND sg13cmos5l_antennanp
XANTENNA__1035__X Tile_X4Y0_S2BEG[4] VPWR VGND sg13cmos5l_antennanp
XFILLER_5_1749 VPWR VGND sg13cmos5l_decap_8
XANTENNA__0874__X Tile_X2Y0_S2BEG[7] VPWR VGND sg13cmos5l_antennanp
XFILLER_3_2174 VPWR VGND sg13cmos5l_decap_8
XFILLER_15_308 VPWR VGND sg13cmos5l_decap_8
XANTENNA__0455__GATE Tile_X3Y0_FrameStrobe[1] VPWR VGND sg13cmos5l_antennanp
XANTENNA__1092__A1 Tile_X3Y0_N2MID[3] VPWR VGND sg13cmos5l_antennanp
XFILLER_11_514 VPWR VGND sg13cmos5l_decap_8
XANTENNA__0472__D Tile_X0Y0_FrameData[1] VPWR VGND sg13cmos5l_antennanp
XFILLER_14_2750 VPWR VGND sg13cmos5l_decap_8
XFILLER_10_2625 VPWR VGND sg13cmos5l_decap_8
XFILLER_3_724 VPWR VGND sg13cmos5l_decap_8
XANTENNA__1147__A2 Tile_X0Y0_NN4END[8] VPWR VGND sg13cmos5l_antennanp
XFILLER_2_256 VPWR VGND sg13cmos5l_decap_4
XFILLER_8_2041 VPWR VGND sg13cmos5l_decap_4
XANTENNA__0408__GATE Tile_X2Y0_FrameStrobe[2] VPWR VGND sg13cmos5l_antennanp
XANTENNA__0784__X Tile_X3Y0_S4BEG[5] VPWR VGND sg13cmos5l_antennanp
XFILLER_15_842 VPWR VGND sg13cmos5l_decap_8
XANTENNA__1083__A1 Tile_X2Y0_N2MID[3] VPWR VGND sg13cmos5l_antennanp
XANTENNA__0382__D Tile_X0Y0_FrameData[27] VPWR VGND sg13cmos5l_antennanp
XANTENNA__0960__A Tile_X1Y0_FrameStrobe[5] VPWR VGND sg13cmos5l_antennanp
X_0830_ Tile_X4Y0_FrameData_O[19] Tile_X0Y0_FrameData[19] VPWR VGND sg13cmos5l_buf_1
XFILLER_15_1846 VPWR VGND sg13cmos5l_decap_8
X_0761_ Tile_X3Y0_S1BEG[2] Tile_X3Y0_N1END[1] VPWR VGND sg13cmos5l_buf_1
XFILLER_10_591 VPWR VGND sg13cmos5l_decap_8
XANTENNA__0568__CLK Tile_X0Y0_UserCLK VPWR VGND sg13cmos5l_antennanp
X_0692_ Tile_X0Y0_FrameStrobe_O[5] Tile_X0Y0_FrameStrobe[5] VPWR VGND sg13cmos5l_buf_1
XFILLER_6_573 VPWR VGND sg13cmos5l_decap_8
XANTENNA__0959__X Tile_X1Y0_FrameStrobe_O[4] VPWR VGND sg13cmos5l_antennanp
XANTENNA__1138__A2 Tile_X0Y0_N2END[0] VPWR VGND sg13cmos5l_antennanp
XFILLER_9_1137 VPWR VGND sg13cmos5l_decap_8
XFILLER_6_2759 VPWR VGND sg13cmos5l_decap_8
X_1244_ _1244_/X Tile_X2Y0_N2END[1] Tile_X2Y0_N4END[9] Tile_X2Y0_NN4END[6] _0582_/Q
+ _0343_/Q _0342_/Q VPWR VGND sg13cmos5l_mux4_1
XFILLER_0_2303 VPWR VGND sg13cmos5l_fill_1
XANTENNA__0694__X Tile_X0Y0_FrameStrobe_O[7] VPWR VGND sg13cmos5l_antennanp
XFILLER_0_2347 VPWR VGND sg13cmos5l_fill_1
X_1175_ _1175_/X Tile_X1Y0_N1END[0] Tile_X1Y0_N2MID[4] Tile_X1Y0_N2END[3] _0592_/Q
+ _0305_/Q _0304_/Q VPWR VGND sg13cmos5l_mux4_1
XFILLER_4_1782 VPWR VGND sg13cmos5l_decap_8
X_0126_ _0126_/Q Tile_X0Y0_FrameData[27] VGND VPWR Tile_X0Y0_FrameStrobe[1] latch
XFILLER_4_1793 VPWR VGND sg13cmos5l_fill_1
XANTENNA__1031__A Tile_X4Y0_N2MID[7] VPWR VGND sg13cmos5l_antennanp
XANTENNA_12 Tile_X0Y0_FrameData[15] VPWR VGND sg13cmos5l_antennanp
XANTENNA_23 Tile_X0Y0_FrameData[29] VPWR VGND sg13cmos5l_antennanp
XANTENNA__0292__D Tile_X0Y0_FrameData[5] VPWR VGND sg13cmos5l_antennanp
XANTENNA_34 Tile_X0Y0_FrameData[2] VPWR VGND sg13cmos5l_antennanp
XANTENNA_45 Tile_X0Y0_FrameData[6] VPWR VGND sg13cmos5l_antennanp
XANTENNA_56 Tile_X0Y0_FrameData[8] VPWR VGND sg13cmos5l_antennanp
XANTENNA__0870__A Tile_X2Y0_N2MID[4] VPWR VGND sg13cmos5l_antennanp
XFILLER_14_1323 VPWR VGND sg13cmos5l_decap_8
XANTENNA_67 Tile_X0Y0_FrameData[11] VPWR VGND sg13cmos5l_antennanp
XANTENNA_78 Tile_X0Y0_FrameData[3] VPWR VGND sg13cmos5l_antennanp
XANTENNA_89 Tile_X0Y0_FrameData[23] VPWR VGND sg13cmos5l_antennanp
XFILLER_14_2079 VPWR VGND sg13cmos5l_decap_8
X_0959_ Tile_X1Y0_FrameStrobe_O[4] Tile_X1Y0_FrameStrobe[4] VPWR VGND sg13cmos5l_buf_1
XFILLER_12_1091 VPWR VGND sg13cmos5l_decap_8
XANTENNA__0869__X Tile_X2Y0_S2BEG[2] VPWR VGND sg13cmos5l_antennanp
XANTENNA__1129__A2 Tile_X4Y0_N2MID[6] VPWR VGND sg13cmos5l_antennanp
XFILLER_9_2361 VPWR VGND sg13cmos5l_decap_8
XFILLER_0_749 VPWR VGND sg13cmos5l_fill_1
XFILLER_9_1693 VPWR VGND sg13cmos5l_decap_8
XFILLER_5_2247 VPWR VGND sg13cmos5l_decap_8
XFILLER_5_1513 VPWR VGND sg13cmos5l_decap_8
XANTENNA__0467__D Tile_X0Y0_FrameData[6] VPWR VGND sg13cmos5l_antennanp
XANTENNA__0394__GATE Tile_X2Y0_FrameStrobe[2] VPWR VGND sg13cmos5l_antennanp
XFILLER_16_639 VPWR VGND sg13cmos5l_decap_8
XFILLER_15_105 VPWR VGND sg13cmos5l_decap_8
XANTENNA__0553__Q NPU_WDATA29 VPWR VGND sg13cmos5l_antennanp
XFILLER_7_18 VPWR VGND sg13cmos5l_fill_2
XFILLER_11_366 VPWR VGND sg13cmos5l_decap_4
XFILLER_14_2591 VPWR VGND sg13cmos5l_decap_8
XFILLER_11_399 VPWR VGND sg13cmos5l_fill_2
XANTENNA__0332__GATE Tile_X2Y0_FrameStrobe[0] VPWR VGND sg13cmos5l_antennanp
XFILLER_10_2433 VPWR VGND sg13cmos5l_decap_8
XFILLER_10_1732 VPWR VGND sg13cmos5l_fill_2
XFILLER_11_60 VPWR VGND sg13cmos5l_fill_1
XANTENNA__0779__X Tile_X3Y0_S4BEG[0] VPWR VGND sg13cmos5l_antennanp
XANTENNA__0347__GATE Tile_X2Y0_FrameStrobe[1] VPWR VGND sg13cmos5l_antennanp
XFILLER_3_565 VPWR VGND sg13cmos5l_decap_8
XANTENNA__0377__D Tile_X0Y0_FrameData[0] VPWR VGND sg13cmos5l_antennanp
XFILLER_1_2612 VPWR VGND sg13cmos5l_decap_8
XANTENNA__0955__A Tile_X1Y0_FrameStrobe[0] VPWR VGND sg13cmos5l_antennanp
XFILLER_4_1078 VPWR VGND sg13cmos5l_decap_8
XFILLER_1_1955 VPWR VGND sg13cmos5l_fill_2
XFILLER_15_661 VPWR VGND sg13cmos5l_decap_8
XFILLER_15_2322 VPWR VGND sg13cmos5l_decap_8
XANTENNA__0690__A Tile_X0Y0_FrameStrobe[3] VPWR VGND sg13cmos5l_antennanp
XFILLER_15_1621 VPWR VGND sg13cmos5l_fill_1
X_0813_ Tile_X4Y0_FrameData_O[2] Tile_X0Y0_FrameData[2] VPWR VGND sg13cmos5l_buf_1
XFILLER_15_1676 VPWR VGND sg13cmos5l_fill_2
X_0744_ Tile_X1Y0_SS4BEG[13] _1208_/X VPWR VGND sg13cmos5l_buf_1
XANTENNA__0689__X Tile_X0Y0_FrameStrobe_O[2] VPWR VGND sg13cmos5l_antennanp
X_0675_ _0675_/L_HI VPWR VGND sg13cmos5l_tiehi
XFILLER_6_2512 VPWR VGND sg13cmos5l_decap_8
XANTENNA__1026__A Tile_X0Y0_N1END[0] VPWR VGND sg13cmos5l_antennanp
XFILLER_6_2556 VPWR VGND sg13cmos5l_fill_2
XFILLER_2_2409 VPWR VGND sg13cmos5l_decap_8
XANTENNA__0287__D Tile_X0Y0_FrameData[10] VPWR VGND sg13cmos5l_antennanp
XFILLER_6_1866 VPWR VGND sg13cmos5l_decap_4
XANTENNA__0865__A Tile_X2Y0_N1END[1] VPWR VGND sg13cmos5l_antennanp
X_1227_ _1227_/X Tile_X2Y0_N2MID[0] Tile_X2Y0_N4END[7] Tile_X2Y0_NN4END[8] _0582_/Q
+ _0377_/Q _0376_/Q VPWR VGND sg13cmos5l_mux4_1
XFILLER_6_1899 VPWR VGND sg13cmos5l_decap_4
XFILLER_6_1888 VPWR VGND sg13cmos5l_fill_1
XFILLER_0_1421 VPWR VGND sg13cmos5l_fill_2
XFILLER_0_2144 VPWR VGND sg13cmos5l_decap_4
X_1158_ _1158_/X Tile_X0Y0_N2END[3] Tile_X0Y0_N4END[3] Tile_X0Y0_NN4END[12] _0602_/Q
+ _0147_/Q _0146_/Q VPWR VGND sg13cmos5l_mux4_1
XFILLER_0_2188 VPWR VGND sg13cmos5l_fill_2
X_0109_ _0109_/Q Tile_X0Y0_FrameData[12] VGND VPWR Tile_X0Y0_FrameStrobe[0] latch
XFILLER_16_49 VPWR VGND sg13cmos5l_decap_8
X_1089_ _1089_/X Tile_X3Y0_N1END[1] Tile_X3Y0_N2MID[1] Tile_X3Y0_N2MID[6] Tile_X3Y0_N2END[6]
+ _0423_/Q _0422_/Q VPWR VGND sg13cmos5l_mux4_1
XFILLER_16_2108 VPWR VGND sg13cmos5l_decap_8
XFILLER_14_1186 VPWR VGND sg13cmos5l_decap_8
XFILLER_11_2786 VPWR VGND sg13cmos5l_decap_4
XFILLER_0_524 VPWR VGND sg13cmos5l_fill_1
XFILLER_0_535 VPWR VGND sg13cmos5l_fill_1
XANTENNA__0548__Q NPU_WDATA24 VPWR VGND sg13cmos5l_antennanp
XFILLER_5_2055 VPWR VGND sg13cmos5l_fill_1
XANTENNA__0197__D Tile_X0Y0_FrameData[20] VPWR VGND sg13cmos5l_antennanp
XANTENNA__1286__A1 Tile_X3Y0_N4END[11] VPWR VGND sg13cmos5l_antennanp
XFILLER_16_2620 VPWR VGND sg13cmos5l_decap_8
XFILLER_12_653 VPWR VGND sg13cmos5l_decap_8
XANTENNA__0271__GATE Tile_X1Y0_FrameStrobe[2] VPWR VGND sg13cmos5l_antennanp
XFILLER_8_646 VPWR VGND sg13cmos5l_decap_8
XFILLER_16_2697 VPWR VGND sg13cmos5l_decap_8
XFILLER_16_1941 VPWR VGND sg13cmos5l_decap_8
XFILLER_12_1805 VPWR VGND sg13cmos5l_decap_8
XFILLER_11_152 VPWR VGND sg13cmos5l_fill_2
XFILLER_10_2230 VPWR VGND sg13cmos5l_decap_8
XFILLER_7_156 VPWR VGND sg13cmos5l_fill_2
XANTENNA__0286__GATE Tile_X1Y0_FrameStrobe[2] VPWR VGND sg13cmos5l_antennanp
XANTENNA__1210__A1 Tile_X1Y0_N4END[15] VPWR VGND sg13cmos5l_antennanp
X_0460_ _0460_/Q Tile_X0Y0_FrameData[13] VGND VPWR Tile_X3Y0_FrameStrobe[1] latch
X_0391_ _0391_/Q Tile_X0Y0_FrameData[18] VGND VPWR Tile_X2Y0_FrameStrobe[2] latch
XFILLER_3_2729 VPWR VGND sg13cmos5l_decap_8
XANTENNA__1277__A1 Tile_X3Y0_N4END[2] VPWR VGND sg13cmos5l_antennanp
X_1012_ Tile_X0Y0_S2BEGb[5] _1136_/X VPWR VGND sg13cmos5l_buf_1
XFILLER_1_2464 VPWR VGND sg13cmos5l_decap_8
XANTENNA__0224__GATE Tile_X1Y0_FrameStrobe[0] VPWR VGND sg13cmos5l_antennanp
XFILLER_1_1763 VPWR VGND sg13cmos5l_decap_8
XFILLER_1_1752 VPWR VGND sg13cmos5l_decap_4
XANTENNA__0972__X Tile_X1Y0_FrameStrobe_O[17] VPWR VGND sg13cmos5l_antennanp
XFILLER_1_1774 VPWR VGND sg13cmos5l_fill_2
XANTENNA__0239__GATE Tile_X1Y0_FrameStrobe[1] VPWR VGND sg13cmos5l_antennanp
XFILLER_15_2152 VPWR VGND sg13cmos5l_fill_2
XFILLER_11_2027 VPWR VGND sg13cmos5l_decap_8
XFILLER_11_1315 VPWR VGND sg13cmos5l_decap_4
XANTENNA__1201__A1 Tile_X1Y0_N4END[6] VPWR VGND sg13cmos5l_antennanp
X_0727_ Tile_X1Y0_S4BEG[12] _1191_/X VPWR VGND sg13cmos5l_buf_1
XFILLER_8_2607 VPWR VGND sg13cmos5l_decap_8
X_0658_ _0658_/L_HI VPWR VGND sg13cmos5l_tiehi
XFILLER_8_1917 VPWR VGND sg13cmos5l_decap_8
X_0589_ _0589_/Q Tile_X0Y0_UserCLK NPU_RDATA17 _0622_/L_HI VPWR VGND sg13cmos5l_dfrbpq_1
XFILLER_6_2342 VPWR VGND sg13cmos5l_decap_8
XFILLER_6_1652 VPWR VGND sg13cmos5l_decap_8
XFILLER_2_2228 VPWR VGND sg13cmos5l_decap_8
XANTENNA__1043__X Tile_X4Y0_S2BEGb[4] VPWR VGND sg13cmos5l_antennanp
XANTENNA__1268__A1 Tile_X3Y0_N4END[6] VPWR VGND sg13cmos5l_antennanp
XFILLER_2_1549 VPWR VGND sg13cmos5l_fill_1
XANTENNA__0882__X Tile_X2Y0_S2BEGb[7] VPWR VGND sg13cmos5l_antennanp
XFILLER_13_417 VPWR VGND sg13cmos5l_fill_1
XFILLER_16_1226 VPWR VGND sg13cmos5l_fill_2
XFILLER_16_1215 VPWR VGND sg13cmos5l_decap_8
XANTENNA__0480__D Tile_X0Y0_FrameData[25] VPWR VGND sg13cmos5l_antennanp
XFILLER_5_616 VPWR VGND sg13cmos5l_decap_8
XFILLER_4_148 VPWR VGND sg13cmos5l_fill_1
XFILLER_11_2583 VPWR VGND sg13cmos5l_decap_8
XFILLER_11_1860 VPWR VGND sg13cmos5l_decap_8
XFILLER_1_822 VPWR VGND sg13cmos5l_decap_4
XFILLER_1_888 VPWR VGND sg13cmos5l_decap_8
XFILLER_0_398 VPWR VGND sg13cmos5l_fill_2
XFILLER_2_2773 VPWR VGND sg13cmos5l_decap_8
XFILLER_2_2751 VPWR VGND sg13cmos5l_fill_1
XFILLER_2_2740 VPWR VGND sg13cmos5l_decap_8
XANTENNA__1259__A1 Tile_X3Y0_N4END[15] VPWR VGND sg13cmos5l_antennanp
XANTENNA__0792__X Tile_X3Y0_S4BEG[13] VPWR VGND sg13cmos5l_antennanp
XFILLER_16_244 VPWR VGND sg13cmos5l_decap_8
XFILLER_16_2472 VPWR VGND sg13cmos5l_decap_8
XFILLER_12_472 VPWR VGND sg13cmos5l_fill_2
XANTENNA__0390__D Tile_X0Y0_FrameData[19] VPWR VGND sg13cmos5l_antennanp
XFILLER_12_2347 VPWR VGND sg13cmos5l_decap_8
XFILLER_12_1679 VPWR VGND sg13cmos5l_decap_8
XANTENNA__1195__A0 Tile_X1Y0_N2END[0] VPWR VGND sg13cmos5l_antennanp
XFILLER_4_671 VPWR VGND sg13cmos5l_decap_8
X_0512_ _0512_/Q Tile_X0Y0_FrameData[31] VGND VPWR Tile_X4Y0_FrameStrobe[0] latch
XFILLER_4_682 VPWR VGND sg13cmos5l_fill_1
XANTENNA__0967__X Tile_X1Y0_FrameStrobe_O[12] VPWR VGND sg13cmos5l_antennanp
X_0443_ _0443_/Q Tile_X0Y0_FrameData[30] VGND VPWR Tile_X3Y0_FrameStrobe[1] latch
X_0374_ _0374_/Q Tile_X0Y0_FrameData[3] VGND VPWR Tile_X2Y0_FrameStrobe[1] latch
XFILLER_7_2673 VPWR VGND sg13cmos5l_decap_8
XFILLER_3_2504 VPWR VGND sg13cmos5l_decap_8
XFILLER_7_1983 VPWR VGND sg13cmos5l_decap_4
XFILLER_3_2559 VPWR VGND sg13cmos5l_decap_8
XANTENNA__0163__GATE Tile_X0Y0_FrameStrobe[2] VPWR VGND sg13cmos5l_antennanp
XFILLER_1_2283 VPWR VGND sg13cmos5l_decap_4
XANTENNA__0178__GATE Tile_X0Y0_FrameStrobe[2] VPWR VGND sg13cmos5l_antennanp
XANTENNA__0101__GATE Tile_X0Y0_FrameStrobe[0] VPWR VGND sg13cmos5l_antennanp
XFILLER_11_1112 VPWR VGND sg13cmos5l_decap_8
XANTENNA__1038__X Tile_X4Y0_S2BEG[7] VPWR VGND sg13cmos5l_antennanp
XANTENNA__1186__A0 Tile_X1Y0_N2MID[7] VPWR VGND sg13cmos5l_antennanp
XFILLER_11_1189 VPWR VGND sg13cmos5l_decap_8
XANTENNA__0116__GATE Tile_X0Y0_FrameStrobe[0] VPWR VGND sg13cmos5l_antennanp
XANTENNA__0877__X Tile_X2Y0_S2BEGb[2] VPWR VGND sg13cmos5l_antennanp
XFILLER_8_2459 VPWR VGND sg13cmos5l_decap_8
XFILLER_2_2014 VPWR VGND sg13cmos5l_fill_2
XFILLER_2_2003 VPWR VGND sg13cmos5l_decap_8
XFILLER_6_1482 VPWR VGND sg13cmos5l_decap_4
XFILLER_2_2069 VPWR VGND sg13cmos5l_decap_8
XFILLER_2_1335 VPWR VGND sg13cmos5l_decap_8
XANTENNA__0475__D Tile_X0Y0_FrameData[30] VPWR VGND sg13cmos5l_antennanp
XANTENNA__1110__A0 Tile_X1Y0_N4END[14] VPWR VGND sg13cmos5l_antennanp
XFILLER_14_759 VPWR VGND sg13cmos5l_decap_4
XFILLER_9_218 VPWR VGND sg13cmos5l_decap_8
XANTENNA__0561__Q NPU_WE5 VPWR VGND sg13cmos5l_antennanp
XFILLER_6_903 VPWR VGND sg13cmos5l_fill_2
XFILLER_13_2656 VPWR VGND sg13cmos5l_decap_8
XFILLER_13_1933 VPWR VGND sg13cmos5l_decap_8
XFILLER_6_947 VPWR VGND sg13cmos5l_fill_2
XANTENNA__1177__A0 Tile_X1Y0_N1END[2] VPWR VGND sg13cmos5l_antennanp
XFILLER_11_2391 VPWR VGND sg13cmos5l_decap_8
XANTENNA__0787__X Tile_X3Y0_S4BEG[8] VPWR VGND sg13cmos5l_antennanp
XFILLER_1_652 VPWR VGND sg13cmos5l_decap_4
XFILLER_0_151 VPWR VGND sg13cmos5l_decap_4
XFILLER_7_1224 VPWR VGND sg13cmos5l_fill_2
XFILLER_0_195 VPWR VGND sg13cmos5l_fill_1
XFILLER_7_1268 VPWR VGND sg13cmos5l_decap_8
X_0090_ _0560_/D _0516_/Q _1092_/X VPWR VGND sg13cmos5l_nor2b_1
XFILLER_2_2581 VPWR VGND sg13cmos5l_decap_8
XANTENNA__0385__D Tile_X0Y0_FrameData[24] VPWR VGND sg13cmos5l_antennanp
XANTENNA__0963__A Tile_X1Y0_FrameStrobe[8] VPWR VGND sg13cmos5l_antennanp
XANTENNA__1101__A0 Tile_X1Y0_N4END[5] VPWR VGND sg13cmos5l_antennanp
XFILLER_14_2409 VPWR VGND sg13cmos5l_decap_8
X_0992_ Tile_X0Y0_S4BEG[1] _1140_/X VPWR VGND sg13cmos5l_buf_1
XFILLER_9_741 VPWR VGND sg13cmos5l_fill_1
XFILLER_12_291 VPWR VGND sg13cmos5l_decap_8
XFILLER_12_2144 VPWR VGND sg13cmos5l_fill_2
XANTENNA__1168__A0 Tile_X0Y0_N2END[5] VPWR VGND sg13cmos5l_antennanp
XFILLER_12_1476 VPWR VGND sg13cmos5l_decap_8
XANTENNA__0697__X Tile_X0Y0_FrameStrobe_O[10] VPWR VGND sg13cmos5l_antennanp
XFILLER_9_2746 VPWR VGND sg13cmos5l_decap_8
X_0426_ _0426_/Q Tile_X0Y0_FrameData[15] VGND VPWR Tile_X3Y0_FrameStrobe[0] latch
XANTENNA__1034__A Tile_X4Y0_N2MID[4] VPWR VGND sg13cmos5l_antennanp
X_0357_ _0357_/Q Tile_X0Y0_FrameData[20] VGND VPWR Tile_X2Y0_FrameStrobe[1] latch
XFILLER_7_1791 VPWR VGND sg13cmos5l_decap_8
XFILLER_3_2367 VPWR VGND sg13cmos5l_decap_8
XFILLER_3_1611 VPWR VGND sg13cmos5l_decap_8
X_0288_ _0288_/Q Tile_X0Y0_FrameData[9] VGND VPWR Tile_X1Y0_FrameStrobe[2] latch
XANTENNA__0295__D Tile_X0Y0_FrameData[2] VPWR VGND sg13cmos5l_antennanp
XANTENNA__0873__A Tile_X2Y0_N2MID[1] VPWR VGND sg13cmos5l_antennanp
XFILLER_3_1666 VPWR VGND sg13cmos5l_decap_4
XFILLER_1_1390 VPWR VGND sg13cmos5l_decap_8
XFILLER_11_718 VPWR VGND sg13cmos5l_decap_8
XANTENNA__1159__A0 Tile_X0Y0_N2END[4] VPWR VGND sg13cmos5l_antennanp
XFILLER_8_2256 VPWR VGND sg13cmos5l_decap_8
XFILLER_8_1522 VPWR VGND sg13cmos5l_fill_1
XFILLER_8_1511 VPWR VGND sg13cmos5l_decap_8
XFILLER_4_2109 VPWR VGND sg13cmos5l_decap_4
XFILLER_8_1555 VPWR VGND sg13cmos5l_decap_8
XANTENNA_102 Tile_X0Y0_FrameData[16] VPWR VGND sg13cmos5l_antennanp
XANTENNA__0556__Q NPU_WE0 VPWR VGND sg13cmos5l_antennanp
XFILLER_2_1176 VPWR VGND sg13cmos5l_decap_8
XFILLER_15_2707 VPWR VGND sg13cmos5l_decap_8
XFILLER_13_2420 VPWR VGND sg13cmos5l_decap_8
XFILLER_13_2497 VPWR VGND sg13cmos5l_decap_8
XFILLER_13_1741 VPWR VGND sg13cmos5l_decap_8
XFILLER_5_254 VPWR VGND sg13cmos5l_decap_4
XFILLER_5_243 VPWR VGND sg13cmos5l_decap_4
XANTENNA__0958__A Tile_X1Y0_FrameStrobe[3] VPWR VGND sg13cmos5l_antennanp
X_1260_ _1260_/X Tile_X3Y0_N2MID[1] Tile_X3Y0_N4END[14] Tile_X3Y0_NN4END[1] _0579_/Q
+ _0487_/Q _0486_/Q VPWR VGND sg13cmos5l_mux4_1
X_0211_ _0211_/Q Tile_X0Y0_FrameData[22] VGND VPWR Tile_X1Y0_FrameStrobe[0] latch
X_1191_ _1191_/X Tile_X1Y0_N2MID[4] Tile_X1Y0_N4END[3] Tile_X1Y0_NN4END[12] _0588_/Q
+ _0273_/Q _0272_/Q VPWR VGND sg13cmos5l_mux4_1
XFILLER_7_1054 VPWR VGND sg13cmos5l_decap_8
XFILLER_4_2654 VPWR VGND sg13cmos5l_decap_8
X_0142_ _0142_/Q Tile_X0Y0_FrameData[11] VGND VPWR Tile_X0Y0_FrameStrobe[1] latch
XANTENNA__0693__A Tile_X0Y0_FrameStrobe[6] VPWR VGND sg13cmos5l_antennanp
XANTENNA__0980__X Tile_X0Y0_SS4BEG[5] VPWR VGND sg13cmos5l_antennanp
XFILLER_9_571 VPWR VGND sg13cmos5l_decap_8
X_0975_ Tile_X0Y0_SS4BEG[0] _1155_/X VPWR VGND sg13cmos5l_buf_1
XFILLER_12_1273 VPWR VGND sg13cmos5l_decap_8
XANTENNA__1029__A Tile_X4Y0_N1END[1] VPWR VGND sg13cmos5l_antennanp
XFILLER_10_29 VPWR VGND sg13cmos5l_fill_1
XANTENNA__0868__A Tile_X2Y0_N2MID[6] VPWR VGND sg13cmos5l_antennanp
X_0409_ _0409_/Q Tile_X0Y0_FrameData[0] VGND VPWR Tile_X2Y0_FrameStrobe[2] latch
XFILLER_3_2153 VPWR VGND sg13cmos5l_decap_8
XANTENNA__1051__X Tile_X4Y0_S4BEG[4] VPWR VGND sg13cmos5l_antennanp
XFILLER_3_1485 VPWR VGND sg13cmos5l_fill_1
XANTENNA__0890__X Tile_X2Y0_S4BEG[7] VPWR VGND sg13cmos5l_antennanp
XANTENNA__1092__A2 Tile_X3Y0_N2MID[4] VPWR VGND sg13cmos5l_antennanp
XFILLER_10_2604 VPWR VGND sg13cmos5l_decap_8
XFILLER_10_1903 VPWR VGND sg13cmos5l_fill_1
XFILLER_3_747 VPWR VGND sg13cmos5l_decap_8
XFILLER_8_1363 VPWR VGND sg13cmos5l_fill_2
XFILLER_4_1216 VPWR VGND sg13cmos5l_fill_2
XFILLER_4_1205 VPWR VGND sg13cmos5l_fill_2
XFILLER_15_821 VPWR VGND sg13cmos5l_decap_8
XANTENNA__1083__A2 Tile_X2Y0_N2MID[4] VPWR VGND sg13cmos5l_antennanp
XFILLER_15_1825 VPWR VGND sg13cmos5l_decap_8
X_0760_ Tile_X3Y0_S1BEG[1] Tile_X3Y0_N1END[2] VPWR VGND sg13cmos5l_buf_1
XFILLER_10_570 VPWR VGND sg13cmos5l_decap_8
XANTENNA__0500__GATE Tile_X3Y0_FrameStrobe[2] VPWR VGND sg13cmos5l_antennanp
XFILLER_13_2294 VPWR VGND sg13cmos5l_decap_8
X_0691_ Tile_X0Y0_FrameStrobe_O[4] Tile_X0Y0_FrameStrobe[4] VPWR VGND sg13cmos5l_buf_1
XANTENNA__0515__GATE Tile_X4Y0_FrameStrobe[0] VPWR VGND sg13cmos5l_antennanp
XANTENNA__0688__A Tile_X0Y0_FrameStrobe[1] VPWR VGND sg13cmos5l_antennanp
XFILLER_9_1116 VPWR VGND sg13cmos5l_decap_8
XFILLER_6_2738 VPWR VGND sg13cmos5l_decap_8
XFILLER_2_780 VPWR VGND sg13cmos5l_decap_4
XANTENNA__0975__X Tile_X0Y0_SS4BEG[0] VPWR VGND sg13cmos5l_antennanp
X_1243_ _1243_/X Tile_X2Y0_N2END[0] Tile_X2Y0_N4END[8] Tile_X2Y0_NN4END[7] _0583_/Q
+ _0345_/Q _0344_/Q VPWR VGND sg13cmos5l_mux4_1
XFILLER_2_52 VPWR VGND sg13cmos5l_fill_1
XFILLER_0_2315 VPWR VGND sg13cmos5l_fill_2
XFILLER_2_63 VPWR VGND sg13cmos5l_fill_2
X_1174_ _1174_/X Tile_X1Y0_N1END[3] Tile_X1Y0_N2MID[3] Tile_X1Y0_N2END[4] _0591_/Q
+ _0307_/Q _0306_/Q VPWR VGND sg13cmos5l_mux4_1
XFILLER_4_2495 VPWR VGND sg13cmos5l_decap_8
XFILLER_4_1761 VPWR VGND sg13cmos5l_decap_8
XFILLER_0_2359 VPWR VGND sg13cmos5l_fill_2
X_0125_ _0125_/Q Tile_X0Y0_FrameData[28] VGND VPWR Tile_X0Y0_FrameStrobe[1] latch
XFILLER_0_1658 VPWR VGND sg13cmos5l_decap_4
XANTENNA__0573__D NPU_RDATA1 VPWR VGND sg13cmos5l_antennanp
XANTENNA_13 Tile_X0Y0_FrameData[15] VPWR VGND sg13cmos5l_antennanp
XFILLER_14_2025 VPWR VGND sg13cmos5l_decap_8
XANTENNA_24 Tile_X0Y0_FrameData[29] VPWR VGND sg13cmos5l_antennanp
XANTENNA_35 Tile_X0Y0_FrameData[2] VPWR VGND sg13cmos5l_antennanp
XANTENNA_46 Tile_X0Y0_FrameData[6] VPWR VGND sg13cmos5l_antennanp
XANTENNA_57 Tile_X0Y0_FrameData[8] VPWR VGND sg13cmos5l_antennanp
XFILLER_14_2058 VPWR VGND sg13cmos5l_decap_8
XFILLER_14_2047 VPWR VGND sg13cmos5l_decap_8
XANTENNA_68 Tile_X0Y0_FrameData[13] VPWR VGND sg13cmos5l_antennanp
XANTENNA_79 Tile_X0Y0_FrameData[3] VPWR VGND sg13cmos5l_antennanp
X_0958_ Tile_X1Y0_FrameStrobe_O[3] Tile_X1Y0_FrameStrobe[3] VPWR VGND sg13cmos5l_buf_1
X_0889_ Tile_X2Y0_S4BEG[6] _1225_/X VPWR VGND sg13cmos5l_buf_1
XFILLER_12_1070 VPWR VGND sg13cmos5l_decap_8
XANTENNA__1129__A3 Tile_X4Y0_N2END[6] VPWR VGND sg13cmos5l_antennanp
XANTENNA__1046__X Tile_X4Y0_S2BEGb[7] VPWR VGND sg13cmos5l_antennanp
XFILLER_0_717 VPWR VGND sg13cmos5l_fill_1
XFILLER_9_2340 VPWR VGND sg13cmos5l_decap_8
XFILLER_5_2226 VPWR VGND sg13cmos5l_decap_8
XANTENNA__0885__X Tile_X2Y0_S4BEG[2] VPWR VGND sg13cmos5l_antennanp
XFILLER_9_1672 VPWR VGND sg13cmos5l_decap_8
XFILLER_3_1260 VPWR VGND sg13cmos5l_decap_8
XFILLER_16_618 VPWR VGND sg13cmos5l_decap_8
XFILLER_15_139 VPWR VGND sg13cmos5l_decap_8
XANTENNA__0483__D Tile_X0Y0_FrameData[22] VPWR VGND sg13cmos5l_antennanp
XFILLER_10_2412 VPWR VGND sg13cmos5l_decap_8
XFILLER_8_839 VPWR VGND sg13cmos5l_decap_8
XFILLER_7_327 VPWR VGND sg13cmos5l_fill_2
XFILLER_10_1711 VPWR VGND sg13cmos5l_decap_8
XFILLER_10_2489 VPWR VGND sg13cmos5l_decap_8
XFILLER_3_544 VPWR VGND sg13cmos5l_decap_8
XFILLER_10_1799 VPWR VGND sg13cmos5l_decap_8
XANTENNA__0795__X Tile_X3Y0_SS4BEG[0] VPWR VGND sg13cmos5l_antennanp
XFILLER_8_1182 VPWR VGND sg13cmos5l_fill_2
XFILLER_4_1002 VPWR VGND sg13cmos5l_decap_4
XFILLER_4_1057 VPWR VGND sg13cmos5l_decap_8
XANTENNA__0393__D Tile_X0Y0_FrameData[16] VPWR VGND sg13cmos5l_antennanp
XFILLER_15_640 VPWR VGND sg13cmos5l_decap_8
XFILLER_15_2301 VPWR VGND sg13cmos5l_decap_8
XANTENNA__0971__A Tile_X1Y0_FrameStrobe[16] VPWR VGND sg13cmos5l_antennanp
XANTENNA__0535__CLK Tile_X0Y0_UserCLK VPWR VGND sg13cmos5l_antennanp
X_0812_ Tile_X4Y0_FrameData_O[1] Tile_X0Y0_FrameData[1] VPWR VGND sg13cmos5l_buf_1
XFILLER_15_1644 VPWR VGND sg13cmos5l_fill_1
XFILLER_11_2209 VPWR VGND sg13cmos5l_decap_8
XFILLER_13_2080 VPWR VGND sg13cmos5l_fill_1
X_0743_ Tile_X1Y0_SS4BEG[12] _1207_/X VPWR VGND sg13cmos5l_buf_1
XANTENNA__0454__GATE Tile_X3Y0_FrameStrobe[1] VPWR VGND sg13cmos5l_antennanp
X_0674_ _0674_/L_HI VPWR VGND sg13cmos5l_tiehi
XFILLER_6_393 VPWR VGND sg13cmos5l_decap_4
XANTENNA__0469__GATE Tile_X3Y0_FrameStrobe[1] VPWR VGND sg13cmos5l_antennanp
X_1226_ _1226_/X Tile_X2Y0_N2MID[7] Tile_X2Y0_N4END[8] Tile_X2Y0_NN4END[7] _0585_/Q
+ _0379_/Q _0378_/Q VPWR VGND sg13cmos5l_mux4_1
X_1157_ _1157_/X Tile_X0Y0_N2END[2] Tile_X0Y0_N4END[2] Tile_X0Y0_NN4END[13] _0603_/Q
+ _0149_/Q _0148_/Q VPWR VGND sg13cmos5l_mux4_1
XANTENNA__1042__A Tile_X4Y0_N2END[4] VPWR VGND sg13cmos5l_antennanp
X_0108_ _0108_/Q Tile_X0Y0_FrameData[13] VGND VPWR Tile_X0Y0_FrameStrobe[0] latch
XFILLER_16_28 VPWR VGND sg13cmos5l_decap_8
X_1088_ _1088_/X Tile_X3Y0_N1END[0] Tile_X3Y0_N2MID[0] Tile_X3Y0_N2MID[7] Tile_X3Y0_N2END[7]
+ _0425_/Q _0424_/Q VPWR VGND sg13cmos5l_mux4_1
XANTENNA__0407__GATE Tile_X2Y0_FrameStrobe[2] VPWR VGND sg13cmos5l_antennanp
XFILLER_14_1165 VPWR VGND sg13cmos5l_decap_8
XFILLER_4_319 VPWR VGND sg13cmos5l_decap_4
XFILLER_11_2765 VPWR VGND sg13cmos5l_decap_8
XFILLER_0_547 VPWR VGND sg13cmos5l_fill_1
XANTENNA__0478__D Tile_X0Y0_FrameData[27] VPWR VGND sg13cmos5l_antennanp
XFILLER_0_558 VPWR VGND sg13cmos5l_decap_4
XANTENNA__1286__A2 Tile_X3Y0_NN4END[4] VPWR VGND sg13cmos5l_antennanp
XANTENNA__0558__CLK Tile_X0Y0_UserCLK VPWR VGND sg13cmos5l_antennanp
XANTENNA__0564__Q NPU_ADDR0 VPWR VGND sg13cmos5l_antennanp
XFILLER_16_2676 VPWR VGND sg13cmos5l_decap_8
XFILLER_16_1920 VPWR VGND sg13cmos5l_decap_8
XFILLER_12_632 VPWR VGND sg13cmos5l_decap_8
XFILLER_8_625 VPWR VGND sg13cmos5l_decap_8
XFILLER_12_2529 VPWR VGND sg13cmos5l_decap_8
XFILLER_7_146 VPWR VGND sg13cmos5l_fill_1
XFILLER_11_197 VPWR VGND sg13cmos5l_fill_1
XFILLER_11_186 VPWR VGND sg13cmos5l_fill_1
XFILLER_11_175 VPWR VGND sg13cmos5l_decap_4
XFILLER_7_168 VPWR VGND sg13cmos5l_fill_2
XFILLER_4_820 VPWR VGND sg13cmos5l_fill_1
XANTENNA__1210__A2 Tile_X1Y0_NN4END[0] VPWR VGND sg13cmos5l_antennanp
XFILLER_10_2286 VPWR VGND sg13cmos5l_decap_8
XFILLER_10_1585 VPWR VGND sg13cmos5l_decap_8
XANTENNA__0388__D Tile_X0Y0_FrameData[21] VPWR VGND sg13cmos5l_antennanp
X_0390_ _0390_/Q Tile_X0Y0_FrameData[19] VGND VPWR Tile_X2Y0_FrameStrobe[2] latch
XFILLER_3_2708 VPWR VGND sg13cmos5l_decap_8
XANTENNA__0966__A Tile_X1Y0_FrameStrobe[11] VPWR VGND sg13cmos5l_antennanp
XFILLER_1_2421 VPWR VGND sg13cmos5l_fill_2
X_1011_ Tile_X0Y0_S2BEGb[4] _1135_/X VPWR VGND sg13cmos5l_buf_1
XFILLER_1_2443 VPWR VGND sg13cmos5l_fill_1
XANTENNA__1277__A2 Tile_X3Y0_NN4END[13] VPWR VGND sg13cmos5l_antennanp
XFILLER_1_1742 VPWR VGND sg13cmos5l_decap_8
XFILLER_1_1797 VPWR VGND sg13cmos5l_decap_4
XFILLER_16_982 VPWR VGND sg13cmos5l_fill_2
XFILLER_11_2006 VPWR VGND sg13cmos5l_decap_8
XANTENNA__0393__GATE Tile_X2Y0_FrameStrobe[2] VPWR VGND sg13cmos5l_antennanp
XANTENNA__1201__A2 Tile_X1Y0_NN4END[9] VPWR VGND sg13cmos5l_antennanp
X_0726_ Tile_X1Y0_S4BEG[11] _1190_/X VPWR VGND sg13cmos5l_buf_1
XFILLER_7_691 VPWR VGND sg13cmos5l_decap_8
XANTENNA__1037__A Tile_X4Y0_N2MID[1] VPWR VGND sg13cmos5l_antennanp
X_0657_ _0657_/L_HI VPWR VGND sg13cmos5l_tiehi
XANTENNA__0298__D Tile_X0Y0_FrameData[31] VPWR VGND sg13cmos5l_antennanp
X_0588_ _0588_/Q Tile_X0Y0_UserCLK NPU_RDATA16 _0621_/L_HI VPWR VGND sg13cmos5l_dfrbpq_1
XFILLER_6_2321 VPWR VGND sg13cmos5l_decap_8
XFILLER_6_1631 VPWR VGND sg13cmos5l_decap_8
XFILLER_2_2207 VPWR VGND sg13cmos5l_decap_8
XFILLER_6_2398 VPWR VGND sg13cmos5l_decap_8
XANTENNA__0331__GATE Tile_X2Y0_FrameStrobe[0] VPWR VGND sg13cmos5l_antennanp
X_1209_ _1209_/X Tile_X1Y0_N2END[6] Tile_X1Y0_N4END[14] Tile_X1Y0_NN4END[1] _0589_/Q
+ _0237_/Q _0236_/Q VPWR VGND sg13cmos5l_mux4_1
XFILLER_2_1539 VPWR VGND sg13cmos5l_fill_2
XFILLER_2_1528 VPWR VGND sg13cmos5l_decap_8
XANTENNA__1268__A2 Tile_X3Y0_NN4END[9] VPWR VGND sg13cmos5l_antennanp
XFILLER_14_919 VPWR VGND sg13cmos5l_fill_2
XANTENNA__0346__GATE Tile_X2Y0_FrameStrobe[1] VPWR VGND sg13cmos5l_antennanp
XFILLER_16_1238 VPWR VGND sg13cmos5l_decap_8
XFILLER_11_2551 VPWR VGND sg13cmos5l_decap_8
XFILLER_0_300 VPWR VGND sg13cmos5l_fill_1
XFILLER_7_2129 VPWR VGND sg13cmos5l_decap_8
XANTENNA__0559__Q NPU_WE3 VPWR VGND sg13cmos5l_antennanp
XANTENNA__1259__A2 Tile_X3Y0_NN4END[0] VPWR VGND sg13cmos5l_antennanp
XFILLER_5_1185 VPWR VGND sg13cmos5l_decap_8
XFILLER_16_223 VPWR VGND sg13cmos5l_fill_1
XFILLER_16_212 VPWR VGND sg13cmos5l_decap_8
XFILLER_16_234 VPWR VGND sg13cmos5l_decap_8
XFILLER_16_2451 VPWR VGND sg13cmos5l_decap_8
XFILLER_8_422 VPWR VGND sg13cmos5l_fill_2
XFILLER_12_2326 VPWR VGND sg13cmos5l_decap_8
XFILLER_16_1794 VPWR VGND sg13cmos5l_decap_8
XFILLER_12_1658 VPWR VGND sg13cmos5l_decap_8
XANTENNA__1195__A1 Tile_X1Y0_N4END[0] VPWR VGND sg13cmos5l_antennanp
X_0511_ _0511_/Q Tile_X0Y0_FrameData[26] VGND VPWR Tile_X4Y0_FrameStrobe[0] latch
XFILLER_4_650 VPWR VGND sg13cmos5l_decap_8
X_0442_ _0442_/Q Tile_X0Y0_FrameData[31] VGND VPWR Tile_X3Y0_FrameStrobe[1] latch
XFILLER_3_193 VPWR VGND sg13cmos5l_decap_8
XANTENNA__0696__A Tile_X0Y0_FrameStrobe[9] VPWR VGND sg13cmos5l_antennanp
X_0373_ _0373_/Q Tile_X0Y0_FrameData[4] VGND VPWR Tile_X2Y0_FrameStrobe[1] latch
XFILLER_7_2652 VPWR VGND sg13cmos5l_decap_8
XANTENNA__0983__X Tile_X0Y0_SS4BEG[8] VPWR VGND sg13cmos5l_antennanp
XANTENNA__0581__D NPU_RDATA9 VPWR VGND sg13cmos5l_antennanp
XFILLER_15_1282 VPWR VGND sg13cmos5l_decap_8
XANTENNA__1186__A1 Tile_X1Y0_N4END[8] VPWR VGND sg13cmos5l_antennanp
XFILLER_11_1168 VPWR VGND sg13cmos5l_decap_8
X_0709_ Tile_X1Y0_S2BEGb[2] _1173_/X VPWR VGND sg13cmos5l_buf_1
XFILLER_8_2438 VPWR VGND sg13cmos5l_decap_8
XFILLER_8_1748 VPWR VGND sg13cmos5l_fill_2
XANTENNA__0270__GATE Tile_X1Y0_FrameStrobe[2] VPWR VGND sg13cmos5l_antennanp
XANTENNA__1054__X Tile_X4Y0_S4BEG[7] VPWR VGND sg13cmos5l_antennanp
XFILLER_6_2195 VPWR VGND sg13cmos5l_decap_8
XANTENNA__0893__X Tile_X2Y0_S4BEG[10] VPWR VGND sg13cmos5l_antennanp
XANTENNA__1110__A1 Tile_X1Y0_N4END[15] VPWR VGND sg13cmos5l_antennanp
XANTENNA__0285__GATE Tile_X1Y0_FrameStrobe[2] VPWR VGND sg13cmos5l_antennanp
XFILLER_0_1071 VPWR VGND sg13cmos5l_fill_1
XANTENNA__0491__D Tile_X0Y0_FrameData[14] VPWR VGND sg13cmos5l_antennanp
XFILLER_16_1035 VPWR VGND sg13cmos5l_decap_4
XFILLER_16_1057 VPWR VGND sg13cmos5l_decap_8
XFILLER_13_2635 VPWR VGND sg13cmos5l_decap_8
XFILLER_13_1912 VPWR VGND sg13cmos5l_decap_8
XFILLER_16_1079 VPWR VGND sg13cmos5l_decap_8
XFILLER_5_436 VPWR VGND sg13cmos5l_decap_8
XFILLER_13_1989 VPWR VGND sg13cmos5l_decap_8
XFILLER_11_2370 VPWR VGND sg13cmos5l_decap_8
XANTENNA__0223__GATE Tile_X1Y0_FrameStrobe[0] VPWR VGND sg13cmos5l_antennanp
XANTENNA__1177__A1 Tile_X1Y0_N2MID[6] VPWR VGND sg13cmos5l_antennanp
XFILLER_7_1203 VPWR VGND sg13cmos5l_decap_8
XFILLER_1_664 VPWR VGND sg13cmos5l_fill_2
XANTENNA__0238__GATE Tile_X1Y0_FrameStrobe[1] VPWR VGND sg13cmos5l_antennanp
XFILLER_7_1247 VPWR VGND sg13cmos5l_decap_8
XFILLER_2_2560 VPWR VGND sg13cmos5l_decap_8
XANTENNA__1101__A1 Tile_X1Y0_N4END[6] VPWR VGND sg13cmos5l_antennanp
XFILLER_9_720 VPWR VGND sg13cmos5l_decap_8
X_0991_ Tile_X0Y0_S4BEG[0] _1139_/X VPWR VGND sg13cmos5l_buf_1
XFILLER_16_2281 VPWR VGND sg13cmos5l_fill_1
XFILLER_12_270 VPWR VGND sg13cmos5l_decap_4
XFILLER_12_2123 VPWR VGND sg13cmos5l_decap_8
XFILLER_8_241 VPWR VGND sg13cmos5l_fill_2
XFILLER_16_1591 VPWR VGND sg13cmos5l_fill_1
XFILLER_16_1580 VPWR VGND sg13cmos5l_decap_8
XFILLER_8_274 VPWR VGND sg13cmos5l_fill_2
XFILLER_12_1455 VPWR VGND sg13cmos5l_decap_8
XANTENNA__1168__A1 Tile_X0Y0_N4END[13] VPWR VGND sg13cmos5l_antennanp
XANTENNA__0978__X Tile_X0Y0_SS4BEG[3] VPWR VGND sg13cmos5l_antennanp
XFILLER_9_2725 VPWR VGND sg13cmos5l_decap_8
XFILLER_5_96 VPWR VGND sg13cmos5l_fill_1
X_0425_ _0425_/Q Tile_X0Y0_FrameData[16] VGND VPWR Tile_X3Y0_FrameStrobe[0] latch
XFILLER_7_2493 VPWR VGND sg13cmos5l_decap_8
XANTENNA__0576__D NPU_RDATA4 VPWR VGND sg13cmos5l_antennanp
X_0356_ _0356_/Q Tile_X0Y0_FrameData[21] VGND VPWR Tile_X2Y0_FrameStrobe[1] latch
XFILLER_7_1770 VPWR VGND sg13cmos5l_decap_8
XFILLER_3_2346 VPWR VGND sg13cmos5l_decap_8
X_0287_ _0287_/Q Tile_X0Y0_FrameData[10] VGND VPWR Tile_X1Y0_FrameStrobe[2] latch
XANTENNA__1050__A Tile_X4Y0_N4END[12] VPWR VGND sg13cmos5l_antennanp
XANTENNA__1049__X Tile_X4Y0_S4BEG[2] VPWR VGND sg13cmos5l_antennanp
XFILLER_15_1090 VPWR VGND sg13cmos5l_decap_8
XANTENNA__1159__A1 Tile_X0Y0_N4END[4] VPWR VGND sg13cmos5l_antennanp
XANTENNA__0888__X Tile_X2Y0_S4BEG[5] VPWR VGND sg13cmos5l_antennanp
XFILLER_8_2235 VPWR VGND sg13cmos5l_decap_8
XFILLER_8_1534 VPWR VGND sg13cmos5l_decap_8
XANTENNA__0486__D Tile_X0Y0_FrameData[19] VPWR VGND sg13cmos5l_antennanp
XANTENNA_103 Tile_X0Y0_FrameData[19] VPWR VGND sg13cmos5l_antennanp
XFILLER_2_1155 VPWR VGND sg13cmos5l_decap_8
XANTENNA__1095__A0 Tile_X3Y0_N1END[3] VPWR VGND sg13cmos5l_antennanp
XFILLER_14_72 VPWR VGND sg13cmos5l_fill_2
XFILLER_6_701 VPWR VGND sg13cmos5l_decap_8
XFILLER_13_1720 VPWR VGND sg13cmos5l_decap_8
XFILLER_6_734 VPWR VGND sg13cmos5l_fill_2
XFILLER_13_2476 VPWR VGND sg13cmos5l_decap_8
XANTENNA__0162__GATE Tile_X0Y0_FrameStrobe[2] VPWR VGND sg13cmos5l_antennanp
XFILLER_6_778 VPWR VGND sg13cmos5l_fill_1
XANTENNA__0798__X Tile_X3Y0_SS4BEG[3] VPWR VGND sg13cmos5l_antennanp
XFILLER_5_288 VPWR VGND sg13cmos5l_decap_4
XANTENNA__0177__GATE Tile_X0Y0_FrameStrobe[2] VPWR VGND sg13cmos5l_antennanp
XFILLER_7_1022 VPWR VGND sg13cmos5l_decap_8
XFILLER_4_2633 VPWR VGND sg13cmos5l_decap_8
X_0210_ _0210_/Q Tile_X0Y0_FrameData[23] VGND VPWR Tile_X1Y0_FrameStrobe[0] latch
X_1190_ _1190_/X Tile_X1Y0_N2MID[3] Tile_X1Y0_N4END[4] Tile_X1Y0_NN4END[11] _0591_/Q
+ _0275_/Q _0274_/Q VPWR VGND sg13cmos5l_mux4_1
XFILLER_4_1921 VPWR VGND sg13cmos5l_decap_8
XANTENNA__0100__GATE Tile_X0Y0_FrameStrobe[0] VPWR VGND sg13cmos5l_antennanp
XANTENNA__0396__D Tile_X0Y0_FrameData[13] VPWR VGND sg13cmos5l_antennanp
XANTENNA__0974__A Tile_X1Y0_FrameStrobe[19] VPWR VGND sg13cmos5l_antennanp
XFILLER_0_2519 VPWR VGND sg13cmos5l_decap_8
X_0141_ _0141_/Q Tile_X0Y0_FrameData[12] VGND VPWR Tile_X0Y0_FrameStrobe[1] latch
XFILLER_4_1976 VPWR VGND sg13cmos5l_fill_2
XFILLER_2_2390 VPWR VGND sg13cmos5l_decap_8
XANTENNA__1086__A0 Tile_X2Y0_N1END[2] VPWR VGND sg13cmos5l_antennanp
XANTENNA__0115__GATE Tile_X0Y0_FrameStrobe[0] VPWR VGND sg13cmos5l_antennanp
XFILLER_14_2229 VPWR VGND sg13cmos5l_decap_8
XFILLER_9_550 VPWR VGND sg13cmos5l_decap_8
X_0974_ Tile_X1Y0_FrameStrobe_O[19] Tile_X1Y0_FrameStrobe[19] VPWR VGND sg13cmos5l_buf_1
XFILLER_14_1528 VPWR VGND sg13cmos5l_decap_8
XFILLER_12_1252 VPWR VGND sg13cmos5l_decap_8
XFILLER_9_2522 VPWR VGND sg13cmos5l_decap_8
XFILLER_9_2533 VPWR VGND sg13cmos5l_fill_2
XFILLER_9_1821 VPWR VGND sg13cmos5l_decap_8
XANTENNA__1045__A Tile_X4Y0_N2END[1] VPWR VGND sg13cmos5l_antennanp
XFILLER_9_2599 VPWR VGND sg13cmos5l_decap_8
X_0408_ _0408_/Q Tile_X0Y0_FrameData[1] VGND VPWR Tile_X2Y0_FrameStrobe[2] latch
XFILLER_3_2132 VPWR VGND sg13cmos5l_decap_8
X_0339_ _0339_/Q Tile_X0Y0_FrameData[6] VGND VPWR Tile_X2Y0_FrameStrobe[0] latch
XANTENNA__0591__CLK Tile_X0Y0_UserCLK VPWR VGND sg13cmos5l_antennanp
XANTENNA__1092__A3 Tile_X3Y0_N2END[3] VPWR VGND sg13cmos5l_antennanp
XFILLER_11_549 VPWR VGND sg13cmos5l_decap_8
XFILLER_14_2785 VPWR VGND sg13cmos5l_decap_4
XFILLER_3_715 VPWR VGND sg13cmos5l_fill_2
XFILLER_8_2087 VPWR VGND sg13cmos5l_decap_8
XFILLER_8_1320 VPWR VGND sg13cmos5l_decap_8
XANTENNA__0567__Q NPU_ADDR3 VPWR VGND sg13cmos5l_antennanp
XFILLER_4_1239 VPWR VGND sg13cmos5l_decap_8
XFILLER_15_800 VPWR VGND sg13cmos5l_decap_8
XFILLER_15_877 VPWR VGND sg13cmos5l_decap_8
XFILLER_15_2505 VPWR VGND sg13cmos5l_decap_8
XANTENNA__1083__A3 Tile_X2Y0_N2END[4] VPWR VGND sg13cmos5l_antennanp
XFILLER_15_1804 VPWR VGND sg13cmos5l_decap_8
XFILLER_13_2273 VPWR VGND sg13cmos5l_decap_8
XANTENNA__1240__A0 Tile_X2Y0_N2END[5] VPWR VGND sg13cmos5l_antennanp
X_0690_ Tile_X0Y0_FrameStrobe_O[3] Tile_X0Y0_FrameStrobe[3] VPWR VGND sg13cmos5l_buf_1
XANTENNA__0969__A Tile_X1Y0_FrameStrobe[14] VPWR VGND sg13cmos5l_antennanp
XFILLER_6_564 VPWR VGND sg13cmos5l_decap_4
XFILLER_6_2717 VPWR VGND sg13cmos5l_decap_8
XFILLER_2_770 VPWR VGND sg13cmos5l_fill_2
X_1242_ _1242_/X Tile_X2Y0_N2END[7] Tile_X2Y0_N4END[7] Tile_X2Y0_NN4END[8] _0584_/Q
+ _0347_/Q _0346_/Q VPWR VGND sg13cmos5l_mux4_1
XFILLER_1_280 VPWR VGND sg13cmos5l_fill_1
XFILLER_4_2463 VPWR VGND sg13cmos5l_fill_1
XFILLER_2_86 VPWR VGND sg13cmos5l_fill_2
XFILLER_0_2338 VPWR VGND sg13cmos5l_decap_4
X_1173_ _1173_/X Tile_X1Y0_N1END[2] Tile_X1Y0_N2MID[2] Tile_X1Y0_N2END[5] _0590_/Q
+ _0309_/Q _0308_/Q VPWR VGND sg13cmos5l_mux4_1
XFILLER_4_1740 VPWR VGND sg13cmos5l_decap_8
XFILLER_0_1626 VPWR VGND sg13cmos5l_fill_1
X_0124_ _0124_/Q Tile_X0Y0_FrameData[29] VGND VPWR Tile_X0Y0_FrameStrobe[1] latch
XANTENNA__0991__X Tile_X0Y0_S4BEG[0] VPWR VGND sg13cmos5l_antennanp
XFILLER_0_1648 VPWR VGND sg13cmos5l_fill_2
XANTENNA_14 Tile_X0Y0_FrameData[16] VPWR VGND sg13cmos5l_antennanp
XFILLER_14_2004 VPWR VGND sg13cmos5l_decap_8
XANTENNA_25 Tile_X0Y0_FrameData[29] VPWR VGND sg13cmos5l_antennanp
XANTENNA_36 Tile_X0Y0_FrameData[30] VPWR VGND sg13cmos5l_antennanp
XANTENNA_47 Tile_X0Y0_FrameData[6] VPWR VGND sg13cmos5l_antennanp
XANTENNA_58 Tile_X0Y0_FrameData[8] VPWR VGND sg13cmos5l_antennanp
XANTENNA_69 Tile_X0Y0_FrameData[19] VPWR VGND sg13cmos5l_antennanp
X_0957_ Tile_X1Y0_FrameStrobe_O[2] Tile_X1Y0_FrameStrobe[2] VPWR VGND sg13cmos5l_buf_1
XFILLER_14_1358 VPWR VGND sg13cmos5l_decap_8
XANTENNA__1231__A0 Tile_X2Y0_N2MID[4] VPWR VGND sg13cmos5l_antennanp
X_0888_ Tile_X2Y0_S4BEG[5] _1224_/X VPWR VGND sg13cmos5l_buf_1
XFILLER_9_1651 VPWR VGND sg13cmos5l_decap_8
XFILLER_9_2396 VPWR VGND sg13cmos5l_decap_8
XANTENNA__1062__X Tile_X4Y0_S4BEG[15] VPWR VGND sg13cmos5l_antennanp
XFILLER_12_825 VPWR VGND sg13cmos5l_decap_8
XFILLER_11_324 VPWR VGND sg13cmos5l_decap_8
XANTENNA__1222__A0 Tile_X2Y0_N2MID[3] VPWR VGND sg13cmos5l_antennanp
XFILLER_10_1734 VPWR VGND sg13cmos5l_fill_1
XFILLER_10_1745 VPWR VGND sg13cmos5l_decap_8
XFILLER_10_2468 VPWR VGND sg13cmos5l_decap_8
XFILLER_10_1778 VPWR VGND sg13cmos5l_decap_8
XFILLER_3_523 VPWR VGND sg13cmos5l_decap_8
XANTENNA__1289__A0 Tile_X3Y0_N2END[6] VPWR VGND sg13cmos5l_antennanp
XFILLER_5_2772 VPWR VGND sg13cmos5l_decap_8
XFILLER_1_2636 VPWR VGND sg13cmos5l_decap_8
XFILLER_1_1902 VPWR VGND sg13cmos5l_decap_8
XFILLER_1_1946 VPWR VGND sg13cmos5l_fill_2
XFILLER_1_1935 VPWR VGND sg13cmos5l_decap_4
XFILLER_1_1968 VPWR VGND sg13cmos5l_decap_8
XFILLER_15_696 VPWR VGND sg13cmos5l_fill_1
XFILLER_14_195 VPWR VGND sg13cmos5l_fill_2
XFILLER_14_184 VPWR VGND sg13cmos5l_decap_8
X_0811_ Tile_X4Y0_FrameData_O[0] Tile_X0Y0_FrameData[0] VPWR VGND sg13cmos5l_buf_1
XFILLER_15_2379 VPWR VGND sg13cmos5l_decap_8
XANTENNA__1213__A0 Tile_X2Y0_N1END[2] VPWR VGND sg13cmos5l_antennanp
X_0742_ Tile_X1Y0_SS4BEG[11] _1206_/X VPWR VGND sg13cmos5l_buf_1
XFILLER_15_1689 VPWR VGND sg13cmos5l_decap_8
XFILLER_11_1509 VPWR VGND sg13cmos5l_decap_8
XFILLER_7_884 VPWR VGND sg13cmos5l_fill_1
XANTENNA__0699__A Tile_X0Y0_FrameStrobe[12] VPWR VGND sg13cmos5l_antennanp
X_0673_ _0673_/L_HI VPWR VGND sg13cmos5l_tiehi
XFILLER_13_1391 VPWR VGND sg13cmos5l_decap_8
XANTENNA__0986__X Tile_X0Y0_SS4BEG[11] VPWR VGND sg13cmos5l_antennanp
XFILLER_6_1802 VPWR VGND sg13cmos5l_decap_8
XFILLER_0_2102 VPWR VGND sg13cmos5l_fill_2
X_1225_ _1225_/X Tile_X2Y0_N2MID[6] Tile_X2Y0_N4END[9] Tile_X2Y0_NN4END[6] _0584_/Q
+ _0381_/Q _0380_/Q VPWR VGND sg13cmos5l_mux4_1
XFILLER_6_1879 VPWR VGND sg13cmos5l_decap_8
X_1156_ _1156_/X Tile_X0Y0_N2END[1] Tile_X0Y0_N4END[1] Tile_X0Y0_NN4END[14] _0602_/Q
+ _0151_/Q _0150_/Q VPWR VGND sg13cmos5l_mux4_1
XFILLER_4_1570 VPWR VGND sg13cmos5l_decap_8
XANTENNA__0584__D NPU_RDATA12 VPWR VGND sg13cmos5l_antennanp
X_0107_ _0107_/Q Tile_X0Y0_FrameData[14] VGND VPWR Tile_X0Y0_FrameStrobe[0] latch
X_1087_ _1087_/X Tile_X2Y0_N1END[3] Tile_X2Y0_N2MID[0] Tile_X2Y0_N2MID[7] Tile_X2Y0_N2END[0]
+ _0315_/Q _0410_/Q VPWR VGND sg13cmos5l_mux4_1
XANTENNA__1204__A0 Tile_X1Y0_N2END[1] VPWR VGND sg13cmos5l_antennanp
XFILLER_14_1144 VPWR VGND sg13cmos5l_decap_8
XFILLER_11_2744 VPWR VGND sg13cmos5l_decap_8
XFILLER_10_1019 VPWR VGND sg13cmos5l_decap_8
XANTENNA__1057__X Tile_X4Y0_S4BEG[10] VPWR VGND sg13cmos5l_antennanp
XFILLER_0_504 VPWR VGND sg13cmos5l_fill_1
XANTENNA__0896__X Tile_X2Y0_S4BEG[13] VPWR VGND sg13cmos5l_antennanp
XFILLER_9_2193 VPWR VGND sg13cmos5l_decap_8
XFILLER_5_2035 VPWR VGND sg13cmos5l_decap_4
XFILLER_9_1470 VPWR VGND sg13cmos5l_fill_2
XFILLER_9_1492 VPWR VGND sg13cmos5l_decap_8
XANTENNA__0494__D Tile_X0Y0_FrameData[11] VPWR VGND sg13cmos5l_antennanp
XFILLER_3_1080 VPWR VGND sg13cmos5l_decap_8
XFILLER_0_2680 VPWR VGND sg13cmos5l_fill_1
XFILLER_12_611 VPWR VGND sg13cmos5l_decap_8
XANTENNA__0514__GATE Tile_X4Y0_FrameStrobe[0] VPWR VGND sg13cmos5l_antennanp
XFILLER_8_604 VPWR VGND sg13cmos5l_fill_2
XFILLER_16_2655 VPWR VGND sg13cmos5l_decap_8
XFILLER_11_110 VPWR VGND sg13cmos5l_fill_1
XFILLER_12_688 VPWR VGND sg13cmos5l_decap_8
XFILLER_12_2508 VPWR VGND sg13cmos5l_decap_8
XFILLER_11_154 VPWR VGND sg13cmos5l_fill_1
XFILLER_16_1976 VPWR VGND sg13cmos5l_decap_8
XFILLER_10_2265 VPWR VGND sg13cmos5l_decap_8
XFILLER_10_1553 VPWR VGND sg13cmos5l_decap_8
XFILLER_4_832 VPWR VGND sg13cmos5l_decap_8
XFILLER_6_1109 VPWR VGND sg13cmos5l_decap_8
X_1010_ Tile_X0Y0_S2BEGb[3] _1134_/X VPWR VGND sg13cmos5l_buf_1
XFILLER_1_2433 VPWR VGND sg13cmos5l_decap_8
XFILLER_1_2499 VPWR VGND sg13cmos5l_fill_1
XFILLER_1_1721 VPWR VGND sg13cmos5l_decap_8
XFILLER_16_994 VPWR VGND sg13cmos5l_decap_4
XFILLER_15_2154 VPWR VGND sg13cmos5l_fill_1
XFILLER_15_1475 VPWR VGND sg13cmos5l_decap_8
X_0725_ Tile_X1Y0_S4BEG[10] _1189_/X VPWR VGND sg13cmos5l_buf_1
X_0656_ _0656_/L_HI VPWR VGND sg13cmos5l_tiehi
XFILLER_6_191 VPWR VGND sg13cmos5l_decap_8
XANTENNA__0579__D NPU_RDATA7 VPWR VGND sg13cmos5l_antennanp
XFILLER_6_2300 VPWR VGND sg13cmos5l_decap_8
X_0587_ _0587_/Q Tile_X0Y0_UserCLK NPU_RDATA15 _0620_/L_HI VPWR VGND sg13cmos5l_dfrbpq_1
XFILLER_6_2377 VPWR VGND sg13cmos5l_decap_8
XFILLER_6_1610 VPWR VGND sg13cmos5l_decap_8
XANTENNA__1053__A Tile_X4Y0_N4END[9] VPWR VGND sg13cmos5l_antennanp
X_1208_ _1208_/X Tile_X1Y0_N2END[5] Tile_X1Y0_N4END[13] Tile_X1Y0_NN4END[2] _0588_/Q
+ _0239_/Q _0238_/Q VPWR VGND sg13cmos5l_mux4_1
XFILLER_6_1687 VPWR VGND sg13cmos5l_decap_8
X_1139_ _1139_/X Tile_X0Y0_N2MID[0] Tile_X0Y0_N4END[15] Tile_X0Y0_NN4END[0] _0602_/Q
+ _0185_/Q _0184_/Q VPWR VGND sg13cmos5l_mux4_1
XFILLER_11_1895 VPWR VGND sg13cmos5l_decap_8
XANTENNA__0489__D Tile_X0Y0_FrameData[16] VPWR VGND sg13cmos5l_antennanp
XFILLER_0_312 VPWR VGND sg13cmos5l_fill_2
XFILLER_0_345 VPWR VGND sg13cmos5l_decap_4
XFILLER_7_1418 VPWR VGND sg13cmos5l_decap_4
XANTENNA__0525__CLK Tile_X0Y0_UserCLK VPWR VGND sg13cmos5l_antennanp
XFILLER_5_1153 VPWR VGND sg13cmos5l_decap_4
XANTENNA__0453__GATE Tile_X3Y0_FrameStrobe[1] VPWR VGND sg13cmos5l_antennanp
XFILLER_16_279 VPWR VGND sg13cmos5l_decap_8
XFILLER_16_2430 VPWR VGND sg13cmos5l_decap_8
XFILLER_12_2305 VPWR VGND sg13cmos5l_decap_8
XFILLER_16_1773 VPWR VGND sg13cmos5l_decap_8
XFILLER_12_474 VPWR VGND sg13cmos5l_fill_1
XANTENNA__0468__GATE Tile_X3Y0_FrameStrobe[1] VPWR VGND sg13cmos5l_antennanp
XFILLER_12_1637 VPWR VGND sg13cmos5l_decap_8
XFILLER_10_2051 VPWR VGND sg13cmos5l_decap_8
XANTENNA__1195__A2 Tile_X1Y0_NN4END[15] VPWR VGND sg13cmos5l_antennanp
X_0510_ _0510_/Q Tile_X0Y0_FrameData[27] VGND VPWR Tile_X4Y0_FrameStrobe[0] latch
XANTENNA__0399__D Tile_X0Y0_FrameData[10] VPWR VGND sg13cmos5l_antennanp
XFILLER_3_161 VPWR VGND sg13cmos5l_decap_8
X_0441_ _0441_/Q Tile_X0Y0_FrameData[0] VGND VPWR Tile_X3Y0_FrameStrobe[0] latch
XFILLER_7_2631 VPWR VGND sg13cmos5l_decap_8
XFILLER_3_183 VPWR VGND sg13cmos5l_fill_2
X_0372_ _0372_/Q Tile_X0Y0_FrameData[5] VGND VPWR Tile_X2Y0_FrameStrobe[1] latch
XANTENNA__0406__GATE Tile_X2Y0_FrameStrobe[2] VPWR VGND sg13cmos5l_antennanp
XFILLER_3_2528 VPWR VGND sg13cmos5l_decap_8
XFILLER_3_1805 VPWR VGND sg13cmos5l_decap_4
XFILLER_3_1816 VPWR VGND sg13cmos5l_fill_2
XFILLER_1_2230 VPWR VGND sg13cmos5l_decap_8
XFILLER_1_2252 VPWR VGND sg13cmos5l_decap_8
XFILLER_1_1584 VPWR VGND sg13cmos5l_fill_2
XFILLER_16_780 VPWR VGND sg13cmos5l_decap_8
XFILLER_15_1261 VPWR VGND sg13cmos5l_decap_8
XFILLER_11_1147 VPWR VGND sg13cmos5l_decap_8
XANTENNA__1048__A Tile_X4Y0_N4END[14] VPWR VGND sg13cmos5l_antennanp
XANTENNA__1186__A2 Tile_X1Y0_NN4END[7] VPWR VGND sg13cmos5l_antennanp
XANTENNA__0548__CLK Tile_X0Y0_UserCLK VPWR VGND sg13cmos5l_antennanp
X_0708_ Tile_X1Y0_S2BEGb[1] _1172_/X VPWR VGND sg13cmos5l_buf_1
XFILLER_8_2417 VPWR VGND sg13cmos5l_decap_8
XFILLER_1_109 VPWR VGND sg13cmos5l_fill_2
XANTENNA__0102__D Tile_X0Y0_FrameData[19] VPWR VGND sg13cmos5l_antennanp
X_0639_ _0639_/L_HI VPWR VGND sg13cmos5l_tiehi
XFILLER_8_1738 VPWR VGND sg13cmos5l_fill_1
XFILLER_6_2174 VPWR VGND sg13cmos5l_decap_8
XFILLER_2_1304 VPWR VGND sg13cmos5l_decap_4
XANTENNA__1070__X Tile_X4Y0_SS4BEG[7] VPWR VGND sg13cmos5l_antennanp
XANTENNA__1110__A2 Tile_X1Y0_NN4END[12] VPWR VGND sg13cmos5l_antennanp
XFILLER_14_728 VPWR VGND sg13cmos5l_decap_4
XFILLER_0_1083 VPWR VGND sg13cmos5l_fill_1
XFILLER_16_1003 VPWR VGND sg13cmos5l_fill_1
XFILLER_13_2614 VPWR VGND sg13cmos5l_decap_8
XFILLER_6_916 VPWR VGND sg13cmos5l_fill_2
XFILLER_6_905 VPWR VGND sg13cmos5l_fill_1
XFILLER_6_949 VPWR VGND sg13cmos5l_fill_1
XFILLER_13_1968 VPWR VGND sg13cmos5l_decap_8
XANTENNA__1177__A2 Tile_X1Y0_N2END[1] VPWR VGND sg13cmos5l_antennanp
XFILLER_11_1692 VPWR VGND sg13cmos5l_decap_8
XFILLER_0_131 VPWR VGND sg13cmos5l_decap_4
XFILLER_7_1226 VPWR VGND sg13cmos5l_fill_1
XANTENNA__0392__GATE Tile_X2Y0_FrameStrobe[2] VPWR VGND sg13cmos5l_antennanp
XANTENNA__1101__A2 Tile_X1Y0_NN4END[5] VPWR VGND sg13cmos5l_antennanp
XFILLER_2_1871 VPWR VGND sg13cmos5l_fill_1
X_0990_ Tile_X0Y0_SS4BEG[15] _1170_/X VPWR VGND sg13cmos5l_buf_1
XFILLER_13_794 VPWR VGND sg13cmos5l_decap_8
XFILLER_12_2102 VPWR VGND sg13cmos5l_decap_8
XFILLER_9_765 VPWR VGND sg13cmos5l_fill_2
XFILLER_12_2179 VPWR VGND sg13cmos5l_decap_8
XFILLER_12_1423 VPWR VGND sg13cmos5l_fill_1
XANTENNA__0330__GATE Tile_X2Y0_FrameStrobe[0] VPWR VGND sg13cmos5l_antennanp
XANTENNA__1168__A2 Tile_X0Y0_NN4END[2] VPWR VGND sg13cmos5l_antennanp
XFILLER_9_2704 VPWR VGND sg13cmos5l_decap_8
XFILLER_5_982 VPWR VGND sg13cmos5l_fill_2
XFILLER_4_470 VPWR VGND sg13cmos5l_decap_8
XFILLER_10_1191 VPWR VGND sg13cmos5l_decap_8
XFILLER_4_481 VPWR VGND sg13cmos5l_fill_2
XANTENNA__0345__GATE Tile_X2Y0_FrameStrobe[0] VPWR VGND sg13cmos5l_antennanp
X_0424_ _0424_/Q Tile_X0Y0_FrameData[17] VGND VPWR Tile_X3Y0_FrameStrobe[0] latch
XANTENNA__0994__X Tile_X0Y0_S4BEG[3] VPWR VGND sg13cmos5l_antennanp
XFILLER_7_2472 VPWR VGND sg13cmos5l_decap_8
XFILLER_3_2303 VPWR VGND sg13cmos5l_fill_2
X_0355_ _0355_/Q Tile_X0Y0_FrameData[22] VGND VPWR Tile_X2Y0_FrameStrobe[1] latch
X_0286_ _0286_/Q Tile_X0Y0_FrameData[11] VGND VPWR Tile_X1Y0_FrameStrobe[2] latch
XANTENNA__0592__D NPU_RDATA20 VPWR VGND sg13cmos5l_antennanp
XANTENNA__1159__A2 Tile_X0Y0_NN4END[11] VPWR VGND sg13cmos5l_antennanp
XFILLER_8_2214 VPWR VGND sg13cmos5l_decap_8
XFILLER_6_9 VPWR VGND sg13cmos5l_fill_1
XANTENNA__1065__X Tile_X4Y0_SS4BEG[2] VPWR VGND sg13cmos5l_antennanp
XANTENNA_104 Tile_X0Y0_FrameData[20] VPWR VGND sg13cmos5l_antennanp
XFILLER_2_1134 VPWR VGND sg13cmos5l_decap_8
XANTENNA__1095__A1 Tile_X3Y0_N2MID[0] VPWR VGND sg13cmos5l_antennanp
XFILLER_14_536 VPWR VGND sg13cmos5l_decap_8
XFILLER_14_95 VPWR VGND sg13cmos5l_fill_1
XFILLER_13_2455 VPWR VGND sg13cmos5l_decap_8
XFILLER_5_201 VPWR VGND sg13cmos5l_fill_2
XFILLER_10_786 VPWR VGND sg13cmos5l_decap_8
XFILLER_6_746 VPWR VGND sg13cmos5l_decap_8
XFILLER_13_1776 VPWR VGND sg13cmos5l_decap_8
XFILLER_2_952 VPWR VGND sg13cmos5l_decap_4
XFILLER_4_2612 VPWR VGND sg13cmos5l_decap_8
X_0140_ _0140_/Q Tile_X0Y0_FrameData[13] VGND VPWR Tile_X0Y0_FrameStrobe[1] latch
XFILLER_7_1089 VPWR VGND sg13cmos5l_decap_8
XFILLER_4_2689 VPWR VGND sg13cmos5l_decap_8
XFILLER_0_1819 VPWR VGND sg13cmos5l_fill_1
XANTENNA__1086__A1 Tile_X2Y0_N2MID[1] VPWR VGND sg13cmos5l_antennanp
XFILLER_4_1999 VPWR VGND sg13cmos5l_decap_4
XFILLER_14_2208 VPWR VGND sg13cmos5l_decap_8
XFILLER_14_1507 VPWR VGND sg13cmos5l_decap_8
X_0973_ Tile_X1Y0_FrameStrobe_O[18] Tile_X1Y0_FrameStrobe[18] VPWR VGND sg13cmos5l_buf_1
XFILLER_12_1231 VPWR VGND sg13cmos5l_decap_8
XANTENNA__0989__X Tile_X0Y0_SS4BEG[14] VPWR VGND sg13cmos5l_antennanp
XFILLER_9_2501 VPWR VGND sg13cmos5l_decap_8
XFILLER_9_1800 VPWR VGND sg13cmos5l_decap_8
XFILLER_9_2545 VPWR VGND sg13cmos5l_decap_8
XFILLER_5_790 VPWR VGND sg13cmos5l_fill_2
XANTENNA__0284__GATE Tile_X1Y0_FrameStrobe[2] VPWR VGND sg13cmos5l_antennanp
XFILLER_9_2578 VPWR VGND sg13cmos5l_decap_8
XANTENNA__0587__D NPU_RDATA15 VPWR VGND sg13cmos5l_antennanp
XFILLER_5_1708 VPWR VGND sg13cmos5l_fill_1
X_0407_ _0407_/Q Tile_X0Y0_FrameData[2] VGND VPWR Tile_X2Y0_FrameStrobe[2] latch
XFILLER_7_2280 VPWR VGND sg13cmos5l_decap_8
XFILLER_3_2111 VPWR VGND sg13cmos5l_fill_1
XANTENNA__0299__GATE Tile_X1Y0_FrameStrobe[3] VPWR VGND sg13cmos5l_antennanp
X_0338_ _0338_/Q Tile_X0Y0_FrameData[7] VGND VPWR Tile_X2Y0_FrameStrobe[0] latch
XFILLER_3_1410 VPWR VGND sg13cmos5l_decap_8
XFILLER_3_2188 VPWR VGND sg13cmos5l_decap_8
XANTENNA__1061__A Tile_X4Y0_N4END[1] VPWR VGND sg13cmos5l_antennanp
X_0269_ _0269_/Q Tile_X0Y0_FrameData[28] VGND VPWR Tile_X1Y0_FrameStrobe[2] latch
XANTENNA__0222__GATE Tile_X1Y0_FrameStrobe[0] VPWR VGND sg13cmos5l_antennanp
XFILLER_11_528 VPWR VGND sg13cmos5l_decap_8
XFILLER_14_2764 VPWR VGND sg13cmos5l_decap_8
XANTENNA__0237__GATE Tile_X1Y0_FrameStrobe[1] VPWR VGND sg13cmos5l_antennanp
XFILLER_10_2639 VPWR VGND sg13cmos5l_decap_8
XANTENNA__0899__X Tile_X2Y0_SS4BEG[0] VPWR VGND sg13cmos5l_antennanp
XFILLER_2_204 VPWR VGND sg13cmos5l_decap_4
XFILLER_2_237 VPWR VGND sg13cmos5l_fill_2
XANTENNA__0497__D Tile_X0Y0_FrameData[8] VPWR VGND sg13cmos5l_antennanp
XFILLER_14_311 VPWR VGND sg13cmos5l_decap_8
XFILLER_15_856 VPWR VGND sg13cmos5l_decap_8
XFILLER_13_2252 VPWR VGND sg13cmos5l_decap_8
XANTENNA__1240__A1 Tile_X2Y0_N4END[5] VPWR VGND sg13cmos5l_antennanp
XFILLER_6_543 VPWR VGND sg13cmos5l_decap_8
XFILLER_13_1584 VPWR VGND sg13cmos5l_fill_1
XFILLER_2_760 VPWR VGND sg13cmos5l_fill_2
X_1241_ _1241_/X Tile_X2Y0_N2END[6] Tile_X2Y0_N4END[6] Tile_X2Y0_NN4END[9] _0585_/Q
+ _0349_/Q _0348_/Q VPWR VGND sg13cmos5l_mux4_1
XANTENNA__0200__D Tile_X0Y0_FrameData[17] VPWR VGND sg13cmos5l_antennanp
X_1172_ _1172_/X Tile_X1Y0_N1END[1] Tile_X1Y0_N2MID[1] Tile_X1Y0_N2END[6] _0589_/Q
+ _0311_/Q _0310_/Q VPWR VGND sg13cmos5l_mux4_1
X_0123_ _0123_/Q Tile_X0Y0_FrameData[30] VGND VPWR Tile_X0Y0_FrameStrobe[1] latch
XANTENNA_15 Tile_X0Y0_FrameData[16] VPWR VGND sg13cmos5l_antennanp
XANTENNA_26 Tile_X0Y0_FrameData[2] VPWR VGND sg13cmos5l_antennanp
XANTENNA_37 Tile_X0Y0_FrameData[3] VPWR VGND sg13cmos5l_antennanp
XANTENNA_48 Tile_X0Y0_FrameData[6] VPWR VGND sg13cmos5l_antennanp
XANTENNA_59 Tile_X0Y0_FrameData[8] VPWR VGND sg13cmos5l_antennanp
X_0956_ Tile_X1Y0_FrameStrobe_O[1] Tile_X1Y0_FrameStrobe[1] VPWR VGND sg13cmos5l_buf_1
XFILLER_14_1337 VPWR VGND sg13cmos5l_decap_8
XANTENNA__1231__A1 Tile_X2Y0_N4END[3] VPWR VGND sg13cmos5l_antennanp
X_0887_ Tile_X2Y0_S4BEG[4] _1223_/X VPWR VGND sg13cmos5l_buf_1
XANTENNA__1056__A Tile_X4Y0_N4END[6] VPWR VGND sg13cmos5l_antennanp
XFILLER_9_1630 VPWR VGND sg13cmos5l_decap_8
XFILLER_9_2375 VPWR VGND sg13cmos5l_decap_8
XANTENNA__0110__D Tile_X0Y0_FrameData[11] VPWR VGND sg13cmos5l_antennanp
XFILLER_5_1549 VPWR VGND sg13cmos5l_decap_8
XFILLER_5_1527 VPWR VGND sg13cmos5l_decap_8
XANTENNA__0161__GATE Tile_X0Y0_FrameStrobe[2] VPWR VGND sg13cmos5l_antennanp
XANTENNA__0176__GATE Tile_X0Y0_FrameStrobe[2] VPWR VGND sg13cmos5l_antennanp
XFILLER_8_808 VPWR VGND sg13cmos5l_decap_8
XANTENNA__1222__A1 Tile_X2Y0_N4END[12] VPWR VGND sg13cmos5l_antennanp
XFILLER_10_2447 VPWR VGND sg13cmos5l_decap_8
XFILLER_14_2583 VPWR VGND sg13cmos5l_decap_4
XFILLER_3_502 VPWR VGND sg13cmos5l_decap_8
XFILLER_14_1893 VPWR VGND sg13cmos5l_fill_2
XFILLER_11_85 VPWR VGND sg13cmos5l_decap_4
XFILLER_11_74 VPWR VGND sg13cmos5l_fill_2
XFILLER_3_579 VPWR VGND sg13cmos5l_decap_8
XANTENNA__0114__GATE Tile_X0Y0_FrameStrobe[0] VPWR VGND sg13cmos5l_antennanp
XFILLER_8_1140 VPWR VGND sg13cmos5l_fill_1
XANTENNA__1289__A1 Tile_X3Y0_N4END[14] VPWR VGND sg13cmos5l_antennanp
XFILLER_8_1162 VPWR VGND sg13cmos5l_fill_2
XFILLER_5_2751 VPWR VGND sg13cmos5l_decap_8
XANTENNA__0129__GATE Tile_X0Y0_FrameStrobe[1] VPWR VGND sg13cmos5l_antennanp
XFILLER_15_675 VPWR VGND sg13cmos5l_decap_8
XFILLER_14_163 VPWR VGND sg13cmos5l_decap_4
XFILLER_14_141 VPWR VGND sg13cmos5l_fill_1
XFILLER_15_2336 VPWR VGND sg13cmos5l_fill_2
X_0810_ Tile_X3Y0_SS4BEG[15] _1290_/X VPWR VGND sg13cmos5l_buf_1
XANTENNA__1213__A1 Tile_X2Y0_N2MID[2] VPWR VGND sg13cmos5l_antennanp
X_0741_ Tile_X1Y0_SS4BEG[10] _1205_/X VPWR VGND sg13cmos5l_buf_1
XFILLER_10_391 VPWR VGND sg13cmos5l_decap_4
X_0672_ _0672_/L_HI VPWR VGND sg13cmos5l_tiehi
XFILLER_6_373 VPWR VGND sg13cmos5l_decap_8
XFILLER_6_2526 VPWR VGND sg13cmos5l_decap_8
XANTENNA__0581__CLK Tile_X0Y0_UserCLK VPWR VGND sg13cmos5l_antennanp
X_1224_ _1224_/X Tile_X2Y0_N2MID[5] Tile_X2Y0_N4END[10] Tile_X2Y0_NN4END[5] _0585_/Q
+ _0383_/Q _0382_/Q VPWR VGND sg13cmos5l_mux4_1
XFILLER_4_2283 VPWR VGND sg13cmos5l_decap_8
XFILLER_0_1402 VPWR VGND sg13cmos5l_fill_1
X_1155_ _1155_/X Tile_X0Y0_N2END[0] Tile_X0Y0_N4END[0] Tile_X0Y0_NN4END[15] _0603_/Q
+ _0153_/Q _0152_/Q VPWR VGND sg13cmos5l_mux4_1
X_0106_ _0106_/Q Tile_X0Y0_FrameData[15] VGND VPWR Tile_X0Y0_FrameStrobe[0] latch
X_1086_ _1086_/X Tile_X2Y0_N1END[2] Tile_X2Y0_N2MID[1] Tile_X2Y0_N2MID[6] Tile_X2Y0_N2END[1]
+ _0317_/Q _0316_/Q VPWR VGND sg13cmos5l_mux4_1
XFILLER_0_1479 VPWR VGND sg13cmos5l_fill_1
XFILLER_14_1123 VPWR VGND sg13cmos5l_decap_8
XANTENNA__1204__A1 Tile_X1Y0_N4END[9] VPWR VGND sg13cmos5l_antennanp
XFILLER_11_2723 VPWR VGND sg13cmos5l_decap_8
XANTENNA__0105__D Tile_X0Y0_FrameData[16] VPWR VGND sg13cmos5l_antennanp
X_0939_ Tile_X2Y0_FrameStrobe_O[4] Tile_X2Y0_FrameStrobe[4] VPWR VGND sg13cmos5l_buf_1
XFILLER_0_516 VPWR VGND sg13cmos5l_decap_4
XFILLER_9_2172 VPWR VGND sg13cmos5l_decap_8
XANTENNA__1073__X Tile_X4Y0_SS4BEG[10] VPWR VGND sg13cmos5l_antennanp
XFILLER_5_1357 VPWR VGND sg13cmos5l_decap_4
XANTENNA__1140__A0 Tile_X0Y0_N2MID[1] VPWR VGND sg13cmos5l_antennanp
XFILLER_16_439 VPWR VGND sg13cmos5l_fill_1
XFILLER_16_2634 VPWR VGND sg13cmos5l_decap_8
XFILLER_16_1955 VPWR VGND sg13cmos5l_decap_4
XFILLER_12_667 VPWR VGND sg13cmos5l_decap_8
XFILLER_11_133 VPWR VGND sg13cmos5l_fill_2
XFILLER_16_1988 VPWR VGND sg13cmos5l_decap_8
XFILLER_12_1819 VPWR VGND sg13cmos5l_decap_8
XFILLER_10_2244 VPWR VGND sg13cmos5l_decap_8
XFILLER_4_811 VPWR VGND sg13cmos5l_decap_8
XFILLER_10_1532 VPWR VGND sg13cmos5l_decap_8
XFILLER_14_1690 VPWR VGND sg13cmos5l_decap_8
XFILLER_4_855 VPWR VGND sg13cmos5l_decap_8
XFILLER_4_899 VPWR VGND sg13cmos5l_decap_4
XFILLER_1_2412 VPWR VGND sg13cmos5l_fill_2
XFILLER_1_2401 VPWR VGND sg13cmos5l_fill_1
XANTENNA__1131__A0 Tile_X0Y0_N1END[0] VPWR VGND sg13cmos5l_antennanp
XFILLER_5_2592 VPWR VGND sg13cmos5l_decap_8
XFILLER_1_2423 VPWR VGND sg13cmos5l_fill_1
XFILLER_15_494 VPWR VGND sg13cmos5l_fill_2
XFILLER_15_2166 VPWR VGND sg13cmos5l_fill_2
XFILLER_15_2144 VPWR VGND sg13cmos5l_decap_4
XFILLER_15_1421 VPWR VGND sg13cmos5l_decap_4
XFILLER_15_1410 VPWR VGND sg13cmos5l_fill_2
XANTENNA__1198__A0 Tile_X1Y0_N2END[3] VPWR VGND sg13cmos5l_antennanp
XFILLER_8_86 VPWR VGND sg13cmos5l_fill_1
XFILLER_15_1487 VPWR VGND sg13cmos5l_decap_8
X_0724_ Tile_X1Y0_S4BEG[9] _1188_/X VPWR VGND sg13cmos5l_buf_1
XANTENNA__0997__X Tile_X0Y0_S4BEG[6] VPWR VGND sg13cmos5l_antennanp
X_0655_ _0655_/L_HI VPWR VGND sg13cmos5l_tiehi
XFILLER_6_181 VPWR VGND sg13cmos5l_decap_4
X_0586_ _0586_/Q Tile_X0Y0_UserCLK NPU_RDATA14 _0623_/L_HI VPWR VGND sg13cmos5l_dfrbpq_1
XFILLER_6_2356 VPWR VGND sg13cmos5l_decap_8
XFILLER_6_1666 VPWR VGND sg13cmos5l_fill_2
XANTENNA__0595__D NPU_RDATA23 VPWR VGND sg13cmos5l_antennanp
XANTENNA__1122__A0 Tile_X0Y0_N4END[10] VPWR VGND sg13cmos5l_antennanp
X_1207_ _1207_/X Tile_X1Y0_N2END[4] Tile_X1Y0_N4END[12] Tile_X1Y0_NN4END[3] _0589_/Q
+ _0241_/Q _0240_/Q VPWR VGND sg13cmos5l_mux4_1
XFILLER_2_1519 VPWR VGND sg13cmos5l_fill_2
XFILLER_0_1232 VPWR VGND sg13cmos5l_fill_1
X_1138_ _1138_/X Tile_X0Y0_N1END[3] Tile_X0Y0_N2MID[7] Tile_X0Y0_N2END[0] _0603_/Q
+ _0187_/Q _0186_/Q VPWR VGND sg13cmos5l_mux4_1
X_1069_ Tile_X4Y0_SS4BEG[6] Tile_X4Y0_NN4END[9] VPWR VGND sg13cmos5l_buf_1
XANTENNA__1068__X Tile_X4Y0_SS4BEG[5] VPWR VGND sg13cmos5l_antennanp
XANTENNA__1189__A0 Tile_X1Y0_N2MID[2] VPWR VGND sg13cmos5l_antennanp
XFILLER_11_2531 VPWR VGND sg13cmos5l_decap_8
XFILLER_11_2597 VPWR VGND sg13cmos5l_decap_8
XFILLER_11_1874 VPWR VGND sg13cmos5l_decap_8
XANTENNA__0700__X Tile_X0Y0_FrameStrobe_O[13] VPWR VGND sg13cmos5l_antennanp
XFILLER_7_2109 VPWR VGND sg13cmos5l_decap_8
XFILLER_1_803 VPWR VGND sg13cmos5l_decap_8
XFILLER_5_1132 VPWR VGND sg13cmos5l_decap_8
XANTENNA__1113__A0 Tile_X0Y0_N4END[1] VPWR VGND sg13cmos5l_antennanp
XFILLER_2_2798 VPWR VGND sg13cmos5l_fill_2
XFILLER_16_258 VPWR VGND sg13cmos5l_decap_8
XFILLER_13_976 VPWR VGND sg13cmos5l_fill_1
XFILLER_16_2486 VPWR VGND sg13cmos5l_decap_8
XFILLER_16_1752 VPWR VGND sg13cmos5l_decap_8
XFILLER_12_497 VPWR VGND sg13cmos5l_decap_8
XFILLER_10_2030 VPWR VGND sg13cmos5l_decap_8
XFILLER_12_1616 VPWR VGND sg13cmos5l_decap_8
XFILLER_10_1362 VPWR VGND sg13cmos5l_decap_8
X_0440_ _0440_/Q Tile_X0Y0_FrameData[1] VGND VPWR Tile_X3Y0_FrameStrobe[0] latch
XFILLER_7_2610 VPWR VGND sg13cmos5l_decap_8
X_0371_ _0371_/Q Tile_X0Y0_FrameData[6] VGND VPWR Tile_X2Y0_FrameStrobe[1] latch
XFILLER_7_1920 VPWR VGND sg13cmos5l_fill_2
XFILLER_0_891 VPWR VGND sg13cmos5l_decap_4
XFILLER_7_2687 VPWR VGND sg13cmos5l_decap_8
XFILLER_3_2518 VPWR VGND sg13cmos5l_fill_2
XFILLER_7_1975 VPWR VGND sg13cmos5l_fill_1
XANTENNA__1104__A0 Tile_X1Y0_N4END[8] VPWR VGND sg13cmos5l_antennanp
XFILLER_1_2297 VPWR VGND sg13cmos5l_decap_8
XFILLER_15_280 VPWR VGND sg13cmos5l_decap_8
XFILLER_11_1126 VPWR VGND sg13cmos5l_decap_8
X_0707_ Tile_X1Y0_S2BEGb[0] _1171_/X VPWR VGND sg13cmos5l_buf_1
X_0638_ _0638_/L_HI VPWR VGND sg13cmos5l_tiehi
XFILLER_8_1706 VPWR VGND sg13cmos5l_decap_8
XANTENNA__0513__GATE Tile_X4Y0_FrameStrobe[0] VPWR VGND sg13cmos5l_antennanp
XANTENNA__1064__A Tile_X4Y0_NN4END[14] VPWR VGND sg13cmos5l_antennanp
X_0569_ NPU_ADDR5 Tile_X0Y0_UserCLK _1085_/X _0672_/L_HI VPWR VGND sg13cmos5l_dfrbpq_1
XFILLER_6_2153 VPWR VGND sg13cmos5l_decap_8
XFILLER_2_1327 VPWR VGND sg13cmos5l_fill_2
XFILLER_2_1349 VPWR VGND sg13cmos5l_decap_8
XANTENNA__1110__A3 Tile_X1Y0_NN4END[14] VPWR VGND sg13cmos5l_antennanp
XFILLER_14_707 VPWR VGND sg13cmos5l_decap_8
XFILLER_13_206 VPWR VGND sg13cmos5l_fill_1
XFILLER_13_217 VPWR VGND sg13cmos5l_decap_8
XFILLER_13_1947 VPWR VGND sg13cmos5l_decap_8
XFILLER_11_1671 VPWR VGND sg13cmos5l_decap_8
XFILLER_1_633 VPWR VGND sg13cmos5l_fill_2
XFILLER_0_176 VPWR VGND sg13cmos5l_fill_1
XFILLER_2_2595 VPWR VGND sg13cmos5l_decap_8
XANTENNA__1101__A3 Tile_X1Y0_NN4END[7] VPWR VGND sg13cmos5l_antennanp
XFILLER_8_210 VPWR VGND sg13cmos5l_fill_2
XFILLER_13_773 VPWR VGND sg13cmos5l_decap_8
XFILLER_8_254 VPWR VGND sg13cmos5l_decap_8
XFILLER_12_1402 VPWR VGND sg13cmos5l_decap_8
XFILLER_8_276 VPWR VGND sg13cmos5l_fill_1
XFILLER_8_265 VPWR VGND sg13cmos5l_fill_2
XANTENNA__0203__D Tile_X0Y0_FrameData[30] VPWR VGND sg13cmos5l_antennanp
XFILLER_10_1170 VPWR VGND sg13cmos5l_decap_8
XFILLER_5_972 VPWR VGND sg13cmos5l_decap_4
XFILLER_5_32 VPWR VGND sg13cmos5l_fill_1
X_0423_ _0423_/Q Tile_X0Y0_FrameData[18] VGND VPWR Tile_X3Y0_FrameStrobe[0] latch
X_0354_ _0354_/Q Tile_X0Y0_FrameData[23] VGND VPWR Tile_X2Y0_FrameStrobe[1] latch
X_0285_ _0285_/Q Tile_X0Y0_FrameData[12] VGND VPWR Tile_X1Y0_FrameStrobe[2] latch
XFILLER_3_1625 VPWR VGND sg13cmos5l_decap_8
XANTENNA__1059__A Tile_X4Y0_N4END[3] VPWR VGND sg13cmos5l_antennanp
XANTENNA__0113__D Tile_X0Y0_FrameData[8] VPWR VGND sg13cmos5l_antennanp
XFILLER_12_1980 VPWR VGND sg13cmos5l_decap_8
XANTENNA__0452__GATE Tile_X3Y0_FrameStrobe[1] VPWR VGND sg13cmos5l_antennanp
XFILLER_8_1569 VPWR VGND sg13cmos5l_fill_1
XANTENNA__0467__GATE Tile_X3Y0_FrameStrobe[1] VPWR VGND sg13cmos5l_antennanp
XFILLER_6_1260 VPWR VGND sg13cmos5l_fill_2
XFILLER_2_1113 VPWR VGND sg13cmos5l_decap_8
XANTENNA_105 Tile_X0Y0_FrameData[22] VPWR VGND sg13cmos5l_antennanp
XANTENNA__1095__A2 Tile_X3Y0_N2MID[7] VPWR VGND sg13cmos5l_antennanp
XFILLER_14_515 VPWR VGND sg13cmos5l_decap_8
XFILLER_13_2434 VPWR VGND sg13cmos5l_decap_8
XFILLER_10_732 VPWR VGND sg13cmos5l_decap_8
XANTENNA__0405__GATE Tile_X2Y0_FrameStrobe[2] VPWR VGND sg13cmos5l_antennanp
XFILLER_13_1755 VPWR VGND sg13cmos5l_decap_8
XFILLER_8_2782 VPWR VGND sg13cmos5l_fill_2
XFILLER_7_1002 VPWR VGND sg13cmos5l_fill_2
XFILLER_2_986 VPWR VGND sg13cmos5l_decap_8
XFILLER_7_1068 VPWR VGND sg13cmos5l_decap_8
XFILLER_4_2668 VPWR VGND sg13cmos5l_decap_8
XANTENNA__1086__A2 Tile_X2Y0_N2MID[6] VPWR VGND sg13cmos5l_antennanp
XANTENNA__0538__CLK Tile_X0Y0_UserCLK VPWR VGND sg13cmos5l_antennanp
X_0972_ Tile_X1Y0_FrameStrobe_O[17] Tile_X1Y0_FrameStrobe[17] VPWR VGND sg13cmos5l_buf_1
XFILLER_16_2080 VPWR VGND sg13cmos5l_decap_8
XFILLER_9_585 VPWR VGND sg13cmos5l_decap_8
XFILLER_12_1210 VPWR VGND sg13cmos5l_decap_8
XFILLER_12_1287 VPWR VGND sg13cmos5l_decap_8
X_0406_ _0406_/Q Tile_X0Y0_FrameData[3] VGND VPWR Tile_X2Y0_FrameStrobe[2] latch
X_0337_ _0337_/Q Tile_X0Y0_FrameData[8] VGND VPWR Tile_X2Y0_FrameStrobe[0] latch
XFILLER_3_2167 VPWR VGND sg13cmos5l_decap_8
XFILLER_3_1455 VPWR VGND sg13cmos5l_fill_2
X_0268_ _0268_/Q Tile_X0Y0_FrameData[29] VGND VPWR Tile_X1Y0_FrameStrobe[2] latch
X_0199_ _0199_/Q Tile_X0Y0_FrameData[18] VGND VPWR Tile_X0Y0_FrameStrobe[3] latch
XANTENNA__0108__D Tile_X0Y0_FrameData[13] VPWR VGND sg13cmos5l_antennanp
XFILLER_14_2710 VPWR VGND sg13cmos5l_decap_8
XFILLER_11_507 VPWR VGND sg13cmos5l_decap_8
XFILLER_14_2743 VPWR VGND sg13cmos5l_decap_8
XFILLER_10_2618 VPWR VGND sg13cmos5l_decap_8
XANTENNA__1076__X Tile_X4Y0_SS4BEG[13] VPWR VGND sg13cmos5l_antennanp
XANTENNA__0391__GATE Tile_X2Y0_FrameStrobe[2] VPWR VGND sg13cmos5l_antennanp
XFILLER_8_2001 VPWR VGND sg13cmos5l_decap_8
XFILLER_8_2045 VPWR VGND sg13cmos5l_fill_1
XFILLER_2_249 VPWR VGND sg13cmos5l_decap_8
XFILLER_15_835 VPWR VGND sg13cmos5l_decap_8
XANTENNA__0344__GATE Tile_X2Y0_FrameStrobe[0] VPWR VGND sg13cmos5l_antennanp
XFILLER_15_1839 VPWR VGND sg13cmos5l_decap_8
XFILLER_13_2231 VPWR VGND sg13cmos5l_decap_8
XANTENNA__1240__A2 Tile_X2Y0_NN4END[10] VPWR VGND sg13cmos5l_antennanp
XFILLER_6_522 VPWR VGND sg13cmos5l_decap_8
XFILLER_10_584 VPWR VGND sg13cmos5l_decap_8
XANTENNA__0359__GATE Tile_X2Y0_FrameStrobe[1] VPWR VGND sg13cmos5l_antennanp
XFILLER_6_599 VPWR VGND sg13cmos5l_decap_4
XFILLER_2_772 VPWR VGND sg13cmos5l_fill_1
X_1240_ _1240_/X Tile_X2Y0_N2END[5] Tile_X2Y0_N4END[5] Tile_X2Y0_NN4END[10] _0584_/Q
+ _0351_/Q _0350_/Q VPWR VGND sg13cmos5l_mux4_1
XFILLER_1_271 VPWR VGND sg13cmos5l_decap_8
X_1171_ _1171_/X Tile_X1Y0_N1END[0] Tile_X1Y0_N2MID[0] Tile_X1Y0_N2END[7] _0588_/Q
+ _0313_/Q _0312_/Q VPWR VGND sg13cmos5l_mux4_1
XFILLER_4_2443 VPWR VGND sg13cmos5l_fill_2
X_0122_ _0122_/Q Tile_X0Y0_FrameData[31] VGND VPWR Tile_X0Y0_FrameStrobe[1] latch
XFILLER_2_88 VPWR VGND sg13cmos5l_fill_1
XFILLER_4_1797 VPWR VGND sg13cmos5l_decap_4
XFILLER_4_1775 VPWR VGND sg13cmos5l_decap_8
XANTENNA_16 Tile_X0Y0_FrameData[16] VPWR VGND sg13cmos5l_antennanp
XANTENNA_27 Tile_X0Y0_FrameData[2] VPWR VGND sg13cmos5l_antennanp
XANTENNA_38 Tile_X0Y0_FrameData[4] VPWR VGND sg13cmos5l_antennanp
XFILLER_14_2039 VPWR VGND sg13cmos5l_fill_2
XANTENNA_49 Tile_X0Y0_FrameData[6] VPWR VGND sg13cmos5l_antennanp
X_0955_ Tile_X1Y0_FrameStrobe_O[0] Tile_X1Y0_FrameStrobe[0] VPWR VGND sg13cmos5l_buf_1
XANTENNA__1231__A2 Tile_X2Y0_NN4END[12] VPWR VGND sg13cmos5l_antennanp
XFILLER_9_393 VPWR VGND sg13cmos5l_fill_1
X_0886_ Tile_X2Y0_S4BEG[3] _1222_/X VPWR VGND sg13cmos5l_buf_1
XFILLER_12_1084 VPWR VGND sg13cmos5l_decap_8
XANTENNA__0598__D NPU_RDATA26 VPWR VGND sg13cmos5l_antennanp
XFILLER_9_2354 VPWR VGND sg13cmos5l_decap_8
XFILLER_5_2218 VPWR VGND sg13cmos5l_decap_4
XFILLER_9_1686 VPWR VGND sg13cmos5l_decap_8
XANTENNA__1072__A Tile_X4Y0_NN4END[6] VPWR VGND sg13cmos5l_antennanp
XFILLER_3_1230 VPWR VGND sg13cmos5l_decap_8
XFILLER_3_1274 VPWR VGND sg13cmos5l_fill_2
XANTENNA__0703__X Tile_X0Y0_FrameStrobe_O[16] VPWR VGND sg13cmos5l_antennanp
XANTENNA__1222__A2 Tile_X2Y0_NN4END[3] VPWR VGND sg13cmos5l_antennanp
XFILLER_10_2426 VPWR VGND sg13cmos5l_decap_8
XFILLER_10_1725 VPWR VGND sg13cmos5l_decap_8
XFILLER_14_1872 VPWR VGND sg13cmos5l_decap_8
XFILLER_11_64 VPWR VGND sg13cmos5l_fill_1
XFILLER_3_558 VPWR VGND sg13cmos5l_decap_8
XANTENNA__0301__D Tile_X0Y0_FrameData[28] VPWR VGND sg13cmos5l_antennanp
XFILLER_5_2730 VPWR VGND sg13cmos5l_decap_8
XFILLER_1_2605 VPWR VGND sg13cmos5l_decap_8
XANTENNA__1289__A2 Tile_X3Y0_NN4END[1] VPWR VGND sg13cmos5l_antennanp
XFILLER_8_1196 VPWR VGND sg13cmos5l_fill_2
XFILLER_15_654 VPWR VGND sg13cmos5l_decap_8
XANTENNA__0283__GATE Tile_X1Y0_FrameStrobe[2] VPWR VGND sg13cmos5l_antennanp
XFILLER_15_2315 VPWR VGND sg13cmos5l_decap_8
XFILLER_15_1603 VPWR VGND sg13cmos5l_fill_2
XANTENNA__1213__A2 Tile_X2Y0_N2END[5] VPWR VGND sg13cmos5l_antennanp
X_0740_ Tile_X1Y0_SS4BEG[9] _1204_/X VPWR VGND sg13cmos5l_buf_1
XFILLER_15_1669 VPWR VGND sg13cmos5l_decap_8
XANTENNA__0298__GATE Tile_X1Y0_FrameStrobe[3] VPWR VGND sg13cmos5l_antennanp
X_0671_ _0671_/L_HI VPWR VGND sg13cmos5l_tiehi
XANTENNA__0221__GATE Tile_X1Y0_FrameStrobe[0] VPWR VGND sg13cmos5l_antennanp
XFILLER_6_2505 VPWR VGND sg13cmos5l_decap_8
XANTENNA__0211__D Tile_X0Y0_FrameData[22] VPWR VGND sg13cmos5l_antennanp
X_1223_ _1223_/X Tile_X2Y0_N2MID[4] Tile_X2Y0_N4END[11] Tile_X2Y0_NN4END[4] _0584_/Q
+ _0385_/Q _0384_/Q VPWR VGND sg13cmos5l_mux4_1
XANTENNA__0236__GATE Tile_X1Y0_FrameStrobe[1] VPWR VGND sg13cmos5l_antennanp
XFILLER_6_1859 VPWR VGND sg13cmos5l_decap_8
XFILLER_4_2262 VPWR VGND sg13cmos5l_decap_8
XFILLER_0_2137 VPWR VGND sg13cmos5l_decap_8
X_1154_ _1154_/X Tile_X0Y0_N2MID[7] Tile_X0Y0_N4END[0] Tile_X0Y0_NN4END[15] _0597_/Q
+ _0155_/Q _0154_/Q VPWR VGND sg13cmos5l_mux4_1
XFILLER_4_1561 VPWR VGND sg13cmos5l_decap_4
XFILLER_0_1414 VPWR VGND sg13cmos5l_decap_8
X_0105_ _0105_/Q Tile_X0Y0_FrameData[16] VGND VPWR Tile_X0Y0_FrameStrobe[0] latch
X_1085_ _1085_/X Tile_X2Y0_N1END[1] Tile_X2Y0_N2MID[2] Tile_X2Y0_N2MID[5] Tile_X2Y0_N2END[2]
+ _0319_/Q _0318_/Q VPWR VGND sg13cmos5l_mux4_1
XFILLER_14_1102 VPWR VGND sg13cmos5l_decap_8
XFILLER_11_2702 VPWR VGND sg13cmos5l_decap_8
XANTENNA__1204__A2 Tile_X1Y0_NN4END[6] VPWR VGND sg13cmos5l_antennanp
X_0938_ Tile_X2Y0_FrameStrobe_O[3] Tile_X2Y0_FrameStrobe[3] VPWR VGND sg13cmos5l_buf_1
XFILLER_14_1179 VPWR VGND sg13cmos5l_decap_8
XFILLER_11_2779 VPWR VGND sg13cmos5l_decap_8
XANTENNA__1067__A Tile_X4Y0_NN4END[11] VPWR VGND sg13cmos5l_antennanp
X_0869_ Tile_X2Y0_S2BEG[2] Tile_X2Y0_N2MID[5] VPWR VGND sg13cmos5l_buf_1
XFILLER_0_528 VPWR VGND sg13cmos5l_fill_1
XANTENNA__0121__D Tile_X0Y0_FrameData[0] VPWR VGND sg13cmos5l_antennanp
XFILLER_0_539 VPWR VGND sg13cmos5l_fill_2
XANTENNA__1140__A1 Tile_X0Y0_N4END[14] VPWR VGND sg13cmos5l_antennanp
XFILLER_16_2613 VPWR VGND sg13cmos5l_decap_8
XFILLER_12_646 VPWR VGND sg13cmos5l_decap_8
XFILLER_16_1934 VPWR VGND sg13cmos5l_decap_8
XFILLER_8_639 VPWR VGND sg13cmos5l_decap_8
XFILLER_14_2381 VPWR VGND sg13cmos5l_decap_8
XFILLER_10_1511 VPWR VGND sg13cmos5l_decap_8
XFILLER_10_2223 VPWR VGND sg13cmos5l_decap_8
XFILLER_10_1599 VPWR VGND sg13cmos5l_fill_1
XFILLER_5_2571 VPWR VGND sg13cmos5l_decap_8
XANTENNA__1131__A1 Tile_X0Y0_N2MID[0] VPWR VGND sg13cmos5l_antennanp
XFILLER_1_1756 VPWR VGND sg13cmos5l_fill_1
XFILLER_15_2134 VPWR VGND sg13cmos5l_decap_4
XANTENNA__0206__D Tile_X0Y0_FrameData[27] VPWR VGND sg13cmos5l_antennanp
XFILLER_8_43 VPWR VGND sg13cmos5l_fill_2
XANTENNA__1198__A1 Tile_X1Y0_N4END[3] VPWR VGND sg13cmos5l_antennanp
XFILLER_7_650 VPWR VGND sg13cmos5l_decap_8
XFILLER_11_1308 VPWR VGND sg13cmos5l_decap_8
X_0723_ Tile_X1Y0_S4BEG[8] _1187_/X VPWR VGND sg13cmos5l_buf_1
XANTENNA__0160__GATE Tile_X0Y0_FrameStrobe[2] VPWR VGND sg13cmos5l_antennanp
X_0654_ _0654_/L_HI VPWR VGND sg13cmos5l_tiehi
XFILLER_10_2790 VPWR VGND sg13cmos5l_fill_1
X_0585_ _0585_/Q Tile_X0Y0_UserCLK NPU_RDATA13 _0651_/L_HI VPWR VGND sg13cmos5l_dfrbpq_1
XANTENNA__0175__GATE Tile_X0Y0_FrameStrobe[2] VPWR VGND sg13cmos5l_antennanp
XFILLER_6_2335 VPWR VGND sg13cmos5l_decap_8
XFILLER_6_1645 VPWR VGND sg13cmos5l_decap_8
X_1206_ _1206_/X Tile_X1Y0_N2END[3] Tile_X1Y0_N4END[11] Tile_X1Y0_NN4END[4] _0590_/Q
+ _0243_/Q _0242_/Q VPWR VGND sg13cmos5l_mux4_1
XANTENNA__1122__A1 Tile_X0Y0_N4END[11] VPWR VGND sg13cmos5l_antennanp
X_1137_ _1137_/X Tile_X0Y0_N1END[2] Tile_X0Y0_N2MID[6] Tile_X0Y0_N2END[1] _0602_/Q
+ _0189_/Q _0188_/Q VPWR VGND sg13cmos5l_mux4_1
X_1068_ Tile_X4Y0_SS4BEG[5] Tile_X4Y0_NN4END[10] VPWR VGND sg13cmos5l_buf_1
XFILLER_16_1208 VPWR VGND sg13cmos5l_decap_8
XANTENNA__0113__GATE Tile_X0Y0_FrameStrobe[0] VPWR VGND sg13cmos5l_antennanp
XFILLER_13_2808 VPWR VGND sg13cmos5l_fill_1
XANTENNA__0116__D Tile_X0Y0_FrameData[5] VPWR VGND sg13cmos5l_antennanp
XFILLER_11_2510 VPWR VGND sg13cmos5l_decap_8
XANTENNA__1189__A1 Tile_X1Y0_N4END[5] VPWR VGND sg13cmos5l_antennanp
XFILLER_5_609 VPWR VGND sg13cmos5l_decap_8
XFILLER_11_2576 VPWR VGND sg13cmos5l_decap_8
XANTENNA__0128__GATE Tile_X0Y0_FrameStrobe[1] VPWR VGND sg13cmos5l_antennanp
XFILLER_11_1853 VPWR VGND sg13cmos5l_decap_8
XFILLER_1_826 VPWR VGND sg13cmos5l_fill_1
XFILLER_1_815 VPWR VGND sg13cmos5l_decap_8
XFILLER_5_1111 VPWR VGND sg13cmos5l_decap_8
XFILLER_2_2755 VPWR VGND sg13cmos5l_fill_1
XFILLER_2_2733 VPWR VGND sg13cmos5l_decap_8
XANTENNA__1113__A1 Tile_X0Y0_N4END[2] VPWR VGND sg13cmos5l_antennanp
XFILLER_2_2766 VPWR VGND sg13cmos5l_decap_8
XFILLER_9_915 VPWR VGND sg13cmos5l_decap_4
XFILLER_16_2465 VPWR VGND sg13cmos5l_decap_8
XFILLER_16_1731 VPWR VGND sg13cmos5l_decap_8
XANTENNA__0571__CLK Tile_X0Y0_UserCLK VPWR VGND sg13cmos5l_antennanp
XFILLER_12_465 VPWR VGND sg13cmos5l_fill_1
XFILLER_10_1330 VPWR VGND sg13cmos5l_decap_8
XFILLER_4_664 VPWR VGND sg13cmos5l_decap_8
XFILLER_10_1396 VPWR VGND sg13cmos5l_decap_8
XFILLER_4_697 VPWR VGND sg13cmos5l_fill_1
XFILLER_3_185 VPWR VGND sg13cmos5l_fill_1
X_0370_ _0370_/Q Tile_X0Y0_FrameData[7] VGND VPWR Tile_X2Y0_FrameStrobe[1] latch
XFILLER_7_2666 VPWR VGND sg13cmos5l_decap_8
XFILLER_5_2390 VPWR VGND sg13cmos5l_decap_8
XFILLER_3_1818 VPWR VGND sg13cmos5l_fill_1
XANTENNA__1104__A1 Tile_X1Y0_N4END[9] VPWR VGND sg13cmos5l_antennanp
XFILLER_1_2276 VPWR VGND sg13cmos5l_decap_8
XFILLER_11_1105 VPWR VGND sg13cmos5l_decap_8
XFILLER_15_1296 VPWR VGND sg13cmos5l_decap_4
XANTENNA__0801__X Tile_X3Y0_SS4BEG[6] VPWR VGND sg13cmos5l_antennanp
X_0706_ Tile_X0Y0_FrameStrobe_O[19] Tile_X0Y0_FrameStrobe[19] VPWR VGND sg13cmos5l_buf_1
X_0637_ _0637_/L_HI VPWR VGND sg13cmos5l_tiehi
X_0568_ NPU_ADDR4 Tile_X0Y0_UserCLK _1084_/X _0673_/L_HI VPWR VGND sg13cmos5l_dfrbpq_1
XFILLER_6_2132 VPWR VGND sg13cmos5l_decap_8
X_0499_ _0499_/Q Tile_X0Y0_FrameData[6] VGND VPWR Tile_X3Y0_FrameStrobe[2] latch
XFILLER_6_1442 VPWR VGND sg13cmos5l_decap_4
XFILLER_6_1486 VPWR VGND sg13cmos5l_fill_2
XFILLER_6_1475 VPWR VGND sg13cmos5l_decap_8
XANTENNA__0594__CLK Tile_X0Y0_UserCLK VPWR VGND sg13cmos5l_antennanp
XFILLER_0_1063 VPWR VGND sg13cmos5l_fill_1
XANTENNA__1079__X Tile_X4Y0_UserCLKo VPWR VGND sg13cmos5l_antennanp
XFILLER_16_1027 VPWR VGND sg13cmos5l_decap_4
XFILLER_6_918 VPWR VGND sg13cmos5l_fill_1
XFILLER_13_2649 VPWR VGND sg13cmos5l_decap_8
XFILLER_13_1926 VPWR VGND sg13cmos5l_decap_8
XANTENNA__0711__X Tile_X1Y0_S2BEGb[4] VPWR VGND sg13cmos5l_antennanp
XFILLER_11_2384 VPWR VGND sg13cmos5l_decap_8
XFILLER_11_1650 VPWR VGND sg13cmos5l_decap_8
XFILLER_7_1217 VPWR VGND sg13cmos5l_decap_8
XFILLER_1_656 VPWR VGND sg13cmos5l_fill_2
XFILLER_1_645 VPWR VGND sg13cmos5l_decap_8
XFILLER_0_155 VPWR VGND sg13cmos5l_fill_2
XANTENNA__1098__A0 Tile_X1Y0_N4END[2] VPWR VGND sg13cmos5l_antennanp
XFILLER_2_2574 VPWR VGND sg13cmos5l_decap_8
XFILLER_13_752 VPWR VGND sg13cmos5l_decap_8
XFILLER_13_741 VPWR VGND sg13cmos5l_fill_1
XFILLER_13_730 VPWR VGND sg13cmos5l_decap_8
XFILLER_9_734 VPWR VGND sg13cmos5l_decap_8
XFILLER_16_2262 VPWR VGND sg13cmos5l_decap_8
XANTENNA__1270__A0 Tile_X3Y0_N2MID[3] VPWR VGND sg13cmos5l_antennanp
XFILLER_12_284 VPWR VGND sg13cmos5l_decap_8
XFILLER_12_2137 VPWR VGND sg13cmos5l_decap_8
XFILLER_8_288 VPWR VGND sg13cmos5l_decap_4
XFILLER_5_951 VPWR VGND sg13cmos5l_decap_8
XFILLER_12_1469 VPWR VGND sg13cmos5l_decap_8
XFILLER_9_2739 VPWR VGND sg13cmos5l_decap_8
XFILLER_5_66 VPWR VGND sg13cmos5l_fill_2
X_0422_ _0422_/Q Tile_X0Y0_FrameData[19] VGND VPWR Tile_X3Y0_FrameStrobe[0] latch
X_0353_ _0353_/Q Tile_X0Y0_FrameData[24] VGND VPWR Tile_X2Y0_FrameStrobe[1] latch
XFILLER_7_1751 VPWR VGND sg13cmos5l_decap_8
XFILLER_3_1604 VPWR VGND sg13cmos5l_decap_8
XANTENNA__1089__A0 Tile_X3Y0_N1END[1] VPWR VGND sg13cmos5l_antennanp
X_0284_ _0284_/Q Tile_X0Y0_FrameData[13] VGND VPWR Tile_X1Y0_FrameStrobe[2] latch
XFILLER_7_1784 VPWR VGND sg13cmos5l_decap_8
XFILLER_1_1383 VPWR VGND sg13cmos5l_decap_8
XFILLER_16_590 VPWR VGND sg13cmos5l_decap_8
XANTENNA__1261__A0 Tile_X3Y0_N2MID[2] VPWR VGND sg13cmos5l_antennanp
XFILLER_12_2682 VPWR VGND sg13cmos5l_decap_8
XANTENNA__1075__A Tile_X4Y0_NN4END[3] VPWR VGND sg13cmos5l_antennanp
XFILLER_8_2249 VPWR VGND sg13cmos5l_decap_8
XFILLER_8_1504 VPWR VGND sg13cmos5l_decap_8
XFILLER_8_1548 VPWR VGND sg13cmos5l_decap_8
XANTENNA_106 Tile_X0Y0_FrameData[23] VPWR VGND sg13cmos5l_antennanp
XFILLER_2_1169 VPWR VGND sg13cmos5l_decap_8
XANTENNA__0706__X Tile_X0Y0_FrameStrobe_O[19] VPWR VGND sg13cmos5l_antennanp
XANTENNA__1095__A3 Tile_X3Y0_N2END[0] VPWR VGND sg13cmos5l_antennanp
XFILLER_13_2413 VPWR VGND sg13cmos5l_decap_8
XFILLER_10_711 VPWR VGND sg13cmos5l_decap_8
XANTENNA__1252__A0 Tile_X3Y0_N1END[1] VPWR VGND sg13cmos5l_antennanp
XFILLER_14_64 VPWR VGND sg13cmos5l_fill_1
XFILLER_5_203 VPWR VGND sg13cmos5l_fill_1
XFILLER_13_1734 VPWR VGND sg13cmos5l_decap_8
XANTENNA__0304__D Tile_X0Y0_FrameData[25] VPWR VGND sg13cmos5l_antennanp
XFILLER_5_236 VPWR VGND sg13cmos5l_decap_8
XFILLER_5_258 VPWR VGND sg13cmos5l_fill_2
XFILLER_11_2181 VPWR VGND sg13cmos5l_decap_8
XFILLER_2_921 VPWR VGND sg13cmos5l_fill_2
XFILLER_1_453 VPWR VGND sg13cmos5l_fill_2
XFILLER_8_2761 VPWR VGND sg13cmos5l_decap_8
XFILLER_4_2647 VPWR VGND sg13cmos5l_decap_8
XFILLER_4_1957 VPWR VGND sg13cmos5l_fill_1
XANTENNA__1086__A3 Tile_X2Y0_N2END[1] VPWR VGND sg13cmos5l_antennanp
XFILLER_2_1692 VPWR VGND sg13cmos5l_decap_8
X_0971_ Tile_X1Y0_FrameStrobe_O[16] Tile_X1Y0_FrameStrobe[16] VPWR VGND sg13cmos5l_buf_1
XANTENNA__0512__GATE Tile_X4Y0_FrameStrobe[0] VPWR VGND sg13cmos5l_antennanp
XANTENNA__1243__A0 Tile_X2Y0_N2END[0] VPWR VGND sg13cmos5l_antennanp
XFILLER_13_593 VPWR VGND sg13cmos5l_decap_8
XFILLER_9_564 VPWR VGND sg13cmos5l_decap_8
XANTENNA__0214__D Tile_X0Y0_FrameData[19] VPWR VGND sg13cmos5l_antennanp
XFILLER_16_1391 VPWR VGND sg13cmos5l_decap_4
XFILLER_12_1266 VPWR VGND sg13cmos5l_decap_8
XFILLER_9_1835 VPWR VGND sg13cmos5l_fill_2
X_0405_ _0405_/Q Tile_X0Y0_FrameData[4] VGND VPWR Tile_X2Y0_FrameStrobe[2] latch
XFILLER_3_2102 VPWR VGND sg13cmos5l_decap_8
X_0336_ _0336_/Q Tile_X0Y0_FrameData[9] VGND VPWR Tile_X2Y0_FrameStrobe[0] latch
XFILLER_3_2146 VPWR VGND sg13cmos5l_decap_8
X_0267_ _0267_/Q Tile_X0Y0_FrameData[30] VGND VPWR Tile_X1Y0_FrameStrobe[2] latch
XFILLER_7_1592 VPWR VGND sg13cmos5l_fill_1
X_0198_ _0198_/Q Tile_X0Y0_FrameData[19] VGND VPWR Tile_X0Y0_FrameStrobe[3] latch
XFILLER_14_2722 VPWR VGND sg13cmos5l_decap_8
XANTENNA__1234__A0 Tile_X2Y0_N2MID[7] VPWR VGND sg13cmos5l_antennanp
XANTENNA__0124__D Tile_X0Y0_FrameData[29] VPWR VGND sg13cmos5l_antennanp
XFILLER_14_2799 VPWR VGND sg13cmos5l_fill_1
XANTENNA__0702__A Tile_X0Y0_FrameStrobe[15] VPWR VGND sg13cmos5l_antennanp
XFILLER_8_1334 VPWR VGND sg13cmos5l_decap_4
XFILLER_3_2680 VPWR VGND sg13cmos5l_decap_8
XFILLER_15_814 VPWR VGND sg13cmos5l_decap_8
XANTENNA__1225__A0 Tile_X2Y0_N2MID[6] VPWR VGND sg13cmos5l_antennanp
XFILLER_15_1818 VPWR VGND sg13cmos5l_decap_8
XFILLER_13_2210 VPWR VGND sg13cmos5l_decap_8
XFILLER_6_501 VPWR VGND sg13cmos5l_decap_8
XFILLER_13_1520 VPWR VGND sg13cmos5l_fill_1
XFILLER_13_2287 VPWR VGND sg13cmos5l_decap_8
XFILLER_10_563 VPWR VGND sg13cmos5l_decap_8
XFILLER_9_1109 VPWR VGND sg13cmos5l_decap_8
XFILLER_2_762 VPWR VGND sg13cmos5l_fill_1
XFILLER_1_250 VPWR VGND sg13cmos5l_decap_8
XFILLER_4_2422 VPWR VGND sg13cmos5l_decap_8
XFILLER_2_795 VPWR VGND sg13cmos5l_decap_8
XFILLER_1_294 VPWR VGND sg13cmos5l_decap_8
X_1170_ _1170_/X Tile_X0Y0_N2END[7] Tile_X0Y0_N4END[15] Tile_X0Y0_NN4END[0] _0596_/Q
+ _0123_/Q _0122_/Q VPWR VGND sg13cmos5l_mux4_1
XFILLER_8_1890 VPWR VGND sg13cmos5l_fill_2
XFILLER_2_56 VPWR VGND sg13cmos5l_fill_1
X_0121_ _0121_/Q Tile_X0Y0_FrameData[0] VGND VPWR Tile_X0Y0_FrameStrobe[0] latch
XFILLER_4_2488 VPWR VGND sg13cmos5l_decap_8
XFILLER_4_2477 VPWR VGND sg13cmos5l_decap_8
XFILLER_4_1754 VPWR VGND sg13cmos5l_decap_8
XFILLER_0_1618 VPWR VGND sg13cmos5l_fill_1
XANTENNA__0209__D Tile_X0Y0_FrameData[24] VPWR VGND sg13cmos5l_antennanp
XANTENNA__0451__GATE Tile_X3Y0_FrameStrobe[1] VPWR VGND sg13cmos5l_antennanp
XFILLER_14_2018 VPWR VGND sg13cmos5l_decap_8
XANTENNA_17 Tile_X0Y0_FrameData[16] VPWR VGND sg13cmos5l_antennanp
XANTENNA_28 Tile_X0Y0_FrameData[2] VPWR VGND sg13cmos5l_antennanp
XANTENNA_39 Tile_X0Y0_FrameData[4] VPWR VGND sg13cmos5l_antennanp
XANTENNA__1216__A0 Tile_X2Y0_N1END[1] VPWR VGND sg13cmos5l_antennanp
X_0954_ Tile_X2Y0_FrameStrobe_O[19] Tile_X2Y0_FrameStrobe[19] VPWR VGND sg13cmos5l_buf_1
X_0885_ Tile_X2Y0_S4BEG[2] _1221_/X VPWR VGND sg13cmos5l_buf_1
XANTENNA__0466__GATE Tile_X3Y0_FrameStrobe[1] VPWR VGND sg13cmos5l_antennanp
XFILLER_12_1063 VPWR VGND sg13cmos5l_decap_8
XFILLER_9_2333 VPWR VGND sg13cmos5l_decap_8
XFILLER_9_1665 VPWR VGND sg13cmos5l_decap_8
XANTENNA__0404__GATE Tile_X2Y0_FrameStrobe[2] VPWR VGND sg13cmos5l_antennanp
X_0319_ _0319_/Q Tile_X0Y0_FrameData[26] VGND VPWR Tile_X2Y0_FrameStrobe[0] latch
XANTENNA__0119__D Tile_X0Y0_FrameData[2] VPWR VGND sg13cmos5l_antennanp
XFILLER_16_2806 VPWR VGND sg13cmos5l_fill_2
XANTENNA__0419__GATE Tile_X3Y0_FrameStrobe[0] VPWR VGND sg13cmos5l_antennanp
XFILLER_11_305 VPWR VGND sg13cmos5l_decap_4
XANTENNA__1207__A0 Tile_X1Y0_N2END[4] VPWR VGND sg13cmos5l_antennanp
XFILLER_12_839 VPWR VGND sg13cmos5l_decap_4
XFILLER_10_2405 VPWR VGND sg13cmos5l_decap_8
XFILLER_14_2563 VPWR VGND sg13cmos5l_fill_2
XFILLER_14_2552 VPWR VGND sg13cmos5l_decap_8
XFILLER_14_1851 VPWR VGND sg13cmos5l_decap_8
XFILLER_10_1704 VPWR VGND sg13cmos5l_decap_8
XFILLER_10_1759 VPWR VGND sg13cmos5l_fill_1
XFILLER_3_537 VPWR VGND sg13cmos5l_decap_8
XFILLER_11_98 VPWR VGND sg13cmos5l_fill_2
XANTENNA__0528__CLK Tile_X0Y0_UserCLK VPWR VGND sg13cmos5l_antennanp
XFILLER_4_1017 VPWR VGND sg13cmos5l_decap_4
XFILLER_15_633 VPWR VGND sg13cmos5l_decap_8
X_0670_ _0670_/L_HI VPWR VGND sg13cmos5l_tiehi
XFILLER_13_2095 VPWR VGND sg13cmos5l_decap_8
XFILLER_13_2084 VPWR VGND sg13cmos5l_decap_4
XFILLER_13_1383 VPWR VGND sg13cmos5l_decap_4
XFILLER_6_397 VPWR VGND sg13cmos5l_fill_1
X_1222_ _1222_/X Tile_X2Y0_N2MID[3] Tile_X2Y0_N4END[12] Tile_X2Y0_NN4END[3] _0587_/Q
+ _0387_/Q _0386_/Q VPWR VGND sg13cmos5l_mux4_1
XFILLER_6_1816 VPWR VGND sg13cmos5l_decap_4
XFILLER_4_2241 VPWR VGND sg13cmos5l_decap_8
X_1153_ _1153_/X Tile_X0Y0_N2MID[6] Tile_X0Y0_N4END[1] Tile_X0Y0_NN4END[14] _0596_/Q
+ _0157_/Q _0156_/Q VPWR VGND sg13cmos5l_mux4_1
X_0104_ _0104_/Q Tile_X0Y0_FrameData[17] VGND VPWR Tile_X0Y0_FrameStrobe[0] latch
X_1084_ _1084_/X Tile_X2Y0_N1END[0] Tile_X2Y0_N2MID[3] Tile_X2Y0_N2MID[4] Tile_X2Y0_N2END[3]
+ _0321_/Q _0320_/Q VPWR VGND sg13cmos5l_mux4_1
XFILLER_4_1584 VPWR VGND sg13cmos5l_decap_8
XANTENNA__0390__GATE Tile_X2Y0_FrameStrobe[2] VPWR VGND sg13cmos5l_antennanp
XANTENNA__0804__X Tile_X3Y0_SS4BEG[9] VPWR VGND sg13cmos5l_antennanp
X_0937_ Tile_X2Y0_FrameStrobe_O[2] Tile_X2Y0_FrameStrobe[2] VPWR VGND sg13cmos5l_buf_1
XFILLER_14_1158 VPWR VGND sg13cmos5l_decap_8
XFILLER_11_2758 VPWR VGND sg13cmos5l_decap_8
X_0868_ Tile_X2Y0_S2BEG[1] Tile_X2Y0_N2MID[6] VPWR VGND sg13cmos5l_buf_1
XANTENNA__0402__D Tile_X0Y0_FrameData[7] VPWR VGND sg13cmos5l_antennanp
X_0799_ Tile_X3Y0_SS4BEG[4] _1279_/X VPWR VGND sg13cmos5l_buf_1
XANTENNA__0343__GATE Tile_X2Y0_FrameStrobe[0] VPWR VGND sg13cmos5l_antennanp
XANTENNA__1140__A2 Tile_X0Y0_NN4END[1] VPWR VGND sg13cmos5l_antennanp
XFILLER_16_419 VPWR VGND sg13cmos5l_decap_4
XANTENNA__0358__GATE Tile_X2Y0_FrameStrobe[1] VPWR VGND sg13cmos5l_antennanp
XFILLER_3_1094 VPWR VGND sg13cmos5l_decap_8
XFILLER_0_1993 VPWR VGND sg13cmos5l_decap_8
XFILLER_16_1913 VPWR VGND sg13cmos5l_decap_8
XFILLER_16_1902 VPWR VGND sg13cmos5l_fill_1
XFILLER_12_625 VPWR VGND sg13cmos5l_decap_8
XANTENNA__0714__X Tile_X1Y0_S2BEGb[7] VPWR VGND sg13cmos5l_antennanp
XFILLER_8_618 VPWR VGND sg13cmos5l_decap_8
XFILLER_16_2669 VPWR VGND sg13cmos5l_decap_8
XFILLER_11_135 VPWR VGND sg13cmos5l_fill_1
XFILLER_10_2202 VPWR VGND sg13cmos5l_decap_8
XFILLER_16_1968 VPWR VGND sg13cmos5l_decap_4
XFILLER_14_2360 VPWR VGND sg13cmos5l_decap_8
XFILLER_11_168 VPWR VGND sg13cmos5l_decap_8
XFILLER_10_2279 VPWR VGND sg13cmos5l_decap_8
XANTENNA__0312__D Tile_X0Y0_FrameData[17] VPWR VGND sg13cmos5l_antennanp
XFILLER_10_1578 VPWR VGND sg13cmos5l_decap_8
XFILLER_4_846 VPWR VGND sg13cmos5l_fill_2
XFILLER_3_334 VPWR VGND sg13cmos5l_decap_4
XFILLER_5_2550 VPWR VGND sg13cmos5l_decap_8
XFILLER_1_2447 VPWR VGND sg13cmos5l_decap_8
XFILLER_1_2414 VPWR VGND sg13cmos5l_fill_1
XANTENNA__1131__A2 Tile_X0Y0_N2END[7] VPWR VGND sg13cmos5l_antennanp
XFILLER_1_1735 VPWR VGND sg13cmos5l_decap_8
XFILLER_16_953 VPWR VGND sg13cmos5l_fill_2
XANTENNA__1198__A2 Tile_X1Y0_NN4END[12] VPWR VGND sg13cmos5l_antennanp
X_0722_ Tile_X1Y0_S4BEG[7] _1186_/X VPWR VGND sg13cmos5l_buf_1
XFILLER_7_684 VPWR VGND sg13cmos5l_fill_1
X_0653_ _0653_/L_HI VPWR VGND sg13cmos5l_tiehi
XANTENNA__0222__D Tile_X0Y0_FrameData[11] VPWR VGND sg13cmos5l_antennanp
X_0584_ _0584_/Q Tile_X0Y0_UserCLK NPU_RDATA12 _0652_/L_HI VPWR VGND sg13cmos5l_dfrbpq_1
XFILLER_6_2314 VPWR VGND sg13cmos5l_decap_8
XFILLER_6_1624 VPWR VGND sg13cmos5l_decap_8
X_1205_ _1205_/X Tile_X1Y0_N2END[2] Tile_X1Y0_N4END[10] Tile_X1Y0_NN4END[5] _0591_/Q
+ _0245_/Q _0244_/Q VPWR VGND sg13cmos5l_mux4_1
XFILLER_6_1668 VPWR VGND sg13cmos5l_fill_1
XFILLER_4_2082 VPWR VGND sg13cmos5l_decap_8
XANTENNA__1122__A2 Tile_X0Y0_NN4END[8] VPWR VGND sg13cmos5l_antennanp
XFILLER_0_1212 VPWR VGND sg13cmos5l_fill_1
X_1136_ _1136_/X Tile_X0Y0_N1END[1] Tile_X0Y0_N2MID[5] Tile_X0Y0_N2END[2] _0601_/Q
+ _0191_/Q _0190_/Q VPWR VGND sg13cmos5l_mux4_1
X_1067_ Tile_X4Y0_SS4BEG[4] Tile_X4Y0_NN4END[11] VPWR VGND sg13cmos5l_buf_1
XANTENNA__1078__A Tile_X4Y0_NN4END[0] VPWR VGND sg13cmos5l_antennanp
XANTENNA__1189__A2 Tile_X1Y0_NN4END[10] VPWR VGND sg13cmos5l_antennanp
XFILLER_11_1832 VPWR VGND sg13cmos5l_decap_8
XANTENNA__0132__D Tile_X0Y0_FrameData[21] VPWR VGND sg13cmos5l_antennanp
XFILLER_0_304 VPWR VGND sg13cmos5l_fill_1
XANTENNA__0282__GATE Tile_X1Y0_FrameStrobe[2] VPWR VGND sg13cmos5l_antennanp
XFILLER_9_1281 VPWR VGND sg13cmos5l_decap_8
XFILLER_9_1292 VPWR VGND sg13cmos5l_fill_2
XFILLER_2_2712 VPWR VGND sg13cmos5l_decap_8
XANTENNA__0709__X Tile_X1Y0_S2BEGb[2] VPWR VGND sg13cmos5l_antennanp
XANTENNA__0297__GATE Tile_X1Y0_FrameStrobe[2] VPWR VGND sg13cmos5l_antennanp
XANTENNA__1113__A2 Tile_X0Y0_NN4END[1] VPWR VGND sg13cmos5l_antennanp
XFILLER_5_1178 VPWR VGND sg13cmos5l_decap_8
XFILLER_16_205 VPWR VGND sg13cmos5l_decap_8
XFILLER_16_227 VPWR VGND sg13cmos5l_decap_8
XFILLER_0_2491 VPWR VGND sg13cmos5l_decap_8
XANTENNA__0220__GATE Tile_X1Y0_FrameStrobe[0] VPWR VGND sg13cmos5l_antennanp
XANTENNA__0307__D Tile_X0Y0_FrameData[22] VPWR VGND sg13cmos5l_antennanp
XFILLER_16_2444 VPWR VGND sg13cmos5l_decap_8
XFILLER_16_1710 VPWR VGND sg13cmos5l_decap_8
XFILLER_12_2319 VPWR VGND sg13cmos5l_decap_8
XFILLER_16_1787 VPWR VGND sg13cmos5l_fill_1
XANTENNA__0235__GATE Tile_X1Y0_FrameStrobe[1] VPWR VGND sg13cmos5l_antennanp
XFILLER_10_2065 VPWR VGND sg13cmos5l_decap_8
XFILLER_4_643 VPWR VGND sg13cmos5l_decap_8
XFILLER_7_2645 VPWR VGND sg13cmos5l_decap_8
XFILLER_7_1922 VPWR VGND sg13cmos5l_fill_1
XANTENNA__1104__A2 Tile_X1Y0_NN4END[8] VPWR VGND sg13cmos5l_antennanp
XFILLER_5_1690 VPWR VGND sg13cmos5l_decap_8
XFILLER_1_1521 VPWR VGND sg13cmos5l_fill_1
XFILLER_16_794 VPWR VGND sg13cmos5l_decap_4
XANTENNA__0217__D Tile_X0Y0_FrameData[16] VPWR VGND sg13cmos5l_antennanp
XFILLER_15_1242 VPWR VGND sg13cmos5l_fill_1
XFILLER_15_1275 VPWR VGND sg13cmos5l_decap_8
X_0705_ Tile_X0Y0_FrameStrobe_O[18] Tile_X0Y0_FrameStrobe[18] VPWR VGND sg13cmos5l_buf_1
X_0636_ _0636_/L_HI VPWR VGND sg13cmos5l_tiehi
X_0567_ NPU_ADDR3 Tile_X0Y0_UserCLK _1083_/X _0674_/L_HI VPWR VGND sg13cmos5l_dfrbpq_1
XFILLER_6_2111 VPWR VGND sg13cmos5l_decap_8
X_0498_ _0498_/Q Tile_X0Y0_FrameData[7] VGND VPWR Tile_X3Y0_FrameStrobe[2] latch
XFILLER_6_2188 VPWR VGND sg13cmos5l_decap_8
XFILLER_6_1498 VPWR VGND sg13cmos5l_fill_2
X_1119_ _1119_/X Tile_X0Y0_N4END[4] Tile_X0Y0_N4END[7] Tile_X0Y0_NN4END[5] Tile_X0Y0_NN4END[7]
+ _0107_/Q _0106_/Q VPWR VGND sg13cmos5l_mux4_1
XFILLER_0_1075 VPWR VGND sg13cmos5l_fill_1
XANTENNA__0127__D Tile_X0Y0_FrameData[26] VPWR VGND sg13cmos5l_antennanp
XANTENNA__0705__A Tile_X0Y0_FrameStrobe[18] VPWR VGND sg13cmos5l_antennanp
XFILLER_16_1039 VPWR VGND sg13cmos5l_fill_1
XFILLER_13_2628 VPWR VGND sg13cmos5l_decap_8
XFILLER_13_1905 VPWR VGND sg13cmos5l_decap_8
XFILLER_11_2363 VPWR VGND sg13cmos5l_decap_8
XFILLER_1_602 VPWR VGND sg13cmos5l_fill_2
XFILLER_4_2807 VPWR VGND sg13cmos5l_fill_2
XANTENNA__1098__A1 Tile_X1Y0_N4END[3] VPWR VGND sg13cmos5l_antennanp
XFILLER_2_2553 VPWR VGND sg13cmos5l_decap_8
XFILLER_16_2241 VPWR VGND sg13cmos5l_decap_8
XFILLER_12_263 VPWR VGND sg13cmos5l_decap_8
XANTENNA__0174__GATE Tile_X0Y0_FrameStrobe[2] VPWR VGND sg13cmos5l_antennanp
XANTENNA__1270__A1 Tile_X3Y0_N4END[4] VPWR VGND sg13cmos5l_antennanp
XFILLER_16_2285 VPWR VGND sg13cmos5l_fill_1
XFILLER_16_1573 VPWR VGND sg13cmos5l_decap_8
XFILLER_12_2116 VPWR VGND sg13cmos5l_decap_8
XANTENNA__0902__X Tile_X2Y0_SS4BEG[3] VPWR VGND sg13cmos5l_antennanp
XFILLER_16_1595 VPWR VGND sg13cmos5l_decap_8
XFILLER_5_941 VPWR VGND sg13cmos5l_fill_2
XFILLER_9_2718 VPWR VGND sg13cmos5l_decap_8
XANTENNA__0189__GATE Tile_X0Y0_FrameStrobe[3] VPWR VGND sg13cmos5l_antennanp
XFILLER_5_78 VPWR VGND sg13cmos5l_fill_2
X_0421_ _0421_/Q Tile_X0Y0_FrameData[20] VGND VPWR Tile_X3Y0_FrameStrobe[0] latch
XFILLER_7_2420 VPWR VGND sg13cmos5l_decap_8
XANTENNA__0500__D Tile_X0Y0_FrameData[5] VPWR VGND sg13cmos5l_antennanp
X_0352_ _0352_/Q Tile_X0Y0_FrameData[25] VGND VPWR Tile_X2Y0_FrameStrobe[1] latch
XANTENNA__0112__GATE Tile_X0Y0_FrameStrobe[0] VPWR VGND sg13cmos5l_antennanp
XFILLER_7_2486 VPWR VGND sg13cmos5l_decap_8
XFILLER_3_2339 VPWR VGND sg13cmos5l_decap_8
X_0283_ _0283_/Q Tile_X0Y0_FrameData[14] VGND VPWR Tile_X1Y0_FrameStrobe[2] latch
XANTENNA__1089__A1 Tile_X3Y0_N2MID[1] VPWR VGND sg13cmos5l_antennanp
XANTENNA__0127__GATE Tile_X0Y0_FrameStrobe[1] VPWR VGND sg13cmos5l_antennanp
XFILLER_1_1362 VPWR VGND sg13cmos5l_decap_8
XANTENNA__1261__A1 Tile_X3Y0_N4END[13] VPWR VGND sg13cmos5l_antennanp
XANTENNA__0812__X Tile_X4Y0_FrameData_O[1] VPWR VGND sg13cmos5l_antennanp
XFILLER_12_2661 VPWR VGND sg13cmos5l_decap_8
XFILLER_8_2228 VPWR VGND sg13cmos5l_decap_8
X_0619_ _0619_/L_HI VPWR VGND sg13cmos5l_tiehi
XANTENNA__0410__D Tile_X0Y0_FrameData[31] VPWR VGND sg13cmos5l_antennanp
XFILLER_8_1527 VPWR VGND sg13cmos5l_decap_8
XANTENNA__0561__CLK Tile_X0Y0_UserCLK VPWR VGND sg13cmos5l_antennanp
XFILLER_6_1262 VPWR VGND sg13cmos5l_fill_1
XANTENNA_107 Tile_X0Y0_FrameData[11] VPWR VGND sg13cmos5l_antennanp
XFILLER_2_1148 VPWR VGND sg13cmos5l_decap_8
XANTENNA__1252__A1 Tile_X3Y0_N2MID[1] VPWR VGND sg13cmos5l_antennanp
XANTENNA__0722__X Tile_X1Y0_S4BEG[7] VPWR VGND sg13cmos5l_antennanp
XFILLER_13_2469 VPWR VGND sg13cmos5l_decap_8
XFILLER_13_1713 VPWR VGND sg13cmos5l_decap_8
XFILLER_11_1481 VPWR VGND sg13cmos5l_decap_8
XFILLER_8_2740 VPWR VGND sg13cmos5l_decap_8
XANTENNA__0320__D Tile_X0Y0_FrameData[25] VPWR VGND sg13cmos5l_antennanp
XFILLER_2_999 VPWR VGND sg13cmos5l_decap_8
XFILLER_8_2784 VPWR VGND sg13cmos5l_fill_1
XFILLER_4_2626 VPWR VGND sg13cmos5l_decap_8
XFILLER_1_498 VPWR VGND sg13cmos5l_decap_8
XFILLER_4_1914 VPWR VGND sg13cmos5l_decap_8
XFILLER_2_2383 VPWR VGND sg13cmos5l_decap_8
XFILLER_2_1671 VPWR VGND sg13cmos5l_decap_8
X_0970_ Tile_X1Y0_FrameStrobe_O[15] Tile_X1Y0_FrameStrobe[15] VPWR VGND sg13cmos5l_buf_1
XANTENNA__1243__A1 Tile_X2Y0_N4END[8] VPWR VGND sg13cmos5l_antennanp
XFILLER_9_543 VPWR VGND sg13cmos5l_decap_8
XFILLER_13_572 VPWR VGND sg13cmos5l_decap_8
XFILLER_12_1245 VPWR VGND sg13cmos5l_decap_8
XFILLER_9_2515 VPWR VGND sg13cmos5l_decap_8
XANTENNA__0584__CLK Tile_X0Y0_UserCLK VPWR VGND sg13cmos5l_antennanp
XFILLER_9_1814 VPWR VGND sg13cmos5l_decap_8
XFILLER_9_2559 VPWR VGND sg13cmos5l_fill_1
XFILLER_4_270 VPWR VGND sg13cmos5l_decap_8
XANTENNA__0230__D Tile_X0Y0_FrameData[3] VPWR VGND sg13cmos5l_antennanp
X_0404_ _0404_/Q Tile_X0Y0_FrameData[5] VGND VPWR Tile_X2Y0_FrameStrobe[2] latch
X_0335_ _0335_/Q Tile_X0Y0_FrameData[10] VGND VPWR Tile_X2Y0_FrameStrobe[0] latch
XFILLER_7_2294 VPWR VGND sg13cmos5l_decap_8
XFILLER_3_2125 VPWR VGND sg13cmos5l_decap_8
X_0266_ _0266_/Q Tile_X0Y0_FrameData[31] VGND VPWR Tile_X1Y0_FrameStrobe[2] latch
XANTENNA__0807__X Tile_X3Y0_SS4BEG[12] VPWR VGND sg13cmos5l_antennanp
X_0197_ _0197_/Q Tile_X0Y0_FrameData[20] VGND VPWR Tile_X0Y0_FrameStrobe[3] latch
XANTENNA__1234__A1 Tile_X2Y0_N4END[0] VPWR VGND sg13cmos5l_antennanp
XANTENNA__0405__D Tile_X0Y0_FrameData[4] VPWR VGND sg13cmos5l_antennanp
XFILLER_14_2789 VPWR VGND sg13cmos5l_fill_2
XFILLER_14_2778 VPWR VGND sg13cmos5l_decap_8
XFILLER_3_708 VPWR VGND sg13cmos5l_decap_8
XFILLER_12_2480 VPWR VGND sg13cmos5l_decap_8
XANTENNA__0140__D Tile_X0Y0_FrameData[13] VPWR VGND sg13cmos5l_antennanp
XANTENNA__1170__A0 Tile_X0Y0_N2END[7] VPWR VGND sg13cmos5l_antennanp
XFILLER_6_1081 VPWR VGND sg13cmos5l_decap_8
XANTENNA__0717__X Tile_X1Y0_S4BEG[2] VPWR VGND sg13cmos5l_antennanp
XFILLER_14_325 VPWR VGND sg13cmos5l_fill_2
XANTENNA__1225__A1 Tile_X2Y0_N4END[9] VPWR VGND sg13cmos5l_antennanp
XANTENNA__0315__D Tile_X0Y0_FrameData[30] VPWR VGND sg13cmos5l_antennanp
XFILLER_10_542 VPWR VGND sg13cmos5l_decap_8
XFILLER_13_2266 VPWR VGND sg13cmos5l_decap_8
XFILLER_6_568 VPWR VGND sg13cmos5l_fill_2
XFILLER_6_557 VPWR VGND sg13cmos5l_decap_8
XFILLER_13_1565 VPWR VGND sg13cmos5l_decap_8
XANTENNA__1161__A0 Tile_X0Y0_N2END[6] VPWR VGND sg13cmos5l_antennanp
XFILLER_4_2456 VPWR VGND sg13cmos5l_decap_8
X_0120_ _0120_/Q Tile_X0Y0_FrameData[1] VGND VPWR Tile_X0Y0_FrameStrobe[0] latch
XFILLER_4_1733 VPWR VGND sg13cmos5l_decap_8
XANTENNA_18 Tile_X0Y0_FrameData[17] VPWR VGND sg13cmos5l_antennanp
XANTENNA_29 Tile_X0Y0_FrameData[2] VPWR VGND sg13cmos5l_antennanp
XANTENNA__1216__A1 Tile_X2Y0_N2MID[5] VPWR VGND sg13cmos5l_antennanp
XFILLER_14_881 VPWR VGND sg13cmos5l_decap_4
XANTENNA__0225__D Tile_X0Y0_FrameData[8] VPWR VGND sg13cmos5l_antennanp
X_0953_ Tile_X2Y0_FrameStrobe_O[18] Tile_X2Y0_FrameStrobe[18] VPWR VGND sg13cmos5l_buf_1
X_0884_ Tile_X2Y0_S4BEG[1] _1220_/X VPWR VGND sg13cmos5l_buf_1
XFILLER_9_2312 VPWR VGND sg13cmos5l_decap_8
XFILLER_5_2209 VPWR VGND sg13cmos5l_decap_4
XFILLER_9_1644 VPWR VGND sg13cmos5l_decap_8
XFILLER_9_2389 VPWR VGND sg13cmos5l_decap_8
XANTENNA__1152__A0 Tile_X0Y0_N2MID[5] VPWR VGND sg13cmos5l_antennanp
X_0318_ _0318_/Q Tile_X0Y0_FrameData[27] VGND VPWR Tile_X2Y0_FrameStrobe[0] latch
X_0249_ _0249_/Q Tile_X0Y0_FrameData[16] VGND VPWR Tile_X1Y0_FrameStrobe[1] latch
XFILLER_12_818 VPWR VGND sg13cmos5l_decap_8
XANTENNA__1207__A1 Tile_X1Y0_N4END[12] VPWR VGND sg13cmos5l_antennanp
XFILLER_14_2531 VPWR VGND sg13cmos5l_decap_8
XFILLER_11_317 VPWR VGND sg13cmos5l_decap_8
XANTENNA__0135__D Tile_X0Y0_FrameData[18] VPWR VGND sg13cmos5l_antennanp
XFILLER_14_1830 VPWR VGND sg13cmos5l_decap_8
XFILLER_10_1738 VPWR VGND sg13cmos5l_decap_8
XFILLER_3_516 VPWR VGND sg13cmos5l_decap_8
XFILLER_11_44 VPWR VGND sg13cmos5l_decap_4
XANTENNA__1143__A0 Tile_X0Y0_N2MID[4] VPWR VGND sg13cmos5l_antennanp
XFILLER_5_2765 VPWR VGND sg13cmos5l_decap_8
XANTENNA__0511__GATE Tile_X4Y0_FrameStrobe[0] VPWR VGND sg13cmos5l_antennanp
XFILLER_1_2629 VPWR VGND sg13cmos5l_decap_8
XFILLER_1_1928 VPWR VGND sg13cmos5l_decap_8
XFILLER_15_612 VPWR VGND sg13cmos5l_decap_8
XFILLER_14_155 VPWR VGND sg13cmos5l_decap_4
XFILLER_15_689 VPWR VGND sg13cmos5l_decap_8
XFILLER_14_177 VPWR VGND sg13cmos5l_decap_8
XFILLER_11_851 VPWR VGND sg13cmos5l_fill_2
XFILLER_7_833 VPWR VGND sg13cmos5l_fill_2
XFILLER_6_310 VPWR VGND sg13cmos5l_fill_1
XFILLER_13_2074 VPWR VGND sg13cmos5l_fill_1
XFILLER_13_2052 VPWR VGND sg13cmos5l_decap_8
XFILLER_13_1362 VPWR VGND sg13cmos5l_decap_8
XANTENNA__0910__X Tile_X2Y0_SS4BEG[11] VPWR VGND sg13cmos5l_antennanp
XFILLER_6_365 VPWR VGND sg13cmos5l_fill_1
XFILLER_2_582 VPWR VGND sg13cmos5l_decap_8
XANTENNA__1134__A0 Tile_X0Y0_N1END[3] VPWR VGND sg13cmos5l_antennanp
X_1221_ _1221_/X Tile_X2Y0_N2MID[2] Tile_X2Y0_N4END[13] Tile_X2Y0_NN4END[2] _0586_/Q
+ _0389_/Q _0388_/Q VPWR VGND sg13cmos5l_mux4_1
XFILLER_6_1839 VPWR VGND sg13cmos5l_decap_4
XFILLER_4_2220 VPWR VGND sg13cmos5l_decap_8
X_1152_ _1152_/X Tile_X0Y0_N2MID[5] Tile_X0Y0_N4END[2] Tile_X0Y0_NN4END[13] _0597_/Q
+ _0159_/Q _0158_/Q VPWR VGND sg13cmos5l_mux4_1
XFILLER_4_2297 VPWR VGND sg13cmos5l_decap_8
X_0103_ _0103_/Q Tile_X0Y0_FrameData[18] VGND VPWR Tile_X0Y0_FrameStrobe[0] latch
X_1083_ _1083_/X Tile_X2Y0_N1END[3] Tile_X2Y0_N2MID[3] Tile_X2Y0_N2MID[4] Tile_X2Y0_N2END[4]
+ _0323_/Q _0322_/Q VPWR VGND sg13cmos5l_mux4_1
X_0936_ Tile_X2Y0_FrameStrobe_O[1] Tile_X2Y0_FrameStrobe[1] VPWR VGND sg13cmos5l_buf_1
XFILLER_14_1137 VPWR VGND sg13cmos5l_decap_8
XFILLER_11_2737 VPWR VGND sg13cmos5l_decap_8
XANTENNA__0820__X Tile_X4Y0_FrameData_O[9] VPWR VGND sg13cmos5l_antennanp
X_0867_ Tile_X2Y0_S2BEG[0] Tile_X2Y0_N2MID[7] VPWR VGND sg13cmos5l_buf_1
X_0798_ Tile_X3Y0_SS4BEG[3] _1278_/X VPWR VGND sg13cmos5l_buf_1
XFILLER_0_508 VPWR VGND sg13cmos5l_fill_1
XFILLER_9_2186 VPWR VGND sg13cmos5l_decap_8
XFILLER_9_1463 VPWR VGND sg13cmos5l_decap_8
XANTENNA__1125__A0 Tile_X0Y0_N4END[13] VPWR VGND sg13cmos5l_antennanp
XFILLER_9_1485 VPWR VGND sg13cmos5l_decap_8
XFILLER_3_1073 VPWR VGND sg13cmos5l_decap_8
XFILLER_0_1983 VPWR VGND sg13cmos5l_fill_2
XFILLER_12_604 VPWR VGND sg13cmos5l_decap_8
XFILLER_16_2648 VPWR VGND sg13cmos5l_decap_8
XFILLER_11_103 VPWR VGND sg13cmos5l_decap_8
XFILLER_11_125 VPWR VGND sg13cmos5l_fill_2
XFILLER_7_118 VPWR VGND sg13cmos5l_fill_1
XFILLER_11_158 VPWR VGND sg13cmos5l_decap_8
XANTENNA__0730__X Tile_X1Y0_S4BEG[15] VPWR VGND sg13cmos5l_antennanp
XFILLER_10_2258 VPWR VGND sg13cmos5l_decap_8
XFILLER_4_825 VPWR VGND sg13cmos5l_decap_8
XFILLER_10_1546 VPWR VGND sg13cmos5l_decap_8
XFILLER_4_869 VPWR VGND sg13cmos5l_decap_4
XFILLER_3_368 VPWR VGND sg13cmos5l_decap_4
XANTENNA__0450__GATE Tile_X3Y0_FrameStrobe[1] VPWR VGND sg13cmos5l_antennanp
XANTENNA__1116__A0 Tile_X0Y0_N4END[4] VPWR VGND sg13cmos5l_antennanp
XANTENNA__0465__GATE Tile_X3Y0_FrameStrobe[1] VPWR VGND sg13cmos5l_antennanp
XFILLER_1_1714 VPWR VGND sg13cmos5l_decap_8
XFILLER_15_431 VPWR VGND sg13cmos5l_fill_2
XANTENNA__0905__X Tile_X2Y0_SS4BEG[6] VPWR VGND sg13cmos5l_antennanp
XFILLER_16_998 VPWR VGND sg13cmos5l_fill_2
XFILLER_8_45 VPWR VGND sg13cmos5l_fill_1
X_0721_ Tile_X1Y0_S4BEG[6] _1185_/X VPWR VGND sg13cmos5l_buf_1
XFILLER_15_1468 VPWR VGND sg13cmos5l_decap_8
XANTENNA__0403__GATE Tile_X2Y0_FrameStrobe[2] VPWR VGND sg13cmos5l_antennanp
XANTENNA__0503__D Tile_X0Y0_FrameData[2] VPWR VGND sg13cmos5l_antennanp
X_0652_ _0652_/L_HI VPWR VGND sg13cmos5l_tiehi
XFILLER_6_173 VPWR VGND sg13cmos5l_fill_2
X_0583_ _0583_/Q Tile_X0Y0_UserCLK NPU_RDATA11 _0653_/L_HI VPWR VGND sg13cmos5l_dfrbpq_1
XANTENNA__0418__GATE Tile_X3Y0_FrameStrobe[0] VPWR VGND sg13cmos5l_antennanp
XFILLER_6_1603 VPWR VGND sg13cmos5l_decap_8
XFILLER_2_390 VPWR VGND sg13cmos5l_decap_4
XANTENNA__1107__A0 Tile_X1Y0_N4END[8] VPWR VGND sg13cmos5l_antennanp
X_1204_ _1204_/X Tile_X1Y0_N2END[1] Tile_X1Y0_N4END[9] Tile_X1Y0_NN4END[6] _0590_/Q
+ _0247_/Q _0246_/Q VPWR VGND sg13cmos5l_mux4_1
XFILLER_4_2050 VPWR VGND sg13cmos5l_decap_8
XANTENNA__1122__A3 Tile_X0Y0_NN4END[10] VPWR VGND sg13cmos5l_antennanp
X_1135_ _1135_/X Tile_X0Y0_N1END[0] Tile_X0Y0_N2MID[4] Tile_X0Y0_N2END[3] _0600_/Q
+ _0193_/Q _0192_/Q VPWR VGND sg13cmos5l_mux4_1
XFILLER_4_2094 VPWR VGND sg13cmos5l_decap_4
X_1066_ Tile_X4Y0_SS4BEG[3] Tile_X4Y0_NN4END[12] VPWR VGND sg13cmos5l_buf_1
XANTENNA__0815__X Tile_X4Y0_FrameData_O[4] VPWR VGND sg13cmos5l_antennanp
XANTENNA__0413__D Tile_X0Y0_FrameData[28] VPWR VGND sg13cmos5l_antennanp
X_0919_ Tile_X3Y0_FrameStrobe_O[4] Tile_X3Y0_FrameStrobe[4] VPWR VGND sg13cmos5l_buf_1
XFILLER_11_1811 VPWR VGND sg13cmos5l_decap_8
XFILLER_11_1888 VPWR VGND sg13cmos5l_decap_8
XFILLER_5_1157 VPWR VGND sg13cmos5l_fill_2
XFILLER_5_1146 VPWR VGND sg13cmos5l_decap_8
XANTENNA__1113__A3 Tile_X0Y0_NN4END[3] VPWR VGND sg13cmos5l_antennanp
XFILLER_0_2470 VPWR VGND sg13cmos5l_decap_8
XANTENNA__0725__X Tile_X1Y0_S4BEG[10] VPWR VGND sg13cmos5l_antennanp
XFILLER_16_2423 VPWR VGND sg13cmos5l_decap_8
XFILLER_8_438 VPWR VGND sg13cmos5l_decap_4
XFILLER_16_1766 VPWR VGND sg13cmos5l_decap_8
XANTENNA__0323__D Tile_X0Y0_FrameData[22] VPWR VGND sg13cmos5l_antennanp
XFILLER_10_2044 VPWR VGND sg13cmos5l_decap_8
XFILLER_14_2191 VPWR VGND sg13cmos5l_decap_8
XFILLER_4_622 VPWR VGND sg13cmos5l_decap_8
XFILLER_10_1376 VPWR VGND sg13cmos5l_decap_4
XFILLER_3_132 VPWR VGND sg13cmos5l_fill_1
XFILLER_7_2624 VPWR VGND sg13cmos5l_decap_8
XFILLER_3_176 VPWR VGND sg13cmos5l_decap_8
XFILLER_0_861 VPWR VGND sg13cmos5l_decap_4
XFILLER_3_1809 VPWR VGND sg13cmos5l_fill_1
XANTENNA__1104__A3 Tile_X1Y0_NN4END[10] VPWR VGND sg13cmos5l_antennanp
XFILLER_1_2245 VPWR VGND sg13cmos5l_decap_8
XFILLER_1_2223 VPWR VGND sg13cmos5l_decap_8
XFILLER_1_1577 VPWR VGND sg13cmos5l_decap_8
XFILLER_16_773 VPWR VGND sg13cmos5l_decap_4
XFILLER_15_294 VPWR VGND sg13cmos5l_decap_8
XFILLER_15_1221 VPWR VGND sg13cmos5l_decap_8
XANTENNA__0342__GATE Tile_X2Y0_FrameStrobe[0] VPWR VGND sg13cmos5l_antennanp
XFILLER_15_1254 VPWR VGND sg13cmos5l_decap_8
XANTENNA__0233__D Tile_X0Y0_FrameData[0] VPWR VGND sg13cmos5l_antennanp
XANTENNA__0811__A Tile_X0Y0_FrameData[0] VPWR VGND sg13cmos5l_antennanp
X_0704_ Tile_X0Y0_FrameStrobe_O[17] Tile_X0Y0_FrameStrobe[17] VPWR VGND sg13cmos5l_buf_1
XFILLER_7_482 VPWR VGND sg13cmos5l_fill_2
X_0635_ _0635_/L_HI VPWR VGND sg13cmos5l_tiehi
XANTENNA__0357__GATE Tile_X2Y0_FrameStrobe[1] VPWR VGND sg13cmos5l_antennanp
X_0566_ NPU_ADDR2 Tile_X0Y0_UserCLK _1082_/X _0675_/L_HI VPWR VGND sg13cmos5l_dfrbpq_1
X_0497_ _0497_/Q Tile_X0Y0_FrameData[8] VGND VPWR Tile_X3Y0_FrameStrobe[2] latch
XFILLER_6_2167 VPWR VGND sg13cmos5l_decap_8
XFILLER_2_1308 VPWR VGND sg13cmos5l_fill_2
XFILLER_0_1054 VPWR VGND sg13cmos5l_fill_1
X_1118_ _1118_/X Tile_X0Y0_N4END[6] Tile_X0Y0_N4END[7] Tile_X0Y0_NN4END[4] Tile_X0Y0_NN4END[6]
+ _0109_/Q _0108_/Q VPWR VGND sg13cmos5l_mux4_1
XANTENNA__0408__D Tile_X0Y0_FrameData[1] VPWR VGND sg13cmos5l_antennanp
XFILLER_0_1087 VPWR VGND sg13cmos5l_fill_1
X_1049_ Tile_X4Y0_S4BEG[2] Tile_X4Y0_N4END[13] VPWR VGND sg13cmos5l_buf_1
XFILLER_13_2607 VPWR VGND sg13cmos5l_decap_8
XFILLER_10_916 VPWR VGND sg13cmos5l_decap_4
XFILLER_11_2342 VPWR VGND sg13cmos5l_decap_8
XANTENNA__0143__D Tile_X0Y0_FrameData[10] VPWR VGND sg13cmos5l_antennanp
XFILLER_11_1685 VPWR VGND sg13cmos5l_decap_8
XFILLER_0_124 VPWR VGND sg13cmos5l_decap_8
XFILLER_0_135 VPWR VGND sg13cmos5l_fill_2
XFILLER_1_669 VPWR VGND sg13cmos5l_decap_4
XFILLER_2_2532 VPWR VGND sg13cmos5l_decap_8
XANTENNA__1098__A2 Tile_X1Y0_NN4END[0] VPWR VGND sg13cmos5l_antennanp
XFILLER_2_1886 VPWR VGND sg13cmos5l_fill_2
XANTENNA__0318__D Tile_X0Y0_FrameData[27] VPWR VGND sg13cmos5l_antennanp
XFILLER_12_220 VPWR VGND sg13cmos5l_decap_8
XFILLER_9_714 VPWR VGND sg13cmos5l_fill_2
XFILLER_13_787 VPWR VGND sg13cmos5l_decap_8
XFILLER_12_242 VPWR VGND sg13cmos5l_decap_8
XANTENNA__1270__A2 Tile_X3Y0_NN4END[11] VPWR VGND sg13cmos5l_antennanp
XFILLER_16_1552 VPWR VGND sg13cmos5l_decap_8
XFILLER_12_1416 VPWR VGND sg13cmos5l_decap_8
XFILLER_5_920 VPWR VGND sg13cmos5l_decap_4
XFILLER_5_24 VPWR VGND sg13cmos5l_fill_2
XFILLER_10_1184 VPWR VGND sg13cmos5l_decap_8
XFILLER_5_68 VPWR VGND sg13cmos5l_fill_1
X_0420_ _0420_/Q Tile_X0Y0_FrameData[21] VGND VPWR Tile_X3Y0_FrameStrobe[0] latch
XFILLER_4_496 VPWR VGND sg13cmos5l_decap_8
X_0351_ _0351_/Q Tile_X0Y0_FrameData[26] VGND VPWR Tile_X2Y0_FrameStrobe[1] latch
XFILLER_7_2465 VPWR VGND sg13cmos5l_decap_8
X_0282_ _0282_/Q Tile_X0Y0_FrameData[15] VGND VPWR Tile_X1Y0_FrameStrobe[2] latch
XANTENNA__1089__A2 Tile_X3Y0_N2MID[6] VPWR VGND sg13cmos5l_antennanp
XFILLER_1_1341 VPWR VGND sg13cmos5l_decap_8
XANTENNA__0228__D Tile_X0Y0_FrameData[5] VPWR VGND sg13cmos5l_antennanp
XANTENNA__0281__GATE Tile_X1Y0_FrameStrobe[2] VPWR VGND sg13cmos5l_antennanp
XANTENNA__1261__A2 Tile_X3Y0_NN4END[2] VPWR VGND sg13cmos5l_antennanp
XFILLER_12_2640 VPWR VGND sg13cmos5l_decap_8
XANTENNA__0296__GATE Tile_X1Y0_FrameStrobe[2] VPWR VGND sg13cmos5l_antennanp
XFILLER_7_290 VPWR VGND sg13cmos5l_fill_2
XFILLER_8_2207 VPWR VGND sg13cmos5l_decap_8
XFILLER_12_1994 VPWR VGND sg13cmos5l_decap_8
X_0618_ _0618_/L_HI VPWR VGND sg13cmos5l_tiehi
X_0549_ NPU_WDATA25 Tile_X0Y0_UserCLK _1121_/X _0660_/L_HI VPWR VGND sg13cmos5l_dfrbpq_1
XANTENNA__0234__GATE Tile_X1Y0_FrameStrobe[1] VPWR VGND sg13cmos5l_antennanp
XFILLER_2_1127 VPWR VGND sg13cmos5l_decap_8
XANTENNA_108 Tile_X0Y0_FrameData[13] VPWR VGND sg13cmos5l_antennanp
XANTENNA__0138__D Tile_X0Y0_FrameData[15] VPWR VGND sg13cmos5l_antennanp
XFILLER_14_529 VPWR VGND sg13cmos5l_decap_8
XANTENNA__0249__GATE Tile_X1Y0_FrameStrobe[1] VPWR VGND sg13cmos5l_antennanp
XFILLER_14_44 VPWR VGND sg13cmos5l_decap_4
XANTENNA__1252__A2 Tile_X3Y0_N2END[6] VPWR VGND sg13cmos5l_antennanp
XFILLER_13_2448 VPWR VGND sg13cmos5l_decap_8
XFILLER_10_746 VPWR VGND sg13cmos5l_decap_8
XFILLER_6_739 VPWR VGND sg13cmos5l_decap_8
XFILLER_13_1769 VPWR VGND sg13cmos5l_decap_8
XFILLER_11_2150 VPWR VGND sg13cmos5l_fill_1
XFILLER_11_1460 VPWR VGND sg13cmos5l_decap_8
XANTENNA__0601__D NPU_RDATA29 VPWR VGND sg13cmos5l_antennanp
XFILLER_2_923 VPWR VGND sg13cmos5l_fill_1
XFILLER_2_956 VPWR VGND sg13cmos5l_fill_2
XFILLER_1_433 VPWR VGND sg13cmos5l_decap_4
XFILLER_4_2605 VPWR VGND sg13cmos5l_decap_8
XFILLER_1_455 VPWR VGND sg13cmos5l_fill_1
XFILLER_2_2362 VPWR VGND sg13cmos5l_decap_8
XFILLER_2_1650 VPWR VGND sg13cmos5l_decap_8
XANTENNA__0913__X Tile_X2Y0_SS4BEG[14] VPWR VGND sg13cmos5l_antennanp
XANTENNA__1243__A2 Tile_X2Y0_NN4END[7] VPWR VGND sg13cmos5l_antennanp
XFILLER_16_2094 VPWR VGND sg13cmos5l_decap_4
XFILLER_9_599 VPWR VGND sg13cmos5l_decap_8
XFILLER_12_1224 VPWR VGND sg13cmos5l_decap_8
XFILLER_5_772 VPWR VGND sg13cmos5l_decap_8
XANTENNA__0511__D Tile_X0Y0_FrameData[26] VPWR VGND sg13cmos5l_antennanp
X_0403_ _0403_/Q Tile_X0Y0_FrameData[6] VGND VPWR Tile_X2Y0_FrameStrobe[2] latch
XFILLER_7_2273 VPWR VGND sg13cmos5l_decap_8
X_0334_ _0334_/Q Tile_X0Y0_FrameData[11] VGND VPWR Tile_X2Y0_FrameStrobe[0] latch
X_0265_ _0265_/Q Tile_X0Y0_FrameData[0] VGND VPWR Tile_X1Y0_FrameStrobe[1] latch
X_0196_ _0196_/Q Tile_X0Y0_FrameData[21] VGND VPWR Tile_X0Y0_FrameStrobe[3] latch
XANTENNA__0823__X Tile_X4Y0_FrameData_O[12] VPWR VGND sg13cmos5l_antennanp
XANTENNA__1234__A2 Tile_X2Y0_NN4END[15] VPWR VGND sg13cmos5l_antennanp
XFILLER_14_2757 VPWR VGND sg13cmos5l_decap_8
XFILLER_2_208 VPWR VGND sg13cmos5l_fill_1
XFILLER_12_1791 VPWR VGND sg13cmos5l_decap_8
XANTENNA__0421__D Tile_X0Y0_FrameData[20] VPWR VGND sg13cmos5l_antennanp
XFILLER_8_2015 VPWR VGND sg13cmos5l_decap_4
XANTENNA__1170__A1 Tile_X0Y0_N4END[15] VPWR VGND sg13cmos5l_antennanp
XANTENNA__0173__GATE Tile_X0Y0_FrameStrobe[2] VPWR VGND sg13cmos5l_antennanp
XFILLER_6_1060 VPWR VGND sg13cmos5l_decap_8
XFILLER_14_304 VPWR VGND sg13cmos5l_decap_8
XANTENNA__0188__GATE Tile_X0Y0_FrameStrobe[3] VPWR VGND sg13cmos5l_antennanp
XFILLER_15_849 VPWR VGND sg13cmos5l_decap_8
XANTENNA__0733__X Tile_X1Y0_SS4BEG[2] VPWR VGND sg13cmos5l_antennanp
XANTENNA__1225__A2 Tile_X2Y0_NN4END[6] VPWR VGND sg13cmos5l_antennanp
XANTENNA__0111__GATE Tile_X0Y0_FrameStrobe[0] VPWR VGND sg13cmos5l_antennanp
XFILLER_13_2245 VPWR VGND sg13cmos5l_decap_8
XFILLER_13_1500 VPWR VGND sg13cmos5l_fill_2
XFILLER_10_521 VPWR VGND sg13cmos5l_decap_8
XFILLER_6_536 VPWR VGND sg13cmos5l_decap_8
XFILLER_13_1544 VPWR VGND sg13cmos5l_fill_2
XFILLER_13_1588 VPWR VGND sg13cmos5l_fill_2
XFILLER_10_598 VPWR VGND sg13cmos5l_decap_8
XANTENNA__0126__GATE Tile_X0Y0_FrameStrobe[1] VPWR VGND sg13cmos5l_antennanp
XANTENNA__0331__D Tile_X0Y0_FrameData[14] VPWR VGND sg13cmos5l_antennanp
XFILLER_2_742 VPWR VGND sg13cmos5l_fill_1
XFILLER_2_753 VPWR VGND sg13cmos5l_decap_8
XFILLER_4_2413 VPWR VGND sg13cmos5l_decap_4
XANTENNA__1161__A1 Tile_X0Y0_N4END[6] VPWR VGND sg13cmos5l_antennanp
XFILLER_8_2593 VPWR VGND sg13cmos5l_decap_8
XFILLER_4_1712 VPWR VGND sg13cmos5l_decap_8
XANTENNA__0908__X Tile_X2Y0_SS4BEG[9] VPWR VGND sg13cmos5l_antennanp
XFILLER_4_1789 VPWR VGND sg13cmos5l_decap_4
XFILLER_14_860 VPWR VGND sg13cmos5l_decap_8
XANTENNA_19 Tile_X0Y0_FrameData[17] VPWR VGND sg13cmos5l_antennanp
XANTENNA__0506__D Tile_X0Y0_FrameData[31] VPWR VGND sg13cmos5l_antennanp
XANTENNA__1216__A2 Tile_X2Y0_N2END[2] VPWR VGND sg13cmos5l_antennanp
X_0952_ Tile_X2Y0_FrameStrobe_O[17] Tile_X2Y0_FrameStrobe[17] VPWR VGND sg13cmos5l_buf_1
XANTENNA__0551__CLK Tile_X0Y0_UserCLK VPWR VGND sg13cmos5l_antennanp
X_0883_ Tile_X2Y0_S4BEG[0] _1219_/X VPWR VGND sg13cmos5l_buf_1
XANTENNA__0241__D Tile_X0Y0_FrameData[24] VPWR VGND sg13cmos5l_antennanp
XFILLER_12_1098 VPWR VGND sg13cmos5l_decap_8
XFILLER_9_1623 VPWR VGND sg13cmos5l_decap_8
XFILLER_9_2368 VPWR VGND sg13cmos5l_decap_8
XANTENNA__1152__A1 Tile_X0Y0_N4END[2] VPWR VGND sg13cmos5l_antennanp
XFILLER_7_2081 VPWR VGND sg13cmos5l_decap_8
XANTENNA__0818__X Tile_X4Y0_FrameData_O[7] VPWR VGND sg13cmos5l_antennanp
X_0317_ _0317_/Q Tile_X0Y0_FrameData[28] VGND VPWR Tile_X2Y0_FrameStrobe[0] latch
XFILLER_7_1391 VPWR VGND sg13cmos5l_fill_2
X_0248_ _0248_/Q Tile_X0Y0_FrameData[17] VGND VPWR Tile_X1Y0_FrameStrobe[1] latch
X_0179_ _0179_/Q Tile_X0Y0_FrameData[6] VGND VPWR Tile_X0Y0_FrameStrobe[2] latch
XFILLER_16_2808 VPWR VGND sg13cmos5l_fill_1
XANTENNA__0416__D Tile_X0Y0_FrameData[25] VPWR VGND sg13cmos5l_antennanp
XANTENNA__1207__A2 Tile_X1Y0_NN4END[3] VPWR VGND sg13cmos5l_antennanp
XFILLER_14_2598 VPWR VGND sg13cmos5l_decap_8
XFILLER_14_2587 VPWR VGND sg13cmos5l_fill_1
XFILLER_14_2576 VPWR VGND sg13cmos5l_decap_8
XFILLER_14_1886 VPWR VGND sg13cmos5l_decap_8
XFILLER_11_12 VPWR VGND sg13cmos5l_fill_2
XFILLER_11_56 VPWR VGND sg13cmos5l_fill_1
XFILLER_11_34 VPWR VGND sg13cmos5l_fill_2
XANTENNA__0151__D Tile_X0Y0_FrameData[2] VPWR VGND sg13cmos5l_antennanp
XFILLER_8_1133 VPWR VGND sg13cmos5l_fill_1
XFILLER_8_1122 VPWR VGND sg13cmos5l_decap_8
XFILLER_5_2711 VPWR VGND sg13cmos5l_decap_8
XFILLER_8_1144 VPWR VGND sg13cmos5l_decap_4
XFILLER_5_2744 VPWR VGND sg13cmos5l_decap_8
XANTENNA__0728__X Tile_X1Y0_S4BEG[13] VPWR VGND sg13cmos5l_antennanp
XANTENNA__1143__A1 Tile_X0Y0_N4END[11] VPWR VGND sg13cmos5l_antennanp
XFILLER_1_2619 VPWR VGND sg13cmos5l_decap_8
XANTENNA__0574__CLK Tile_X0Y0_UserCLK VPWR VGND sg13cmos5l_antennanp
XFILLER_15_668 VPWR VGND sg13cmos5l_decap_8
XANTENNA__0326__D Tile_X0Y0_FrameData[19] VPWR VGND sg13cmos5l_antennanp
XFILLER_15_2329 VPWR VGND sg13cmos5l_decap_8
XFILLER_13_2031 VPWR VGND sg13cmos5l_decap_8
XFILLER_11_830 VPWR VGND sg13cmos5l_decap_8
XFILLER_6_322 VPWR VGND sg13cmos5l_fill_1
XFILLER_13_1341 VPWR VGND sg13cmos5l_decap_8
XFILLER_10_395 VPWR VGND sg13cmos5l_fill_1
XFILLER_7_878 VPWR VGND sg13cmos5l_fill_2
XFILLER_6_2519 VPWR VGND sg13cmos5l_decap_8
XFILLER_2_561 VPWR VGND sg13cmos5l_decap_8
X_1220_ _1220_/X Tile_X2Y0_N2MID[1] Tile_X2Y0_N4END[14] Tile_X2Y0_NN4END[1] _0587_/Q
+ _0391_/Q _0390_/Q VPWR VGND sg13cmos5l_mux4_1
XANTENNA__1134__A1 Tile_X0Y0_N2MID[3] VPWR VGND sg13cmos5l_antennanp
X_1151_ _1151_/X Tile_X0Y0_N2MID[4] Tile_X0Y0_N4END[3] Tile_X0Y0_NN4END[12] _0596_/Q
+ _0161_/Q _0160_/Q VPWR VGND sg13cmos5l_mux4_1
X_0102_ _0102_/Q Tile_X0Y0_FrameData[19] VGND VPWR Tile_X0Y0_FrameStrobe[0] latch
XFILLER_4_2276 VPWR VGND sg13cmos5l_decap_8
X_1082_ _1082_/X Tile_X2Y0_N1END[2] Tile_X2Y0_N2MID[2] Tile_X2Y0_N2MID[5] Tile_X2Y0_N2END[5]
+ _0325_/Q _0324_/Q VPWR VGND sg13cmos5l_mux4_1
XANTENNA__0236__D Tile_X0Y0_FrameData[29] VPWR VGND sg13cmos5l_antennanp
XANTENNA__0814__A Tile_X0Y0_FrameData[3] VPWR VGND sg13cmos5l_antennanp
X_0935_ Tile_X2Y0_FrameStrobe_O[0] Tile_X2Y0_FrameStrobe[0] VPWR VGND sg13cmos5l_buf_1
XFILLER_14_1116 VPWR VGND sg13cmos5l_decap_8
XFILLER_11_2716 VPWR VGND sg13cmos5l_decap_8
XFILLER_9_171 VPWR VGND sg13cmos5l_decap_4
X_0866_ Tile_X2Y0_S1BEG[3] Tile_X2Y0_N1END[0] VPWR VGND sg13cmos5l_buf_1
X_0797_ Tile_X3Y0_SS4BEG[2] _1277_/X VPWR VGND sg13cmos5l_buf_1
XANTENNA__1125__A1 Tile_X0Y0_N4END[14] VPWR VGND sg13cmos5l_antennanp
XANTENNA__0597__CLK Tile_X0Y0_UserCLK VPWR VGND sg13cmos5l_antennanp
XFILLER_0_2641 VPWR VGND sg13cmos5l_fill_1
XFILLER_0_2652 VPWR VGND sg13cmos5l_fill_1
XFILLER_3_1052 VPWR VGND sg13cmos5l_decap_8
XFILLER_0_2663 VPWR VGND sg13cmos5l_fill_2
XFILLER_0_2685 VPWR VGND sg13cmos5l_fill_1
XANTENNA__0146__D Tile_X0Y0_FrameData[7] VPWR VGND sg13cmos5l_antennanp
XFILLER_16_2627 VPWR VGND sg13cmos5l_decap_8
XFILLER_16_1948 VPWR VGND sg13cmos5l_decap_8
XFILLER_11_148 VPWR VGND sg13cmos5l_fill_1
XFILLER_10_2237 VPWR VGND sg13cmos5l_decap_8
XFILLER_14_2395 VPWR VGND sg13cmos5l_decap_8
XFILLER_10_1525 VPWR VGND sg13cmos5l_decap_8
XFILLER_4_804 VPWR VGND sg13cmos5l_decap_8
XFILLER_14_1683 VPWR VGND sg13cmos5l_decap_8
XANTENNA__1116__A1 Tile_X0Y0_N4END[5] VPWR VGND sg13cmos5l_antennanp
XFILLER_5_2585 VPWR VGND sg13cmos5l_decap_8
XFILLER_1_2427 VPWR VGND sg13cmos5l_fill_2
XFILLER_1_2405 VPWR VGND sg13cmos5l_decap_8
XFILLER_5_1895 VPWR VGND sg13cmos5l_decap_8
XFILLER_15_2148 VPWR VGND sg13cmos5l_fill_1
XFILLER_15_2126 VPWR VGND sg13cmos5l_decap_4
XFILLER_15_1436 VPWR VGND sg13cmos5l_fill_1
XFILLER_15_1425 VPWR VGND sg13cmos5l_fill_1
XANTENNA__0921__X Tile_X3Y0_FrameStrobe_O[6] VPWR VGND sg13cmos5l_antennanp
X_0720_ Tile_X1Y0_S4BEG[5] _1184_/X VPWR VGND sg13cmos5l_buf_1
XFILLER_11_682 VPWR VGND sg13cmos5l_decap_8
XFILLER_7_664 VPWR VGND sg13cmos5l_decap_4
X_0651_ _0651_/L_HI VPWR VGND sg13cmos5l_tiehi
XFILLER_13_1182 VPWR VGND sg13cmos5l_decap_8
X_0582_ _0582_/Q Tile_X0Y0_UserCLK NPU_RDATA10 _0654_/L_HI VPWR VGND sg13cmos5l_dfrbpq_1
XFILLER_6_2349 VPWR VGND sg13cmos5l_decap_8
XANTENNA__1107__A1 Tile_X1Y0_N4END[11] VPWR VGND sg13cmos5l_antennanp
X_1203_ _1203_/X Tile_X1Y0_N2END[0] Tile_X1Y0_N4END[8] Tile_X1Y0_NN4END[7] _0591_/Q
+ _0249_/Q _0248_/Q VPWR VGND sg13cmos5l_mux4_1
XFILLER_6_1659 VPWR VGND sg13cmos5l_decap_8
X_1134_ _1134_/X Tile_X0Y0_N1END[3] Tile_X0Y0_N2MID[3] Tile_X0Y0_N2END[4] _0599_/Q
+ _0195_/Q _0194_/Q VPWR VGND sg13cmos5l_mux4_1
X_1065_ Tile_X4Y0_SS4BEG[2] Tile_X4Y0_NN4END[13] VPWR VGND sg13cmos5l_buf_1
XANTENNA__0510__GATE Tile_X4Y0_FrameStrobe[0] VPWR VGND sg13cmos5l_antennanp
XANTENNA__0831__X Tile_X4Y0_FrameData_O[20] VPWR VGND sg13cmos5l_antennanp
XFILLER_15_2693 VPWR VGND sg13cmos5l_decap_8
XFILLER_11_2524 VPWR VGND sg13cmos5l_decap_8
X_0918_ Tile_X3Y0_FrameStrobe_O[3] Tile_X3Y0_FrameStrobe[3] VPWR VGND sg13cmos5l_buf_1
XFILLER_11_2568 VPWR VGND sg13cmos5l_decap_4
X_0849_ Tile_X4Y0_FrameStrobe_O[6] Tile_X4Y0_FrameStrobe[6] VPWR VGND sg13cmos5l_buf_1
XFILLER_11_1867 VPWR VGND sg13cmos5l_decap_8
XFILLER_5_1125 VPWR VGND sg13cmos5l_decap_8
XFILLER_2_2747 VPWR VGND sg13cmos5l_fill_1
XFILLER_16_2402 VPWR VGND sg13cmos5l_decap_8
XANTENNA__1282__A0 Tile_X3Y0_N2END[7] VPWR VGND sg13cmos5l_antennanp
XFILLER_16_2479 VPWR VGND sg13cmos5l_decap_8
XFILLER_16_1745 VPWR VGND sg13cmos5l_decap_8
XANTENNA__0741__X Tile_X1Y0_SS4BEG[10] VPWR VGND sg13cmos5l_antennanp
XFILLER_14_2170 VPWR VGND sg13cmos5l_decap_8
XFILLER_12_1609 VPWR VGND sg13cmos5l_decap_8
XFILLER_10_2023 VPWR VGND sg13cmos5l_decap_8
XFILLER_4_601 VPWR VGND sg13cmos5l_decap_8
XFILLER_10_1344 VPWR VGND sg13cmos5l_decap_4
XFILLER_10_1355 VPWR VGND sg13cmos5l_decap_8
XFILLER_10_1388 VPWR VGND sg13cmos5l_fill_1
XFILLER_7_2603 VPWR VGND sg13cmos5l_decap_8
XFILLER_4_678 VPWR VGND sg13cmos5l_decap_4
XFILLER_7_1913 VPWR VGND sg13cmos5l_fill_1
XFILLER_7_1902 VPWR VGND sg13cmos5l_decap_8
XFILLER_0_895 VPWR VGND sg13cmos5l_fill_2
XFILLER_1_2202 VPWR VGND sg13cmos5l_decap_8
XANTENNA__0916__X Tile_X3Y0_FrameStrobe_O[1] VPWR VGND sg13cmos5l_antennanp
XFILLER_1_1512 VPWR VGND sg13cmos5l_decap_8
XFILLER_16_752 VPWR VGND sg13cmos5l_decap_8
XFILLER_15_251 VPWR VGND sg13cmos5l_decap_8
XANTENNA__1273__A0 Tile_X3Y0_N2MID[6] VPWR VGND sg13cmos5l_antennanp
XFILLER_15_273 VPWR VGND sg13cmos5l_decap_8
XANTENNA__0514__D Tile_X0Y0_FrameData[19] VPWR VGND sg13cmos5l_antennanp
XFILLER_11_1119 VPWR VGND sg13cmos5l_decap_8
X_0703_ Tile_X0Y0_FrameStrobe_O[16] Tile_X0Y0_FrameStrobe[16] VPWR VGND sg13cmos5l_buf_1
X_0634_ _0634_/L_HI VPWR VGND sg13cmos5l_tiehi
X_0565_ NPU_ADDR1 Tile_X0Y0_UserCLK _1081_/X _0676_/L_HI VPWR VGND sg13cmos5l_dfrbpq_1
X_0496_ _0496_/Q Tile_X0Y0_FrameData[9] VGND VPWR Tile_X3Y0_FrameStrobe[2] latch
XFILLER_6_2146 VPWR VGND sg13cmos5l_decap_8
XFILLER_0_1000 VPWR VGND sg13cmos5l_fill_2
X_1117_ _1117_/X Tile_X0Y0_N4END[5] Tile_X0Y0_N4END[6] Tile_X0Y0_NN4END[5] Tile_X0Y0_NN4END[7]
+ _0111_/Q _0110_/Q VPWR VGND sg13cmos5l_mux4_1
XANTENNA__0826__X Tile_X4Y0_FrameData_O[15] VPWR VGND sg13cmos5l_antennanp
XFILLER_0_1022 VPWR VGND sg13cmos5l_fill_1
XFILLER_0_1044 VPWR VGND sg13cmos5l_decap_8
X_1048_ Tile_X4Y0_S4BEG[1] Tile_X4Y0_N4END[14] VPWR VGND sg13cmos5l_buf_1
XANTENNA__1264__A0 Tile_X3Y0_N2MID[5] VPWR VGND sg13cmos5l_antennanp
XANTENNA__0424__D Tile_X0Y0_FrameData[17] VPWR VGND sg13cmos5l_antennanp
XFILLER_11_2321 VPWR VGND sg13cmos5l_decap_8
XANTENNA__0464__GATE Tile_X3Y0_FrameStrobe[1] VPWR VGND sg13cmos5l_antennanp
XFILLER_11_2398 VPWR VGND sg13cmos5l_decap_8
XFILLER_11_1664 VPWR VGND sg13cmos5l_decap_8
XFILLER_1_604 VPWR VGND sg13cmos5l_fill_1
XANTENNA__0479__GATE Tile_X3Y0_FrameStrobe[2] VPWR VGND sg13cmos5l_antennanp
XFILLER_0_169 VPWR VGND sg13cmos5l_decap_8
XFILLER_2_2511 VPWR VGND sg13cmos5l_decap_8
XANTENNA__0402__GATE Tile_X2Y0_FrameStrobe[2] VPWR VGND sg13cmos5l_antennanp
XANTENNA__1098__A3 Tile_X1Y0_NN4END[2] VPWR VGND sg13cmos5l_antennanp
XFILLER_2_2588 VPWR VGND sg13cmos5l_decap_8
XANTENNA__0736__X Tile_X1Y0_SS4BEG[5] VPWR VGND sg13cmos5l_antennanp
XANTENNA__1255__A0 Tile_X3Y0_N1END[0] VPWR VGND sg13cmos5l_antennanp
XFILLER_16_2210 VPWR VGND sg13cmos5l_fill_2
XANTENNA__0417__GATE Tile_X3Y0_FrameStrobe[0] VPWR VGND sg13cmos5l_antennanp
XFILLER_9_704 VPWR VGND sg13cmos5l_fill_2
XFILLER_8_203 VPWR VGND sg13cmos5l_decap_8
XFILLER_13_766 VPWR VGND sg13cmos5l_decap_8
XANTENNA__0334__D Tile_X0Y0_FrameData[11] VPWR VGND sg13cmos5l_antennanp
XFILLER_9_748 VPWR VGND sg13cmos5l_fill_1
XFILLER_16_2276 VPWR VGND sg13cmos5l_fill_2
XFILLER_8_247 VPWR VGND sg13cmos5l_decap_8
XFILLER_12_298 VPWR VGND sg13cmos5l_decap_8
XFILLER_5_976 VPWR VGND sg13cmos5l_fill_2
XFILLER_5_965 VPWR VGND sg13cmos5l_decap_8
XFILLER_5_943 VPWR VGND sg13cmos5l_fill_1
XFILLER_10_1163 VPWR VGND sg13cmos5l_decap_8
X_0350_ _0350_/Q Tile_X0Y0_FrameData[27] VGND VPWR Tile_X2Y0_FrameStrobe[1] latch
X_0281_ _0281_/Q Tile_X0Y0_FrameData[16] VGND VPWR Tile_X1Y0_FrameStrobe[2] latch
XFILLER_7_1798 VPWR VGND sg13cmos5l_decap_8
XFILLER_3_1618 VPWR VGND sg13cmos5l_decap_8
XFILLER_1_2010 VPWR VGND sg13cmos5l_fill_2
XANTENNA__0509__D Tile_X0Y0_FrameData[28] VPWR VGND sg13cmos5l_antennanp
XANTENNA__1089__A3 Tile_X3Y0_N2END[6] VPWR VGND sg13cmos5l_antennanp
XANTENNA__1246__A0 Tile_X2Y0_N2END[3] VPWR VGND sg13cmos5l_antennanp
XFILLER_1_1397 VPWR VGND sg13cmos5l_fill_2
XANTENNA__0244__D Tile_X0Y0_FrameData[21] VPWR VGND sg13cmos5l_antennanp
XANTENNA__0822__A Tile_X0Y0_FrameData[11] VPWR VGND sg13cmos5l_antennanp
XFILLER_8_770 VPWR VGND sg13cmos5l_fill_2
XFILLER_12_2696 VPWR VGND sg13cmos5l_decap_8
XFILLER_12_1973 VPWR VGND sg13cmos5l_decap_8
X_0617_ _0617_/L_HI VPWR VGND sg13cmos5l_tiehi
X_0548_ NPU_WDATA24 Tile_X0Y0_UserCLK _1120_/X _0661_/L_HI VPWR VGND sg13cmos5l_dfrbpq_1
X_0479_ _0479_/Q Tile_X0Y0_FrameData[26] VGND VPWR Tile_X3Y0_FrameStrobe[2] latch
XFILLER_6_1242 VPWR VGND sg13cmos5l_decap_8
XFILLER_2_1106 VPWR VGND sg13cmos5l_decap_8
XANTENNA_109 Tile_X0Y0_FrameData[19] VPWR VGND sg13cmos5l_antennanp
XANTENNA__0419__D Tile_X0Y0_FrameData[22] VPWR VGND sg13cmos5l_antennanp
XFILLER_14_508 VPWR VGND sg13cmos5l_fill_2
XANTENNA__1237__A0 Tile_X2Y0_N2END[2] VPWR VGND sg13cmos5l_antennanp
XANTENNA__0154__D Tile_X0Y0_FrameData[31] VPWR VGND sg13cmos5l_antennanp
XFILLER_13_2427 VPWR VGND sg13cmos5l_decap_8
XFILLER_10_725 VPWR VGND sg13cmos5l_decap_8
XFILLER_6_729 VPWR VGND sg13cmos5l_fill_1
XFILLER_13_1748 VPWR VGND sg13cmos5l_decap_8
XFILLER_11_2195 VPWR VGND sg13cmos5l_decap_8
XFILLER_8_2775 VPWR VGND sg13cmos5l_decap_8
XANTENNA__0341__GATE Tile_X2Y0_FrameStrobe[0] VPWR VGND sg13cmos5l_antennanp
XFILLER_2_2330 VPWR VGND sg13cmos5l_fill_1
XANTENNA__0329__D Tile_X0Y0_FrameData[16] VPWR VGND sg13cmos5l_antennanp
XANTENNA__0356__GATE Tile_X2Y0_FrameStrobe[1] VPWR VGND sg13cmos5l_antennanp
XANTENNA__1228__A0 Tile_X2Y0_N2MID[1] VPWR VGND sg13cmos5l_antennanp
XFILLER_16_2073 VPWR VGND sg13cmos5l_decap_8
XFILLER_9_578 VPWR VGND sg13cmos5l_decap_8
XFILLER_16_1372 VPWR VGND sg13cmos5l_decap_8
XFILLER_12_1203 VPWR VGND sg13cmos5l_decap_8
X_0402_ _0402_/Q Tile_X0Y0_FrameData[7] VGND VPWR Tile_X2Y0_FrameStrobe[2] latch
XFILLER_7_2252 VPWR VGND sg13cmos5l_decap_8
XANTENNA__0309__GATE Tile_X1Y0_FrameStrobe[3] VPWR VGND sg13cmos5l_antennanp
X_0333_ _0333_/Q Tile_X0Y0_FrameData[12] VGND VPWR Tile_X2Y0_FrameStrobe[0] latch
XFILLER_7_1573 VPWR VGND sg13cmos5l_fill_2
XFILLER_7_1562 VPWR VGND sg13cmos5l_decap_8
X_0264_ _0264_/Q Tile_X0Y0_FrameData[1] VGND VPWR Tile_X1Y0_FrameStrobe[1] latch
XFILLER_3_1426 VPWR VGND sg13cmos5l_fill_1
XANTENNA__0239__D Tile_X0Y0_FrameData[26] VPWR VGND sg13cmos5l_antennanp
XANTENNA__0817__A Tile_X0Y0_FrameData[6] VPWR VGND sg13cmos5l_antennanp
X_0195_ _0195_/Q Tile_X0Y0_FrameData[22] VGND VPWR Tile_X0Y0_FrameStrobe[3] latch
XFILLER_1_1150 VPWR VGND sg13cmos5l_decap_8
XANTENNA__1219__A0 Tile_X2Y0_N2MID[0] VPWR VGND sg13cmos5l_antennanp
XFILLER_14_2703 VPWR VGND sg13cmos5l_decap_8
XFILLER_14_2736 VPWR VGND sg13cmos5l_decap_8
XANTENNA__1000__X Tile_X0Y0_S4BEG[9] VPWR VGND sg13cmos5l_antennanp
XFILLER_12_1770 VPWR VGND sg13cmos5l_decap_8
XFILLER_8_1359 VPWR VGND sg13cmos5l_decap_4
XANTENNA__1170__A2 Tile_X0Y0_NN4END[0] VPWR VGND sg13cmos5l_antennanp
XANTENNA__0149__D Tile_X0Y0_FrameData[4] VPWR VGND sg13cmos5l_antennanp
XFILLER_3_2694 VPWR VGND sg13cmos5l_decap_8
XFILLER_3_1982 VPWR VGND sg13cmos5l_decap_4
XFILLER_15_828 VPWR VGND sg13cmos5l_decap_8
XFILLER_10_500 VPWR VGND sg13cmos5l_decap_8
XFILLER_13_2224 VPWR VGND sg13cmos5l_decap_8
XFILLER_6_515 VPWR VGND sg13cmos5l_decap_8
XFILLER_10_577 VPWR VGND sg13cmos5l_decap_8
XFILLER_13_1578 VPWR VGND sg13cmos5l_fill_2
XFILLER_2_710 VPWR VGND sg13cmos5l_fill_1
XFILLER_11_1280 VPWR VGND sg13cmos5l_decap_8
XFILLER_8_2572 VPWR VGND sg13cmos5l_decap_8
XFILLER_2_15 VPWR VGND sg13cmos5l_fill_1
XFILLER_1_264 VPWR VGND sg13cmos5l_decap_8
XANTENNA__0280__GATE Tile_X1Y0_FrameStrobe[2] VPWR VGND sg13cmos5l_antennanp
XFILLER_4_2436 VPWR VGND sg13cmos5l_decap_8
XANTENNA__1161__A2 Tile_X0Y0_NN4END[9] VPWR VGND sg13cmos5l_antennanp
XFILLER_4_1768 VPWR VGND sg13cmos5l_decap_8
XANTENNA__0295__GATE Tile_X1Y0_FrameStrobe[2] VPWR VGND sg13cmos5l_antennanp
XFILLER_2_2193 VPWR VGND sg13cmos5l_decap_8
XANTENNA__0924__X Tile_X3Y0_FrameStrobe_O[9] VPWR VGND sg13cmos5l_antennanp
X_0951_ Tile_X2Y0_FrameStrobe_O[16] Tile_X2Y0_FrameStrobe[16] VPWR VGND sg13cmos5l_buf_1
XFILLER_14_894 VPWR VGND sg13cmos5l_fill_2
X_0882_ Tile_X2Y0_S2BEGb[7] _1218_/X VPWR VGND sg13cmos5l_buf_1
XANTENNA__0233__GATE Tile_X1Y0_FrameStrobe[0] VPWR VGND sg13cmos5l_antennanp
XFILLER_12_1077 VPWR VGND sg13cmos5l_decap_8
XFILLER_5_581 VPWR VGND sg13cmos5l_decap_8
XFILLER_9_1602 VPWR VGND sg13cmos5l_decap_8
XFILLER_9_2347 VPWR VGND sg13cmos5l_decap_8
XANTENNA__0248__GATE Tile_X1Y0_FrameStrobe[1] VPWR VGND sg13cmos5l_antennanp
XFILLER_9_1679 VPWR VGND sg13cmos5l_decap_8
XANTENNA__1152__A2 Tile_X0Y0_NN4END[13] VPWR VGND sg13cmos5l_antennanp
X_0316_ _0316_/Q Tile_X0Y0_FrameData[29] VGND VPWR Tile_X2Y0_FrameStrobe[0] latch
XFILLER_3_1223 VPWR VGND sg13cmos5l_decap_8
X_0247_ _0247_/Q Tile_X0Y0_FrameData[18] VGND VPWR Tile_X1Y0_FrameStrobe[1] latch
XFILLER_3_1267 VPWR VGND sg13cmos5l_decap_8
X_0178_ _0178_/Q Tile_X0Y0_FrameData[7] VGND VPWR Tile_X0Y0_FrameStrobe[2] latch
XANTENNA__0834__X Tile_X4Y0_FrameData_O[23] VPWR VGND sg13cmos5l_antennanp
XFILLER_14_2500 VPWR VGND sg13cmos5l_decap_8
XFILLER_10_2419 VPWR VGND sg13cmos5l_decap_8
XFILLER_10_1718 VPWR VGND sg13cmos5l_decap_8
XFILLER_14_1865 VPWR VGND sg13cmos5l_decap_8
XANTENNA__0432__D Tile_X0Y0_FrameData[9] VPWR VGND sg13cmos5l_antennanp
XFILLER_8_1101 VPWR VGND sg13cmos5l_decap_8
XFILLER_5_2723 VPWR VGND sg13cmos5l_decap_8
XANTENNA__1143__A2 Tile_X0Y0_NN4END[4] VPWR VGND sg13cmos5l_antennanp
XFILLER_3_1790 VPWR VGND sg13cmos5l_fill_2
XANTENNA__0744__X Tile_X1Y0_SS4BEG[13] VPWR VGND sg13cmos5l_antennanp
XFILLER_15_647 VPWR VGND sg13cmos5l_decap_8
XFILLER_15_2308 VPWR VGND sg13cmos5l_decap_8
XFILLER_13_2010 VPWR VGND sg13cmos5l_decap_8
XFILLER_6_301 VPWR VGND sg13cmos5l_decap_8
XFILLER_13_1320 VPWR VGND sg13cmos5l_decap_8
XFILLER_10_341 VPWR VGND sg13cmos5l_fill_1
XFILLER_7_846 VPWR VGND sg13cmos5l_decap_4
XFILLER_11_897 VPWR VGND sg13cmos5l_fill_1
XANTENNA__0342__D Tile_X0Y0_FrameData[3] VPWR VGND sg13cmos5l_antennanp
XANTENNA__0920__A Tile_X3Y0_FrameStrobe[5] VPWR VGND sg13cmos5l_antennanp
XFILLER_2_540 VPWR VGND sg13cmos5l_decap_8
XANTENNA__0919__X Tile_X3Y0_FrameStrobe_O[4] VPWR VGND sg13cmos5l_antennanp
XANTENNA__1134__A2 Tile_X0Y0_N2END[4] VPWR VGND sg13cmos5l_antennanp
X_1150_ _1150_/X Tile_X0Y0_N2MID[3] Tile_X0Y0_N4END[4] Tile_X0Y0_NN4END[11] _0599_/Q
+ _0163_/Q _0162_/Q VPWR VGND sg13cmos5l_mux4_1
XFILLER_4_2255 VPWR VGND sg13cmos5l_decap_8
X_0101_ _0101_/Q Tile_X0Y0_FrameData[20] VGND VPWR Tile_X0Y0_FrameStrobe[0] latch
X_1081_ _1081_/X Tile_X2Y0_N1END[1] Tile_X2Y0_N2MID[1] Tile_X2Y0_N2MID[6] Tile_X2Y0_N2END[6]
+ _0327_/Q _0326_/Q VPWR VGND sg13cmos5l_mux4_1
XFILLER_4_1565 VPWR VGND sg13cmos5l_fill_2
XANTENNA__0517__D Tile_X0Y0_FrameData[22] VPWR VGND sg13cmos5l_antennanp
X_0934_ Tile_X3Y0_FrameStrobe_O[19] Tile_X3Y0_FrameStrobe[19] VPWR VGND sg13cmos5l_buf_1
XANTENNA__0172__GATE Tile_X0Y0_FrameStrobe[2] VPWR VGND sg13cmos5l_antennanp
XFILLER_9_194 VPWR VGND sg13cmos5l_fill_1
X_0865_ Tile_X2Y0_S1BEG[2] Tile_X2Y0_N1END[1] VPWR VGND sg13cmos5l_buf_1
XANTENNA__0252__D Tile_X0Y0_FrameData[13] VPWR VGND sg13cmos5l_antennanp
XANTENNA__0830__A Tile_X0Y0_FrameData[19] VPWR VGND sg13cmos5l_antennanp
X_0796_ Tile_X3Y0_SS4BEG[1] _1276_/X VPWR VGND sg13cmos5l_buf_1
XANTENNA__0187__GATE Tile_X0Y0_FrameStrobe[3] VPWR VGND sg13cmos5l_antennanp
XFILLER_9_1421 VPWR VGND sg13cmos5l_decap_8
XFILLER_9_2144 VPWR VGND sg13cmos5l_decap_8
XANTENNA__0829__X Tile_X4Y0_FrameData_O[18] VPWR VGND sg13cmos5l_antennanp
XANTENNA__1125__A2 Tile_X0Y0_NN4END[13] VPWR VGND sg13cmos5l_antennanp
XANTENNA__0110__GATE Tile_X0Y0_FrameStrobe[0] VPWR VGND sg13cmos5l_antennanp
X_1279_ _1279_/X Tile_X3Y0_N2END[4] Tile_X3Y0_N4END[4] Tile_X3Y0_NN4END[11] _0577_/Q
+ _0449_/Q _0448_/Q VPWR VGND sg13cmos5l_mux4_1
XFILLER_0_2675 VPWR VGND sg13cmos5l_fill_1
XANTENNA__0125__GATE Tile_X0Y0_FrameStrobe[1] VPWR VGND sg13cmos5l_antennanp
XANTENNA__0427__D Tile_X0Y0_FrameData[14] VPWR VGND sg13cmos5l_antennanp
XFILLER_16_2606 VPWR VGND sg13cmos5l_decap_8
XFILLER_0_1985 VPWR VGND sg13cmos5l_fill_1
XFILLER_16_1927 VPWR VGND sg13cmos5l_decap_4
XFILLER_12_639 VPWR VGND sg13cmos5l_decap_8
XFILLER_14_2341 VPWR VGND sg13cmos5l_fill_1
XFILLER_10_2216 VPWR VGND sg13cmos5l_decap_8
XFILLER_14_2374 VPWR VGND sg13cmos5l_decap_8
XANTENNA__0162__D Tile_X0Y0_FrameData[23] VPWR VGND sg13cmos5l_antennanp
XFILLER_14_1662 VPWR VGND sg13cmos5l_decap_8
XANTENNA__0739__X Tile_X1Y0_SS4BEG[8] VPWR VGND sg13cmos5l_antennanp
XANTENNA__1116__A2 Tile_X0Y0_NN4END[4] VPWR VGND sg13cmos5l_antennanp
XFILLER_5_2564 VPWR VGND sg13cmos5l_decap_8
XANTENNA__0541__CLK Tile_X0Y0_UserCLK VPWR VGND sg13cmos5l_antennanp
XFILLER_5_1841 VPWR VGND sg13cmos5l_decap_4
XANTENNA__0337__D Tile_X0Y0_FrameData[8] VPWR VGND sg13cmos5l_antennanp
XANTENNA__0915__A Tile_X3Y0_FrameStrobe[0] VPWR VGND sg13cmos5l_antennanp
XFILLER_15_2138 VPWR VGND sg13cmos5l_fill_2
XFILLER_8_36 VPWR VGND sg13cmos5l_fill_1
XFILLER_7_643 VPWR VGND sg13cmos5l_decap_8
XFILLER_11_694 VPWR VGND sg13cmos5l_fill_2
XFILLER_11_661 VPWR VGND sg13cmos5l_decap_8
XFILLER_10_182 VPWR VGND sg13cmos5l_decap_4
XFILLER_6_153 VPWR VGND sg13cmos5l_fill_2
XFILLER_13_1161 VPWR VGND sg13cmos5l_decap_8
X_0650_ _0650_/L_HI VPWR VGND sg13cmos5l_tiehi
XFILLER_7_698 VPWR VGND sg13cmos5l_fill_2
XFILLER_6_164 VPWR VGND sg13cmos5l_fill_2
XFILLER_10_2772 VPWR VGND sg13cmos5l_decap_8
X_0581_ _0581_/Q Tile_X0Y0_UserCLK NPU_RDATA9 _0655_/L_HI VPWR VGND sg13cmos5l_dfrbpq_1
XFILLER_6_2328 VPWR VGND sg13cmos5l_decap_8
XANTENNA__1107__A2 Tile_X1Y0_NN4END[9] VPWR VGND sg13cmos5l_antennanp
X_1202_ _1202_/X Tile_X1Y0_N2END[7] Tile_X1Y0_N4END[7] Tile_X1Y0_NN4END[8] _0592_/Q
+ _0251_/Q _0250_/Q VPWR VGND sg13cmos5l_mux4_1
XFILLER_6_1638 VPWR VGND sg13cmos5l_decap_8
X_1133_ _1133_/X Tile_X0Y0_N1END[2] Tile_X0Y0_N2MID[2] Tile_X0Y0_N2END[5] _0598_/Q
+ _0197_/Q _0196_/Q VPWR VGND sg13cmos5l_mux4_1
X_1064_ Tile_X4Y0_SS4BEG[1] Tile_X4Y0_NN4END[14] VPWR VGND sg13cmos5l_buf_1
XANTENNA__0247__D Tile_X0Y0_FrameData[18] VPWR VGND sg13cmos5l_antennanp
XANTENNA__0825__A Tile_X0Y0_FrameData[14] VPWR VGND sg13cmos5l_antennanp
XFILLER_15_2672 VPWR VGND sg13cmos5l_decap_8
XFILLER_11_2503 VPWR VGND sg13cmos5l_decap_8
X_0917_ Tile_X3Y0_FrameStrobe_O[2] Tile_X3Y0_FrameStrobe[2] VPWR VGND sg13cmos5l_buf_1
XFILLER_15_1971 VPWR VGND sg13cmos5l_decap_8
X_0848_ Tile_X4Y0_FrameStrobe_O[5] Tile_X4Y0_FrameStrobe[5] VPWR VGND sg13cmos5l_buf_1
XFILLER_11_1846 VPWR VGND sg13cmos5l_decap_8
X_0779_ Tile_X3Y0_S4BEG[0] _1259_/X VPWR VGND sg13cmos5l_buf_1
XANTENNA__0564__CLK Tile_X0Y0_UserCLK VPWR VGND sg13cmos5l_antennanp
XFILLER_9_1273 VPWR VGND sg13cmos5l_fill_2
XFILLER_5_1104 VPWR VGND sg13cmos5l_decap_8
XFILLER_2_2726 VPWR VGND sg13cmos5l_decap_8
XFILLER_2_2759 VPWR VGND sg13cmos5l_decap_8
XFILLER_16_219 VPWR VGND sg13cmos5l_decap_4
XANTENNA__0157__D Tile_X0Y0_FrameData[28] VPWR VGND sg13cmos5l_antennanp
XANTENNA__1282__A1 Tile_X3Y0_N4END[7] VPWR VGND sg13cmos5l_antennanp
XFILLER_13_948 VPWR VGND sg13cmos5l_fill_1
XFILLER_9_919 VPWR VGND sg13cmos5l_fill_2
XFILLER_16_2458 VPWR VGND sg13cmos5l_decap_8
XFILLER_16_1724 VPWR VGND sg13cmos5l_decap_8
XFILLER_10_1323 VPWR VGND sg13cmos5l_decap_8
XFILLER_3_101 VPWR VGND sg13cmos5l_fill_2
XFILLER_4_657 VPWR VGND sg13cmos5l_decap_8
XFILLER_7_2659 VPWR VGND sg13cmos5l_decap_8
XFILLER_5_2383 VPWR VGND sg13cmos5l_decap_8
XFILLER_1_2269 VPWR VGND sg13cmos5l_decap_8
XFILLER_16_731 VPWR VGND sg13cmos5l_decap_8
XANTENNA__1273__A1 Tile_X3Y0_N4END[1] VPWR VGND sg13cmos5l_antennanp
XANTENNA__0932__X Tile_X3Y0_FrameStrobe_O[17] VPWR VGND sg13cmos5l_antennanp
XFILLER_15_1289 VPWR VGND sg13cmos5l_decap_8
X_0702_ Tile_X0Y0_FrameStrobe_O[15] Tile_X0Y0_FrameStrobe[15] VPWR VGND sg13cmos5l_buf_1
XANTENNA__0587__CLK Tile_X0Y0_UserCLK VPWR VGND sg13cmos5l_antennanp
X_0633_ _0633_/L_HI VPWR VGND sg13cmos5l_tiehi
X_0564_ NPU_ADDR0 Tile_X0Y0_UserCLK _1080_/X _0677_/L_HI VPWR VGND sg13cmos5l_dfrbpq_1
XFILLER_6_2125 VPWR VGND sg13cmos5l_decap_8
X_0495_ _0495_/Q Tile_X0Y0_FrameData[10] VGND VPWR Tile_X3Y0_FrameStrobe[2] latch
XFILLER_6_1446 VPWR VGND sg13cmos5l_fill_1
X_1116_ _1116_/X Tile_X0Y0_N4END[4] Tile_X0Y0_N4END[5] Tile_X0Y0_NN4END[4] Tile_X0Y0_NN4END[6]
+ _0113_/Q _0112_/Q VPWR VGND sg13cmos5l_mux4_1
XANTENNA__1003__X Tile_X0Y0_S4BEG[12] VPWR VGND sg13cmos5l_antennanp
XFILLER_0_1067 VPWR VGND sg13cmos5l_fill_1
X_1047_ Tile_X4Y0_S4BEG[0] Tile_X4Y0_N4END[15] VPWR VGND sg13cmos5l_buf_1
XANTENNA__1264__A1 Tile_X3Y0_N4END[10] VPWR VGND sg13cmos5l_antennanp
XANTENNA__0842__X Tile_X4Y0_FrameData_O[31] VPWR VGND sg13cmos5l_antennanp
XFILLER_13_1919 VPWR VGND sg13cmos5l_decap_8
XFILLER_11_2300 VPWR VGND sg13cmos5l_decap_8
XFILLER_15_2491 VPWR VGND sg13cmos5l_decap_8
XFILLER_11_2377 VPWR VGND sg13cmos5l_decap_8
XFILLER_11_1643 VPWR VGND sg13cmos5l_decap_8
XANTENNA__0440__D Tile_X0Y0_FrameData[1] VPWR VGND sg13cmos5l_antennanp
XFILLER_1_638 VPWR VGND sg13cmos5l_decap_8
XFILLER_9_1081 VPWR VGND sg13cmos5l_decap_8
XFILLER_2_2567 VPWR VGND sg13cmos5l_decap_4
XFILLER_2_1888 VPWR VGND sg13cmos5l_fill_1
XANTENNA__1255__A1 Tile_X3Y0_N2MID[4] VPWR VGND sg13cmos5l_antennanp
XFILLER_16_2222 VPWR VGND sg13cmos5l_decap_8
XFILLER_13_723 VPWR VGND sg13cmos5l_decap_8
XANTENNA__0752__X Tile_X1Y0_S2BEG[1] VPWR VGND sg13cmos5l_antennanp
XFILLER_9_716 VPWR VGND sg13cmos5l_fill_1
XFILLER_9_727 VPWR VGND sg13cmos5l_decap_8
XFILLER_16_2255 VPWR VGND sg13cmos5l_decap_8
XFILLER_13_745 VPWR VGND sg13cmos5l_decap_8
XFILLER_16_1532 VPWR VGND sg13cmos5l_fill_2
XFILLER_12_277 VPWR VGND sg13cmos5l_decap_8
XFILLER_16_1587 VPWR VGND sg13cmos5l_decap_4
XFILLER_10_1142 VPWR VGND sg13cmos5l_decap_8
XANTENNA__0350__D Tile_X0Y0_FrameData[27] VPWR VGND sg13cmos5l_antennanp
XANTENNA__1191__A0 Tile_X1Y0_N2MID[4] VPWR VGND sg13cmos5l_antennanp
X_0280_ _0280_/Q Tile_X0Y0_FrameData[17] VGND VPWR Tile_X1Y0_FrameStrobe[2] latch
XFILLER_7_1744 VPWR VGND sg13cmos5l_decap_8
XFILLER_7_1733 VPWR VGND sg13cmos5l_fill_2
XANTENNA__0927__X Tile_X3Y0_FrameStrobe_O[12] VPWR VGND sg13cmos5l_antennanp
XFILLER_7_1777 VPWR VGND sg13cmos5l_decap_8
XFILLER_1_2044 VPWR VGND sg13cmos5l_fill_2
XFILLER_1_1376 VPWR VGND sg13cmos5l_decap_8
XANTENNA__1246__A1 Tile_X2Y0_N4END[11] VPWR VGND sg13cmos5l_antennanp
XFILLER_16_583 VPWR VGND sg13cmos5l_decap_8
XFILLER_16_572 VPWR VGND sg13cmos5l_decap_8
XFILLER_15_1097 VPWR VGND sg13cmos5l_decap_8
XFILLER_12_2675 VPWR VGND sg13cmos5l_decap_8
XFILLER_12_1952 VPWR VGND sg13cmos5l_decap_8
XANTENNA__0260__D Tile_X0Y0_FrameData[5] VPWR VGND sg13cmos5l_antennanp
X_0616_ _0616_/L_HI VPWR VGND sg13cmos5l_tiehi
XANTENNA__1182__A0 Tile_X1Y0_N2MID[3] VPWR VGND sg13cmos5l_antennanp
X_0547_ NPU_WDATA23 Tile_X0Y0_UserCLK _1119_/X _0680_/L_HI VPWR VGND sg13cmos5l_dfrbpq_1
XFILLER_6_1221 VPWR VGND sg13cmos5l_decap_8
XANTENNA__0837__X Tile_X4Y0_FrameData_O[26] VPWR VGND sg13cmos5l_antennanp
X_0478_ _0478_/Q Tile_X0Y0_FrameData[27] VGND VPWR Tile_X3Y0_FrameStrobe[2] latch
XANTENNA__0602__CLK Tile_X0Y0_UserCLK VPWR VGND sg13cmos5l_antennanp
XANTENNA__1237__A1 Tile_X2Y0_N4END[2] VPWR VGND sg13cmos5l_antennanp
XANTENNA__0435__D Tile_X0Y0_FrameData[6] VPWR VGND sg13cmos5l_antennanp
XFILLER_14_68 VPWR VGND sg13cmos5l_fill_1
XFILLER_13_2406 VPWR VGND sg13cmos5l_decap_8
XFILLER_13_1727 VPWR VGND sg13cmos5l_decap_8
XFILLER_11_2130 VPWR VGND sg13cmos5l_decap_4
XANTENNA__0170__D Tile_X0Y0_FrameData[15] VPWR VGND sg13cmos5l_antennanp
XANTENNA__0521__Q NPU_READ_BANK_SEL0 VPWR VGND sg13cmos5l_antennanp
XFILLER_11_1495 VPWR VGND sg13cmos5l_decap_8
XANTENNA__1173__A0 Tile_X1Y0_N1END[2] VPWR VGND sg13cmos5l_antennanp
XFILLER_8_2754 VPWR VGND sg13cmos5l_decap_8
XFILLER_7_1029 VPWR VGND sg13cmos5l_decap_4
XFILLER_4_1928 VPWR VGND sg13cmos5l_fill_1
XANTENNA__0747__X Tile_X1Y0_S1BEG[0] VPWR VGND sg13cmos5l_antennanp
XFILLER_2_2397 VPWR VGND sg13cmos5l_decap_8
XFILLER_2_1685 VPWR VGND sg13cmos5l_decap_8
XANTENNA__1228__A1 Tile_X2Y0_N4END[6] VPWR VGND sg13cmos5l_antennanp
XANTENNA__0345__D Tile_X0Y0_FrameData[0] VPWR VGND sg13cmos5l_antennanp
XANTENNA__0923__A Tile_X3Y0_FrameStrobe[8] VPWR VGND sg13cmos5l_antennanp
XFILLER_16_2052 VPWR VGND sg13cmos5l_decap_8
XFILLER_13_586 VPWR VGND sg13cmos5l_decap_8
XFILLER_9_557 VPWR VGND sg13cmos5l_decap_8
XFILLER_16_1395 VPWR VGND sg13cmos5l_fill_1
XFILLER_12_1259 VPWR VGND sg13cmos5l_decap_8
XFILLER_5_763 VPWR VGND sg13cmos5l_fill_2
XFILLER_9_2529 VPWR VGND sg13cmos5l_decap_4
XFILLER_4_262 VPWR VGND sg13cmos5l_fill_1
XANTENNA__1164__A0 Tile_X0Y0_N2END[1] VPWR VGND sg13cmos5l_antennanp
XFILLER_9_1828 VPWR VGND sg13cmos5l_decap_8
X_0401_ _0401_/Q Tile_X0Y0_FrameData[8] VGND VPWR Tile_X2Y0_FrameStrobe[2] latch
XFILLER_7_2231 VPWR VGND sg13cmos5l_decap_8
X_0332_ _0332_/Q Tile_X0Y0_FrameData[13] VGND VPWR Tile_X2Y0_FrameStrobe[0] latch
XFILLER_7_1541 VPWR VGND sg13cmos5l_decap_8
XFILLER_3_2139 VPWR VGND sg13cmos5l_decap_8
X_0263_ _0263_/Q Tile_X0Y0_FrameData[2] VGND VPWR Tile_X1Y0_FrameStrobe[1] latch
XFILLER_7_1596 VPWR VGND sg13cmos5l_decap_8
XFILLER_7_1585 VPWR VGND sg13cmos5l_decap_8
X_0194_ _0194_/Q Tile_X0Y0_FrameData[23] VGND VPWR Tile_X0Y0_FrameStrobe[3] latch
XANTENNA__0463__GATE Tile_X3Y0_FrameStrobe[1] VPWR VGND sg13cmos5l_antennanp
XANTENNA__1219__A1 Tile_X2Y0_N4END[15] VPWR VGND sg13cmos5l_antennanp
XFILLER_1_1195 VPWR VGND sg13cmos5l_decap_8
XFILLER_1_1184 VPWR VGND sg13cmos5l_fill_1
XANTENNA__0255__D Tile_X0Y0_FrameData[10] VPWR VGND sg13cmos5l_antennanp
XANTENNA__0833__A Tile_X0Y0_FrameData[22] VPWR VGND sg13cmos5l_antennanp
XANTENNA__0478__GATE Tile_X3Y0_FrameStrobe[2] VPWR VGND sg13cmos5l_antennanp
XFILLER_12_2494 VPWR VGND sg13cmos5l_decap_8
XANTENNA__0401__GATE Tile_X2Y0_FrameStrobe[2] VPWR VGND sg13cmos5l_antennanp
XANTENNA__1155__A0 Tile_X0Y0_N2END[0] VPWR VGND sg13cmos5l_antennanp
XFILLER_8_1327 VPWR VGND sg13cmos5l_decap_8
XANTENNA__0416__GATE Tile_X3Y0_FrameStrobe[0] VPWR VGND sg13cmos5l_antennanp
XFILLER_6_1095 VPWR VGND sg13cmos5l_decap_8
XFILLER_3_2673 VPWR VGND sg13cmos5l_decap_8
XFILLER_15_807 VPWR VGND sg13cmos5l_decap_8
XANTENNA__0165__D Tile_X0Y0_FrameData[20] VPWR VGND sg13cmos5l_antennanp
XFILLER_13_2203 VPWR VGND sg13cmos5l_decap_8
XFILLER_13_1502 VPWR VGND sg13cmos5l_fill_1
XFILLER_13_1513 VPWR VGND sg13cmos5l_decap_8
XFILLER_10_556 VPWR VGND sg13cmos5l_decap_8
XANTENNA__1146__A0 Tile_X0Y0_N2MID[7] VPWR VGND sg13cmos5l_antennanp
XFILLER_1_243 VPWR VGND sg13cmos5l_decap_8
XFILLER_8_1872 VPWR VGND sg13cmos5l_decap_8
XANTENNA__0918__A Tile_X3Y0_FrameStrobe[3] VPWR VGND sg13cmos5l_antennanp
XFILLER_4_1747 VPWR VGND sg13cmos5l_decap_8
XFILLER_2_2172 VPWR VGND sg13cmos5l_decap_8
XFILLER_2_1471 VPWR VGND sg13cmos5l_fill_1
XFILLER_9_310 VPWR VGND sg13cmos5l_decap_8
X_0950_ Tile_X2Y0_FrameStrobe_O[15] Tile_X2Y0_FrameStrobe[15] VPWR VGND sg13cmos5l_buf_1
XANTENNA__0940__X Tile_X2Y0_FrameStrobe_O[5] VPWR VGND sg13cmos5l_antennanp
X_0881_ Tile_X2Y0_S2BEGb[6] _1217_/X VPWR VGND sg13cmos5l_buf_1
XFILLER_16_1170 VPWR VGND sg13cmos5l_fill_2
XFILLER_13_2770 VPWR VGND sg13cmos5l_decap_8
XFILLER_12_1056 VPWR VGND sg13cmos5l_decap_8
XFILLER_9_2326 VPWR VGND sg13cmos5l_decap_8
XFILLER_5_560 VPWR VGND sg13cmos5l_decap_8
XANTENNA__1137__A0 Tile_X0Y0_N1END[2] VPWR VGND sg13cmos5l_antennanp
XFILLER_9_1658 VPWR VGND sg13cmos5l_decap_8
XFILLER_7_2050 VPWR VGND sg13cmos5l_decap_8
XANTENNA__0828__A Tile_X0Y0_FrameData[17] VPWR VGND sg13cmos5l_antennanp
X_0315_ _0315_/Q Tile_X0Y0_FrameData[30] VGND VPWR Tile_X2Y0_FrameStrobe[0] latch
XFILLER_3_1202 VPWR VGND sg13cmos5l_decap_8
X_0246_ _0246_/Q Tile_X0Y0_FrameData[19] VGND VPWR Tile_X1Y0_FrameStrobe[1] latch
XFILLER_7_1382 VPWR VGND sg13cmos5l_fill_2
X_0177_ _0177_/Q Tile_X0Y0_FrameData[8] VGND VPWR Tile_X0Y0_FrameStrobe[2] latch
XFILLER_11_309 VPWR VGND sg13cmos5l_fill_1
XANTENNA__1011__X Tile_X0Y0_S2BEGb[4] VPWR VGND sg13cmos5l_antennanp
XFILLER_14_2545 VPWR VGND sg13cmos5l_decap_8
XANTENNA__0850__X Tile_X4Y0_FrameStrobe_O[7] VPWR VGND sg13cmos5l_antennanp
XFILLER_14_1844 VPWR VGND sg13cmos5l_decap_8
XANTENNA__0340__GATE Tile_X2Y0_FrameStrobe[0] VPWR VGND sg13cmos5l_antennanp
XFILLER_14_1899 VPWR VGND sg13cmos5l_decap_8
XFILLER_12_2291 VPWR VGND sg13cmos5l_decap_8
XANTENNA__0355__GATE Tile_X2Y0_FrameStrobe[1] VPWR VGND sg13cmos5l_antennanp
XANTENNA__1128__A0 Tile_X4Y0_N1END[0] VPWR VGND sg13cmos5l_antennanp
XFILLER_5_2779 VPWR VGND sg13cmos5l_fill_2
XFILLER_1_1909 VPWR VGND sg13cmos5l_decap_4
XFILLER_15_626 VPWR VGND sg13cmos5l_decap_8
XFILLER_10_320 VPWR VGND sg13cmos5l_decap_8
XANTENNA__0308__GATE Tile_X1Y0_FrameStrobe[3] VPWR VGND sg13cmos5l_antennanp
XANTENNA__0760__X Tile_X3Y0_S1BEG[1] VPWR VGND sg13cmos5l_antennanp
XFILLER_13_2088 VPWR VGND sg13cmos5l_fill_1
XFILLER_13_2066 VPWR VGND sg13cmos5l_fill_2
XFILLER_13_1376 VPWR VGND sg13cmos5l_decap_8
XFILLER_13_1398 VPWR VGND sg13cmos5l_fill_1
XANTENNA__1119__A0 Tile_X0Y0_N4END[4] VPWR VGND sg13cmos5l_antennanp
XFILLER_6_1809 VPWR VGND sg13cmos5l_decap_8
XFILLER_2_596 VPWR VGND sg13cmos5l_decap_8
XFILLER_4_2234 VPWR VGND sg13cmos5l_decap_8
X_0100_ _0100_/Q Tile_X0Y0_FrameData[21] VGND VPWR Tile_X0Y0_FrameStrobe[0] latch
X_1080_ _1080_/X Tile_X2Y0_N1END[0] Tile_X2Y0_N2MID[0] Tile_X2Y0_N2MID[7] Tile_X2Y0_N2END[7]
+ _0329_/Q _0328_/Q VPWR VGND sg13cmos5l_mux4_1
XFILLER_4_1577 VPWR VGND sg13cmos5l_decap_8
XANTENNA__0935__X Tile_X2Y0_FrameStrobe_O[0] VPWR VGND sg13cmos5l_antennanp
X_0933_ Tile_X3Y0_FrameStrobe_O[18] Tile_X3Y0_FrameStrobe[18] VPWR VGND sg13cmos5l_buf_1
XFILLER_13_191 VPWR VGND sg13cmos5l_decap_8
X_0864_ Tile_X2Y0_S1BEG[1] Tile_X2Y0_N1END[2] VPWR VGND sg13cmos5l_buf_1
X_0795_ Tile_X3Y0_SS4BEG[0] _1275_/X VPWR VGND sg13cmos5l_buf_1
XFILLER_9_2134 VPWR VGND sg13cmos5l_decap_8
XFILLER_5_2009 VPWR VGND sg13cmos5l_decap_4
XANTENNA__1125__A3 Tile_X0Y0_NN4END[15] VPWR VGND sg13cmos5l_antennanp
XFILLER_9_1499 VPWR VGND sg13cmos5l_decap_8
XFILLER_3_70 VPWR VGND sg13cmos5l_fill_2
XANTENNA__1006__X Tile_X0Y0_S4BEG[15] VPWR VGND sg13cmos5l_antennanp
X_1278_ _1278_/X Tile_X3Y0_N2END[3] Tile_X3Y0_N4END[3] Tile_X3Y0_NN4END[12] _0578_/Q
+ _0451_/Q _0450_/Q VPWR VGND sg13cmos5l_mux4_1
XANTENNA__0845__X Tile_X4Y0_FrameStrobe_O[2] VPWR VGND sg13cmos5l_antennanp
X_0229_ _0229_/Q Tile_X0Y0_FrameData[4] VGND VPWR Tile_X1Y0_FrameStrobe[0] latch
XFILLER_3_1087 VPWR VGND sg13cmos5l_decap_8
XFILLER_12_618 VPWR VGND sg13cmos5l_decap_8
XFILLER_16_1906 VPWR VGND sg13cmos5l_decap_8
XANTENNA__0443__D Tile_X0Y0_FrameData[30] VPWR VGND sg13cmos5l_antennanp
XFILLER_14_2353 VPWR VGND sg13cmos5l_decap_8
XFILLER_14_1641 VPWR VGND sg13cmos5l_decap_8
XFILLER_4_839 VPWR VGND sg13cmos5l_decap_8
XANTENNA__0294__GATE Tile_X1Y0_FrameStrobe[2] VPWR VGND sg13cmos5l_antennanp
XFILLER_3_338 VPWR VGND sg13cmos5l_fill_2
XFILLER_9_2690 VPWR VGND sg13cmos5l_decap_8
XFILLER_5_2510 VPWR VGND sg13cmos5l_decap_8
XANTENNA__1116__A3 Tile_X0Y0_NN4END[6] VPWR VGND sg13cmos5l_antennanp
XFILLER_5_2543 VPWR VGND sg13cmos5l_decap_8
XFILLER_5_2532 VPWR VGND sg13cmos5l_decap_8
XFILLER_5_1831 VPWR VGND sg13cmos5l_decap_4
XFILLER_1_2429 VPWR VGND sg13cmos5l_fill_1
XFILLER_1_1706 VPWR VGND sg13cmos5l_fill_2
XANTENNA__0755__X Tile_X1Y0_S2BEG[4] VPWR VGND sg13cmos5l_antennanp
XFILLER_1_1728 VPWR VGND sg13cmos5l_decap_8
XANTENNA__0232__GATE Tile_X1Y0_FrameStrobe[0] VPWR VGND sg13cmos5l_antennanp
XANTENNA__0247__GATE Tile_X1Y0_FrameStrobe[1] VPWR VGND sg13cmos5l_antennanp
XFILLER_15_1416 VPWR VGND sg13cmos5l_fill_1
XFILLER_11_640 VPWR VGND sg13cmos5l_decap_8
XANTENNA__0353__D Tile_X0Y0_FrameData[24] VPWR VGND sg13cmos5l_antennanp
XANTENNA__0931__A Tile_X3Y0_FrameStrobe[16] VPWR VGND sg13cmos5l_antennanp
XFILLER_7_622 VPWR VGND sg13cmos5l_decap_8
XFILLER_10_172 VPWR VGND sg13cmos5l_decap_8
XFILLER_13_1140 VPWR VGND sg13cmos5l_decap_8
XFILLER_10_2751 VPWR VGND sg13cmos5l_decap_8
X_0580_ _0580_/Q Tile_X0Y0_UserCLK NPU_RDATA8 _0657_/L_HI VPWR VGND sg13cmos5l_dfrbpq_1
XFILLER_6_198 VPWR VGND sg13cmos5l_fill_1
XFILLER_6_2307 VPWR VGND sg13cmos5l_decap_8
XANTENNA__1107__A3 Tile_X1Y0_NN4END[11] VPWR VGND sg13cmos5l_antennanp
X_1201_ _1201_/X Tile_X1Y0_N2END[6] Tile_X1Y0_N4END[6] Tile_X1Y0_NN4END[9] _0593_/Q
+ _0253_/Q _0252_/Q VPWR VGND sg13cmos5l_mux4_1
XFILLER_6_1617 VPWR VGND sg13cmos5l_decap_8
XFILLER_4_2064 VPWR VGND sg13cmos5l_fill_1
X_1132_ _1132_/X Tile_X0Y0_N1END[1] Tile_X0Y0_N2MID[1] Tile_X0Y0_N2END[6] _0597_/Q
+ _0199_/Q _0198_/Q VPWR VGND sg13cmos5l_mux4_1
XFILLER_4_2075 VPWR VGND sg13cmos5l_decap_8
XFILLER_0_1205 VPWR VGND sg13cmos5l_decap_8
X_1063_ Tile_X4Y0_SS4BEG[0] Tile_X4Y0_NN4END[15] VPWR VGND sg13cmos5l_buf_1
XFILLER_15_2651 VPWR VGND sg13cmos5l_decap_8
XANTENNA__0263__D Tile_X0Y0_FrameData[2] VPWR VGND sg13cmos5l_antennanp
XANTENNA__0841__A Tile_X0Y0_FrameData[30] VPWR VGND sg13cmos5l_antennanp
X_0916_ Tile_X3Y0_FrameStrobe_O[1] Tile_X3Y0_FrameStrobe[1] VPWR VGND sg13cmos5l_buf_1
XFILLER_15_1994 VPWR VGND sg13cmos5l_decap_8
XFILLER_11_1825 VPWR VGND sg13cmos5l_decap_8
X_0847_ Tile_X4Y0_FrameStrobe_O[4] Tile_X4Y0_FrameStrobe[4] VPWR VGND sg13cmos5l_buf_1
X_0778_ Tile_X3Y0_S2BEGb[7] _1258_/X VPWR VGND sg13cmos5l_buf_1
XFILLER_0_308 VPWR VGND sg13cmos5l_decap_4
XFILLER_9_1252 VPWR VGND sg13cmos5l_decap_8
XFILLER_2_2705 VPWR VGND sg13cmos5l_decap_8
XANTENNA__0438__D Tile_X0Y0_FrameData[3] VPWR VGND sg13cmos5l_antennanp
XFILLER_0_2484 VPWR VGND sg13cmos5l_decap_8
XANTENNA__1282__A2 Tile_X3Y0_NN4END[8] VPWR VGND sg13cmos5l_antennanp
XFILLER_16_2437 VPWR VGND sg13cmos5l_decap_8
XANTENNA__0173__D Tile_X0Y0_FrameData[12] VPWR VGND sg13cmos5l_antennanp
XANTENNA__0524__Q NPU_WDATA0 VPWR VGND sg13cmos5l_antennanp
XANTENNA__0751__A Tile_X1Y0_N2MID[7] VPWR VGND sg13cmos5l_antennanp
XFILLER_10_1302 VPWR VGND sg13cmos5l_decap_8
XFILLER_10_2058 VPWR VGND sg13cmos5l_decap_8
XFILLER_14_1493 VPWR VGND sg13cmos5l_decap_8
XFILLER_4_636 VPWR VGND sg13cmos5l_decap_8
XFILLER_3_168 VPWR VGND sg13cmos5l_fill_1
XFILLER_7_2638 VPWR VGND sg13cmos5l_decap_8
XFILLER_0_842 VPWR VGND sg13cmos5l_fill_1
XFILLER_0_853 VPWR VGND sg13cmos5l_decap_4
XFILLER_5_2362 VPWR VGND sg13cmos5l_decap_8
XFILLER_1_2237 VPWR VGND sg13cmos5l_decap_4
XANTENNA__0171__GATE Tile_X0Y0_FrameStrobe[2] VPWR VGND sg13cmos5l_antennanp
XANTENNA__0348__D Tile_X0Y0_FrameData[29] VPWR VGND sg13cmos5l_antennanp
XANTENNA__0926__A Tile_X3Y0_FrameStrobe[11] VPWR VGND sg13cmos5l_antennanp
XFILLER_5_1683 VPWR VGND sg13cmos5l_decap_8
XFILLER_1_2259 VPWR VGND sg13cmos5l_decap_8
XFILLER_1_1525 VPWR VGND sg13cmos5l_fill_1
XFILLER_1_1503 VPWR VGND sg13cmos5l_fill_2
XFILLER_16_710 VPWR VGND sg13cmos5l_decap_8
XFILLER_1_1558 VPWR VGND sg13cmos5l_fill_1
XANTENNA__0186__GATE Tile_X0Y0_FrameStrobe[3] VPWR VGND sg13cmos5l_antennanp
XANTENNA__1273__A2 Tile_X3Y0_NN4END[14] VPWR VGND sg13cmos5l_antennanp
XFILLER_16_787 VPWR VGND sg13cmos5l_decap_8
XFILLER_15_1202 VPWR VGND sg13cmos5l_fill_1
XFILLER_15_1235 VPWR VGND sg13cmos5l_decap_8
X_0701_ Tile_X0Y0_FrameStrobe_O[14] Tile_X0Y0_FrameStrobe[14] VPWR VGND sg13cmos5l_buf_1
XFILLER_15_1268 VPWR VGND sg13cmos5l_decap_8
X_0632_ _0632_/L_HI VPWR VGND sg13cmos5l_tiehi
XFILLER_7_496 VPWR VGND sg13cmos5l_decap_8
X_0563_ NPU_WE7 Tile_X0Y0_UserCLK _0563_/D _0604_/L_HI VPWR VGND sg13cmos5l_dfrbpq_1
XANTENNA__0124__GATE Tile_X0Y0_FrameStrobe[1] VPWR VGND sg13cmos5l_antennanp
XFILLER_6_2104 VPWR VGND sg13cmos5l_decap_8
X_0494_ _0494_/Q Tile_X0Y0_FrameData[11] VGND VPWR Tile_X3Y0_FrameStrobe[2] latch
XFILLER_6_1414 VPWR VGND sg13cmos5l_fill_2
XANTENNA__0139__GATE Tile_X0Y0_FrameStrobe[1] VPWR VGND sg13cmos5l_antennanp
XANTENNA__0258__D Tile_X0Y0_FrameData[7] VPWR VGND sg13cmos5l_antennanp
XANTENNA__0836__A Tile_X0Y0_FrameData[25] VPWR VGND sg13cmos5l_antennanp
X_1115_ _1115_/X Tile_X0Y0_N4END[0] Tile_X0Y0_N4END[3] Tile_X0Y0_NN4END[1] Tile_X0Y0_NN4END[3]
+ _0115_/Q _0114_/Q VPWR VGND sg13cmos5l_mux4_1
X_1046_ Tile_X4Y0_S2BEGb[7] Tile_X4Y0_N2END[0] VPWR VGND sg13cmos5l_buf_1
XANTENNA__1264__A2 Tile_X3Y0_NN4END[5] VPWR VGND sg13cmos5l_antennanp
XFILLER_0_1079 VPWR VGND sg13cmos5l_fill_1
XFILLER_15_2470 VPWR VGND sg13cmos5l_decap_8
XANTENNA__0531__CLK Tile_X0Y0_UserCLK VPWR VGND sg13cmos5l_antennanp
XFILLER_15_1791 VPWR VGND sg13cmos5l_fill_2
XFILLER_15_1780 VPWR VGND sg13cmos5l_decap_8
XFILLER_11_2356 VPWR VGND sg13cmos5l_decap_8
XFILLER_11_1622 VPWR VGND sg13cmos5l_decap_8
XFILLER_11_1699 VPWR VGND sg13cmos5l_decap_8
XFILLER_1_628 VPWR VGND sg13cmos5l_fill_2
XFILLER_6_2682 VPWR VGND sg13cmos5l_decap_8
XANTENNA__0168__D Tile_X0Y0_FrameData[17] VPWR VGND sg13cmos5l_antennanp
XFILLER_2_2546 VPWR VGND sg13cmos5l_decap_8
XFILLER_13_702 VPWR VGND sg13cmos5l_decap_8
XANTENNA__1255__A2 Tile_X3Y0_N2END[3] VPWR VGND sg13cmos5l_antennanp
XFILLER_16_2234 VPWR VGND sg13cmos5l_decap_8
XFILLER_16_1511 VPWR VGND sg13cmos5l_decap_8
XFILLER_12_234 VPWR VGND sg13cmos5l_fill_2
XFILLER_16_2289 VPWR VGND sg13cmos5l_fill_1
XFILLER_12_256 VPWR VGND sg13cmos5l_decap_8
XFILLER_12_2109 VPWR VGND sg13cmos5l_decap_8
XFILLER_16_1566 VPWR VGND sg13cmos5l_decap_8
XFILLER_10_1121 VPWR VGND sg13cmos5l_decap_8
XFILLER_4_411 VPWR VGND sg13cmos5l_decap_8
XFILLER_4_477 VPWR VGND sg13cmos5l_decap_4
XFILLER_10_1198 VPWR VGND sg13cmos5l_fill_2
XFILLER_7_2413 VPWR VGND sg13cmos5l_decap_8
XANTENNA__1191__A1 Tile_X1Y0_N4END[3] VPWR VGND sg13cmos5l_antennanp
XFILLER_7_2479 VPWR VGND sg13cmos5l_decap_8
XFILLER_5_2181 VPWR VGND sg13cmos5l_decap_8
XFILLER_1_2012 VPWR VGND sg13cmos5l_fill_1
XFILLER_1_2078 VPWR VGND sg13cmos5l_fill_2
XFILLER_1_1333 VPWR VGND sg13cmos5l_fill_2
XFILLER_1_1355 VPWR VGND sg13cmos5l_decap_8
XFILLER_16_551 VPWR VGND sg13cmos5l_decap_8
XANTENNA__0943__X Tile_X2Y0_FrameStrobe_O[8] VPWR VGND sg13cmos5l_antennanp
XANTENNA__1246__A2 Tile_X2Y0_NN4END[4] VPWR VGND sg13cmos5l_antennanp
XANTENNA__0554__CLK Tile_X0Y0_UserCLK VPWR VGND sg13cmos5l_antennanp
XFILLER_8_772 VPWR VGND sg13cmos5l_fill_1
XFILLER_12_2654 VPWR VGND sg13cmos5l_decap_8
XFILLER_12_1931 VPWR VGND sg13cmos5l_decap_8
XFILLER_8_794 VPWR VGND sg13cmos5l_decap_8
X_0615_ _0615_/L_HI VPWR VGND sg13cmos5l_tiehi
XANTENNA__1182__A1 Tile_X1Y0_N4END[12] VPWR VGND sg13cmos5l_antennanp
X_0546_ NPU_WDATA22 Tile_X0Y0_UserCLK _1118_/X _0681_/L_HI VPWR VGND sg13cmos5l_dfrbpq_1
X_0477_ _0477_/Q Tile_X0Y0_FrameData[28] VGND VPWR Tile_X3Y0_FrameStrobe[2] latch
XFILLER_6_1200 VPWR VGND sg13cmos5l_decap_8
XANTENNA__1014__X Tile_X0Y0_S2BEGb[7] VPWR VGND sg13cmos5l_antennanp
XANTENNA__0853__X Tile_X4Y0_FrameStrobe_O[10] VPWR VGND sg13cmos5l_antennanp
XANTENNA__1237__A2 Tile_X2Y0_NN4END[13] VPWR VGND sg13cmos5l_antennanp
X_1029_ Tile_X4Y0_S1BEG[2] Tile_X4Y0_N1END[1] VPWR VGND sg13cmos5l_buf_1
XFILLER_13_1706 VPWR VGND sg13cmos5l_decap_8
XANTENNA__0451__D Tile_X0Y0_FrameData[22] VPWR VGND sg13cmos5l_antennanp
XFILLER_2_915 VPWR VGND sg13cmos5l_fill_2
XFILLER_11_1474 VPWR VGND sg13cmos5l_decap_8
XANTENNA__1173__A1 Tile_X1Y0_N2MID[2] VPWR VGND sg13cmos5l_antennanp
XFILLER_8_2733 VPWR VGND sg13cmos5l_decap_8
XFILLER_4_2619 VPWR VGND sg13cmos5l_decap_8
XFILLER_2_2321 VPWR VGND sg13cmos5l_decap_8
XFILLER_2_2376 VPWR VGND sg13cmos5l_decap_8
XANTENNA__0577__CLK Tile_X0Y0_UserCLK VPWR VGND sg13cmos5l_antennanp
XFILLER_2_1664 VPWR VGND sg13cmos5l_decap_8
XANTENNA__0763__X Tile_X3Y0_S2BEG[0] VPWR VGND sg13cmos5l_antennanp
XANTENNA__1228__A2 Tile_X2Y0_NN4END[9] VPWR VGND sg13cmos5l_antennanp
XFILLER_16_2031 VPWR VGND sg13cmos5l_decap_8
XFILLER_13_565 VPWR VGND sg13cmos5l_decap_8
XFILLER_13_554 VPWR VGND sg13cmos5l_fill_1
XFILLER_16_1363 VPWR VGND sg13cmos5l_fill_2
XANTENNA__0361__D Tile_X0Y0_FrameData[16] VPWR VGND sg13cmos5l_antennanp
XFILLER_12_1238 VPWR VGND sg13cmos5l_decap_8
XFILLER_9_2508 VPWR VGND sg13cmos5l_decap_8
XFILLER_9_1807 VPWR VGND sg13cmos5l_decap_8
XFILLER_5_786 VPWR VGND sg13cmos5l_decap_4
XANTENNA__1164__A1 Tile_X0Y0_N4END[9] VPWR VGND sg13cmos5l_antennanp
X_0400_ _0400_/Q Tile_X0Y0_FrameData[9] VGND VPWR Tile_X2Y0_FrameStrobe[2] latch
XFILLER_7_2210 VPWR VGND sg13cmos5l_decap_8
XFILLER_4_296 VPWR VGND sg13cmos5l_decap_8
XANTENNA__0938__X Tile_X2Y0_FrameStrobe_O[3] VPWR VGND sg13cmos5l_antennanp
X_0331_ _0331_/Q Tile_X0Y0_FrameData[14] VGND VPWR Tile_X2Y0_FrameStrobe[0] latch
XFILLER_7_2287 VPWR VGND sg13cmos5l_decap_8
X_0262_ _0262_/Q Tile_X0Y0_FrameData[3] VGND VPWR Tile_X1Y0_FrameStrobe[1] latch
XFILLER_3_1417 VPWR VGND sg13cmos5l_fill_2
XFILLER_3_1406 VPWR VGND sg13cmos5l_fill_1
X_0193_ _0193_/Q Tile_X0Y0_FrameData[24] VGND VPWR Tile_X0Y0_FrameStrobe[3] latch
XANTENNA__1219__A2 Tile_X2Y0_NN4END[0] VPWR VGND sg13cmos5l_antennanp
XANTENNA__0271__D Tile_X0Y0_FrameData[26] VPWR VGND sg13cmos5l_antennanp
XFILLER_12_2473 VPWR VGND sg13cmos5l_decap_8
XANTENNA__1009__X Tile_X0Y0_S2BEGb[2] VPWR VGND sg13cmos5l_antennanp
XANTENNA__0848__X Tile_X4Y0_FrameStrobe_O[5] VPWR VGND sg13cmos5l_antennanp
XANTENNA__1155__A1 Tile_X0Y0_N4END[0] VPWR VGND sg13cmos5l_antennanp
X_0529_ NPU_WDATA5 Tile_X0Y0_UserCLK _1101_/X _0605_/L_HI VPWR VGND sg13cmos5l_dfrbpq_1
XFILLER_3_2652 VPWR VGND sg13cmos5l_decap_8
XFILLER_6_1074 VPWR VGND sg13cmos5l_decap_8
XANTENNA__0446__D Tile_X0Y0_FrameData[27] VPWR VGND sg13cmos5l_antennanp
XFILLER_14_318 VPWR VGND sg13cmos5l_decap_8
XANTENNA__1091__A0 Tile_X3Y0_N1END[3] VPWR VGND sg13cmos5l_antennanp
XFILLER_10_535 VPWR VGND sg13cmos5l_decap_8
XFILLER_13_2259 VPWR VGND sg13cmos5l_decap_8
XANTENNA__0181__D Tile_X0Y0_FrameData[4] VPWR VGND sg13cmos5l_antennanp
XANTENNA__0532__Q NPU_WDATA8 VPWR VGND sg13cmos5l_antennanp
XFILLER_13_1558 VPWR VGND sg13cmos5l_decap_8
XFILLER_1_222 VPWR VGND sg13cmos5l_decap_8
XANTENNA__0758__X Tile_X1Y0_S2BEG[7] VPWR VGND sg13cmos5l_antennanp
XANTENNA__1146__A1 Tile_X0Y0_N4END[8] VPWR VGND sg13cmos5l_antennanp
XFILLER_1_288 VPWR VGND sg13cmos5l_fill_2
XFILLER_4_2449 VPWR VGND sg13cmos5l_decap_8
XFILLER_4_1726 VPWR VGND sg13cmos5l_decap_8
XFILLER_2_2151 VPWR VGND sg13cmos5l_decap_8
XFILLER_2_2140 VPWR VGND sg13cmos5l_fill_1
XANTENNA__0356__D Tile_X0Y0_FrameData[21] VPWR VGND sg13cmos5l_antennanp
XANTENNA__0934__A Tile_X3Y0_FrameStrobe[19] VPWR VGND sg13cmos5l_antennanp
XFILLER_14_830 VPWR VGND sg13cmos5l_fill_2
XFILLER_14_874 VPWR VGND sg13cmos5l_decap_8
XFILLER_14_852 VPWR VGND sg13cmos5l_fill_2
XANTENNA__1082__A0 Tile_X2Y0_N1END[2] VPWR VGND sg13cmos5l_antennanp
X_0880_ Tile_X2Y0_S2BEGb[5] _1216_/X VPWR VGND sg13cmos5l_buf_1
XANTENNA__0091__D Tile_X0Y0_FrameData[30] VPWR VGND sg13cmos5l_antennanp
XFILLER_16_1182 VPWR VGND sg13cmos5l_decap_8
XFILLER_9_2305 VPWR VGND sg13cmos5l_decap_8
XANTENNA__1137__A1 Tile_X0Y0_N2MID[6] VPWR VGND sg13cmos5l_antennanp
XFILLER_9_1637 VPWR VGND sg13cmos5l_decap_8
X_0314_ _0314_/Q Tile_X0Y0_FrameData[31] VGND VPWR Tile_X1Y0_FrameStrobe[0] latch
XFILLER_7_2095 VPWR VGND sg13cmos5l_decap_8
X_0245_ _0245_/Q Tile_X0Y0_FrameData[20] VGND VPWR Tile_X1Y0_FrameStrobe[1] latch
XANTENNA__0266__D Tile_X0Y0_FrameData[31] VPWR VGND sg13cmos5l_antennanp
X_0176_ _0176_/Q Tile_X0Y0_FrameData[9] VGND VPWR Tile_X0Y0_FrameStrobe[2] latch
XANTENNA__0844__A Tile_X4Y0_FrameStrobe[1] VPWR VGND sg13cmos5l_antennanp
XFILLER_14_2524 VPWR VGND sg13cmos5l_decap_8
XFILLER_14_1823 VPWR VGND sg13cmos5l_decap_8
XFILLER_12_2270 VPWR VGND sg13cmos5l_decap_8
XFILLER_3_509 VPWR VGND sg13cmos5l_decap_8
XFILLER_11_48 VPWR VGND sg13cmos5l_fill_2
XANTENNA__1128__A1 Tile_X4Y0_N2MID[0] VPWR VGND sg13cmos5l_antennanp
XFILLER_5_2758 VPWR VGND sg13cmos5l_decap_8
XANTENNA__0176__D Tile_X0Y0_FrameData[9] VPWR VGND sg13cmos5l_antennanp
XANTENNA__0527__Q NPU_WDATA3 VPWR VGND sg13cmos5l_antennanp
XFILLER_15_605 VPWR VGND sg13cmos5l_decap_8
XANTENNA__0754__A Tile_X1Y0_N2MID[4] VPWR VGND sg13cmos5l_antennanp
XFILLER_14_159 VPWR VGND sg13cmos5l_fill_1
XFILLER_14_148 VPWR VGND sg13cmos5l_decap_4
XFILLER_13_2045 VPWR VGND sg13cmos5l_decap_8
XFILLER_11_844 VPWR VGND sg13cmos5l_decap_8
XFILLER_13_2078 VPWR VGND sg13cmos5l_fill_2
XFILLER_11_888 VPWR VGND sg13cmos5l_fill_2
XFILLER_6_358 VPWR VGND sg13cmos5l_decap_8
XFILLER_13_1355 VPWR VGND sg13cmos5l_decap_8
XANTENNA__0462__GATE Tile_X3Y0_FrameStrobe[1] VPWR VGND sg13cmos5l_antennanp
XANTENNA__1119__A1 Tile_X0Y0_N4END[7] VPWR VGND sg13cmos5l_antennanp
XFILLER_2_575 VPWR VGND sg13cmos5l_decap_8
XANTENNA__0929__A Tile_X3Y0_FrameStrobe[14] VPWR VGND sg13cmos5l_antennanp
XFILLER_8_2382 VPWR VGND sg13cmos5l_decap_8
XANTENNA__0477__GATE Tile_X3Y0_FrameStrobe[2] VPWR VGND sg13cmos5l_antennanp
XFILLER_8_1692 VPWR VGND sg13cmos5l_decap_8
XANTENNA__0400__GATE Tile_X2Y0_FrameStrobe[2] VPWR VGND sg13cmos5l_antennanp
XANTENNA__0951__X Tile_X2Y0_FrameStrobe_O[16] VPWR VGND sg13cmos5l_antennanp
XFILLER_14_693 VPWR VGND sg13cmos5l_decap_8
XANTENNA__0415__GATE Tile_X3Y0_FrameStrobe[0] VPWR VGND sg13cmos5l_antennanp
XFILLER_9_152 VPWR VGND sg13cmos5l_fill_2
X_0932_ Tile_X3Y0_FrameStrobe_O[17] Tile_X3Y0_FrameStrobe[17] VPWR VGND sg13cmos5l_buf_1
X_0863_ Tile_X2Y0_S1BEG[0] Tile_X2Y0_N1END[3] VPWR VGND sg13cmos5l_buf_1
X_0794_ Tile_X3Y0_S4BEG[15] _1274_/X VPWR VGND sg13cmos5l_buf_1
XANTENNA__0839__A Tile_X0Y0_FrameData[28] VPWR VGND sg13cmos5l_antennanp
XFILLER_9_2179 VPWR VGND sg13cmos5l_decap_8
X_1277_ _1277_/X Tile_X3Y0_N2END[2] Tile_X3Y0_N4END[2] Tile_X3Y0_NN4END[13] _0579_/Q
+ _0453_/Q _0452_/Q VPWR VGND sg13cmos5l_mux4_1
X_0228_ _0228_/Q Tile_X0Y0_FrameData[5] VGND VPWR Tile_X1Y0_FrameStrobe[0] latch
XFILLER_3_1066 VPWR VGND sg13cmos5l_decap_8
XANTENNA__1022__X Tile_X0Y0_S2BEG[7] VPWR VGND sg13cmos5l_antennanp
X_0159_ _0159_/Q Tile_X0Y0_FrameData[26] VGND VPWR Tile_X0Y0_FrameStrobe[2] latch
XFILLER_0_1976 VPWR VGND sg13cmos5l_decap_8
XANTENNA__0861__X Tile_X4Y0_FrameStrobe_O[18] VPWR VGND sg13cmos5l_antennanp
XFILLER_11_118 VPWR VGND sg13cmos5l_decap_8
XFILLER_14_2332 VPWR VGND sg13cmos5l_decap_8
XFILLER_14_1620 VPWR VGND sg13cmos5l_decap_8
XFILLER_10_1539 VPWR VGND sg13cmos5l_decap_8
XFILLER_4_818 VPWR VGND sg13cmos5l_fill_2
XFILLER_14_1697 VPWR VGND sg13cmos5l_decap_8
XANTENNA__0749__A Tile_X1Y0_N1END[1] VPWR VGND sg13cmos5l_antennanp
XFILLER_5_2599 VPWR VGND sg13cmos5l_decap_8
XANTENNA__1285__A0 Tile_X3Y0_N2END[2] VPWR VGND sg13cmos5l_antennanp
XANTENNA__0771__X Tile_X3Y0_S2BEGb[0] VPWR VGND sg13cmos5l_antennanp
XFILLER_7_601 VPWR VGND sg13cmos5l_decap_8
XFILLER_6_133 VPWR VGND sg13cmos5l_fill_2
XFILLER_6_122 VPWR VGND sg13cmos5l_fill_1
XFILLER_6_111 VPWR VGND sg13cmos5l_decap_8
XFILLER_10_2730 VPWR VGND sg13cmos5l_decap_8
XFILLER_13_1196 VPWR VGND sg13cmos5l_decap_8
XFILLER_12_91 VPWR VGND sg13cmos5l_fill_1
X_1200_ _1200_/X Tile_X1Y0_N2END[5] Tile_X1Y0_N4END[5] Tile_X1Y0_NN4END[10] _0592_/Q
+ _0255_/Q _0254_/Q VPWR VGND sg13cmos5l_mux4_1
XFILLER_4_2043 VPWR VGND sg13cmos5l_decap_8
XANTENNA__0946__X Tile_X2Y0_FrameStrobe_O[11] VPWR VGND sg13cmos5l_antennanp
X_1131_ _1131_/X Tile_X0Y0_N1END[0] Tile_X0Y0_N2MID[0] Tile_X0Y0_N2END[7] _0596_/Q
+ _0201_/Q _0200_/Q VPWR VGND sg13cmos5l_mux4_1
XFILLER_4_2098 VPWR VGND sg13cmos5l_fill_1
X_1062_ Tile_X4Y0_S4BEG[15] Tile_X4Y0_N4END[0] VPWR VGND sg13cmos5l_buf_1
XANTENNA__1276__A0 Tile_X3Y0_N2END[1] VPWR VGND sg13cmos5l_antennanp
XANTENNA__0354__GATE Tile_X2Y0_FrameStrobe[1] VPWR VGND sg13cmos5l_antennanp
XFILLER_15_2630 VPWR VGND sg13cmos5l_decap_8
X_0915_ Tile_X3Y0_FrameStrobe_O[0] Tile_X3Y0_FrameStrobe[0] VPWR VGND sg13cmos5l_buf_1
XFILLER_11_2538 VPWR VGND sg13cmos5l_fill_1
XFILLER_11_1804 VPWR VGND sg13cmos5l_decap_8
XANTENNA__0369__GATE Tile_X2Y0_FrameStrobe[1] VPWR VGND sg13cmos5l_antennanp
X_0846_ Tile_X4Y0_FrameStrobe_O[3] Tile_X4Y0_FrameStrobe[3] VPWR VGND sg13cmos5l_buf_1
XANTENNA__1200__A0 Tile_X1Y0_N2END[5] VPWR VGND sg13cmos5l_antennanp
X_0777_ Tile_X3Y0_S2BEGb[6] _1257_/X VPWR VGND sg13cmos5l_buf_1
XFILLER_9_1231 VPWR VGND sg13cmos5l_decap_8
XANTENNA__1017__X Tile_X0Y0_S2BEG[2] VPWR VGND sg13cmos5l_antennanp
XFILLER_5_1139 VPWR VGND sg13cmos5l_decap_8
XANTENNA__0307__GATE Tile_X1Y0_FrameStrobe[3] VPWR VGND sg13cmos5l_antennanp
XANTENNA__0856__X Tile_X4Y0_FrameStrobe_O[13] VPWR VGND sg13cmos5l_antennanp
XANTENNA__1267__A0 Tile_X3Y0_N2MID[0] VPWR VGND sg13cmos5l_antennanp
XFILLER_0_1740 VPWR VGND sg13cmos5l_fill_1
XFILLER_0_2463 VPWR VGND sg13cmos5l_decap_8
XANTENNA__0454__D Tile_X0Y0_FrameData[19] VPWR VGND sg13cmos5l_antennanp
XFILLER_0_1795 VPWR VGND sg13cmos5l_fill_2
XFILLER_16_2416 VPWR VGND sg13cmos5l_decap_8
XFILLER_16_1759 VPWR VGND sg13cmos5l_decap_8
XFILLER_10_2037 VPWR VGND sg13cmos5l_decap_8
XFILLER_14_2184 VPWR VGND sg13cmos5l_decap_8
XFILLER_14_1450 VPWR VGND sg13cmos5l_decap_4
XFILLER_4_615 VPWR VGND sg13cmos5l_decap_8
XFILLER_14_1472 VPWR VGND sg13cmos5l_decap_8
XANTENNA__0540__Q NPU_WDATA16 VPWR VGND sg13cmos5l_antennanp
XFILLER_3_103 VPWR VGND sg13cmos5l_fill_1
XFILLER_10_1369 VPWR VGND sg13cmos5l_decap_8
XFILLER_7_2617 VPWR VGND sg13cmos5l_decap_8
XFILLER_0_876 VPWR VGND sg13cmos5l_fill_2
XFILLER_5_2341 VPWR VGND sg13cmos5l_decap_8
XANTENNA__0766__X Tile_X3Y0_S2BEG[3] VPWR VGND sg13cmos5l_antennanp
XFILLER_1_2216 VPWR VGND sg13cmos5l_decap_8
XFILLER_5_1662 VPWR VGND sg13cmos5l_decap_8
XANTENNA__1258__A0 Tile_X3Y0_N1END[3] VPWR VGND sg13cmos5l_antennanp
XFILLER_16_766 VPWR VGND sg13cmos5l_decap_8
XANTENNA__0364__D Tile_X0Y0_FrameData[13] VPWR VGND sg13cmos5l_antennanp
XFILLER_15_287 VPWR VGND sg13cmos5l_decap_8
XFILLER_15_265 VPWR VGND sg13cmos5l_decap_4
XANTENNA__0942__A Tile_X2Y0_FrameStrobe[7] VPWR VGND sg13cmos5l_antennanp
XFILLER_15_1247 VPWR VGND sg13cmos5l_decap_8
XFILLER_15_1214 VPWR VGND sg13cmos5l_decap_8
X_0700_ Tile_X0Y0_FrameStrobe_O[13] Tile_X0Y0_FrameStrobe[13] VPWR VGND sg13cmos5l_buf_1
XFILLER_7_431 VPWR VGND sg13cmos5l_decap_8
X_0631_ _0631_/L_HI VPWR VGND sg13cmos5l_tiehi
X_0562_ NPU_WE6 Tile_X0Y0_UserCLK _0562_/D _0665_/L_HI VPWR VGND sg13cmos5l_dfrbpq_1
X_0493_ _0493_/Q Tile_X0Y0_FrameData[12] VGND VPWR Tile_X3Y0_FrameStrobe[2] latch
X_1114_ _1114_/X Tile_X0Y0_N4END[2] Tile_X0Y0_N4END[3] Tile_X0Y0_NN4END[0] Tile_X0Y0_NN4END[2]
+ _0117_/Q _0116_/Q VPWR VGND sg13cmos5l_mux4_1
XFILLER_4_1161 VPWR VGND sg13cmos5l_decap_8
XFILLER_4_1150 VPWR VGND sg13cmos5l_fill_1
XANTENNA__1249__A0 Tile_X2Y0_N2END[6] VPWR VGND sg13cmos5l_antennanp
XFILLER_4_1194 VPWR VGND sg13cmos5l_decap_8
XFILLER_0_1058 VPWR VGND sg13cmos5l_fill_2
X_1045_ Tile_X4Y0_S2BEGb[6] Tile_X4Y0_N2END[1] VPWR VGND sg13cmos5l_buf_1
XANTENNA__0293__GATE Tile_X1Y0_FrameStrobe[2] VPWR VGND sg13cmos5l_antennanp
XANTENNA__0274__D Tile_X0Y0_FrameData[23] VPWR VGND sg13cmos5l_antennanp
XANTENNA__0852__A Tile_X4Y0_FrameStrobe[9] VPWR VGND sg13cmos5l_antennanp
XFILLER_11_2335 VPWR VGND sg13cmos5l_decap_8
XFILLER_11_1601 VPWR VGND sg13cmos5l_decap_8
X_0829_ Tile_X4Y0_FrameData_O[18] Tile_X0Y0_FrameData[18] VPWR VGND sg13cmos5l_buf_1
XANTENNA__0231__GATE Tile_X1Y0_FrameStrobe[0] VPWR VGND sg13cmos5l_antennanp
XFILLER_11_1678 VPWR VGND sg13cmos5l_decap_8
XFILLER_6_2661 VPWR VGND sg13cmos5l_decap_8
XANTENNA__0246__GATE Tile_X1Y0_FrameStrobe[1] VPWR VGND sg13cmos5l_antennanp
XANTENNA__0449__D Tile_X0Y0_FrameData[24] VPWR VGND sg13cmos5l_antennanp
XFILLER_2_2525 VPWR VGND sg13cmos5l_decap_8
XFILLER_2_1835 VPWR VGND sg13cmos5l_decap_4
XFILLER_2_1879 VPWR VGND sg13cmos5l_decap_8
XANTENNA__0535__Q NPU_WDATA11 VPWR VGND sg13cmos5l_antennanp
XANTENNA__0184__D Tile_X0Y0_FrameData[1] VPWR VGND sg13cmos5l_antennanp
XANTENNA__0762__A Tile_X3Y0_N1END[0] VPWR VGND sg13cmos5l_antennanp
XFILLER_12_213 VPWR VGND sg13cmos5l_decap_8
XFILLER_16_1545 VPWR VGND sg13cmos5l_decap_8
XFILLER_16_1534 VPWR VGND sg13cmos5l_fill_1
XFILLER_12_1409 VPWR VGND sg13cmos5l_decap_8
XFILLER_10_1100 VPWR VGND sg13cmos5l_decap_8
XFILLER_14_1291 VPWR VGND sg13cmos5l_decap_4
XFILLER_10_1177 VPWR VGND sg13cmos5l_decap_8
XFILLER_4_489 VPWR VGND sg13cmos5l_decap_8
XANTENNA__1191__A2 Tile_X1Y0_NN4END[12] VPWR VGND sg13cmos5l_antennanp
XFILLER_7_1702 VPWR VGND sg13cmos5l_fill_1
XANTENNA__0359__D Tile_X0Y0_FrameData[18] VPWR VGND sg13cmos5l_antennanp
XANTENNA__0937__A Tile_X2Y0_FrameStrobe[2] VPWR VGND sg13cmos5l_antennanp
XFILLER_5_2160 VPWR VGND sg13cmos5l_decap_8
XFILLER_10_9 VPWR VGND sg13cmos5l_fill_1
XFILLER_1_2046 VPWR VGND sg13cmos5l_fill_1
XFILLER_16_530 VPWR VGND sg13cmos5l_fill_2
XANTENNA__0094__D Tile_X0Y0_FrameData[27] VPWR VGND sg13cmos5l_antennanp
XFILLER_12_2633 VPWR VGND sg13cmos5l_decap_8
XFILLER_12_1910 VPWR VGND sg13cmos5l_decap_8
X_0614_ _0614_/L_HI VPWR VGND sg13cmos5l_tiehi
XFILLER_12_1987 VPWR VGND sg13cmos5l_decap_8
XFILLER_4_990 VPWR VGND sg13cmos5l_fill_1
XANTENNA__1182__A2 Tile_X1Y0_NN4END[3] VPWR VGND sg13cmos5l_antennanp
X_0545_ NPU_WDATA21 Tile_X0Y0_UserCLK _1117_/X _0682_/L_HI VPWR VGND sg13cmos5l_dfrbpq_1
X_0476_ _0476_/Q Tile_X0Y0_FrameData[29] VGND VPWR Tile_X3Y0_FrameStrobe[2] latch
XFILLER_3_2801 VPWR VGND sg13cmos5l_fill_2
XANTENNA__0269__D Tile_X0Y0_FrameData[28] VPWR VGND sg13cmos5l_antennanp
XANTENNA__0847__A Tile_X4Y0_FrameStrobe[4] VPWR VGND sg13cmos5l_antennanp
XFILLER_1_2591 VPWR VGND sg13cmos5l_decap_8
X_1028_ Tile_X4Y0_S1BEG[1] Tile_X4Y0_N1END[2] VPWR VGND sg13cmos5l_buf_1
XANTENNA__1030__X Tile_X4Y0_S1BEG[3] VPWR VGND sg13cmos5l_antennanp
XFILLER_14_48 VPWR VGND sg13cmos5l_fill_1
XFILLER_14_37 VPWR VGND sg13cmos5l_fill_1
XFILLER_10_739 VPWR VGND sg13cmos5l_decap_8
XFILLER_11_2143 VPWR VGND sg13cmos5l_decap_8
XANTENNA__0170__GATE Tile_X0Y0_FrameStrobe[2] VPWR VGND sg13cmos5l_antennanp
XFILLER_11_2165 VPWR VGND sg13cmos5l_fill_1
XFILLER_11_2154 VPWR VGND sg13cmos5l_fill_2
XFILLER_11_1453 VPWR VGND sg13cmos5l_decap_8
XFILLER_8_2712 VPWR VGND sg13cmos5l_decap_8
XANTENNA__0185__GATE Tile_X0Y0_FrameStrobe[2] VPWR VGND sg13cmos5l_antennanp
XANTENNA__1173__A2 Tile_X1Y0_N2END[5] VPWR VGND sg13cmos5l_antennanp
XANTENNA__0179__D Tile_X0Y0_FrameData[6] VPWR VGND sg13cmos5l_antennanp
XANTENNA__0757__A Tile_X1Y0_N2MID[1] VPWR VGND sg13cmos5l_antennanp
XFILLER_6_2491 VPWR VGND sg13cmos5l_decap_8
XFILLER_2_2344 VPWR VGND sg13cmos5l_fill_1
XFILLER_2_2355 VPWR VGND sg13cmos5l_decap_8
XFILLER_2_1643 VPWR VGND sg13cmos5l_decap_8
XANTENNA__0123__GATE Tile_X0Y0_FrameStrobe[1] VPWR VGND sg13cmos5l_antennanp
XFILLER_9_504 VPWR VGND sg13cmos5l_decap_4
XFILLER_16_2087 VPWR VGND sg13cmos5l_decap_8
XFILLER_16_1342 VPWR VGND sg13cmos5l_decap_8
XFILLER_16_1386 VPWR VGND sg13cmos5l_fill_2
XFILLER_12_1217 VPWR VGND sg13cmos5l_decap_8
XANTENNA__0138__GATE Tile_X0Y0_FrameStrobe[1] VPWR VGND sg13cmos5l_antennanp
XFILLER_4_286 VPWR VGND sg13cmos5l_fill_2
XANTENNA__1164__A2 Tile_X0Y0_NN4END[6] VPWR VGND sg13cmos5l_antennanp
X_0330_ _0330_/Q Tile_X0Y0_FrameData[15] VGND VPWR Tile_X2Y0_FrameStrobe[0] latch
XFILLER_7_2266 VPWR VGND sg13cmos5l_decap_8
X_0261_ _0261_/Q Tile_X0Y0_FrameData[4] VGND VPWR Tile_X1Y0_FrameStrobe[1] latch
XANTENNA__0521__CLK Tile_X0Y0_UserCLK VPWR VGND sg13cmos5l_antennanp
X_0192_ _0192_/Q Tile_X0Y0_FrameData[25] VGND VPWR Tile_X0Y0_FrameStrobe[3] latch
XANTENNA__0954__X Tile_X2Y0_FrameStrobe_O[19] VPWR VGND sg13cmos5l_antennanp
XFILLER_14_2717 VPWR VGND sg13cmos5l_fill_2
XFILLER_12_2452 VPWR VGND sg13cmos5l_decap_8
XFILLER_12_1784 VPWR VGND sg13cmos5l_decap_8
XFILLER_8_2008 VPWR VGND sg13cmos5l_decap_8
XFILLER_8_2019 VPWR VGND sg13cmos5l_fill_1
XANTENNA__1155__A2 Tile_X0Y0_NN4END[15] VPWR VGND sg13cmos5l_antennanp
X_0528_ NPU_WDATA4 Tile_X0Y0_UserCLK _1100_/X _0624_/L_HI VPWR VGND sg13cmos5l_dfrbpq_1
XFILLER_6_1020 VPWR VGND sg13cmos5l_fill_2
XANTENNA__1025__X Tile_X0Y0_S1BEG[2] VPWR VGND sg13cmos5l_antennanp
X_0459_ _0459_/Q Tile_X0Y0_FrameData[14] VGND VPWR Tile_X3Y0_FrameStrobe[1] latch
XFILLER_6_1053 VPWR VGND sg13cmos5l_decap_8
XFILLER_3_2631 VPWR VGND sg13cmos5l_decap_8
XANTENNA__0864__X Tile_X2Y0_S1BEG[1] VPWR VGND sg13cmos5l_antennanp
XANTENNA__1091__A1 Tile_X3Y0_N2MID[3] VPWR VGND sg13cmos5l_antennanp
XFILLER_13_2238 VPWR VGND sg13cmos5l_decap_8
XFILLER_10_514 VPWR VGND sg13cmos5l_decap_8
XANTENNA__0462__D Tile_X0Y0_FrameData[11] VPWR VGND sg13cmos5l_antennanp
XFILLER_6_529 VPWR VGND sg13cmos5l_decap_8
XFILLER_13_1537 VPWR VGND sg13cmos5l_decap_4
XFILLER_1_201 VPWR VGND sg13cmos5l_decap_8
XFILLER_11_1294 VPWR VGND sg13cmos5l_decap_8
XANTENNA__1146__A2 Tile_X0Y0_NN4END[7] VPWR VGND sg13cmos5l_antennanp
XANTENNA__0544__CLK Tile_X0Y0_UserCLK VPWR VGND sg13cmos5l_antennanp
XFILLER_8_2586 VPWR VGND sg13cmos5l_decap_8
XFILLER_8_1852 VPWR VGND sg13cmos5l_decap_4
XFILLER_8_1841 VPWR VGND sg13cmos5l_fill_1
XFILLER_4_2417 VPWR VGND sg13cmos5l_fill_1
XFILLER_4_2406 VPWR VGND sg13cmos5l_decap_8
XFILLER_1_278 VPWR VGND sg13cmos5l_fill_2
XFILLER_4_1705 VPWR VGND sg13cmos5l_decap_8
XANTENNA__0774__X Tile_X3Y0_S2BEGb[3] VPWR VGND sg13cmos5l_antennanp
XFILLER_14_842 VPWR VGND sg13cmos5l_decap_8
XFILLER_13_341 VPWR VGND sg13cmos5l_fill_2
XFILLER_13_330 VPWR VGND sg13cmos5l_fill_1
XANTENNA__1082__A1 Tile_X2Y0_N2MID[2] VPWR VGND sg13cmos5l_antennanp
XFILLER_15_91 VPWR VGND sg13cmos5l_fill_1
XANTENNA__0372__D Tile_X0Y0_FrameData[5] VPWR VGND sg13cmos5l_antennanp
XANTENNA__0950__A Tile_X2Y0_FrameStrobe[15] VPWR VGND sg13cmos5l_antennanp
XFILLER_9_356 VPWR VGND sg13cmos5l_fill_2
XANTENNA__0949__X Tile_X2Y0_FrameStrobe_O[14] VPWR VGND sg13cmos5l_antennanp
XFILLER_5_595 VPWR VGND sg13cmos5l_decap_8
XANTENNA__1137__A2 Tile_X0Y0_N2END[1] VPWR VGND sg13cmos5l_antennanp
XFILLER_9_1616 VPWR VGND sg13cmos5l_decap_8
X_0313_ _0313_/Q Tile_X0Y0_FrameData[16] VGND VPWR Tile_X1Y0_FrameStrobe[3] latch
X_0244_ _0244_/Q Tile_X0Y0_FrameData[21] VGND VPWR Tile_X1Y0_FrameStrobe[1] latch
XFILLER_3_1237 VPWR VGND sg13cmos5l_fill_2
X_0175_ _0175_/Q Tile_X0Y0_FrameData[10] VGND VPWR Tile_X0Y0_FrameStrobe[2] latch
XANTENNA__1021__A Tile_X0Y0_N2MID[1] VPWR VGND sg13cmos5l_antennanp
XFILLER_14_2514 VPWR VGND sg13cmos5l_decap_4
XANTENNA__0282__D Tile_X0Y0_FrameData[15] VPWR VGND sg13cmos5l_antennanp
XANTENNA__0860__A Tile_X4Y0_FrameStrobe[17] VPWR VGND sg13cmos5l_antennanp
XFILLER_14_2569 VPWR VGND sg13cmos5l_decap_8
XFILLER_14_1802 VPWR VGND sg13cmos5l_decap_8
XFILLER_14_1879 VPWR VGND sg13cmos5l_decap_8
XFILLER_12_1592 VPWR VGND sg13cmos5l_fill_2
XFILLER_12_1581 VPWR VGND sg13cmos5l_fill_1
XANTENNA__0567__CLK Tile_X0Y0_UserCLK VPWR VGND sg13cmos5l_antennanp
XANTENNA__0859__X Tile_X4Y0_FrameStrobe_O[16] VPWR VGND sg13cmos5l_antennanp
XANTENNA__1128__A2 Tile_X4Y0_N2MID[7] VPWR VGND sg13cmos5l_antennanp
XFILLER_8_1115 VPWR VGND sg13cmos5l_decap_8
XFILLER_5_2704 VPWR VGND sg13cmos5l_decap_8
XFILLER_8_1148 VPWR VGND sg13cmos5l_fill_2
XFILLER_5_2737 VPWR VGND sg13cmos5l_decap_8
XFILLER_3_2461 VPWR VGND sg13cmos5l_decap_8
XANTENNA__0457__D Tile_X0Y0_FrameData[16] VPWR VGND sg13cmos5l_antennanp
XFILLER_11_823 VPWR VGND sg13cmos5l_decap_8
XFILLER_11_801 VPWR VGND sg13cmos5l_decap_4
XANTENNA__0192__D Tile_X0Y0_FrameData[25] VPWR VGND sg13cmos5l_antennanp
XANTENNA__0543__Q NPU_WDATA19 VPWR VGND sg13cmos5l_antennanp
XANTENNA__0770__A Tile_X3Y0_N2MID[0] VPWR VGND sg13cmos5l_antennanp
XFILLER_13_2024 VPWR VGND sg13cmos5l_decap_8
XFILLER_13_1301 VPWR VGND sg13cmos5l_fill_1
XFILLER_13_1334 VPWR VGND sg13cmos5l_decap_8
XANTENNA__0769__X Tile_X3Y0_S2BEG[6] VPWR VGND sg13cmos5l_antennanp
XFILLER_11_1091 VPWR VGND sg13cmos5l_decap_8
XANTENNA__1119__A2 Tile_X0Y0_NN4END[5] VPWR VGND sg13cmos5l_antennanp
XFILLER_2_554 VPWR VGND sg13cmos5l_decap_8
XFILLER_8_2361 VPWR VGND sg13cmos5l_decap_8
XFILLER_4_2269 VPWR VGND sg13cmos5l_decap_8
XANTENNA__0367__D Tile_X0Y0_FrameData[10] VPWR VGND sg13cmos5l_antennanp
XANTENNA__0945__A Tile_X2Y0_FrameStrobe[10] VPWR VGND sg13cmos5l_antennanp
X_0931_ Tile_X3Y0_FrameStrobe_O[16] Tile_X3Y0_FrameStrobe[16] VPWR VGND sg13cmos5l_buf_1
XFILLER_14_672 VPWR VGND sg13cmos5l_decap_8
XFILLER_14_1109 VPWR VGND sg13cmos5l_decap_8
XFILLER_11_2709 VPWR VGND sg13cmos5l_decap_8
XFILLER_9_175 VPWR VGND sg13cmos5l_fill_1
X_0862_ Tile_X4Y0_FrameStrobe_O[19] Tile_X4Y0_FrameStrobe[19] VPWR VGND sg13cmos5l_buf_1
X_0793_ Tile_X3Y0_S4BEG[14] _1273_/X VPWR VGND sg13cmos5l_buf_1
XFILLER_6_882 VPWR VGND sg13cmos5l_decap_8
XFILLER_5_392 VPWR VGND sg13cmos5l_fill_2
XFILLER_9_1479 VPWR VGND sg13cmos5l_fill_2
XANTENNA__1016__A Tile_X0Y0_N2MID[6] VPWR VGND sg13cmos5l_antennanp
XANTENNA__0277__D Tile_X0Y0_FrameData[20] VPWR VGND sg13cmos5l_antennanp
X_1276_ _1276_/X Tile_X3Y0_N2END[1] Tile_X3Y0_N4END[1] Tile_X3Y0_NN4END[14] _0578_/Q
+ _0455_/Q _0454_/Q VPWR VGND sg13cmos5l_mux4_1
XANTENNA__0855__A Tile_X4Y0_FrameStrobe[12] VPWR VGND sg13cmos5l_antennanp
XFILLER_0_1922 VPWR VGND sg13cmos5l_decap_8
X_0227_ _0227_/Q Tile_X0Y0_FrameData[6] VGND VPWR Tile_X1Y0_FrameStrobe[0] latch
X_0158_ _0158_/Q Tile_X0Y0_FrameData[27] VGND VPWR Tile_X0Y0_FrameStrobe[2] latch
X_0089_ _0557_/D _0519_/Q _1089_/X VPWR VGND sg13cmos5l_nor2b_1
XFILLER_14_2311 VPWR VGND sg13cmos5l_decap_8
XFILLER_14_2388 VPWR VGND sg13cmos5l_decap_8
XFILLER_10_1507 VPWR VGND sg13cmos5l_fill_1
XFILLER_14_1676 VPWR VGND sg13cmos5l_decap_8
XFILLER_10_1518 VPWR VGND sg13cmos5l_decap_8
XFILLER_5_2501 VPWR VGND sg13cmos5l_decap_4
XFILLER_5_2578 VPWR VGND sg13cmos5l_decap_8
XANTENNA__0187__D Tile_X0Y0_FrameData[30] VPWR VGND sg13cmos5l_antennanp
XANTENNA__0538__Q NPU_WDATA14 VPWR VGND sg13cmos5l_antennanp
XANTENNA__0765__A Tile_X3Y0_N2MID[5] VPWR VGND sg13cmos5l_antennanp
XFILLER_5_1888 VPWR VGND sg13cmos5l_decap_8
XANTENNA__1285__A1 Tile_X3Y0_N4END[10] VPWR VGND sg13cmos5l_antennanp
XFILLER_15_2119 VPWR VGND sg13cmos5l_decap_8
XFILLER_15_1429 VPWR VGND sg13cmos5l_decap_8
XFILLER_11_675 VPWR VGND sg13cmos5l_decap_8
XFILLER_7_657 VPWR VGND sg13cmos5l_decap_8
XFILLER_7_668 VPWR VGND sg13cmos5l_fill_1
XFILLER_13_1175 VPWR VGND sg13cmos5l_decap_8
XFILLER_10_2786 VPWR VGND sg13cmos5l_decap_4
XFILLER_3_896 VPWR VGND sg13cmos5l_decap_8
XFILLER_2_362 VPWR VGND sg13cmos5l_decap_4
X_1130_ _1130_/X Tile_X4Y0_N1END[2] Tile_X4Y0_N2MID[2] Tile_X4Y0_N2MID[5] Tile_X4Y0_N2END[5]
+ _0507_/Q _0512_/Q VPWR VGND sg13cmos5l_mux4_1
XANTENNA__0097__D Tile_X0Y0_FrameData[24] VPWR VGND sg13cmos5l_antennanp
XFILLER_4_1343 VPWR VGND sg13cmos5l_decap_4
X_1061_ Tile_X4Y0_S4BEG[14] Tile_X4Y0_N4END[1] VPWR VGND sg13cmos5l_buf_1
XANTENNA__1276__A1 Tile_X3Y0_N4END[1] VPWR VGND sg13cmos5l_antennanp
XANTENNA__0962__X Tile_X1Y0_FrameStrobe_O[7] VPWR VGND sg13cmos5l_antennanp
X_0914_ Tile_X2Y0_SS4BEG[15] _1250_/X VPWR VGND sg13cmos5l_buf_1
XFILLER_15_2686 VPWR VGND sg13cmos5l_decap_8
XFILLER_11_2517 VPWR VGND sg13cmos5l_decap_8
X_0845_ Tile_X4Y0_FrameStrobe_O[2] Tile_X4Y0_FrameStrobe[2] VPWR VGND sg13cmos5l_buf_1
XFILLER_15_1985 VPWR VGND sg13cmos5l_decap_4
X_0776_ Tile_X3Y0_S2BEGb[5] _1256_/X VPWR VGND sg13cmos5l_buf_1
XANTENNA__1200__A1 Tile_X1Y0_N4END[5] VPWR VGND sg13cmos5l_antennanp
XFILLER_9_1210 VPWR VGND sg13cmos5l_decap_8
XFILLER_5_1118 VPWR VGND sg13cmos5l_decap_8
XANTENNA__1033__X Tile_X4Y0_S2BEG[2] VPWR VGND sg13cmos5l_antennanp
XFILLER_0_2442 VPWR VGND sg13cmos5l_decap_8
X_1259_ _1259_/X Tile_X3Y0_N2MID[0] Tile_X3Y0_N4END[15] Tile_X3Y0_NN4END[0] _0578_/Q
+ _0489_/Q _0488_/Q VPWR VGND sg13cmos5l_mux4_1
XANTENNA__1267__A1 Tile_X3Y0_N4END[7] VPWR VGND sg13cmos5l_antennanp
XANTENNA__0872__X Tile_X2Y0_S2BEG[5] VPWR VGND sg13cmos5l_antennanp
XANTENNA__0461__GATE Tile_X3Y0_FrameStrobe[1] VPWR VGND sg13cmos5l_antennanp
XFILLER_16_1738 VPWR VGND sg13cmos5l_decap_8
XANTENNA__0476__GATE Tile_X3Y0_FrameStrobe[2] VPWR VGND sg13cmos5l_antennanp
XFILLER_10_2016 VPWR VGND sg13cmos5l_decap_8
XANTENNA__0470__D Tile_X0Y0_FrameData[3] VPWR VGND sg13cmos5l_antennanp
XFILLER_10_1337 VPWR VGND sg13cmos5l_decap_8
XFILLER_5_2320 VPWR VGND sg13cmos5l_decap_8
XANTENNA__0414__GATE Tile_X3Y0_FrameStrobe[0] VPWR VGND sg13cmos5l_antennanp
XFILLER_5_2397 VPWR VGND sg13cmos5l_decap_4
XFILLER_5_1641 VPWR VGND sg13cmos5l_decap_8
XANTENNA__1258__A1 Tile_X3Y0_N2MID[7] VPWR VGND sg13cmos5l_antennanp
XANTENNA__0429__GATE Tile_X3Y0_FrameStrobe[0] VPWR VGND sg13cmos5l_antennanp
XANTENNA__0782__X Tile_X3Y0_S4BEG[3] VPWR VGND sg13cmos5l_antennanp
XFILLER_16_745 VPWR VGND sg13cmos5l_decap_4
XFILLER_15_244 VPWR VGND sg13cmos5l_decap_8
XFILLER_15_233 VPWR VGND sg13cmos5l_fill_2
XANTENNA__0380__D Tile_X0Y0_FrameData[29] VPWR VGND sg13cmos5l_antennanp
XFILLER_8_988 VPWR VGND sg13cmos5l_fill_2
X_0630_ _0630_/L_HI VPWR VGND sg13cmos5l_tiehi
XANTENNA__1194__A0 Tile_X1Y0_N2MID[7] VPWR VGND sg13cmos5l_antennanp
XFILLER_10_1871 VPWR VGND sg13cmos5l_decap_8
X_0561_ NPU_WE5 Tile_X0Y0_UserCLK _0561_/D _0666_/L_HI VPWR VGND sg13cmos5l_dfrbpq_1
X_0492_ _0492_/Q Tile_X0Y0_FrameData[13] VGND VPWR Tile_X3Y0_FrameStrobe[2] latch
XFILLER_6_2139 VPWR VGND sg13cmos5l_decap_8
XANTENNA__0957__X Tile_X1Y0_FrameStrobe_O[2] VPWR VGND sg13cmos5l_antennanp
XFILLER_6_1416 VPWR VGND sg13cmos5l_fill_1
X_1113_ _1113_/X Tile_X0Y0_N4END[1] Tile_X0Y0_N4END[2] Tile_X0Y0_NN4END[1] Tile_X0Y0_NN4END[3]
+ _0119_/Q _0118_/Q VPWR VGND sg13cmos5l_mux4_1
XANTENNA__1249__A1 Tile_X2Y0_N4END[14] VPWR VGND sg13cmos5l_antennanp
X_1044_ Tile_X4Y0_S2BEGb[5] Tile_X4Y0_N2END[2] VPWR VGND sg13cmos5l_buf_1
XFILLER_1_2751 VPWR VGND sg13cmos5l_decap_8
XANTENNA__0692__X Tile_X0Y0_FrameStrobe_O[5] VPWR VGND sg13cmos5l_antennanp
XFILLER_0_1037 VPWR VGND sg13cmos5l_decap_8
XFILLER_11_2314 VPWR VGND sg13cmos5l_decap_8
XANTENNA__0290__D Tile_X0Y0_FrameData[7] VPWR VGND sg13cmos5l_antennanp
X_0828_ Tile_X4Y0_FrameData_O[17] Tile_X0Y0_FrameData[17] VPWR VGND sg13cmos5l_buf_1
XFILLER_11_1657 VPWR VGND sg13cmos5l_decap_8
XANTENNA__1185__A0 Tile_X1Y0_N2MID[6] VPWR VGND sg13cmos5l_antennanp
X_0759_ Tile_X3Y0_S1BEG[0] Tile_X3Y0_N1END[3] VPWR VGND sg13cmos5l_buf_1
XFILLER_1_608 VPWR VGND sg13cmos5l_fill_2
XANTENNA__1028__X Tile_X4Y0_S1BEG[1] VPWR VGND sg13cmos5l_antennanp
XFILLER_9_1040 VPWR VGND sg13cmos5l_fill_2
XANTENNA__0867__X Tile_X2Y0_S2BEG[0] VPWR VGND sg13cmos5l_antennanp
XFILLER_6_2640 VPWR VGND sg13cmos5l_decap_8
XFILLER_9_1095 VPWR VGND sg13cmos5l_decap_8
XFILLER_2_2504 VPWR VGND sg13cmos5l_decap_8
XFILLER_2_1847 VPWR VGND sg13cmos5l_fill_1
XANTENNA__0465__D Tile_X0Y0_FrameData[8] VPWR VGND sg13cmos5l_antennanp
XFILLER_2_1869 VPWR VGND sg13cmos5l_fill_2
XFILLER_16_1502 VPWR VGND sg13cmos5l_decap_4
XFILLER_13_759 VPWR VGND sg13cmos5l_decap_8
XFILLER_13_737 VPWR VGND sg13cmos5l_decap_4
XFILLER_16_2269 VPWR VGND sg13cmos5l_decap_4
XANTENNA__0551__Q NPU_WDATA27 VPWR VGND sg13cmos5l_antennanp
XFILLER_5_958 VPWR VGND sg13cmos5l_decap_8
XFILLER_14_1270 VPWR VGND sg13cmos5l_decap_8
XANTENNA__1176__A0 Tile_X1Y0_N1END[1] VPWR VGND sg13cmos5l_antennanp
XFILLER_10_1156 VPWR VGND sg13cmos5l_decap_8
XANTENNA__0353__GATE Tile_X2Y0_FrameStrobe[1] VPWR VGND sg13cmos5l_antennanp
XANTENNA__0777__X Tile_X3Y0_S2BEGb[6] VPWR VGND sg13cmos5l_antennanp
XFILLER_7_1725 VPWR VGND sg13cmos5l_fill_2
XANTENNA__0368__GATE Tile_X2Y0_FrameStrobe[1] VPWR VGND sg13cmos5l_antennanp
XANTENNA__0375__D Tile_X0Y0_FrameData[2] VPWR VGND sg13cmos5l_antennanp
XFILLER_16_520 VPWR VGND sg13cmos5l_decap_4
XANTENNA__0953__A Tile_X2Y0_FrameStrobe[18] VPWR VGND sg13cmos5l_antennanp
XANTENNA__1100__A0 Tile_X1Y0_N4END[4] VPWR VGND sg13cmos5l_antennanp
XFILLER_16_597 VPWR VGND sg13cmos5l_decap_8
XFILLER_12_2612 VPWR VGND sg13cmos5l_decap_8
XANTENNA__0306__GATE Tile_X1Y0_FrameStrobe[3] VPWR VGND sg13cmos5l_antennanp
XFILLER_12_2689 VPWR VGND sg13cmos5l_decap_8
XFILLER_12_1966 VPWR VGND sg13cmos5l_decap_8
XANTENNA__1167__A0 Tile_X0Y0_N2END[4] VPWR VGND sg13cmos5l_antennanp
XFILLER_10_2391 VPWR VGND sg13cmos5l_decap_8
X_0613_ _0613_/L_HI VPWR VGND sg13cmos5l_tiehi
XFILLER_10_1690 VPWR VGND sg13cmos5l_decap_8
X_0544_ NPU_WDATA20 Tile_X0Y0_UserCLK _1116_/X _0683_/L_HI VPWR VGND sg13cmos5l_dfrbpq_1
XANTENNA__0687__X Tile_X0Y0_FrameStrobe_O[0] VPWR VGND sg13cmos5l_antennanp
X_0475_ _0475_/Q Tile_X0Y0_FrameData[30] VGND VPWR Tile_X3Y0_FrameStrobe[2] latch
XFILLER_15_0 VPWR VGND sg13cmos5l_fill_2
XANTENNA__1024__A Tile_X0Y0_N1END[2] VPWR VGND sg13cmos5l_antennanp
XANTENNA__0285__D Tile_X0Y0_FrameData[12] VPWR VGND sg13cmos5l_antennanp
XFILLER_1_2570 VPWR VGND sg13cmos5l_decap_8
XANTENNA__0863__A Tile_X2Y0_N1END[3] VPWR VGND sg13cmos5l_antennanp
X_1027_ Tile_X4Y0_S1BEG[0] Tile_X4Y0_N1END[3] VPWR VGND sg13cmos5l_buf_1
XFILLER_10_718 VPWR VGND sg13cmos5l_decap_8
XFILLER_15_2280 VPWR VGND sg13cmos5l_decap_8
XFILLER_11_1432 VPWR VGND sg13cmos5l_decap_8
XFILLER_11_2188 VPWR VGND sg13cmos5l_decap_8
XANTENNA__1158__A0 Tile_X0Y0_N2END[3] VPWR VGND sg13cmos5l_antennanp
XFILLER_1_449 VPWR VGND sg13cmos5l_fill_1
XFILLER_8_2768 VPWR VGND sg13cmos5l_decap_8
XFILLER_2_1622 VPWR VGND sg13cmos5l_decap_8
XANTENNA__0195__D Tile_X0Y0_FrameData[22] VPWR VGND sg13cmos5l_antennanp
XANTENNA__0546__Q NPU_WDATA22 VPWR VGND sg13cmos5l_antennanp
XFILLER_2_1699 VPWR VGND sg13cmos5l_decap_8
XFILLER_16_1321 VPWR VGND sg13cmos5l_decap_8
XFILLER_16_2066 VPWR VGND sg13cmos5l_decap_4
XFILLER_16_1365 VPWR VGND sg13cmos5l_fill_1
XFILLER_5_722 VPWR VGND sg13cmos5l_decap_8
XANTENNA__1149__A0 Tile_X0Y0_N2MID[2] VPWR VGND sg13cmos5l_antennanp
XANTENNA__0292__GATE Tile_X1Y0_FrameStrobe[2] VPWR VGND sg13cmos5l_antennanp
XANTENNA__0948__A Tile_X2Y0_FrameStrobe[13] VPWR VGND sg13cmos5l_antennanp
XFILLER_7_2245 VPWR VGND sg13cmos5l_decap_8
X_0260_ _0260_/Q Tile_X0Y0_FrameData[5] VGND VPWR Tile_X1Y0_FrameStrobe[1] latch
XFILLER_7_1555 VPWR VGND sg13cmos5l_decap_8
XFILLER_3_2109 VPWR VGND sg13cmos5l_fill_2
X_0191_ _0191_/Q Tile_X0Y0_FrameData[26] VGND VPWR Tile_X0Y0_FrameStrobe[3] latch
XFILLER_1_1176 VPWR VGND sg13cmos5l_fill_2
XANTENNA__0230__GATE Tile_X1Y0_FrameStrobe[0] VPWR VGND sg13cmos5l_antennanp
XFILLER_14_2729 VPWR VGND sg13cmos5l_decap_8
XANTENNA__0970__X Tile_X1Y0_FrameStrobe_O[15] VPWR VGND sg13cmos5l_antennanp
XANTENNA__0245__GATE Tile_X1Y0_FrameStrobe[1] VPWR VGND sg13cmos5l_antennanp
XFILLER_12_2431 VPWR VGND sg13cmos5l_decap_8
XFILLER_8_593 VPWR VGND sg13cmos5l_decap_8
XFILLER_12_1763 VPWR VGND sg13cmos5l_decap_8
XANTENNA__1019__A Tile_X0Y0_N2MID[3] VPWR VGND sg13cmos5l_antennanp
XANTENNA__0858__A Tile_X4Y0_FrameStrobe[15] VPWR VGND sg13cmos5l_antennanp
X_0527_ NPU_WDATA3 Tile_X0Y0_UserCLK _1099_/X _0625_/L_HI VPWR VGND sg13cmos5l_dfrbpq_1
X_0458_ _0458_/Q Tile_X0Y0_FrameData[15] VGND VPWR Tile_X3Y0_FrameStrobe[1] latch
X_0389_ _0389_/Q Tile_X0Y0_FrameData[20] VGND VPWR Tile_X2Y0_FrameStrobe[2] latch
XFILLER_3_2687 VPWR VGND sg13cmos5l_decap_8
XFILLER_3_1964 VPWR VGND sg13cmos5l_fill_2
XFILLER_3_1986 VPWR VGND sg13cmos5l_fill_1
XANTENNA__1041__X Tile_X4Y0_S2BEGb[2] VPWR VGND sg13cmos5l_antennanp
XANTENNA__0880__X Tile_X2Y0_S2BEGb[5] VPWR VGND sg13cmos5l_antennanp
XANTENNA__1091__A2 Tile_X3Y0_N2MID[4] VPWR VGND sg13cmos5l_antennanp
XFILLER_13_2217 VPWR VGND sg13cmos5l_decap_8
XFILLER_6_508 VPWR VGND sg13cmos5l_decap_8
XFILLER_13_1527 VPWR VGND sg13cmos5l_decap_4
XFILLER_2_703 VPWR VGND sg13cmos5l_decap_8
XFILLER_11_1273 VPWR VGND sg13cmos5l_decap_8
XANTENNA__0768__A Tile_X3Y0_N2MID[2] VPWR VGND sg13cmos5l_antennanp
XFILLER_8_2565 VPWR VGND sg13cmos5l_decap_8
XFILLER_8_2543 VPWR VGND sg13cmos5l_decap_8
XFILLER_8_1820 VPWR VGND sg13cmos5l_decap_8
XFILLER_1_257 VPWR VGND sg13cmos5l_decap_8
XFILLER_4_2429 VPWR VGND sg13cmos5l_decap_8
XFILLER_8_1886 VPWR VGND sg13cmos5l_decap_4
XFILLER_2_2186 VPWR VGND sg13cmos5l_decap_8
XANTENNA__0790__X Tile_X3Y0_S4BEG[11] VPWR VGND sg13cmos5l_antennanp
XANTENNA__1082__A2 Tile_X2Y0_N2MID[5] VPWR VGND sg13cmos5l_antennanp
XFILLER_13_2784 VPWR VGND sg13cmos5l_decap_8
XFILLER_5_574 VPWR VGND sg13cmos5l_decap_8
X_0312_ _0312_/Q Tile_X0Y0_FrameData[17] VGND VPWR Tile_X1Y0_FrameStrobe[3] latch
XFILLER_7_2064 VPWR VGND sg13cmos5l_fill_1
XFILLER_7_1330 VPWR VGND sg13cmos5l_fill_1
XANTENNA__0965__X Tile_X1Y0_FrameStrobe_O[10] VPWR VGND sg13cmos5l_antennanp
X_0243_ _0243_/Q Tile_X0Y0_FrameData[22] VGND VPWR Tile_X1Y0_FrameStrobe[1] latch
XFILLER_7_1396 VPWR VGND sg13cmos5l_decap_8
XFILLER_7_1374 VPWR VGND sg13cmos5l_fill_2
XFILLER_3_1216 VPWR VGND sg13cmos5l_decap_8
X_0174_ _0174_/Q Tile_X0Y0_FrameData[11] VGND VPWR Tile_X0Y0_FrameStrobe[2] latch
XFILLER_16_191 VPWR VGND sg13cmos5l_decap_8
XANTENNA__0184__GATE Tile_X0Y0_FrameStrobe[2] VPWR VGND sg13cmos5l_antennanp
XFILLER_14_2559 VPWR VGND sg13cmos5l_decap_4
XFILLER_14_1858 VPWR VGND sg13cmos5l_decap_8
XFILLER_11_39 VPWR VGND sg13cmos5l_fill_2
XFILLER_11_17 VPWR VGND sg13cmos5l_fill_2
XANTENNA__0199__GATE Tile_X0Y0_FrameStrobe[3] VPWR VGND sg13cmos5l_antennanp
XFILLER_12_1560 VPWR VGND sg13cmos5l_decap_8
XANTENNA__1128__A3 Tile_X4Y0_N2END[7] VPWR VGND sg13cmos5l_antennanp
XANTENNA__0122__GATE Tile_X0Y0_FrameStrobe[1] VPWR VGND sg13cmos5l_antennanp
XANTENNA__1036__X Tile_X4Y0_S2BEG[5] VPWR VGND sg13cmos5l_antennanp
XANTENNA__0875__X Tile_X2Y0_S2BEGb[0] VPWR VGND sg13cmos5l_antennanp
XFILLER_3_2440 VPWR VGND sg13cmos5l_decap_8
XFILLER_3_1750 VPWR VGND sg13cmos5l_decap_8
XANTENNA__0137__GATE Tile_X0Y0_FrameStrobe[1] VPWR VGND sg13cmos5l_antennanp
XFILLER_14_139 VPWR VGND sg13cmos5l_fill_2
XANTENNA__0473__D Tile_X0Y0_FrameData[0] VPWR VGND sg13cmos5l_antennanp
XFILLER_13_2003 VPWR VGND sg13cmos5l_decap_8
XFILLER_10_334 VPWR VGND sg13cmos5l_decap_8
XFILLER_7_839 VPWR VGND sg13cmos5l_decap_8
XFILLER_13_1313 VPWR VGND sg13cmos5l_decap_8
XFILLER_2_533 VPWR VGND sg13cmos5l_decap_8
XANTENNA__1119__A3 Tile_X0Y0_NN4END[7] VPWR VGND sg13cmos5l_antennanp
XFILLER_8_2340 VPWR VGND sg13cmos5l_decap_8
XFILLER_8_1661 VPWR VGND sg13cmos5l_decap_8
XANTENNA__0785__X Tile_X3Y0_S4BEG[6] VPWR VGND sg13cmos5l_antennanp
XFILLER_4_2248 VPWR VGND sg13cmos5l_decap_8
XFILLER_2_1260 VPWR VGND sg13cmos5l_decap_4
XANTENNA__0383__D Tile_X0Y0_FrameData[26] VPWR VGND sg13cmos5l_antennanp
XANTENNA__0961__A Tile_X1Y0_FrameStrobe[6] VPWR VGND sg13cmos5l_antennanp
X_0930_ Tile_X3Y0_FrameStrobe_O[15] Tile_X3Y0_FrameStrobe[15] VPWR VGND sg13cmos5l_buf_1
XFILLER_14_651 VPWR VGND sg13cmos5l_decap_8
XFILLER_13_150 VPWR VGND sg13cmos5l_decap_4
XFILLER_9_154 VPWR VGND sg13cmos5l_fill_1
XFILLER_9_165 VPWR VGND sg13cmos5l_fill_2
X_0861_ Tile_X4Y0_FrameStrobe_O[18] Tile_X4Y0_FrameStrobe[18] VPWR VGND sg13cmos5l_buf_1
X_0792_ Tile_X3Y0_S4BEG[13] _1272_/X VPWR VGND sg13cmos5l_buf_1
XFILLER_13_1891 VPWR VGND sg13cmos5l_decap_8
XFILLER_9_1414 VPWR VGND sg13cmos5l_decap_8
XANTENNA__0695__X Tile_X0Y0_FrameStrobe_O[8] VPWR VGND sg13cmos5l_antennanp
X_1275_ _1275_/X Tile_X3Y0_N2END[0] Tile_X3Y0_N4END[0] Tile_X3Y0_NN4END[15] _0579_/Q
+ _0457_/Q _0456_/Q VPWR VGND sg13cmos5l_mux4_1
XFILLER_0_2613 VPWR VGND sg13cmos5l_decap_8
X_0226_ _0226_/Q Tile_X0Y0_FrameData[7] VGND VPWR Tile_X1Y0_FrameStrobe[0] latch
XFILLER_0_1912 VPWR VGND sg13cmos5l_decap_4
XFILLER_0_2657 VPWR VGND sg13cmos5l_fill_2
XANTENNA__1032__A Tile_X4Y0_N2MID[6] VPWR VGND sg13cmos5l_antennanp
XFILLER_0_1956 VPWR VGND sg13cmos5l_fill_1
X_0157_ _0157_/Q Tile_X0Y0_FrameData[28] VGND VPWR Tile_X0Y0_FrameStrobe[2] latch
XFILLER_0_1989 VPWR VGND sg13cmos5l_fill_1
X_0088_ _0559_/D _0517_/Q _1091_/X VPWR VGND sg13cmos5l_nor2b_1
XANTENNA__0293__D Tile_X0Y0_FrameData[4] VPWR VGND sg13cmos5l_antennanp
XANTENNA__0871__A Tile_X2Y0_N2MID[3] VPWR VGND sg13cmos5l_antennanp
XANTENNA__0534__CLK Tile_X0Y0_UserCLK VPWR VGND sg13cmos5l_antennanp
XFILLER_10_2209 VPWR VGND sg13cmos5l_decap_8
XFILLER_14_2367 VPWR VGND sg13cmos5l_decap_8
XFILLER_14_1655 VPWR VGND sg13cmos5l_decap_8
XFILLER_0_9 VPWR VGND sg13cmos5l_fill_1
XFILLER_5_2524 VPWR VGND sg13cmos5l_decap_4
XANTENNA__0468__D Tile_X0Y0_FrameData[5] VPWR VGND sg13cmos5l_antennanp
XFILLER_5_2557 VPWR VGND sg13cmos5l_decap_8
XFILLER_5_1845 VPWR VGND sg13cmos5l_fill_1
XANTENNA__1285__A2 Tile_X3Y0_NN4END[5] VPWR VGND sg13cmos5l_antennanp
XFILLER_3_1580 VPWR VGND sg13cmos5l_decap_8
XFILLER_16_949 VPWR VGND sg13cmos5l_fill_1
XANTENNA__0554__Q NPU_WDATA30 VPWR VGND sg13cmos5l_antennanp
XFILLER_11_654 VPWR VGND sg13cmos5l_decap_8
XFILLER_7_636 VPWR VGND sg13cmos5l_decap_8
XFILLER_6_135 VPWR VGND sg13cmos5l_fill_1
XFILLER_6_146 VPWR VGND sg13cmos5l_decap_8
XFILLER_13_1154 VPWR VGND sg13cmos5l_decap_8
XFILLER_10_2765 VPWR VGND sg13cmos5l_decap_8
XFILLER_3_853 VPWR VGND sg13cmos5l_fill_1
XANTENNA__0378__D Tile_X0Y0_FrameData[31] VPWR VGND sg13cmos5l_antennanp
XANTENNA__0956__A Tile_X1Y0_FrameStrobe[1] VPWR VGND sg13cmos5l_antennanp
XFILLER_4_2089 VPWR VGND sg13cmos5l_fill_1
X_1060_ Tile_X4Y0_S4BEG[13] Tile_X4Y0_N4END[2] VPWR VGND sg13cmos5l_buf_1
XFILLER_4_1355 VPWR VGND sg13cmos5l_decap_8
XANTENNA__1276__A2 Tile_X3Y0_NN4END[14] VPWR VGND sg13cmos5l_antennanp
XANTENNA__0557__CLK Tile_X0Y0_UserCLK VPWR VGND sg13cmos5l_antennanp
XANTENNA__0691__A Tile_X0Y0_FrameStrobe[4] VPWR VGND sg13cmos5l_antennanp
X_0913_ Tile_X2Y0_SS4BEG[14] _1249_/X VPWR VGND sg13cmos5l_buf_1
XFILLER_15_2665 VPWR VGND sg13cmos5l_decap_8
X_0844_ Tile_X4Y0_FrameStrobe_O[1] Tile_X4Y0_FrameStrobe[1] VPWR VGND sg13cmos5l_buf_1
XFILLER_11_1839 VPWR VGND sg13cmos5l_decap_8
X_0775_ Tile_X3Y0_S2BEGb[4] _1255_/X VPWR VGND sg13cmos5l_buf_1
XFILLER_6_680 VPWR VGND sg13cmos5l_decap_8
XANTENNA__1200__A2 Tile_X1Y0_NN4END[10] VPWR VGND sg13cmos5l_antennanp
XANTENNA__1027__A Tile_X4Y0_N1END[3] VPWR VGND sg13cmos5l_antennanp
XANTENNA__0288__D Tile_X0Y0_FrameData[9] VPWR VGND sg13cmos5l_antennanp
XFILLER_9_1266 VPWR VGND sg13cmos5l_decap_8
XFILLER_9_1288 VPWR VGND sg13cmos5l_decap_4
XFILLER_2_2719 VPWR VGND sg13cmos5l_decap_8
XANTENNA__0866__A Tile_X2Y0_N1END[0] VPWR VGND sg13cmos5l_antennanp
XFILLER_0_2421 VPWR VGND sg13cmos5l_decap_8
X_1258_ _1258_/X Tile_X3Y0_N1END[3] Tile_X3Y0_N2MID[7] Tile_X3Y0_N2END[0] _0579_/Q
+ _0491_/Q _0490_/Q VPWR VGND sg13cmos5l_mux4_1
XANTENNA__1267__A2 Tile_X3Y0_NN4END[8] VPWR VGND sg13cmos5l_antennanp
X_0209_ _0209_/Q Tile_X0Y0_FrameData[24] VGND VPWR Tile_X1Y0_FrameStrobe[0] latch
X_1189_ _1189_/X Tile_X1Y0_N2MID[2] Tile_X1Y0_N4END[5] Tile_X1Y0_NN4END[10] _0590_/Q
+ _0277_/Q _0276_/Q VPWR VGND sg13cmos5l_mux4_1
XFILLER_0_2498 VPWR VGND sg13cmos5l_decap_8
XFILLER_0_1775 VPWR VGND sg13cmos5l_fill_1
XFILLER_16_1717 VPWR VGND sg13cmos5l_decap_8
XFILLER_16_1706 VPWR VGND sg13cmos5l_fill_1
XFILLER_10_1316 VPWR VGND sg13cmos5l_decap_8
XFILLER_0_834 VPWR VGND sg13cmos5l_fill_1
XANTENNA__0198__D Tile_X0Y0_FrameData[19] VPWR VGND sg13cmos5l_antennanp
XANTENNA__0549__Q NPU_WDATA25 VPWR VGND sg13cmos5l_antennanp
XFILLER_0_878 VPWR VGND sg13cmos5l_fill_1
XFILLER_5_2376 VPWR VGND sg13cmos5l_decap_8
XFILLER_5_1620 VPWR VGND sg13cmos5l_decap_8
XANTENNA__1258__A2 Tile_X3Y0_N2END[0] VPWR VGND sg13cmos5l_antennanp
XFILLER_5_1697 VPWR VGND sg13cmos5l_decap_8
XFILLER_16_724 VPWR VGND sg13cmos5l_decap_8
XANTENNA__1194__A1 Tile_X1Y0_N4END[0] VPWR VGND sg13cmos5l_antennanp
X_0560_ NPU_WE4 Tile_X0Y0_UserCLK _0560_/D _0667_/L_HI VPWR VGND sg13cmos5l_dfrbpq_1
XFILLER_10_1894 VPWR VGND sg13cmos5l_decap_8
X_0491_ _0491_/Q Tile_X0Y0_FrameData[14] VGND VPWR Tile_X3Y0_FrameStrobe[2] latch
XFILLER_6_2118 VPWR VGND sg13cmos5l_decap_8
XFILLER_3_694 VPWR VGND sg13cmos5l_decap_8
XFILLER_2_160 VPWR VGND sg13cmos5l_decap_8
X_1112_ _1112_/X Tile_X0Y0_N4END[0] Tile_X0Y0_N4END[1] Tile_X0Y0_NN4END[0] Tile_X0Y0_NN4END[2]
+ _0121_/Q _0120_/Q VPWR VGND sg13cmos5l_mux4_1
XFILLER_4_1141 VPWR VGND sg13cmos5l_decap_8
XANTENNA__0973__X Tile_X1Y0_FrameStrobe_O[18] VPWR VGND sg13cmos5l_antennanp
XANTENNA__1249__A2 Tile_X2Y0_NN4END[1] VPWR VGND sg13cmos5l_antennanp
X_1043_ Tile_X4Y0_S2BEGb[4] Tile_X4Y0_N2END[3] VPWR VGND sg13cmos5l_buf_1
XFILLER_15_2484 VPWR VGND sg13cmos5l_decap_8
X_0827_ Tile_X4Y0_FrameData_O[16] Tile_X0Y0_FrameData[16] VPWR VGND sg13cmos5l_buf_1
XFILLER_11_1636 VPWR VGND sg13cmos5l_decap_8
XANTENNA__1185__A1 Tile_X1Y0_N4END[9] VPWR VGND sg13cmos5l_antennanp
X_0758_ Tile_X1Y0_S2BEG[7] Tile_X1Y0_N2MID[0] VPWR VGND sg13cmos5l_buf_1
X_0689_ Tile_X0Y0_FrameStrobe_O[2] Tile_X0Y0_FrameStrobe[2] VPWR VGND sg13cmos5l_buf_1
XFILLER_9_1074 VPWR VGND sg13cmos5l_decap_8
XANTENNA__1044__X Tile_X4Y0_S2BEGb[5] VPWR VGND sg13cmos5l_antennanp
XFILLER_6_2696 VPWR VGND sg13cmos5l_decap_8
XFILLER_6_1940 VPWR VGND sg13cmos5l_fill_1
XFILLER_6_1962 VPWR VGND sg13cmos5l_decap_4
XANTENNA__0883__X Tile_X2Y0_S4BEG[0] VPWR VGND sg13cmos5l_antennanp
XFILLER_0_2240 VPWR VGND sg13cmos5l_decap_8
XFILLER_13_716 VPWR VGND sg13cmos5l_decap_8
XFILLER_9_709 VPWR VGND sg13cmos5l_fill_2
XFILLER_16_2248 VPWR VGND sg13cmos5l_decap_8
XFILLER_16_2215 VPWR VGND sg13cmos5l_decap_8
XFILLER_16_1525 VPWR VGND sg13cmos5l_decap_8
XANTENNA__0481__D Tile_X0Y0_FrameData[24] VPWR VGND sg13cmos5l_antennanp
XFILLER_8_219 VPWR VGND sg13cmos5l_fill_1
XFILLER_10_1135 VPWR VGND sg13cmos5l_decap_8
XANTENNA__1176__A1 Tile_X1Y0_N2MID[5] VPWR VGND sg13cmos5l_antennanp
XFILLER_7_2427 VPWR VGND sg13cmos5l_decap_8
XFILLER_0_642 VPWR VGND sg13cmos5l_fill_1
XFILLER_7_1715 VPWR VGND sg13cmos5l_decap_4
XFILLER_0_686 VPWR VGND sg13cmos5l_fill_2
XFILLER_5_2195 VPWR VGND sg13cmos5l_decap_8
XANTENNA__0793__X Tile_X3Y0_S4BEG[14] VPWR VGND sg13cmos5l_antennanp
XANTENNA__1100__A1 Tile_X1Y0_N4END[5] VPWR VGND sg13cmos5l_antennanp
XFILLER_1_1369 VPWR VGND sg13cmos5l_decap_8
XFILLER_16_565 VPWR VGND sg13cmos5l_decap_8
XANTENNA__0391__D Tile_X0Y0_FrameData[18] VPWR VGND sg13cmos5l_antennanp
XFILLER_16_2793 VPWR VGND sg13cmos5l_fill_2
XFILLER_16_2782 VPWR VGND sg13cmos5l_decap_8
XFILLER_12_760 VPWR VGND sg13cmos5l_fill_1
XFILLER_7_241 VPWR VGND sg13cmos5l_decap_8
XFILLER_12_2668 VPWR VGND sg13cmos5l_decap_8
XFILLER_12_1945 VPWR VGND sg13cmos5l_decap_8
XFILLER_10_2370 VPWR VGND sg13cmos5l_decap_8
X_0612_ _0612_/L_HI VPWR VGND sg13cmos5l_tiehi
XANTENNA__0968__X Tile_X1Y0_FrameStrobe_O[13] VPWR VGND sg13cmos5l_antennanp
XANTENNA__1167__A1 Tile_X0Y0_N4END[12] VPWR VGND sg13cmos5l_antennanp
XANTENNA__0460__GATE Tile_X3Y0_FrameStrobe[1] VPWR VGND sg13cmos5l_antennanp
X_0543_ NPU_WDATA19 Tile_X0Y0_UserCLK _1115_/X _0684_/L_HI VPWR VGND sg13cmos5l_dfrbpq_1
X_0474_ _0474_/Q Tile_X0Y0_FrameData[31] VGND VPWR Tile_X3Y0_FrameStrobe[2] latch
XFILLER_6_1214 VPWR VGND sg13cmos5l_decap_8
XANTENNA__0475__GATE Tile_X3Y0_FrameStrobe[2] VPWR VGND sg13cmos5l_antennanp
XFILLER_1_2560 VPWR VGND sg13cmos5l_decap_4
X_1026_ Tile_X0Y0_S1BEG[3] Tile_X0Y0_N1END[0] VPWR VGND sg13cmos5l_buf_1
XANTENNA__1040__A Tile_X4Y0_N2END[6] VPWR VGND sg13cmos5l_antennanp
XANTENNA__0413__GATE Tile_X3Y0_FrameStrobe[0] VPWR VGND sg13cmos5l_antennanp
XANTENNA__1039__X Tile_X4Y0_S2BEGb[0] VPWR VGND sg13cmos5l_antennanp
XANTENNA__1158__A1 Tile_X0Y0_N4END[3] VPWR VGND sg13cmos5l_antennanp
XFILLER_11_1488 VPWR VGND sg13cmos5l_decap_8
XANTENNA__0428__GATE Tile_X3Y0_FrameStrobe[0] VPWR VGND sg13cmos5l_antennanp
XANTENNA__0878__X Tile_X2Y0_S2BEGb[3] VPWR VGND sg13cmos5l_antennanp
XFILLER_8_2747 VPWR VGND sg13cmos5l_decap_8
XFILLER_2_2302 VPWR VGND sg13cmos5l_fill_1
XFILLER_6_2482 VPWR VGND sg13cmos5l_decap_4
XANTENNA__0476__D Tile_X0Y0_FrameData[29] VPWR VGND sg13cmos5l_antennanp
XFILLER_6_1781 VPWR VGND sg13cmos5l_decap_8
XFILLER_2_1601 VPWR VGND sg13cmos5l_decap_8
XFILLER_0_2092 VPWR VGND sg13cmos5l_fill_2
XFILLER_2_1678 VPWR VGND sg13cmos5l_decap_8
XANTENNA__1094__A0 Tile_X3Y0_N1END[2] VPWR VGND sg13cmos5l_antennanp
XFILLER_16_2045 VPWR VGND sg13cmos5l_decap_8
XFILLER_16_1300 VPWR VGND sg13cmos5l_decap_8
XANTENNA__0562__Q NPU_WE6 VPWR VGND sg13cmos5l_antennanp
XFILLER_9_539 VPWR VGND sg13cmos5l_fill_1
XFILLER_13_579 VPWR VGND sg13cmos5l_decap_8
XFILLER_5_701 VPWR VGND sg13cmos5l_decap_8
XFILLER_4_200 VPWR VGND sg13cmos5l_decap_8
XFILLER_5_756 VPWR VGND sg13cmos5l_decap_8
XFILLER_4_222 VPWR VGND sg13cmos5l_decap_4
XANTENNA__1149__A1 Tile_X0Y0_N4END[5] VPWR VGND sg13cmos5l_antennanp
XANTENNA__0788__X Tile_X3Y0_S4BEG[9] VPWR VGND sg13cmos5l_antennanp
XFILLER_4_288 VPWR VGND sg13cmos5l_fill_1
XFILLER_4_277 VPWR VGND sg13cmos5l_fill_2
XFILLER_7_2224 VPWR VGND sg13cmos5l_decap_8
XFILLER_7_1534 VPWR VGND sg13cmos5l_decap_8
XFILLER_1_973 VPWR VGND sg13cmos5l_fill_1
XFILLER_7_1578 VPWR VGND sg13cmos5l_decap_8
XANTENNA__0386__D Tile_X0Y0_FrameData[23] VPWR VGND sg13cmos5l_antennanp
X_0190_ _0190_/Q Tile_X0Y0_FrameData[27] VGND VPWR Tile_X0Y0_FrameStrobe[3] latch
XANTENNA__0964__A Tile_X1Y0_FrameStrobe[9] VPWR VGND sg13cmos5l_antennanp
XFILLER_16_351 VPWR VGND sg13cmos5l_fill_1
XANTENNA__1085__A0 Tile_X2Y0_N1END[1] VPWR VGND sg13cmos5l_antennanp
XFILLER_1_1188 VPWR VGND sg13cmos5l_decap_8
XFILLER_16_373 VPWR VGND sg13cmos5l_decap_8
XFILLER_16_362 VPWR VGND sg13cmos5l_fill_2
XFILLER_12_2410 VPWR VGND sg13cmos5l_decap_8
XFILLER_12_590 VPWR VGND sg13cmos5l_decap_8
XFILLER_8_572 VPWR VGND sg13cmos5l_decap_8
XFILLER_6_51 VPWR VGND sg13cmos5l_fill_1
XFILLER_12_2487 VPWR VGND sg13cmos5l_decap_8
XFILLER_12_1742 VPWR VGND sg13cmos5l_decap_8
XANTENNA__0698__X Tile_X0Y0_FrameStrobe_O[11] VPWR VGND sg13cmos5l_antennanp
X_0526_ NPU_WDATA2 Tile_X0Y0_UserCLK _1098_/X _0626_/L_HI VPWR VGND sg13cmos5l_dfrbpq_1
XANTENNA__1035__A Tile_X4Y0_N2MID[3] VPWR VGND sg13cmos5l_antennanp
X_0457_ _0457_/Q Tile_X0Y0_FrameData[16] VGND VPWR Tile_X3Y0_FrameStrobe[1] latch
XANTENNA__0296__D Tile_X0Y0_FrameData[1] VPWR VGND sg13cmos5l_antennanp
X_0388_ _0388_/Q Tile_X0Y0_FrameData[21] VGND VPWR Tile_X2Y0_FrameStrobe[2] latch
XFILLER_6_1088 VPWR VGND sg13cmos5l_decap_8
XFILLER_3_2666 VPWR VGND sg13cmos5l_decap_8
XANTENNA__0874__A Tile_X2Y0_N2MID[0] VPWR VGND sg13cmos5l_antennanp
X_1009_ Tile_X0Y0_S2BEGb[2] _1133_/X VPWR VGND sg13cmos5l_buf_1
XANTENNA__0352__GATE Tile_X2Y0_FrameStrobe[1] VPWR VGND sg13cmos5l_antennanp
XANTENNA__1091__A3 Tile_X3Y0_N2END[4] VPWR VGND sg13cmos5l_antennanp
XFILLER_13_1506 VPWR VGND sg13cmos5l_decap_8
XFILLER_10_549 VPWR VGND sg13cmos5l_decap_8
XANTENNA__0367__GATE Tile_X2Y0_FrameStrobe[1] VPWR VGND sg13cmos5l_antennanp
XFILLER_11_1252 VPWR VGND sg13cmos5l_decap_8
XFILLER_8_2522 VPWR VGND sg13cmos5l_decap_8
XFILLER_1_236 VPWR VGND sg13cmos5l_decap_8
XFILLER_8_1865 VPWR VGND sg13cmos5l_decap_8
XANTENNA__0557__Q NPU_WE1 VPWR VGND sg13cmos5l_antennanp
XFILLER_2_2165 VPWR VGND sg13cmos5l_decap_8
XANTENNA__0305__GATE Tile_X1Y0_FrameStrobe[3] VPWR VGND sg13cmos5l_antennanp
XFILLER_2_1475 VPWR VGND sg13cmos5l_fill_1
XFILLER_2_1464 VPWR VGND sg13cmos5l_decap_8
XFILLER_14_822 VPWR VGND sg13cmos5l_decap_4
XFILLER_13_343 VPWR VGND sg13cmos5l_fill_1
XFILLER_13_321 VPWR VGND sg13cmos5l_decap_8
XANTENNA__0590__CLK Tile_X0Y0_UserCLK VPWR VGND sg13cmos5l_antennanp
XANTENNA__1082__A3 Tile_X2Y0_N2END[5] VPWR VGND sg13cmos5l_antennanp
XFILLER_9_303 VPWR VGND sg13cmos5l_fill_2
XFILLER_13_354 VPWR VGND sg13cmos5l_fill_1
XFILLER_16_1152 VPWR VGND sg13cmos5l_decap_8
XFILLER_16_1196 VPWR VGND sg13cmos5l_fill_2
XFILLER_13_2763 VPWR VGND sg13cmos5l_decap_8
XFILLER_12_1027 VPWR VGND sg13cmos5l_fill_1
XFILLER_12_1049 VPWR VGND sg13cmos5l_decap_8
XFILLER_5_553 VPWR VGND sg13cmos5l_decap_8
XANTENNA__0959__A Tile_X1Y0_FrameStrobe[4] VPWR VGND sg13cmos5l_antennanp
XFILLER_9_2319 VPWR VGND sg13cmos5l_decap_8
X_0311_ _0311_/Q Tile_X0Y0_FrameData[18] VGND VPWR Tile_X1Y0_FrameStrobe[3] latch
XFILLER_7_2043 VPWR VGND sg13cmos5l_decap_8
XFILLER_0_291 VPWR VGND sg13cmos5l_decap_8
XFILLER_0_2806 VPWR VGND sg13cmos5l_fill_2
X_0242_ _0242_/Q Tile_X0Y0_FrameData[23] VGND VPWR Tile_X1Y0_FrameStrobe[1] latch
XANTENNA__0694__A Tile_X0Y0_FrameStrobe[7] VPWR VGND sg13cmos5l_antennanp
X_0173_ _0173_/Q Tile_X0Y0_FrameData[12] VGND VPWR Tile_X0Y0_FrameStrobe[2] latch
XANTENNA__0981__X Tile_X0Y0_SS4BEG[6] VPWR VGND sg13cmos5l_antennanp
XFILLER_16_170 VPWR VGND sg13cmos5l_decap_8
XFILLER_14_2538 VPWR VGND sg13cmos5l_decap_8
XFILLER_14_1837 VPWR VGND sg13cmos5l_decap_8
XANTENNA__1230__A0 Tile_X2Y0_N2MID[3] VPWR VGND sg13cmos5l_antennanp
XFILLER_12_2284 VPWR VGND sg13cmos5l_decap_8
XANTENNA__0869__A Tile_X2Y0_N2MID[5] VPWR VGND sg13cmos5l_antennanp
X_0509_ _0509_/Q Tile_X0Y0_FrameData[28] VGND VPWR Tile_X4Y0_FrameStrobe[0] latch
XANTENNA__1052__X Tile_X4Y0_S4BEG[5] VPWR VGND sg13cmos5l_antennanp
XFILLER_15_619 VPWR VGND sg13cmos5l_decap_8
XANTENNA__0891__X Tile_X2Y0_S4BEG[8] VPWR VGND sg13cmos5l_antennanp
XFILLER_14_129 VPWR VGND sg13cmos5l_decap_8
XANTENNA__0291__GATE Tile_X1Y0_FrameStrobe[2] VPWR VGND sg13cmos5l_antennanp
XFILLER_13_2059 VPWR VGND sg13cmos5l_decap_8
XANTENNA__1221__A0 Tile_X2Y0_N2MID[2] VPWR VGND sg13cmos5l_antennanp
XFILLER_13_1369 VPWR VGND sg13cmos5l_decap_8
XFILLER_2_512 VPWR VGND sg13cmos5l_decap_8
XFILLER_2_589 VPWR VGND sg13cmos5l_decap_8
XFILLER_8_2396 VPWR VGND sg13cmos5l_decap_8
XFILLER_8_1640 VPWR VGND sg13cmos5l_decap_8
XFILLER_4_2227 VPWR VGND sg13cmos5l_decap_8
XFILLER_4_1515 VPWR VGND sg13cmos5l_decap_4
XFILLER_4_1504 VPWR VGND sg13cmos5l_decap_4
XANTENNA__0244__GATE Tile_X1Y0_FrameStrobe[1] VPWR VGND sg13cmos5l_antennanp
XANTENNA__1288__A0 Tile_X3Y0_N2END[5] VPWR VGND sg13cmos5l_antennanp
XANTENNA__0259__GATE Tile_X1Y0_FrameStrobe[1] VPWR VGND sg13cmos5l_antennanp
XFILLER_14_630 VPWR VGND sg13cmos5l_decap_8
XFILLER_13_184 VPWR VGND sg13cmos5l_decap_8
XFILLER_13_173 VPWR VGND sg13cmos5l_fill_1
XFILLER_13_162 VPWR VGND sg13cmos5l_decap_8
X_0860_ Tile_X4Y0_FrameStrobe_O[17] Tile_X4Y0_FrameStrobe[17] VPWR VGND sg13cmos5l_buf_1
X_0791_ Tile_X3Y0_S4BEG[12] _1271_/X VPWR VGND sg13cmos5l_buf_1
XFILLER_13_2593 VPWR VGND sg13cmos5l_decap_8
XFILLER_10_880 VPWR VGND sg13cmos5l_decap_4
XANTENNA__1212__A0 Tile_X2Y0_N1END[1] VPWR VGND sg13cmos5l_antennanp
XFILLER_13_1870 VPWR VGND sg13cmos5l_decap_8
XANTENNA__0689__A Tile_X0Y0_FrameStrobe[2] VPWR VGND sg13cmos5l_antennanp
XFILLER_9_2127 VPWR VGND sg13cmos5l_decap_8
XFILLER_9_1448 VPWR VGND sg13cmos5l_fill_1
XANTENNA__0976__X Tile_X0Y0_SS4BEG[1] VPWR VGND sg13cmos5l_antennanp
X_1274_ _1274_/X Tile_X3Y0_N2MID[7] Tile_X3Y0_N4END[0] Tile_X3Y0_NN4END[15] _0573_/Q
+ _0459_/Q _0458_/Q VPWR VGND sg13cmos5l_mux4_1
XFILLER_3_96 VPWR VGND sg13cmos5l_fill_2
XANTENNA__1279__A0 Tile_X3Y0_N2END[4] VPWR VGND sg13cmos5l_antennanp
X_0225_ _0225_/Q Tile_X0Y0_FrameData[8] VGND VPWR Tile_X1Y0_FrameStrobe[0] latch
XFILLER_4_2783 VPWR VGND sg13cmos5l_decap_4
XANTENNA__0574__D NPU_RDATA2 VPWR VGND sg13cmos5l_antennanp
XFILLER_0_2669 VPWR VGND sg13cmos5l_fill_2
X_0156_ _0156_/Q Tile_X0Y0_FrameData[29] VGND VPWR Tile_X0Y0_FrameStrobe[2] latch
X_0087_ _0562_/D _0514_/Q _1094_/X VPWR VGND sg13cmos5l_nor2b_1
XFILLER_14_2346 VPWR VGND sg13cmos5l_decap_8
XFILLER_14_1634 VPWR VGND sg13cmos5l_decap_8
X_0989_ Tile_X0Y0_SS4BEG[14] _1169_/X VPWR VGND sg13cmos5l_buf_1
XANTENNA__1203__A0 Tile_X1Y0_N2END[0] VPWR VGND sg13cmos5l_antennanp
XFILLER_12_2081 VPWR VGND sg13cmos5l_decap_8
XANTENNA__1047__X Tile_X4Y0_S4BEG[0] VPWR VGND sg13cmos5l_antennanp
XANTENNA__0886__X Tile_X2Y0_S4BEG[3] VPWR VGND sg13cmos5l_antennanp
XFILLER_9_2683 VPWR VGND sg13cmos5l_decap_8
XANTENNA__0484__D Tile_X0Y0_FrameData[21] VPWR VGND sg13cmos5l_antennanp
XFILLER_11_633 VPWR VGND sg13cmos5l_decap_8
XFILLER_7_615 VPWR VGND sg13cmos5l_decap_8
XANTENNA__0570__Q NPU_ADDR6 VPWR VGND sg13cmos5l_antennanp
XFILLER_10_165 VPWR VGND sg13cmos5l_decap_8
XFILLER_6_103 VPWR VGND sg13cmos5l_fill_2
XFILLER_13_1133 VPWR VGND sg13cmos5l_decap_8
XFILLER_11_699 VPWR VGND sg13cmos5l_fill_2
XFILLER_10_2744 VPWR VGND sg13cmos5l_decap_8
XFILLER_12_83 VPWR VGND sg13cmos5l_decap_4
XFILLER_10_2799 VPWR VGND sg13cmos5l_fill_1
XFILLER_2_375 VPWR VGND sg13cmos5l_decap_4
XANTENNA__0796__X Tile_X3Y0_SS4BEG[1] VPWR VGND sg13cmos5l_antennanp
XANTENNA__0183__GATE Tile_X0Y0_FrameStrobe[2] VPWR VGND sg13cmos5l_antennanp
XFILLER_8_2193 VPWR VGND sg13cmos5l_decap_8
XFILLER_4_2068 VPWR VGND sg13cmos5l_decap_8
XFILLER_4_2057 VPWR VGND sg13cmos5l_decap_8
XFILLER_4_1334 VPWR VGND sg13cmos5l_fill_2
XFILLER_4_1323 VPWR VGND sg13cmos5l_decap_4
XANTENNA__0198__GATE Tile_X0Y0_FrameStrobe[3] VPWR VGND sg13cmos5l_antennanp
XANTENNA__0394__D Tile_X0Y0_FrameData[15] VPWR VGND sg13cmos5l_antennanp
XANTENNA__0972__A Tile_X1Y0_FrameStrobe[17] VPWR VGND sg13cmos5l_antennanp
XFILLER_15_2644 VPWR VGND sg13cmos5l_decap_8
XANTENNA__0121__GATE Tile_X0Y0_FrameStrobe[0] VPWR VGND sg13cmos5l_antennanp
X_0912_ Tile_X2Y0_SS4BEG[13] _1248_/X VPWR VGND sg13cmos5l_buf_1
X_0843_ Tile_X4Y0_FrameStrobe_O[0] Tile_X4Y0_FrameStrobe[0] VPWR VGND sg13cmos5l_buf_1
XFILLER_15_1943 VPWR VGND sg13cmos5l_fill_1
XFILLER_11_1818 VPWR VGND sg13cmos5l_decap_8
XANTENNA__0136__GATE Tile_X0Y0_FrameStrobe[1] VPWR VGND sg13cmos5l_antennanp
X_0774_ Tile_X3Y0_S2BEGb[3] _1254_/X VPWR VGND sg13cmos5l_buf_1
XFILLER_6_670 VPWR VGND sg13cmos5l_decap_8
XFILLER_9_1245 VPWR VGND sg13cmos5l_decap_8
XFILLER_0_2400 VPWR VGND sg13cmos5l_decap_8
XANTENNA__1043__A Tile_X4Y0_N2END[3] VPWR VGND sg13cmos5l_antennanp
X_1257_ _1257_/X Tile_X3Y0_N1END[2] Tile_X3Y0_N2MID[6] Tile_X3Y0_N2END[1] _0578_/Q
+ _0493_/Q _0492_/Q VPWR VGND sg13cmos5l_mux4_1
XFILLER_4_2591 VPWR VGND sg13cmos5l_decap_8
X_0208_ _0208_/Q Tile_X0Y0_FrameData[25] VGND VPWR Tile_X1Y0_FrameStrobe[0] latch
X_1188_ _1188_/X Tile_X1Y0_N2MID[1] Tile_X1Y0_N4END[6] Tile_X1Y0_NN4END[9] _0591_/Q
+ _0279_/Q _0278_/Q VPWR VGND sg13cmos5l_mux4_1
XFILLER_0_2477 VPWR VGND sg13cmos5l_decap_8
X_0139_ _0139_/Q Tile_X0Y0_FrameData[14] VGND VPWR Tile_X0Y0_FrameStrobe[1] latch
XFILLER_14_2143 VPWR VGND sg13cmos5l_decap_4
XFILLER_14_2198 VPWR VGND sg13cmos5l_decap_8
XFILLER_4_629 VPWR VGND sg13cmos5l_decap_8
XFILLER_14_1486 VPWR VGND sg13cmos5l_decap_8
XFILLER_0_802 VPWR VGND sg13cmos5l_decap_4
XANTENNA__0479__D Tile_X0Y0_FrameData[26] VPWR VGND sg13cmos5l_antennanp
XFILLER_0_846 VPWR VGND sg13cmos5l_decap_8
XFILLER_0_857 VPWR VGND sg13cmos5l_fill_1
XFILLER_9_2480 VPWR VGND sg13cmos5l_decap_8
XFILLER_0_868 VPWR VGND sg13cmos5l_fill_1
XFILLER_5_2355 VPWR VGND sg13cmos5l_decap_8
XFILLER_5_1676 VPWR VGND sg13cmos5l_decap_8
XFILLER_16_703 VPWR VGND sg13cmos5l_decap_8
XANTENNA__0565__Q NPU_ADDR1 VPWR VGND sg13cmos5l_antennanp
XFILLER_15_224 VPWR VGND sg13cmos5l_decap_4
XFILLER_15_213 VPWR VGND sg13cmos5l_fill_1
XFILLER_15_1228 VPWR VGND sg13cmos5l_decap_8
XFILLER_7_401 VPWR VGND sg13cmos5l_fill_2
XFILLER_7_478 VPWR VGND sg13cmos5l_decap_4
XANTENNA__1194__A2 Tile_X1Y0_NN4END[15] VPWR VGND sg13cmos5l_antennanp
X_0490_ _0490_/Q Tile_X0Y0_FrameData[15] VGND VPWR Tile_X3Y0_FrameStrobe[2] latch
XANTENNA__0389__D Tile_X0Y0_FrameData[20] VPWR VGND sg13cmos5l_antennanp
XANTENNA__0967__A Tile_X1Y0_FrameStrobe[12] VPWR VGND sg13cmos5l_antennanp
XANTENNA__0524__CLK Tile_X0Y0_UserCLK VPWR VGND sg13cmos5l_antennanp
X_1111_ _1111_/X Tile_X1Y0_N4END[12] Tile_X1Y0_N4END[15] Tile_X1Y0_NN4END[13] Tile_X1Y0_NN4END[15]
+ _0203_/Q _0314_/Q VPWR VGND sg13cmos5l_mux4_1
XFILLER_4_1120 VPWR VGND sg13cmos5l_decap_8
X_1042_ Tile_X4Y0_S2BEGb[3] Tile_X4Y0_N2END[4] VPWR VGND sg13cmos5l_buf_1
XFILLER_4_1175 VPWR VGND sg13cmos5l_fill_2
XFILLER_14_290 VPWR VGND sg13cmos5l_decap_8
XFILLER_15_2463 VPWR VGND sg13cmos5l_decap_8
XFILLER_15_1773 VPWR VGND sg13cmos5l_decap_8
XFILLER_11_2349 VPWR VGND sg13cmos5l_decap_8
XFILLER_11_1615 VPWR VGND sg13cmos5l_decap_8
X_0826_ Tile_X4Y0_FrameData_O[15] Tile_X0Y0_FrameData[15] VPWR VGND sg13cmos5l_buf_1
X_0757_ Tile_X1Y0_S2BEG[6] Tile_X1Y0_N2MID[1] VPWR VGND sg13cmos5l_buf_1
XANTENNA__1038__A Tile_X4Y0_N2MID[0] VPWR VGND sg13cmos5l_antennanp
XANTENNA__1185__A2 Tile_X1Y0_NN4END[6] VPWR VGND sg13cmos5l_antennanp
XANTENNA__0299__D Tile_X0Y0_FrameData[30] VPWR VGND sg13cmos5l_antennanp
XFILLER_9_1020 VPWR VGND sg13cmos5l_fill_2
X_0688_ Tile_X0Y0_FrameStrobe_O[1] Tile_X0Y0_FrameStrobe[1] VPWR VGND sg13cmos5l_buf_1
XFILLER_9_1042 VPWR VGND sg13cmos5l_fill_1
XFILLER_6_2675 VPWR VGND sg13cmos5l_decap_8
XFILLER_2_2539 VPWR VGND sg13cmos5l_decap_8
XANTENNA__1060__X Tile_X4Y0_S4BEG[13] VPWR VGND sg13cmos5l_antennanp
XFILLER_12_227 VPWR VGND sg13cmos5l_decap_8
XFILLER_12_249 VPWR VGND sg13cmos5l_decap_8
XFILLER_16_1559 VPWR VGND sg13cmos5l_decap_4
XFILLER_10_1114 VPWR VGND sg13cmos5l_decap_8
XFILLER_4_404 VPWR VGND sg13cmos5l_decap_8
XANTENNA__1176__A2 Tile_X1Y0_N2END[2] VPWR VGND sg13cmos5l_antennanp
XFILLER_7_2406 VPWR VGND sg13cmos5l_decap_8
XANTENNA__0547__CLK Tile_X0Y0_UserCLK VPWR VGND sg13cmos5l_antennanp
XFILLER_5_2174 VPWR VGND sg13cmos5l_decap_8
XFILLER_5_1473 VPWR VGND sg13cmos5l_fill_1
XFILLER_1_1348 VPWR VGND sg13cmos5l_decap_8
XANTENNA__1100__A2 Tile_X1Y0_NN4END[4] VPWR VGND sg13cmos5l_antennanp
XFILLER_16_544 VPWR VGND sg13cmos5l_decap_8
XFILLER_16_2761 VPWR VGND sg13cmos5l_decap_8
XFILLER_12_2647 VPWR VGND sg13cmos5l_decap_8
XFILLER_12_1924 VPWR VGND sg13cmos5l_decap_8
XFILLER_11_271 VPWR VGND sg13cmos5l_decap_8
X_0611_ _0611_/L_HI VPWR VGND sg13cmos5l_tiehi
XFILLER_7_286 VPWR VGND sg13cmos5l_decap_4
XANTENNA__1167__A2 Tile_X0Y0_NN4END[3] VPWR VGND sg13cmos5l_antennanp
X_0542_ NPU_WDATA18 Tile_X0Y0_UserCLK _1114_/X _0685_/L_HI VPWR VGND sg13cmos5l_dfrbpq_1
XFILLER_3_481 VPWR VGND sg13cmos5l_decap_8
XANTENNA__0697__A Tile_X0Y0_FrameStrobe[10] VPWR VGND sg13cmos5l_antennanp
X_0473_ _0473_/Q Tile_X0Y0_FrameData[0] VGND VPWR Tile_X3Y0_FrameStrobe[1] latch
XANTENNA__0984__X Tile_X0Y0_SS4BEG[9] VPWR VGND sg13cmos5l_antennanp
X_1025_ Tile_X0Y0_S1BEG[2] Tile_X0Y0_N1END[1] VPWR VGND sg13cmos5l_buf_1
XFILLER_14_18 VPWR VGND sg13cmos5l_fill_1
XANTENNA__0582__D NPU_RDATA10 VPWR VGND sg13cmos5l_antennanp
X_0809_ Tile_X3Y0_SS4BEG[14] _1289_/X VPWR VGND sg13cmos5l_buf_1
XFILLER_11_1467 VPWR VGND sg13cmos5l_decap_8
XANTENNA__1158__A2 Tile_X0Y0_NN4END[12] VPWR VGND sg13cmos5l_antennanp
XFILLER_8_2726 VPWR VGND sg13cmos5l_decap_8
XANTENNA__1055__X Tile_X4Y0_S4BEG[8] VPWR VGND sg13cmos5l_antennanp
XANTENNA__0894__X Tile_X2Y0_S4BEG[11] VPWR VGND sg13cmos5l_antennanp
XFILLER_6_1760 VPWR VGND sg13cmos5l_decap_8
XFILLER_2_2314 VPWR VGND sg13cmos5l_decap_4
XFILLER_2_2369 VPWR VGND sg13cmos5l_decap_4
XFILLER_2_1657 VPWR VGND sg13cmos5l_fill_2
XANTENNA__1094__A1 Tile_X3Y0_N2MID[1] VPWR VGND sg13cmos5l_antennanp
XFILLER_16_2013 VPWR VGND sg13cmos5l_fill_1
XFILLER_16_2002 VPWR VGND sg13cmos5l_decap_8
XANTENNA__0492__D Tile_X0Y0_FrameData[13] VPWR VGND sg13cmos5l_antennanp
XFILLER_16_2024 VPWR VGND sg13cmos5l_decap_8
XFILLER_13_558 VPWR VGND sg13cmos5l_decap_8
XANTENNA__0520__GATE Tile_X4Y0_FrameStrobe[0] VPWR VGND sg13cmos5l_antennanp
XFILLER_16_1356 VPWR VGND sg13cmos5l_decap_8
XANTENNA__1149__A2 Tile_X0Y0_NN4END[10] VPWR VGND sg13cmos5l_antennanp
XFILLER_5_779 VPWR VGND sg13cmos5l_decap_8
XFILLER_7_2203 VPWR VGND sg13cmos5l_decap_8
XFILLER_1_963 VPWR VGND sg13cmos5l_decap_8
XFILLER_0_473 VPWR VGND sg13cmos5l_fill_2
XFILLER_1_1134 VPWR VGND sg13cmos5l_fill_1
XANTENNA__1085__A1 Tile_X2Y0_N2MID[2] VPWR VGND sg13cmos5l_antennanp
XFILLER_16_2591 VPWR VGND sg13cmos5l_fill_2
XFILLER_8_551 VPWR VGND sg13cmos5l_decap_8
XFILLER_12_2466 VPWR VGND sg13cmos5l_decap_8
XFILLER_12_1721 VPWR VGND sg13cmos5l_decap_8
XANTENNA_1 _1124_/X VPWR VGND sg13cmos5l_antennanp
XANTENNA__0979__X Tile_X0Y0_SS4BEG[4] VPWR VGND sg13cmos5l_antennanp
XFILLER_12_1798 VPWR VGND sg13cmos5l_decap_8
X_0525_ NPU_WDATA1 Tile_X0Y0_UserCLK _1097_/X _0627_/L_HI VPWR VGND sg13cmos5l_dfrbpq_1
XFILLER_4_790 VPWR VGND sg13cmos5l_decap_8
X_0456_ _0456_/Q Tile_X0Y0_FrameData[17] VGND VPWR Tile_X3Y0_FrameStrobe[1] latch
XANTENNA__0577__D NPU_RDATA5 VPWR VGND sg13cmos5l_antennanp
X_0387_ _0387_/Q Tile_X0Y0_FrameData[22] VGND VPWR Tile_X2Y0_FrameStrobe[2] latch
XFILLER_6_1067 VPWR VGND sg13cmos5l_decap_8
XFILLER_3_2645 VPWR VGND sg13cmos5l_decap_8
XANTENNA__1051__A Tile_X4Y0_N4END[11] VPWR VGND sg13cmos5l_antennanp
X_1008_ Tile_X0Y0_S2BEGb[1] _1132_/X VPWR VGND sg13cmos5l_buf_1
XFILLER_10_528 VPWR VGND sg13cmos5l_decap_8
XANTENNA__0889__X Tile_X2Y0_S4BEG[6] VPWR VGND sg13cmos5l_antennanp
XFILLER_11_1231 VPWR VGND sg13cmos5l_decap_8
XFILLER_8_2501 VPWR VGND sg13cmos5l_decap_8
XFILLER_1_215 VPWR VGND sg13cmos5l_decap_8
XANTENNA__0487__D Tile_X0Y0_FrameData[18] VPWR VGND sg13cmos5l_antennanp
XFILLER_4_1719 VPWR VGND sg13cmos5l_decap_8
XFILLER_8_1899 VPWR VGND sg13cmos5l_decap_8
XFILLER_2_2144 VPWR VGND sg13cmos5l_decap_8
XFILLER_2_2133 VPWR VGND sg13cmos5l_fill_2
XFILLER_2_1410 VPWR VGND sg13cmos5l_decap_4
XFILLER_14_801 VPWR VGND sg13cmos5l_decap_8
XFILLER_14_867 VPWR VGND sg13cmos5l_decap_8
XFILLER_16_1131 VPWR VGND sg13cmos5l_decap_8
XFILLER_13_2742 VPWR VGND sg13cmos5l_decap_8
XFILLER_16_1175 VPWR VGND sg13cmos5l_decap_8
XANTENNA__0474__GATE Tile_X3Y0_FrameStrobe[2] VPWR VGND sg13cmos5l_antennanp
XFILLER_5_532 VPWR VGND sg13cmos5l_decap_8
XANTENNA__0799__X Tile_X3Y0_SS4BEG[4] VPWR VGND sg13cmos5l_antennanp
XFILLER_7_2011 VPWR VGND sg13cmos5l_decap_4
XANTENNA__0489__GATE Tile_X3Y0_FrameStrobe[2] VPWR VGND sg13cmos5l_antennanp
X_0310_ _0310_/Q Tile_X0Y0_FrameData[19] VGND VPWR Tile_X1Y0_FrameStrobe[3] latch
XANTENNA__0397__D Tile_X0Y0_FrameData[12] VPWR VGND sg13cmos5l_antennanp
XFILLER_0_270 VPWR VGND sg13cmos5l_fill_1
X_1290_ _1290_/X Tile_X3Y0_N2END[7] Tile_X3Y0_N4END[15] Tile_X3Y0_NN4END[0] _0572_/Q
+ _0427_/Q _0426_/Q VPWR VGND sg13cmos5l_mux4_1
XFILLER_7_2088 VPWR VGND sg13cmos5l_decap_8
XFILLER_1_793 VPWR VGND sg13cmos5l_fill_2
X_0241_ _0241_/Q Tile_X0Y0_FrameData[24] VGND VPWR Tile_X1Y0_FrameStrobe[1] latch
XANTENNA__0412__GATE Tile_X3Y0_FrameStrobe[0] VPWR VGND sg13cmos5l_antennanp
X_0172_ _0172_/Q Tile_X0Y0_FrameData[13] VGND VPWR Tile_X0Y0_FrameStrobe[2] latch
XANTENNA__0427__GATE Tile_X3Y0_FrameStrobe[0] VPWR VGND sg13cmos5l_antennanp
XFILLER_14_1816 VPWR VGND sg13cmos5l_decap_8
XFILLER_12_2263 VPWR VGND sg13cmos5l_decap_8
XANTENNA__1230__A1 Tile_X2Y0_N4END[4] VPWR VGND sg13cmos5l_antennanp
XANTENNA__1046__A Tile_X4Y0_N2END[0] VPWR VGND sg13cmos5l_antennanp
X_0508_ _0508_/Q Tile_X0Y0_FrameData[29] VGND VPWR Tile_X4Y0_FrameStrobe[0] latch
XFILLER_8_1129 VPWR VGND sg13cmos5l_decap_4
XFILLER_5_2718 VPWR VGND sg13cmos5l_fill_2
XANTENNA__0100__D Tile_X0Y0_FrameData[21] VPWR VGND sg13cmos5l_antennanp
X_0439_ _0439_/Q Tile_X0Y0_FrameData[2] VGND VPWR Tile_X3Y0_FrameStrobe[0] latch
XFILLER_3_2475 VPWR VGND sg13cmos5l_fill_1
XFILLER_3_1774 VPWR VGND sg13cmos5l_fill_2
XFILLER_13_2038 VPWR VGND sg13cmos5l_decap_8
XFILLER_11_837 VPWR VGND sg13cmos5l_decap_8
XFILLER_6_318 VPWR VGND sg13cmos5l_decap_4
XFILLER_13_1348 VPWR VGND sg13cmos5l_decap_8
XANTENNA__1221__A1 Tile_X2Y0_N4END[13] VPWR VGND sg13cmos5l_antennanp
XFILLER_2_568 VPWR VGND sg13cmos5l_decap_8
XANTENNA__0568__Q NPU_ADDR4 VPWR VGND sg13cmos5l_antennanp
XFILLER_8_2375 VPWR VGND sg13cmos5l_decap_8
XFILLER_8_1685 VPWR VGND sg13cmos5l_decap_8
XANTENNA__1288__A1 Tile_X3Y0_N4END[13] VPWR VGND sg13cmos5l_antennanp
XFILLER_13_141 VPWR VGND sg13cmos5l_fill_2
XFILLER_14_686 VPWR VGND sg13cmos5l_decap_8
XFILLER_9_167 VPWR VGND sg13cmos5l_fill_1
X_0790_ Tile_X3Y0_S4BEG[11] _1270_/X VPWR VGND sg13cmos5l_buf_1
XFILLER_6_830 VPWR VGND sg13cmos5l_decap_4
XANTENNA__1212__A1 Tile_X2Y0_N2MID[1] VPWR VGND sg13cmos5l_antennanp
XFILLER_6_896 VPWR VGND sg13cmos5l_decap_8
XFILLER_5_362 VPWR VGND sg13cmos5l_fill_2
XANTENNA__0351__GATE Tile_X2Y0_FrameStrobe[1] VPWR VGND sg13cmos5l_antennanp
X_1273_ _1273_/X Tile_X3Y0_N2MID[6] Tile_X3Y0_N4END[1] Tile_X3Y0_NN4END[14] _0572_/Q
+ _0461_/Q _0460_/Q VPWR VGND sg13cmos5l_mux4_1
XFILLER_7_1162 VPWR VGND sg13cmos5l_decap_8
XANTENNA__1279__A1 Tile_X3Y0_N4END[4] VPWR VGND sg13cmos5l_antennanp
X_0224_ _0224_/Q Tile_X0Y0_FrameData[9] VGND VPWR Tile_X1Y0_FrameStrobe[0] latch
XFILLER_4_2762 VPWR VGND sg13cmos5l_decap_8
XANTENNA__0992__X Tile_X0Y0_S4BEG[1] VPWR VGND sg13cmos5l_antennanp
XFILLER_3_1059 VPWR VGND sg13cmos5l_decap_8
X_0155_ _0155_/Q Tile_X0Y0_FrameData[30] VGND VPWR Tile_X0Y0_FrameStrobe[2] latch
XANTENNA__0366__GATE Tile_X2Y0_FrameStrobe[1] VPWR VGND sg13cmos5l_antennanp
X_0086_ _0563_/D _0513_/Q _1095_/X VPWR VGND sg13cmos5l_nor2b_1
XFILLER_14_2325 VPWR VGND sg13cmos5l_decap_8
XANTENNA__0590__D NPU_RDATA18 VPWR VGND sg13cmos5l_antennanp
XFILLER_14_1613 VPWR VGND sg13cmos5l_decap_8
X_0988_ Tile_X0Y0_SS4BEG[13] _1168_/X VPWR VGND sg13cmos5l_buf_1
XFILLER_12_2060 VPWR VGND sg13cmos5l_decap_8
XANTENNA__1203__A1 Tile_X1Y0_N4END[8] VPWR VGND sg13cmos5l_antennanp
XANTENNA__0304__GATE Tile_X1Y0_FrameStrobe[3] VPWR VGND sg13cmos5l_antennanp
XFILLER_12_1381 VPWR VGND sg13cmos5l_decap_8
XFILLER_9_2662 VPWR VGND sg13cmos5l_decap_8
XANTENNA__0319__GATE Tile_X2Y0_FrameStrobe[0] VPWR VGND sg13cmos5l_antennanp
XANTENNA__0580__CLK Tile_X0Y0_UserCLK VPWR VGND sg13cmos5l_antennanp
XANTENNA__1063__X Tile_X4Y0_SS4BEG[0] VPWR VGND sg13cmos5l_antennanp
XFILLER_3_2272 VPWR VGND sg13cmos5l_fill_2
XFILLER_11_612 VPWR VGND sg13cmos5l_decap_8
XFILLER_13_1112 VPWR VGND sg13cmos5l_decap_8
XFILLER_11_689 VPWR VGND sg13cmos5l_fill_2
XFILLER_10_2723 VPWR VGND sg13cmos5l_decap_8
XFILLER_10_199 VPWR VGND sg13cmos5l_fill_1
XFILLER_3_822 VPWR VGND sg13cmos5l_fill_2
XFILLER_13_1189 VPWR VGND sg13cmos5l_decap_8
XFILLER_2_332 VPWR VGND sg13cmos5l_fill_2
XFILLER_3_888 VPWR VGND sg13cmos5l_fill_1
XFILLER_8_2172 VPWR VGND sg13cmos5l_decap_8
XFILLER_4_2003 VPWR VGND sg13cmos5l_fill_2
XFILLER_8_1482 VPWR VGND sg13cmos5l_decap_4
XANTENNA__1130__A0 Tile_X4Y0_N1END[2] VPWR VGND sg13cmos5l_antennanp
XFILLER_2_1092 VPWR VGND sg13cmos5l_decap_8
XFILLER_15_2623 VPWR VGND sg13cmos5l_decap_8
XFILLER_14_461 VPWR VGND sg13cmos5l_fill_2
X_0911_ Tile_X2Y0_SS4BEG[12] _1247_/X VPWR VGND sg13cmos5l_buf_1
XFILLER_15_1922 VPWR VGND sg13cmos5l_decap_8
X_0842_ Tile_X4Y0_FrameData_O[31] Tile_X0Y0_FrameData[31] VPWR VGND sg13cmos5l_buf_1
XANTENNA__1197__A0 Tile_X1Y0_N2END[2] VPWR VGND sg13cmos5l_antennanp
X_0773_ Tile_X3Y0_S2BEGb[2] _1253_/X VPWR VGND sg13cmos5l_buf_1
XANTENNA__0987__X Tile_X0Y0_SS4BEG[12] VPWR VGND sg13cmos5l_antennanp
XANTENNA__0290__GATE Tile_X1Y0_FrameStrobe[2] VPWR VGND sg13cmos5l_antennanp
XFILLER_9_1224 VPWR VGND sg13cmos5l_decap_8
XANTENNA__0585__D NPU_RDATA13 VPWR VGND sg13cmos5l_antennanp
X_1256_ _1256_/X Tile_X3Y0_N1END[1] Tile_X3Y0_N2MID[5] Tile_X3Y0_N2END[2] _0577_/Q
+ _0495_/Q _0494_/Q VPWR VGND sg13cmos5l_mux4_1
XFILLER_4_2570 VPWR VGND sg13cmos5l_decap_8
XANTENNA__1121__A0 Tile_X0Y0_N4END[9] VPWR VGND sg13cmos5l_antennanp
XFILLER_0_2456 VPWR VGND sg13cmos5l_decap_8
X_0207_ _0207_/Q Tile_X0Y0_FrameData[26] VGND VPWR Tile_X1Y0_FrameStrobe[0] latch
X_1187_ _1187_/X Tile_X1Y0_N2MID[0] Tile_X1Y0_N4END[7] Tile_X1Y0_NN4END[8] _0590_/Q
+ _0281_/Q _0280_/Q VPWR VGND sg13cmos5l_mux4_1
X_0138_ _0138_/Q Tile_X0Y0_FrameData[15] VGND VPWR Tile_X0Y0_FrameStrobe[1] latch
XFILLER_0_1766 VPWR VGND sg13cmos5l_fill_2
XFILLER_16_2409 VPWR VGND sg13cmos5l_decap_8
XFILLER_10_2008 VPWR VGND sg13cmos5l_decap_4
XFILLER_14_2177 VPWR VGND sg13cmos5l_decap_8
XANTENNA__0243__GATE Tile_X1Y0_FrameStrobe[1] VPWR VGND sg13cmos5l_antennanp
XANTENNA__1188__A0 Tile_X1Y0_N2MID[1] VPWR VGND sg13cmos5l_antennanp
XFILLER_14_1465 VPWR VGND sg13cmos5l_decap_8
XANTENNA__1058__X Tile_X4Y0_S4BEG[11] VPWR VGND sg13cmos5l_antennanp
XFILLER_4_608 VPWR VGND sg13cmos5l_decap_8
XANTENNA__0897__X Tile_X2Y0_S4BEG[14] VPWR VGND sg13cmos5l_antennanp
XANTENNA__0258__GATE Tile_X1Y0_FrameStrobe[1] VPWR VGND sg13cmos5l_antennanp
XFILLER_7_1909 VPWR VGND sg13cmos5l_decap_4
XFILLER_5_2334 VPWR VGND sg13cmos5l_fill_1
XFILLER_1_2209 VPWR VGND sg13cmos5l_decap_8
XANTENNA__0495__D Tile_X0Y0_FrameData[10] VPWR VGND sg13cmos5l_antennanp
XFILLER_5_1655 VPWR VGND sg13cmos5l_decap_8
XANTENNA__1112__A0 Tile_X0Y0_N4END[0] VPWR VGND sg13cmos5l_antennanp
XFILLER_1_1519 VPWR VGND sg13cmos5l_fill_2
XFILLER_16_759 VPWR VGND sg13cmos5l_decap_8
XFILLER_15_269 VPWR VGND sg13cmos5l_fill_1
XFILLER_15_258 VPWR VGND sg13cmos5l_decap_8
XFILLER_15_1207 VPWR VGND sg13cmos5l_decap_8
XFILLER_10_2531 VPWR VGND sg13cmos5l_decap_4
XANTENNA__1179__A0 Tile_X1Y0_N2MID[0] VPWR VGND sg13cmos5l_antennanp
XFILLER_10_1841 VPWR VGND sg13cmos5l_decap_8
XFILLER_10_1885 VPWR VGND sg13cmos5l_fill_2
XFILLER_3_663 VPWR VGND sg13cmos5l_fill_2
X_1110_ _1110_/X Tile_X1Y0_N4END[14] Tile_X1Y0_N4END[15] Tile_X1Y0_NN4END[12] Tile_X1Y0_NN4END[14]
+ _0205_/Q _0204_/Q VPWR VGND sg13cmos5l_mux4_1
XFILLER_1_2721 VPWR VGND sg13cmos5l_decap_4
XANTENNA__1103__A0 Tile_X1Y0_N4END[4] VPWR VGND sg13cmos5l_antennanp
X_1041_ Tile_X4Y0_S2BEGb[2] Tile_X4Y0_N2END[5] VPWR VGND sg13cmos5l_buf_1
XFILLER_4_1154 VPWR VGND sg13cmos5l_decap_8
XFILLER_1_2765 VPWR VGND sg13cmos5l_fill_2
XFILLER_4_1187 VPWR VGND sg13cmos5l_decap_8
XFILLER_15_2442 VPWR VGND sg13cmos5l_decap_8
XFILLER_9_74 VPWR VGND sg13cmos5l_decap_4
XFILLER_15_1752 VPWR VGND sg13cmos5l_decap_8
XFILLER_11_2328 VPWR VGND sg13cmos5l_decap_8
X_0825_ Tile_X4Y0_FrameData_O[14] Tile_X0Y0_FrameData[14] VPWR VGND sg13cmos5l_buf_1
X_0756_ Tile_X1Y0_S2BEG[5] Tile_X1Y0_N2MID[2] VPWR VGND sg13cmos5l_buf_1
X_0687_ Tile_X0Y0_FrameStrobe_O[0] Tile_X0Y0_FrameStrobe[0] VPWR VGND sg13cmos5l_buf_1
XANTENNA__1054__A Tile_X4Y0_N4END[8] VPWR VGND sg13cmos5l_antennanp
XFILLER_6_2654 VPWR VGND sg13cmos5l_decap_8
XFILLER_6_1931 VPWR VGND sg13cmos5l_decap_8
XFILLER_2_2518 VPWR VGND sg13cmos5l_decap_8
X_1239_ _1239_/X Tile_X2Y0_N2END[4] Tile_X2Y0_N4END[4] Tile_X2Y0_NN4END[11] _0585_/Q
+ _0353_/Q _0352_/Q VPWR VGND sg13cmos5l_mux4_1
XFILLER_2_1839 VPWR VGND sg13cmos5l_fill_1
XFILLER_16_2206 VPWR VGND sg13cmos5l_decap_4
XFILLER_12_206 VPWR VGND sg13cmos5l_decap_8
XFILLER_16_1538 VPWR VGND sg13cmos5l_decap_8
XANTENNA__0182__GATE Tile_X0Y0_FrameStrobe[2] VPWR VGND sg13cmos5l_antennanp
XFILLER_14_1284 VPWR VGND sg13cmos5l_decap_8
XFILLER_14_1295 VPWR VGND sg13cmos5l_fill_1
XANTENNA__0197__GATE Tile_X0Y0_FrameStrobe[3] VPWR VGND sg13cmos5l_antennanp
XANTENNA__0120__GATE Tile_X0Y0_FrameStrobe[0] VPWR VGND sg13cmos5l_antennanp
XFILLER_0_699 VPWR VGND sg13cmos5l_fill_1
XFILLER_5_2153 VPWR VGND sg13cmos5l_decap_8
XANTENNA__0135__GATE Tile_X0Y0_FrameStrobe[1] VPWR VGND sg13cmos5l_antennanp
XANTENNA__1100__A3 Tile_X1Y0_NN4END[6] VPWR VGND sg13cmos5l_antennanp
XFILLER_12_751 VPWR VGND sg13cmos5l_decap_8
XFILLER_12_2626 VPWR VGND sg13cmos5l_decap_8
XFILLER_8_755 VPWR VGND sg13cmos5l_fill_2
XFILLER_12_1903 VPWR VGND sg13cmos5l_decap_8
X_0610_ _0610_/L_HI VPWR VGND sg13cmos5l_tiehi
X_0541_ NPU_WDATA17 Tile_X0Y0_UserCLK _1113_/X _0686_/L_HI VPWR VGND sg13cmos5l_dfrbpq_1
XFILLER_3_460 VPWR VGND sg13cmos5l_decap_8
X_0472_ _0472_/Q Tile_X0Y0_FrameData[1] VGND VPWR Tile_X3Y0_FrameStrobe[1] latch
XFILLER_6_1249 VPWR VGND sg13cmos5l_fill_1
X_1024_ Tile_X0Y0_S1BEG[1] Tile_X0Y0_N1END[2] VPWR VGND sg13cmos5l_buf_1
XFILLER_1_2551 VPWR VGND sg13cmos5l_decap_4
XFILLER_1_2584 VPWR VGND sg13cmos5l_decap_8
XFILLER_15_2294 VPWR VGND sg13cmos5l_decap_8
XFILLER_11_2114 VPWR VGND sg13cmos5l_fill_1
XFILLER_11_2103 VPWR VGND sg13cmos5l_decap_4
XANTENNA__1049__A Tile_X4Y0_N4END[13] VPWR VGND sg13cmos5l_antennanp
XFILLER_15_1593 VPWR VGND sg13cmos5l_decap_4
X_0808_ Tile_X3Y0_SS4BEG[13] _1288_/X VPWR VGND sg13cmos5l_buf_1
XFILLER_11_1446 VPWR VGND sg13cmos5l_decap_8
XFILLER_8_2705 VPWR VGND sg13cmos5l_decap_8
XANTENNA__0103__D Tile_X0Y0_FrameData[18] VPWR VGND sg13cmos5l_antennanp
X_0739_ Tile_X1Y0_SS4BEG[8] _1203_/X VPWR VGND sg13cmos5l_buf_1
XFILLER_6_2462 VPWR VGND sg13cmos5l_fill_2
XFILLER_2_2348 VPWR VGND sg13cmos5l_decap_8
XFILLER_2_2337 VPWR VGND sg13cmos5l_decap_8
XANTENNA__1071__X Tile_X4Y0_SS4BEG[8] VPWR VGND sg13cmos5l_antennanp
XFILLER_2_1636 VPWR VGND sg13cmos5l_decap_8
XFILLER_0_2061 VPWR VGND sg13cmos5l_fill_2
XANTENNA__1094__A2 Tile_X3Y0_N2MID[6] VPWR VGND sg13cmos5l_antennanp
XFILLER_0_1382 VPWR VGND sg13cmos5l_fill_2
XFILLER_0_2094 VPWR VGND sg13cmos5l_fill_1
XFILLER_16_1335 VPWR VGND sg13cmos5l_decap_4
XFILLER_16_1379 VPWR VGND sg13cmos5l_decap_8
XFILLER_14_1081 VPWR VGND sg13cmos5l_decap_8
XFILLER_11_2681 VPWR VGND sg13cmos5l_decap_8
XFILLER_7_2259 VPWR VGND sg13cmos5l_decap_8
XFILLER_0_496 VPWR VGND sg13cmos5l_fill_2
XFILLER_7_1569 VPWR VGND sg13cmos5l_decap_4
XFILLER_5_1282 VPWR VGND sg13cmos5l_fill_2
XFILLER_1_1102 VPWR VGND sg13cmos5l_fill_2
XFILLER_1_1157 VPWR VGND sg13cmos5l_fill_1
XANTENNA__1085__A2 Tile_X2Y0_N2MID[5] VPWR VGND sg13cmos5l_antennanp
XFILLER_16_364 VPWR VGND sg13cmos5l_fill_1
XFILLER_8_530 VPWR VGND sg13cmos5l_decap_8
XFILLER_16_2570 VPWR VGND sg13cmos5l_decap_4
XFILLER_16_1891 VPWR VGND sg13cmos5l_decap_8
XFILLER_12_2445 VPWR VGND sg13cmos5l_decap_8
XFILLER_12_1700 VPWR VGND sg13cmos5l_decap_8
XANTENNA_2 _1092_/X VPWR VGND sg13cmos5l_antennanp
XFILLER_6_31 VPWR VGND sg13cmos5l_fill_1
XFILLER_12_1777 VPWR VGND sg13cmos5l_decap_8
X_0524_ NPU_WDATA0 Tile_X0Y0_UserCLK _1096_/X _0628_/L_HI VPWR VGND sg13cmos5l_dfrbpq_1
XANTENNA__0995__X Tile_X0Y0_S4BEG[4] VPWR VGND sg13cmos5l_antennanp
X_0455_ _0455_/Q Tile_X0Y0_FrameData[18] VGND VPWR Tile_X3Y0_FrameStrobe[1] latch
XFILLER_7_2771 VPWR VGND sg13cmos5l_decap_8
XFILLER_6_1046 VPWR VGND sg13cmos5l_decap_8
XFILLER_3_2624 VPWR VGND sg13cmos5l_decap_8
XFILLER_3_2613 VPWR VGND sg13cmos5l_fill_1
X_0386_ _0386_/Q Tile_X0Y0_FrameData[23] VGND VPWR Tile_X2Y0_FrameStrobe[2] latch
XFILLER_13_0 VPWR VGND sg13cmos5l_fill_1
XANTENNA__0593__D NPU_RDATA21 VPWR VGND sg13cmos5l_antennanp
X_1007_ Tile_X0Y0_S2BEGb[0] _1131_/X VPWR VGND sg13cmos5l_buf_1
XANTENNA__0537__CLK Tile_X0Y0_UserCLK VPWR VGND sg13cmos5l_antennanp
XFILLER_10_507 VPWR VGND sg13cmos5l_decap_8
XFILLER_11_1210 VPWR VGND sg13cmos5l_decap_8
XANTENNA__1066__X Tile_X4Y0_SS4BEG[3] VPWR VGND sg13cmos5l_antennanp
XFILLER_11_1287 VPWR VGND sg13cmos5l_decap_8
XFILLER_8_2579 VPWR VGND sg13cmos5l_decap_8
XFILLER_8_1845 VPWR VGND sg13cmos5l_decap_8
XFILLER_8_1834 VPWR VGND sg13cmos5l_decap_8
XFILLER_8_1856 VPWR VGND sg13cmos5l_fill_2
XFILLER_14_835 VPWR VGND sg13cmos5l_decap_8
XFILLER_13_334 VPWR VGND sg13cmos5l_decap_8
XFILLER_9_305 VPWR VGND sg13cmos5l_fill_1
XFILLER_16_1110 VPWR VGND sg13cmos5l_decap_8
XFILLER_9_349 VPWR VGND sg13cmos5l_decap_8
XFILLER_5_511 VPWR VGND sg13cmos5l_decap_8
XFILLER_5_588 VPWR VGND sg13cmos5l_decap_8
XFILLER_9_1609 VPWR VGND sg13cmos5l_decap_8
XFILLER_7_2023 VPWR VGND sg13cmos5l_fill_2
X_0240_ _0240_/Q Tile_X0Y0_FrameData[25] VGND VPWR Tile_X1Y0_FrameStrobe[1] latch
XFILLER_0_2808 VPWR VGND sg13cmos5l_fill_1
X_0171_ _0171_/Q Tile_X0Y0_FrameData[14] VGND VPWR Tile_X0Y0_FrameStrobe[2] latch
XFILLER_5_1090 VPWR VGND sg13cmos5l_decap_8
XFILLER_14_2518 VPWR VGND sg13cmos5l_fill_2
XFILLER_14_2507 VPWR VGND sg13cmos5l_decap_8
XFILLER_12_2242 VPWR VGND sg13cmos5l_decap_8
XANTENNA__1230__A2 Tile_X2Y0_NN4END[11] VPWR VGND sg13cmos5l_antennanp
XFILLER_12_1574 VPWR VGND sg13cmos5l_decap_8
XFILLER_12_1585 VPWR VGND sg13cmos5l_fill_1
XANTENNA__0588__D NPU_RDATA16 VPWR VGND sg13cmos5l_antennanp
X_0507_ _0507_/Q Tile_X0Y0_FrameData[30] VGND VPWR Tile_X4Y0_FrameStrobe[0] latch
XFILLER_8_1108 VPWR VGND sg13cmos5l_decap_8
X_0438_ _0438_/Q Tile_X0Y0_FrameData[3] VGND VPWR Tile_X3Y0_FrameStrobe[0] latch
XFILLER_3_2421 VPWR VGND sg13cmos5l_decap_4
XANTENNA__1062__A Tile_X4Y0_N4END[0] VPWR VGND sg13cmos5l_antennanp
X_0369_ _0369_/Q Tile_X0Y0_FrameData[8] VGND VPWR Tile_X2Y0_FrameStrobe[1] latch
XFILLER_3_2454 VPWR VGND sg13cmos5l_decap_8
XFILLER_3_1764 VPWR VGND sg13cmos5l_fill_2
XFILLER_11_816 VPWR VGND sg13cmos5l_decap_8
XFILLER_11_805 VPWR VGND sg13cmos5l_fill_1
XFILLER_13_2017 VPWR VGND sg13cmos5l_decap_8
XFILLER_6_308 VPWR VGND sg13cmos5l_fill_2
XFILLER_13_1327 VPWR VGND sg13cmos5l_decap_8
XANTENNA__1221__A2 Tile_X2Y0_NN4END[2] VPWR VGND sg13cmos5l_antennanp
XFILLER_11_1084 VPWR VGND sg13cmos5l_decap_8
XFILLER_2_547 VPWR VGND sg13cmos5l_decap_8
XANTENNA__0498__D Tile_X0Y0_FrameData[7] VPWR VGND sg13cmos5l_antennanp
XFILLER_8_2354 VPWR VGND sg13cmos5l_decap_8
XFILLER_8_1675 VPWR VGND sg13cmos5l_decap_8
XANTENNA__1288__A2 Tile_X3Y0_NN4END[2] VPWR VGND sg13cmos5l_antennanp
XFILLER_14_665 VPWR VGND sg13cmos5l_decap_8
XANTENNA__1212__A2 Tile_X2Y0_N2END[6] VPWR VGND sg13cmos5l_antennanp
XFILLER_6_864 VPWR VGND sg13cmos5l_decap_4
XFILLER_6_875 VPWR VGND sg13cmos5l_decap_8
XANTENNA__0201__D Tile_X0Y0_FrameData[16] VPWR VGND sg13cmos5l_antennanp
X_1272_ _1272_/X Tile_X3Y0_N2MID[5] Tile_X3Y0_N4END[2] Tile_X3Y0_NN4END[13] _0573_/Q
+ _0463_/Q _0462_/Q VPWR VGND sg13cmos5l_mux4_1
XFILLER_7_1152 VPWR VGND sg13cmos5l_decap_8
XFILLER_4_2741 VPWR VGND sg13cmos5l_decap_8
XANTENNA__1279__A2 Tile_X3Y0_NN4END[11] VPWR VGND sg13cmos5l_antennanp
X_0223_ _0223_/Q Tile_X0Y0_FrameData[10] VGND VPWR Tile_X1Y0_FrameStrobe[0] latch
XFILLER_7_1196 VPWR VGND sg13cmos5l_decap_8
XFILLER_0_2627 VPWR VGND sg13cmos5l_fill_2
X_0154_ _0154_/Q Tile_X0Y0_FrameData[31] VGND VPWR Tile_X0Y0_FrameStrobe[2] latch
X_0085_ _0561_/D _0515_/Q _1093_/X VPWR VGND sg13cmos5l_nor2b_1
XFILLER_14_2304 VPWR VGND sg13cmos5l_decap_8
X_0987_ Tile_X0Y0_SS4BEG[12] _1167_/X VPWR VGND sg13cmos5l_buf_1
XANTENNA__1203__A2 Tile_X1Y0_NN4END[7] VPWR VGND sg13cmos5l_antennanp
XFILLER_14_1669 VPWR VGND sg13cmos5l_decap_8
XFILLER_12_1360 VPWR VGND sg13cmos5l_decap_8
XANTENNA__1057__A Tile_X4Y0_N4END[5] VPWR VGND sg13cmos5l_antennanp
XFILLER_9_2641 VPWR VGND sg13cmos5l_decap_8
XANTENNA__0111__D Tile_X0Y0_FrameData[10] VPWR VGND sg13cmos5l_antennanp
XFILLER_5_2505 VPWR VGND sg13cmos5l_fill_2
XFILLER_9_1973 VPWR VGND sg13cmos5l_decap_4
XFILLER_9_1984 VPWR VGND sg13cmos5l_fill_2
XFILLER_3_2251 VPWR VGND sg13cmos5l_decap_8
XANTENNA__0473__GATE Tile_X3Y0_FrameStrobe[1] VPWR VGND sg13cmos5l_antennanp
XANTENNA__0488__GATE Tile_X3Y0_FrameStrobe[2] VPWR VGND sg13cmos5l_antennanp
XFILLER_11_668 VPWR VGND sg13cmos5l_decap_8
XFILLER_10_2702 VPWR VGND sg13cmos5l_decap_8
XANTENNA__0411__GATE Tile_X3Y0_FrameStrobe[0] VPWR VGND sg13cmos5l_antennanp
XFILLER_10_189 VPWR VGND sg13cmos5l_decap_8
XFILLER_13_1168 VPWR VGND sg13cmos5l_decap_8
XFILLER_12_41 VPWR VGND sg13cmos5l_decap_4
XFILLER_10_2779 VPWR VGND sg13cmos5l_decap_8
XFILLER_2_311 VPWR VGND sg13cmos5l_decap_8
XFILLER_2_366 VPWR VGND sg13cmos5l_fill_2
XFILLER_2_355 VPWR VGND sg13cmos5l_decap_8
XANTENNA__0426__GATE Tile_X3Y0_FrameStrobe[0] VPWR VGND sg13cmos5l_antennanp
XFILLER_8_2151 VPWR VGND sg13cmos5l_decap_4
XFILLER_8_1494 VPWR VGND sg13cmos5l_decap_4
XFILLER_4_1369 VPWR VGND sg13cmos5l_decap_8
XFILLER_4_1347 VPWR VGND sg13cmos5l_fill_1
XANTENNA__1130__A1 Tile_X4Y0_N2MID[2] VPWR VGND sg13cmos5l_antennanp
XFILLER_2_1071 VPWR VGND sg13cmos5l_decap_8
XFILLER_15_2602 VPWR VGND sg13cmos5l_decap_8
X_0910_ Tile_X2Y0_SS4BEG[11] _1246_/X VPWR VGND sg13cmos5l_buf_1
X_0841_ Tile_X4Y0_FrameData_O[30] Tile_X0Y0_FrameData[30] VPWR VGND sg13cmos5l_buf_1
XFILLER_15_2679 VPWR VGND sg13cmos5l_decap_8
X_0772_ Tile_X3Y0_S2BEGb[1] _1252_/X VPWR VGND sg13cmos5l_buf_1
XFILLER_15_1989 VPWR VGND sg13cmos5l_fill_1
XFILLER_15_1978 VPWR VGND sg13cmos5l_decap_8
XFILLER_13_2392 VPWR VGND sg13cmos5l_decap_8
XANTENNA__1197__A1 Tile_X1Y0_N4END[2] VPWR VGND sg13cmos5l_antennanp
XFILLER_6_694 VPWR VGND sg13cmos5l_decap_8
XFILLER_9_1203 VPWR VGND sg13cmos5l_decap_8
X_1255_ _1255_/X Tile_X3Y0_N1END[0] Tile_X3Y0_N2MID[4] Tile_X3Y0_N2END[3] _0576_/Q
+ _0497_/Q _0496_/Q VPWR VGND sg13cmos5l_mux4_1
XANTENNA__1121__A1 Tile_X0Y0_N4END[10] VPWR VGND sg13cmos5l_antennanp
XFILLER_0_2435 VPWR VGND sg13cmos5l_decap_8
X_0206_ _0206_/Q Tile_X0Y0_FrameData[27] VGND VPWR Tile_X1Y0_FrameStrobe[0] latch
X_1186_ _1186_/X Tile_X1Y0_N2MID[7] Tile_X1Y0_N4END[8] Tile_X1Y0_NN4END[7] _0593_/Q
+ _0283_/Q _0282_/Q VPWR VGND sg13cmos5l_mux4_1
XFILLER_4_1881 VPWR VGND sg13cmos5l_decap_8
X_0137_ _0137_/Q Tile_X0Y0_FrameData[16] VGND VPWR Tile_X0Y0_FrameStrobe[1] latch
XFILLER_4_1892 VPWR VGND sg13cmos5l_fill_1
XANTENNA__0106__D Tile_X0Y0_FrameData[15] VPWR VGND sg13cmos5l_antennanp
XANTENNA__1188__A1 Tile_X1Y0_N4END[6] VPWR VGND sg13cmos5l_antennanp
XANTENNA__1074__X Tile_X4Y0_SS4BEG[11] VPWR VGND sg13cmos5l_antennanp
XFILLER_0_826 VPWR VGND sg13cmos5l_fill_1
XFILLER_5_2313 VPWR VGND sg13cmos5l_decap_8
XFILLER_5_1634 VPWR VGND sg13cmos5l_decap_8
XANTENNA__1112__A1 Tile_X0Y0_N4END[1] VPWR VGND sg13cmos5l_antennanp
XFILLER_16_738 VPWR VGND sg13cmos5l_decap_8
XFILLER_11_421 VPWR VGND sg13cmos5l_decap_4
XFILLER_11_410 VPWR VGND sg13cmos5l_fill_1
XFILLER_8_915 VPWR VGND sg13cmos5l_fill_2
XFILLER_7_403 VPWR VGND sg13cmos5l_fill_1
XFILLER_12_977 VPWR VGND sg13cmos5l_fill_1
XANTENNA__0350__GATE Tile_X2Y0_FrameStrobe[1] VPWR VGND sg13cmos5l_antennanp
XFILLER_10_2510 VPWR VGND sg13cmos5l_decap_8
XFILLER_7_425 VPWR VGND sg13cmos5l_fill_2
XANTENNA__1179__A1 Tile_X1Y0_N4END[15] VPWR VGND sg13cmos5l_antennanp
XFILLER_10_1820 VPWR VGND sg13cmos5l_decap_8
XANTENNA__0365__GATE Tile_X2Y0_FrameStrobe[1] VPWR VGND sg13cmos5l_antennanp
XFILLER_10_1864 VPWR VGND sg13cmos5l_decap_8
XFILLER_3_642 VPWR VGND sg13cmos5l_decap_8
XFILLER_2_174 VPWR VGND sg13cmos5l_fill_2
XFILLER_2_152 VPWR VGND sg13cmos5l_decap_4
XANTENNA__1103__A1 Tile_X1Y0_N4END[7] VPWR VGND sg13cmos5l_antennanp
X_1040_ Tile_X4Y0_S2BEGb[1] Tile_X4Y0_N2END[6] VPWR VGND sg13cmos5l_buf_1
XFILLER_4_1177 VPWR VGND sg13cmos5l_fill_1
XFILLER_1_2744 VPWR VGND sg13cmos5l_decap_8
XFILLER_1_2799 VPWR VGND sg13cmos5l_fill_1
XANTENNA__0303__GATE Tile_X1Y0_FrameStrobe[3] VPWR VGND sg13cmos5l_antennanp
XFILLER_15_793 VPWR VGND sg13cmos5l_decap_8
XFILLER_15_2421 VPWR VGND sg13cmos5l_decap_8
XANTENNA__0318__GATE Tile_X2Y0_FrameStrobe[0] VPWR VGND sg13cmos5l_antennanp
XANTENNA__0570__CLK Tile_X0Y0_UserCLK VPWR VGND sg13cmos5l_antennanp
XFILLER_15_1731 VPWR VGND sg13cmos5l_decap_8
XFILLER_11_2307 VPWR VGND sg13cmos5l_decap_8
X_0824_ Tile_X4Y0_FrameData_O[13] Tile_X0Y0_FrameData[13] VPWR VGND sg13cmos5l_buf_1
XFILLER_15_2498 VPWR VGND sg13cmos5l_decap_8
XFILLER_15_1797 VPWR VGND sg13cmos5l_decap_8
XANTENNA__0998__X Tile_X0Y0_S4BEG[7] VPWR VGND sg13cmos5l_antennanp
X_0755_ Tile_X1Y0_S2BEG[4] Tile_X1Y0_N2MID[3] VPWR VGND sg13cmos5l_buf_1
X_0686_ _0686_/L_HI VPWR VGND sg13cmos5l_tiehi
XFILLER_6_2633 VPWR VGND sg13cmos5l_decap_8
XANTENNA__0596__D NPU_RDATA24 VPWR VGND sg13cmos5l_antennanp
XFILLER_9_1088 VPWR VGND sg13cmos5l_decap_8
XFILLER_6_1910 VPWR VGND sg13cmos5l_decap_8
X_1238_ _1238_/X Tile_X2Y0_N2END[3] Tile_X2Y0_N4END[3] Tile_X2Y0_NN4END[12] _0586_/Q
+ _0355_/Q _0354_/Q VPWR VGND sg13cmos5l_mux4_1
XFILLER_0_2254 VPWR VGND sg13cmos5l_decap_4
XANTENNA__1070__A Tile_X4Y0_NN4END[8] VPWR VGND sg13cmos5l_antennanp
X_1169_ _1169_/X Tile_X0Y0_N2END[6] Tile_X0Y0_N4END[14] Tile_X0Y0_NN4END[1] _0597_/Q
+ _0125_/Q _0124_/Q VPWR VGND sg13cmos5l_mux4_1
XFILLER_16_2229 VPWR VGND sg13cmos5l_fill_2
XFILLER_16_1506 VPWR VGND sg13cmos5l_fill_2
XANTENNA__1069__X Tile_X4Y0_SS4BEG[6] VPWR VGND sg13cmos5l_antennanp
XFILLER_14_1263 VPWR VGND sg13cmos5l_decap_8
XFILLER_10_1149 VPWR VGND sg13cmos5l_decap_8
XANTENNA__0701__X Tile_X0Y0_FrameStrobe_O[14] VPWR VGND sg13cmos5l_antennanp
XFILLER_5_2132 VPWR VGND sg13cmos5l_decap_8
XANTENNA__1097__A0 Tile_X1Y0_N4END[1] VPWR VGND sg13cmos5l_antennanp
XFILLER_16_513 VPWR VGND sg13cmos5l_decap_8
XFILLER_16_535 VPWR VGND sg13cmos5l_decap_4
XANTENNA__0593__CLK Tile_X0Y0_UserCLK VPWR VGND sg13cmos5l_antennanp
XFILLER_16_579 VPWR VGND sg13cmos5l_fill_1
XFILLER_12_730 VPWR VGND sg13cmos5l_decap_8
XFILLER_12_2605 VPWR VGND sg13cmos5l_decap_8
XFILLER_8_734 VPWR VGND sg13cmos5l_fill_2
XFILLER_11_262 VPWR VGND sg13cmos5l_decap_4
XFILLER_7_255 VPWR VGND sg13cmos5l_fill_2
XFILLER_12_1959 VPWR VGND sg13cmos5l_decap_8
XFILLER_10_2384 VPWR VGND sg13cmos5l_decap_8
X_0540_ NPU_WDATA16 Tile_X0Y0_UserCLK _1112_/X _0633_/L_HI VPWR VGND sg13cmos5l_dfrbpq_1
XFILLER_10_1683 VPWR VGND sg13cmos5l_decap_8
XFILLER_4_995 VPWR VGND sg13cmos5l_decap_8
X_0471_ _0471_/Q Tile_X0Y0_FrameData[2] VGND VPWR Tile_X3Y0_FrameStrobe[1] latch
XFILLER_6_1228 VPWR VGND sg13cmos5l_decap_8
XANTENNA__0242__GATE Tile_X1Y0_FrameStrobe[1] VPWR VGND sg13cmos5l_antennanp
XANTENNA__1088__A0 Tile_X3Y0_N1END[0] VPWR VGND sg13cmos5l_antennanp
X_1023_ Tile_X0Y0_S1BEG[0] Tile_X0Y0_N1END[3] VPWR VGND sg13cmos5l_buf_1
XFILLER_1_1895 VPWR VGND sg13cmos5l_decap_8
XANTENNA__0257__GATE Tile_X1Y0_FrameStrobe[1] VPWR VGND sg13cmos5l_antennanp
XANTENNA__1260__A0 Tile_X3Y0_N2MID[1] VPWR VGND sg13cmos5l_antennanp
XFILLER_15_2273 VPWR VGND sg13cmos5l_decap_8
XFILLER_15_1550 VPWR VGND sg13cmos5l_decap_8
XFILLER_15_1572 VPWR VGND sg13cmos5l_decap_8
X_0807_ Tile_X3Y0_SS4BEG[12] _1287_/X VPWR VGND sg13cmos5l_buf_1
XFILLER_11_1425 VPWR VGND sg13cmos5l_decap_8
X_0738_ Tile_X1Y0_SS4BEG[7] _1202_/X VPWR VGND sg13cmos5l_buf_1
XANTENNA__1065__A Tile_X4Y0_NN4END[13] VPWR VGND sg13cmos5l_antennanp
X_0669_ _0669_/L_HI VPWR VGND sg13cmos5l_tiehi
XFILLER_6_2441 VPWR VGND sg13cmos5l_decap_8
XFILLER_2_1615 VPWR VGND sg13cmos5l_decap_8
XFILLER_6_1795 VPWR VGND sg13cmos5l_decap_8
XFILLER_2_1659 VPWR VGND sg13cmos5l_fill_1
XANTENNA__1094__A3 Tile_X3Y0_N2END[1] VPWR VGND sg13cmos5l_antennanp
XFILLER_16_2059 VPWR VGND sg13cmos5l_decap_8
XFILLER_16_1314 VPWR VGND sg13cmos5l_decap_8
XANTENNA__1251__A0 Tile_X3Y0_N1END[0] VPWR VGND sg13cmos5l_antennanp
XFILLER_5_715 VPWR VGND sg13cmos5l_decap_8
XFILLER_4_214 VPWR VGND sg13cmos5l_fill_1
XFILLER_11_2660 VPWR VGND sg13cmos5l_decap_8
XFILLER_4_258 VPWR VGND sg13cmos5l_decap_4
XFILLER_0_431 VPWR VGND sg13cmos5l_fill_1
XFILLER_7_2238 VPWR VGND sg13cmos5l_decap_8
XFILLER_7_1548 VPWR VGND sg13cmos5l_decap_8
XFILLER_16_321 VPWR VGND sg13cmos5l_decap_8
XANTENNA__1085__A3 Tile_X2Y0_N2END[2] VPWR VGND sg13cmos5l_antennanp
XANTENNA__1242__A0 Tile_X2Y0_N2END[7] VPWR VGND sg13cmos5l_antennanp
XFILLER_12_2424 VPWR VGND sg13cmos5l_decap_8
XFILLER_16_1870 VPWR VGND sg13cmos5l_decap_4
XANTENNA_3 _1095_/X VPWR VGND sg13cmos5l_antennanp
XFILLER_8_586 VPWR VGND sg13cmos5l_decap_8
XFILLER_12_1756 VPWR VGND sg13cmos5l_decap_8
XANTENNA__0204__D Tile_X0Y0_FrameData[29] VPWR VGND sg13cmos5l_antennanp
XFILLER_10_2181 VPWR VGND sg13cmos5l_decap_8
X_0523_ NPU_READ_BANK_SEL2 Tile_X0Y0_UserCLK _1130_/X _0629_/L_HI VPWR VGND sg13cmos5l_dfrbpq_1
X_0454_ _0454_/Q Tile_X0Y0_FrameData[19] VGND VPWR Tile_X3Y0_FrameStrobe[1] latch
XFILLER_7_2750 VPWR VGND sg13cmos5l_decap_8
XANTENNA__0181__GATE Tile_X0Y0_FrameStrobe[2] VPWR VGND sg13cmos5l_antennanp
X_0385_ _0385_/Q Tile_X0Y0_FrameData[24] VGND VPWR Tile_X2Y0_FrameStrobe[2] latch
XFILLER_3_1924 VPWR VGND sg13cmos5l_decap_4
XFILLER_1_2371 VPWR VGND sg13cmos5l_fill_2
X_1006_ Tile_X0Y0_S4BEG[15] _1154_/X VPWR VGND sg13cmos5l_buf_1
XFILLER_1_1681 VPWR VGND sg13cmos5l_decap_8
XANTENNA__0196__GATE Tile_X0Y0_FrameStrobe[3] VPWR VGND sg13cmos5l_antennanp
XANTENNA__1233__A0 Tile_X2Y0_N2MID[6] VPWR VGND sg13cmos5l_antennanp
XANTENNA__0114__D Tile_X0Y0_FrameData[7] VPWR VGND sg13cmos5l_antennanp
XFILLER_11_1266 VPWR VGND sg13cmos5l_decap_8
XANTENNA__0134__GATE Tile_X0Y0_FrameStrobe[1] VPWR VGND sg13cmos5l_antennanp
XFILLER_8_2536 VPWR VGND sg13cmos5l_decap_8
XFILLER_8_1813 VPWR VGND sg13cmos5l_decap_8
XANTENNA__0149__GATE Tile_X0Y0_FrameStrobe[1] VPWR VGND sg13cmos5l_antennanp
XFILLER_8_1879 VPWR VGND sg13cmos5l_decap_8
XFILLER_6_2293 VPWR VGND sg13cmos5l_decap_8
XFILLER_2_2135 VPWR VGND sg13cmos5l_fill_1
XFILLER_2_1423 VPWR VGND sg13cmos5l_fill_2
XFILLER_2_2179 VPWR VGND sg13cmos5l_decap_8
XFILLER_13_313 VPWR VGND sg13cmos5l_decap_4
XFILLER_15_63 VPWR VGND sg13cmos5l_decap_8
XANTENNA__1224__A0 Tile_X2Y0_N2MID[5] VPWR VGND sg13cmos5l_antennanp
XFILLER_16_1166 VPWR VGND sg13cmos5l_decap_4
XFILLER_13_2777 VPWR VGND sg13cmos5l_decap_8
XFILLER_5_567 VPWR VGND sg13cmos5l_decap_8
XFILLER_7_2057 VPWR VGND sg13cmos5l_decap_8
XFILLER_7_1345 VPWR VGND sg13cmos5l_decap_4
XFILLER_1_795 VPWR VGND sg13cmos5l_fill_1
XFILLER_1_773 VPWR VGND sg13cmos5l_fill_2
XFILLER_7_1367 VPWR VGND sg13cmos5l_decap_8
XFILLER_3_1209 VPWR VGND sg13cmos5l_decap_4
X_0170_ _0170_/Q Tile_X0Y0_FrameData[15] VGND VPWR Tile_X0Y0_FrameStrobe[2] latch
XFILLER_2_2691 VPWR VGND sg13cmos5l_decap_8
XFILLER_16_184 VPWR VGND sg13cmos5l_decap_8
XANTENNA__1215__A0 Tile_X2Y0_N1END[0] VPWR VGND sg13cmos5l_antennanp
XFILLER_12_2221 VPWR VGND sg13cmos5l_decap_8
XFILLER_12_2298 VPWR VGND sg13cmos5l_decap_8
XFILLER_12_1553 VPWR VGND sg13cmos5l_decap_8
X_0506_ _0506_/Q Tile_X0Y0_FrameData[31] VGND VPWR Tile_X3Y0_FrameStrobe[0] latch
XFILLER_3_2400 VPWR VGND sg13cmos5l_decap_4
X_0437_ _0437_/Q Tile_X0Y0_FrameData[4] VGND VPWR Tile_X3Y0_FrameStrobe[0] latch
X_0368_ _0368_/Q Tile_X0Y0_FrameData[9] VGND VPWR Tile_X2Y0_FrameStrobe[1] latch
XFILLER_3_1743 VPWR VGND sg13cmos5l_decap_8
X_0299_ _0299_/Q Tile_X0Y0_FrameData[30] VGND VPWR Tile_X1Y0_FrameStrobe[3] latch
XFILLER_3_1798 VPWR VGND sg13cmos5l_decap_8
XFILLER_3_1776 VPWR VGND sg13cmos5l_fill_1
XANTENNA__0109__D Tile_X0Y0_FrameData[12] VPWR VGND sg13cmos5l_antennanp
XANTENNA__1206__A0 Tile_X1Y0_N2END[3] VPWR VGND sg13cmos5l_antennanp
XFILLER_13_1306 VPWR VGND sg13cmos5l_decap_8
XFILLER_10_327 VPWR VGND sg13cmos5l_decap_8
XANTENNA__1077__X Tile_X4Y0_SS4BEG[14] VPWR VGND sg13cmos5l_antennanp
XFILLER_11_1041 VPWR VGND sg13cmos5l_fill_2
XFILLER_2_526 VPWR VGND sg13cmos5l_decap_8
XFILLER_8_2333 VPWR VGND sg13cmos5l_decap_8
XFILLER_8_1654 VPWR VGND sg13cmos5l_decap_8
XFILLER_6_2090 VPWR VGND sg13cmos5l_decap_8
XFILLER_2_1264 VPWR VGND sg13cmos5l_fill_1
XFILLER_14_644 VPWR VGND sg13cmos5l_decap_8
XFILLER_13_132 VPWR VGND sg13cmos5l_fill_2
XFILLER_13_154 VPWR VGND sg13cmos5l_fill_2
XFILLER_13_143 VPWR VGND sg13cmos5l_fill_1
XFILLER_9_158 VPWR VGND sg13cmos5l_decap_8
XFILLER_13_198 VPWR VGND sg13cmos5l_fill_2
XFILLER_13_1884 VPWR VGND sg13cmos5l_decap_8
XANTENNA__0527__CLK Tile_X0Y0_UserCLK VPWR VGND sg13cmos5l_antennanp
X_1271_ _1271_/X Tile_X3Y0_N2MID[4] Tile_X3Y0_N4END[3] Tile_X3Y0_NN4END[12] _0572_/Q
+ _0465_/Q _0464_/Q VPWR VGND sg13cmos5l_mux4_1
XFILLER_7_1131 VPWR VGND sg13cmos5l_decap_8
XFILLER_1_581 VPWR VGND sg13cmos5l_fill_1
X_0222_ _0222_/Q Tile_X0Y0_FrameData[11] VGND VPWR Tile_X1Y0_FrameStrobe[0] latch
XFILLER_7_1186 VPWR VGND sg13cmos5l_decap_8
XFILLER_0_1905 VPWR VGND sg13cmos5l_decap_8
XFILLER_0_2639 VPWR VGND sg13cmos5l_fill_2
X_0153_ _0153_/Q Tile_X0Y0_FrameData[0] VGND VPWR Tile_X0Y0_FrameStrobe[1] latch
XFILLER_0_1938 VPWR VGND sg13cmos5l_fill_2
X_0084_ _0556_/D _0520_/Q _1088_/X VPWR VGND sg13cmos5l_nor2b_1
X_0986_ Tile_X0Y0_SS4BEG[11] _1166_/X VPWR VGND sg13cmos5l_buf_1
XFILLER_14_1648 VPWR VGND sg13cmos5l_decap_8
XFILLER_12_2095 VPWR VGND sg13cmos5l_decap_8
XANTENNA__0599__D NPU_RDATA27 VPWR VGND sg13cmos5l_antennanp
XFILLER_9_2620 VPWR VGND sg13cmos5l_decap_8
XFILLER_9_2697 VPWR VGND sg13cmos5l_decap_8
XFILLER_5_2517 VPWR VGND sg13cmos5l_decap_8
XANTENNA__1073__A Tile_X4Y0_NN4END[5] VPWR VGND sg13cmos5l_antennanp
XFILLER_5_2539 VPWR VGND sg13cmos5l_fill_1
XFILLER_3_2230 VPWR VGND sg13cmos5l_decap_8
XFILLER_3_1540 VPWR VGND sg13cmos5l_fill_2
XFILLER_3_2296 VPWR VGND sg13cmos5l_fill_1
XANTENNA__0704__X Tile_X0Y0_FrameStrobe_O[17] VPWR VGND sg13cmos5l_antennanp
XFILLER_11_647 VPWR VGND sg13cmos5l_decap_8
XFILLER_7_629 VPWR VGND sg13cmos5l_decap_8
XFILLER_12_20 VPWR VGND sg13cmos5l_fill_2
XFILLER_6_139 VPWR VGND sg13cmos5l_fill_1
XFILLER_13_1147 VPWR VGND sg13cmos5l_decap_8
XFILLER_10_2758 VPWR VGND sg13cmos5l_decap_8
XFILLER_3_824 VPWR VGND sg13cmos5l_fill_1
XANTENNA__0302__D Tile_X0Y0_FrameData[27] VPWR VGND sg13cmos5l_antennanp
XFILLER_2_345 VPWR VGND sg13cmos5l_fill_2
XANTENNA__1130__A2 Tile_X4Y0_N2MID[5] VPWR VGND sg13cmos5l_antennanp
XFILLER_2_1050 VPWR VGND sg13cmos5l_decap_8
XFILLER_15_2658 VPWR VGND sg13cmos5l_decap_8
X_0840_ Tile_X4Y0_FrameData_O[29] Tile_X0Y0_FrameData[29] VPWR VGND sg13cmos5l_buf_1
X_0771_ Tile_X3Y0_S2BEGb[0] _1251_/X VPWR VGND sg13cmos5l_buf_1
XFILLER_13_2371 VPWR VGND sg13cmos5l_decap_8
XANTENNA__1197__A2 Tile_X1Y0_NN4END[13] VPWR VGND sg13cmos5l_antennanp
XFILLER_13_1692 VPWR VGND sg13cmos5l_decap_8
XANTENNA__0212__D Tile_X0Y0_FrameData[21] VPWR VGND sg13cmos5l_antennanp
XFILLER_5_194 VPWR VGND sg13cmos5l_decap_8
XFILLER_9_1259 VPWR VGND sg13cmos5l_decap_8
X_1254_ _1254_/X Tile_X3Y0_N1END[3] Tile_X3Y0_N2MID[3] Tile_X3Y0_N2END[4] _0575_/Q
+ _0499_/Q _0498_/Q VPWR VGND sg13cmos5l_mux4_1
XFILLER_0_2414 VPWR VGND sg13cmos5l_decap_8
X_0205_ _0205_/Q Tile_X0Y0_FrameData[28] VGND VPWR Tile_X1Y0_FrameStrobe[0] latch
XANTENNA__1121__A2 Tile_X0Y0_NN4END[9] VPWR VGND sg13cmos5l_antennanp
X_1185_ _1185_/X Tile_X1Y0_N2MID[6] Tile_X1Y0_N4END[9] Tile_X1Y0_NN4END[6] _0592_/Q
+ _0285_/Q _0284_/Q VPWR VGND sg13cmos5l_mux4_1
X_0136_ _0136_/Q Tile_X0Y0_FrameData[17] VGND VPWR Tile_X0Y0_FrameStrobe[1] latch
X_0969_ Tile_X1Y0_FrameStrobe_O[14] Tile_X1Y0_FrameStrobe[14] VPWR VGND sg13cmos5l_buf_1
XANTENNA__1068__A Tile_X4Y0_NN4END[10] VPWR VGND sg13cmos5l_antennanp
XANTENNA__1188__A2 Tile_X1Y0_NN4END[9] VPWR VGND sg13cmos5l_antennanp
XFILLER_10_1309 VPWR VGND sg13cmos5l_decap_8
XANTENNA__0122__D Tile_X0Y0_FrameData[31] VPWR VGND sg13cmos5l_antennanp
XANTENNA__0700__A Tile_X0Y0_FrameStrobe[13] VPWR VGND sg13cmos5l_antennanp
XFILLER_9_2494 VPWR VGND sg13cmos5l_decap_8
XFILLER_9_1793 VPWR VGND sg13cmos5l_decap_8
XFILLER_5_2369 VPWR VGND sg13cmos5l_decap_8
XFILLER_5_1613 VPWR VGND sg13cmos5l_decap_8
XANTENNA__1112__A2 Tile_X0Y0_NN4END[0] VPWR VGND sg13cmos5l_antennanp
XFILLER_16_717 VPWR VGND sg13cmos5l_decap_4
XANTENNA__1179__A2 Tile_X1Y0_NN4END[0] VPWR VGND sg13cmos5l_antennanp
XFILLER_3_621 VPWR VGND sg13cmos5l_decap_8
XFILLER_14_1990 VPWR VGND sg13cmos5l_decap_8
XFILLER_10_1887 VPWR VGND sg13cmos5l_fill_1
XFILLER_2_131 VPWR VGND sg13cmos5l_decap_8
XFILLER_3_665 VPWR VGND sg13cmos5l_fill_1
XFILLER_2_197 VPWR VGND sg13cmos5l_fill_2
XFILLER_4_1134 VPWR VGND sg13cmos5l_decap_8
XANTENNA__1103__A2 Tile_X1Y0_NN4END[5] VPWR VGND sg13cmos5l_antennanp
XFILLER_15_772 VPWR VGND sg13cmos5l_decap_8
XFILLER_15_2400 VPWR VGND sg13cmos5l_decap_8
XANTENNA__0207__D Tile_X0Y0_FrameData[26] VPWR VGND sg13cmos5l_antennanp
XFILLER_9_65 VPWR VGND sg13cmos5l_fill_2
XFILLER_15_2477 VPWR VGND sg13cmos5l_decap_8
XFILLER_15_1710 VPWR VGND sg13cmos5l_decap_8
XFILLER_9_98 VPWR VGND sg13cmos5l_fill_2
X_0823_ Tile_X4Y0_FrameData_O[12] Tile_X0Y0_FrameData[12] VPWR VGND sg13cmos5l_buf_1
XFILLER_7_960 VPWR VGND sg13cmos5l_fill_2
XFILLER_15_1787 VPWR VGND sg13cmos5l_decap_4
XFILLER_11_1629 VPWR VGND sg13cmos5l_decap_8
XANTENNA__0472__GATE Tile_X3Y0_FrameStrobe[1] VPWR VGND sg13cmos5l_antennanp
X_0754_ Tile_X1Y0_S2BEG[3] Tile_X1Y0_N2MID[4] VPWR VGND sg13cmos5l_buf_1
X_0685_ _0685_/L_HI VPWR VGND sg13cmos5l_tiehi
XFILLER_6_2612 VPWR VGND sg13cmos5l_decap_8
XANTENNA__0487__GATE Tile_X3Y0_FrameStrobe[2] VPWR VGND sg13cmos5l_antennanp
XFILLER_6_2689 VPWR VGND sg13cmos5l_decap_8
X_1237_ _1237_/X Tile_X2Y0_N2END[2] Tile_X2Y0_N4END[2] Tile_X2Y0_NN4END[13] _0587_/Q
+ _0357_/Q _0356_/Q VPWR VGND sg13cmos5l_mux4_1
XANTENNA__0410__GATE Tile_X2Y0_FrameStrobe[0] VPWR VGND sg13cmos5l_antennanp
X_1168_ _1168_/X Tile_X0Y0_N2END[5] Tile_X0Y0_N4END[13] Tile_X0Y0_NN4END[2] _0596_/Q
+ _0127_/Q _0126_/Q VPWR VGND sg13cmos5l_mux4_1
XFILLER_0_2277 VPWR VGND sg13cmos5l_decap_4
XFILLER_0_2288 VPWR VGND sg13cmos5l_fill_1
XFILLER_0_2299 VPWR VGND sg13cmos5l_decap_4
X_0119_ _0119_/Q Tile_X0Y0_FrameData[2] VGND VPWR Tile_X0Y0_FrameStrobe[0] latch
X_1099_ _1099_/X Tile_X1Y0_N4END[0] Tile_X1Y0_N4END[3] Tile_X1Y0_NN4END[1] Tile_X1Y0_NN4END[3]
+ _0227_/Q _0226_/Q VPWR VGND sg13cmos5l_mux4_1
XFILLER_13_709 VPWR VGND sg13cmos5l_decap_8
XFILLER_16_1518 VPWR VGND sg13cmos5l_decap_8
XANTENNA__0117__D Tile_X0Y0_FrameData[4] VPWR VGND sg13cmos5l_antennanp
XANTENNA__0425__GATE Tile_X3Y0_FrameStrobe[0] VPWR VGND sg13cmos5l_antennanp
XFILLER_14_1242 VPWR VGND sg13cmos5l_decap_8
XFILLER_10_1128 VPWR VGND sg13cmos5l_decap_8
XFILLER_4_418 VPWR VGND sg13cmos5l_fill_2
XFILLER_0_613 VPWR VGND sg13cmos5l_fill_2
XFILLER_0_679 VPWR VGND sg13cmos5l_decap_8
XFILLER_9_2291 VPWR VGND sg13cmos5l_decap_8
XFILLER_5_2188 VPWR VGND sg13cmos5l_decap_8
XFILLER_5_1454 VPWR VGND sg13cmos5l_fill_1
XANTENNA__1097__A1 Tile_X1Y0_N4END[2] VPWR VGND sg13cmos5l_antennanp
XFILLER_1_1329 VPWR VGND sg13cmos5l_decap_4
XFILLER_16_558 VPWR VGND sg13cmos5l_decap_8
XFILLER_16_2775 VPWR VGND sg13cmos5l_decap_8
XFILLER_11_230 VPWR VGND sg13cmos5l_decap_8
XFILLER_11_252 VPWR VGND sg13cmos5l_fill_1
XFILLER_8_757 VPWR VGND sg13cmos5l_fill_1
XFILLER_12_1938 VPWR VGND sg13cmos5l_decap_8
XFILLER_11_285 VPWR VGND sg13cmos5l_decap_4
XFILLER_10_2363 VPWR VGND sg13cmos5l_decap_8
XFILLER_10_1662 VPWR VGND sg13cmos5l_decap_8
X_0470_ _0470_/Q Tile_X0Y0_FrameData[3] VGND VPWR Tile_X3Y0_FrameStrobe[1] latch
XFILLER_3_495 VPWR VGND sg13cmos5l_decap_8
XFILLER_6_1207 VPWR VGND sg13cmos5l_decap_8
XANTENNA__1088__A1 Tile_X3Y0_N2MID[0] VPWR VGND sg13cmos5l_antennanp
X_1022_ Tile_X0Y0_S2BEG[7] Tile_X0Y0_N2MID[0] VPWR VGND sg13cmos5l_buf_1
XFILLER_1_2564 VPWR VGND sg13cmos5l_fill_2
XFILLER_1_2542 VPWR VGND sg13cmos5l_fill_1
XFILLER_15_591 VPWR VGND sg13cmos5l_decap_8
XFILLER_15_2252 VPWR VGND sg13cmos5l_decap_8
XANTENNA__1260__A1 Tile_X3Y0_N4END[14] VPWR VGND sg13cmos5l_antennanp
XANTENNA__0802__X Tile_X3Y0_SS4BEG[7] VPWR VGND sg13cmos5l_antennanp
X_0806_ Tile_X3Y0_SS4BEG[11] _1286_/X VPWR VGND sg13cmos5l_buf_1
X_0737_ Tile_X1Y0_SS4BEG[6] _1201_/X VPWR VGND sg13cmos5l_buf_1
XFILLER_7_790 VPWR VGND sg13cmos5l_fill_1
X_0668_ _0668_/L_HI VPWR VGND sg13cmos5l_tiehi
XANTENNA__0400__D Tile_X0Y0_FrameData[9] VPWR VGND sg13cmos5l_antennanp
X_0599_ _0599_/Q Tile_X0Y0_UserCLK NPU_RDATA27 _0615_/L_HI VPWR VGND sg13cmos5l_dfrbpq_1
XFILLER_6_2486 VPWR VGND sg13cmos5l_fill_2
XFILLER_6_2475 VPWR VGND sg13cmos5l_decap_8
XFILLER_6_2464 VPWR VGND sg13cmos5l_fill_1
XFILLER_6_1774 VPWR VGND sg13cmos5l_decap_8
XFILLER_2_2328 VPWR VGND sg13cmos5l_fill_2
XFILLER_0_1373 VPWR VGND sg13cmos5l_fill_2
XFILLER_0_2085 VPWR VGND sg13cmos5l_decap_8
XANTENNA__0364__GATE Tile_X2Y0_FrameStrobe[1] VPWR VGND sg13cmos5l_antennanp
XFILLER_16_2038 VPWR VGND sg13cmos5l_decap_4
XANTENNA__1251__A1 Tile_X3Y0_N2MID[0] VPWR VGND sg13cmos5l_antennanp
XANTENNA__0379__GATE Tile_X2Y0_FrameStrobe[2] VPWR VGND sg13cmos5l_antennanp
XFILLER_14_1050 VPWR VGND sg13cmos5l_decap_4
XANTENNA__0712__X Tile_X1Y0_S2BEGb[5] VPWR VGND sg13cmos5l_antennanp
XFILLER_5_749 VPWR VGND sg13cmos5l_decap_8
XFILLER_4_226 VPWR VGND sg13cmos5l_fill_1
XFILLER_11_1971 VPWR VGND sg13cmos5l_decap_8
XANTENNA__0302__GATE Tile_X1Y0_FrameStrobe[3] VPWR VGND sg13cmos5l_antennanp
XFILLER_11_1993 VPWR VGND sg13cmos5l_decap_4
XFILLER_7_2217 VPWR VGND sg13cmos5l_decap_8
XANTENNA__0310__D Tile_X0Y0_FrameData[19] VPWR VGND sg13cmos5l_antennanp
XFILLER_0_454 VPWR VGND sg13cmos5l_fill_1
XFILLER_7_1527 VPWR VGND sg13cmos5l_decap_8
XFILLER_0_465 VPWR VGND sg13cmos5l_fill_1
XANTENNA__0317__GATE Tile_X2Y0_FrameStrobe[0] VPWR VGND sg13cmos5l_antennanp
XANTENNA__0560__CLK Tile_X0Y0_UserCLK VPWR VGND sg13cmos5l_antennanp
XFILLER_1_1104 VPWR VGND sg13cmos5l_fill_1
XFILLER_1_1126 VPWR VGND sg13cmos5l_fill_2
XFILLER_16_300 VPWR VGND sg13cmos5l_decap_8
XFILLER_16_355 VPWR VGND sg13cmos5l_fill_2
XFILLER_12_2403 VPWR VGND sg13cmos5l_decap_8
XANTENNA__1242__A1 Tile_X2Y0_N4END[7] VPWR VGND sg13cmos5l_antennanp
XFILLER_12_583 VPWR VGND sg13cmos5l_decap_8
XFILLER_8_565 VPWR VGND sg13cmos5l_decap_8
XFILLER_12_1735 VPWR VGND sg13cmos5l_decap_8
XANTENNA_4 Tile_X0Y0_FrameData[0] VPWR VGND sg13cmos5l_antennanp
XFILLER_6_55 VPWR VGND sg13cmos5l_fill_2
X_0522_ NPU_READ_BANK_SEL1 Tile_X0Y0_UserCLK _1129_/X _0630_/L_HI VPWR VGND sg13cmos5l_dfrbpq_1
XANTENNA__0220__D Tile_X0Y0_FrameData[13] VPWR VGND sg13cmos5l_antennanp
X_0453_ _0453_/Q Tile_X0Y0_FrameData[20] VGND VPWR Tile_X3Y0_FrameStrobe[1] latch
XFILLER_3_292 VPWR VGND sg13cmos5l_decap_8
X_0384_ _0384_/Q Tile_X0Y0_FrameData[25] VGND VPWR Tile_X2Y0_FrameStrobe[2] latch
XFILLER_3_2659 VPWR VGND sg13cmos5l_decap_8
X_1005_ Tile_X0Y0_S4BEG[14] _1153_/X VPWR VGND sg13cmos5l_buf_1
XFILLER_1_1660 VPWR VGND sg13cmos5l_decap_8
XANTENNA__1233__A1 Tile_X2Y0_N4END[1] VPWR VGND sg13cmos5l_antennanp
XFILLER_15_2071 VPWR VGND sg13cmos5l_fill_2
XFILLER_11_1245 VPWR VGND sg13cmos5l_decap_8
XANTENNA__1076__A Tile_X4Y0_NN4END[2] VPWR VGND sg13cmos5l_antennanp
XFILLER_8_2515 VPWR VGND sg13cmos5l_decap_8
XFILLER_1_229 VPWR VGND sg13cmos5l_decap_8
XANTENNA__0583__CLK Tile_X0Y0_UserCLK VPWR VGND sg13cmos5l_antennanp
XANTENNA__0130__D Tile_X0Y0_FrameData[23] VPWR VGND sg13cmos5l_antennanp
XFILLER_6_2272 VPWR VGND sg13cmos5l_decap_8
XFILLER_6_1571 VPWR VGND sg13cmos5l_decap_8
XFILLER_2_2158 VPWR VGND sg13cmos5l_fill_1
XFILLER_2_1457 VPWR VGND sg13cmos5l_decap_8
XANTENNA__0707__X Tile_X1Y0_S2BEGb[0] VPWR VGND sg13cmos5l_antennanp
XFILLER_14_815 VPWR VGND sg13cmos5l_decap_8
XFILLER_15_20 VPWR VGND sg13cmos5l_fill_2
XFILLER_14_826 VPWR VGND sg13cmos5l_fill_1
XFILLER_13_347 VPWR VGND sg13cmos5l_decap_8
XANTENNA__1224__A1 Tile_X2Y0_N4END[10] VPWR VGND sg13cmos5l_antennanp
XFILLER_16_1145 VPWR VGND sg13cmos5l_decap_8
XFILLER_13_2756 VPWR VGND sg13cmos5l_decap_8
XANTENNA__0305__D Tile_X0Y0_FrameData[24] VPWR VGND sg13cmos5l_antennanp
XFILLER_16_1189 VPWR VGND sg13cmos5l_decap_8
XFILLER_5_546 VPWR VGND sg13cmos5l_decap_8
XANTENNA__0241__GATE Tile_X1Y0_FrameStrobe[1] VPWR VGND sg13cmos5l_antennanp
XFILLER_11_1790 VPWR VGND sg13cmos5l_decap_8
XFILLER_7_2025 VPWR VGND sg13cmos5l_fill_1
XANTENNA__0256__GATE Tile_X1Y0_FrameStrobe[1] VPWR VGND sg13cmos5l_antennanp
XANTENNA__1160__A0 Tile_X0Y0_N2END[5] VPWR VGND sg13cmos5l_antennanp
XFILLER_2_2670 VPWR VGND sg13cmos5l_decap_8
XFILLER_16_163 VPWR VGND sg13cmos5l_decap_8
XFILLER_12_2200 VPWR VGND sg13cmos5l_decap_8
XANTENNA__1215__A1 Tile_X2Y0_N2MID[4] VPWR VGND sg13cmos5l_antennanp
XFILLER_9_863 VPWR VGND sg13cmos5l_fill_1
XANTENNA__0215__D Tile_X0Y0_FrameData[18] VPWR VGND sg13cmos5l_antennanp
XFILLER_9_885 VPWR VGND sg13cmos5l_fill_2
XANTENNA__0209__GATE Tile_X1Y0_FrameStrobe[0] VPWR VGND sg13cmos5l_antennanp
XFILLER_12_2277 VPWR VGND sg13cmos5l_decap_8
XFILLER_12_1532 VPWR VGND sg13cmos5l_decap_8
X_0505_ _0505_/Q Tile_X0Y0_FrameData[0] VGND VPWR Tile_X3Y0_FrameStrobe[2] latch
X_0436_ _0436_/Q Tile_X0Y0_FrameData[5] VGND VPWR Tile_X3Y0_FrameStrobe[0] latch
.ends
