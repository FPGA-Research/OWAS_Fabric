* NGSPICE file created from N_term_IO_W.ext - technology: ihp-sg13cmos5l

* Black-box entry subcircuit for sg13cmos5l_fill_1 abstract view
.subckt sg13cmos5l_fill_1 VDD VSS
.ends

* Black-box entry subcircuit for sg13cmos5l_decap_8 abstract view
.subckt sg13cmos5l_decap_8 VDD VSS
.ends

* Black-box entry subcircuit for sg13cmos5l_buf_1 abstract view
.subckt sg13cmos5l_buf_1 X A VDD VSS
.ends

* Black-box entry subcircuit for sg13cmos5l_decap_4 abstract view
.subckt sg13cmos5l_decap_4 VDD VSS
.ends

* Black-box entry subcircuit for sg13cmos5l_fill_2 abstract view
.subckt sg13cmos5l_fill_2 VDD VSS
.ends

* Black-box entry subcircuit for sg13cmos5l_antennanp abstract view
.subckt sg13cmos5l_antennanp A VDD VSS
.ends

* Black-box entry subcircuit for sg13cmos5l_inv_1 abstract view
.subckt sg13cmos5l_inv_1 Y A VDD VSS
.ends

* Black-box entry subcircuit for sg13cmos5l_buf_16 abstract view
.subckt sg13cmos5l_buf_16 X A VDD VSS
.ends

.subckt N_term_IO_W FrameData[0] FrameData[10] FrameData[11] FrameData[12] FrameData[13]
+ FrameData[14] FrameData[15] FrameData[16] FrameData[17] FrameData[18] FrameData[19]
+ FrameData[1] FrameData[20] FrameData[21] FrameData[22] FrameData[23] FrameData[24]
+ FrameData[25] FrameData[26] FrameData[27] FrameData[28] FrameData[29] FrameData[2]
+ FrameData[30] FrameData[31] FrameData[3] FrameData[4] FrameData[5] FrameData[6]
+ FrameData[7] FrameData[8] FrameData[9] FrameData_O[0] FrameData_O[10] FrameData_O[11]
+ FrameData_O[12] FrameData_O[13] FrameData_O[14] FrameData_O[15] FrameData_O[16]
+ FrameData_O[17] FrameData_O[18] FrameData_O[19] FrameData_O[1] FrameData_O[20] FrameData_O[21]
+ FrameData_O[22] FrameData_O[23] FrameData_O[24] FrameData_O[25] FrameData_O[26]
+ FrameData_O[27] FrameData_O[28] FrameData_O[29] FrameData_O[2] FrameData_O[30] FrameData_O[31]
+ FrameData_O[3] FrameData_O[4] FrameData_O[5] FrameData_O[6] FrameData_O[7] FrameData_O[8]
+ FrameData_O[9] FrameStrobe[0] FrameStrobe[10] FrameStrobe[11] FrameStrobe[12] FrameStrobe[13]
+ FrameStrobe[14] FrameStrobe[15] FrameStrobe[16] FrameStrobe[17] FrameStrobe[18]
+ FrameStrobe[19] FrameStrobe[1] FrameStrobe[2] FrameStrobe[3] FrameStrobe[4] FrameStrobe[5]
+ FrameStrobe[6] FrameStrobe[7] FrameStrobe[8] FrameStrobe[9] FrameStrobe_O[0] FrameStrobe_O[10]
+ FrameStrobe_O[11] FrameStrobe_O[12] FrameStrobe_O[13] FrameStrobe_O[14] FrameStrobe_O[15]
+ FrameStrobe_O[16] FrameStrobe_O[17] FrameStrobe_O[18] FrameStrobe_O[19] FrameStrobe_O[1]
+ FrameStrobe_O[2] FrameStrobe_O[3] FrameStrobe_O[4] FrameStrobe_O[5] FrameStrobe_O[6]
+ FrameStrobe_O[7] FrameStrobe_O[8] FrameStrobe_O[9] N1END[0] N1END[1] N1END[2] N1END[3]
+ N2END[0] N2END[1] N2END[2] N2END[3] N2END[4] N2END[5] N2END[6] N2END[7] N2MID[0]
+ N2MID[1] N2MID[2] N2MID[3] N2MID[4] N2MID[5] N2MID[6] N2MID[7] N4END[0] N4END[10]
+ N4END[11] N4END[12] N4END[13] N4END[14] N4END[15] N4END[1] N4END[2] N4END[3] N4END[4]
+ N4END[5] N4END[6] N4END[7] N4END[8] N4END[9] S1BEG[0] S1BEG[1] S1BEG[2] S1BEG[3]
+ S2BEG[0] S2BEG[1] S2BEG[2] S2BEG[3] S2BEG[4] S2BEG[5] S2BEG[6] S2BEG[7] S2BEGb[0]
+ S2BEGb[1] S2BEGb[2] S2BEGb[3] S2BEGb[4] S2BEGb[5] S2BEGb[6] S2BEGb[7] S4BEG[0] S4BEG[10]
+ S4BEG[11] S4BEG[12] S4BEG[13] S4BEG[14] S4BEG[15] S4BEG[1] S4BEG[2] S4BEG[3] S4BEG[4]
+ S4BEG[5] S4BEG[6] S4BEG[7] S4BEG[8] S4BEG[9] UserCLK UserCLKo VGND VPWR
XFILLER_7_7 VPWR VGND sg13cmos5l_fill_1
XFILLER_13_144 VPWR VGND sg13cmos5l_decap_8
X_83_ FrameData_O[26] FrameData[26] VPWR VGND sg13cmos5l_buf_1
XFILLER_9_126 VPWR VGND sg13cmos5l_decap_8
XFILLER_3_78 VPWR VGND sg13cmos5l_decap_8
XFILLER_10_158 VPWR VGND sg13cmos5l_decap_8
XFILLER_12_65 VPWR VGND sg13cmos5l_decap_8
XFILLER_6_129 VPWR VGND sg13cmos5l_decap_8
X_66_ FrameData_O[9] FrameData[9] VPWR VGND sg13cmos5l_buf_1
XFILLER_5_151 VPWR VGND sg13cmos5l_decap_8
XFILLER_9_77 VPWR VGND sg13cmos5l_decap_8
XFILLER_2_187 VPWR VGND sg13cmos5l_decap_8
XFILLER_2_165 VPWR VGND sg13cmos5l_decap_4
X_49_ S2BEG[4] N2MID[3] VPWR VGND sg13cmos5l_buf_1
XFILLER_15_6 VPWR VGND sg13cmos5l_fill_2
XFILLER_4_205 VPWR VGND sg13cmos5l_decap_8
XFILLER_6_45 VPWR VGND sg13cmos5l_decap_8
XFILLER_15_76 VPWR VGND sg13cmos5l_decap_8
XFILLER_16_153 VPWR VGND sg13cmos5l_decap_8
XFILLER_11_0 VPWR VGND sg13cmos5l_fill_2
XFILLER_13_123 VPWR VGND sg13cmos5l_decap_8
XFILLER_9_105 VPWR VGND sg13cmos5l_decap_8
XFILLER_3_57 VPWR VGND sg13cmos5l_decap_8
XFILLER_3_35 VPWR VGND sg13cmos5l_decap_4
X_82_ FrameData_O[25] FrameData[25] VPWR VGND sg13cmos5l_buf_1
XFILLER_10_137 VPWR VGND sg13cmos5l_decap_8
XFILLER_12_44 VPWR VGND sg13cmos5l_decap_8
XFILLER_6_108 VPWR VGND sg13cmos5l_decap_8
X_65_ FrameData_O[8] FrameData[8] VPWR VGND sg13cmos5l_buf_1
XFILLER_5_130 VPWR VGND sg13cmos5l_decap_8
XANTENNA__02__X S4BEG[1] VPWR VGND sg13cmos5l_antennanp
XFILLER_0_36 VPWR VGND sg13cmos5l_fill_1
XFILLER_9_56 VPWR VGND sg13cmos5l_decap_8
XFILLER_9_12 VPWR VGND sg13cmos5l_fill_2
XFILLER_2_111 VPWR VGND sg13cmos5l_decap_4
X_48_ S2BEG[3] N2MID[4] VPWR VGND sg13cmos5l_buf_1
XFILLER_7_214 VPWR VGND sg13cmos5l_decap_8
XFILLER_6_24 VPWR VGND sg13cmos5l_decap_8
XFILLER_15_55 VPWR VGND sg13cmos5l_decap_8
XANTENNA__10__X S4BEG[9] VPWR VGND sg13cmos5l_antennanp
XFILLER_16_132 VPWR VGND sg13cmos5l_decap_8
XANTENNA__05__X S4BEG[4] VPWR VGND sg13cmos5l_antennanp
XFILLER_13_102 VPWR VGND sg13cmos5l_decap_8
XFILLER_13_179 VPWR VGND sg13cmos5l_decap_8
X_81_ FrameData_O[24] FrameData[24] VPWR VGND sg13cmos5l_buf_1
XFILLER_8_183 VPWR VGND sg13cmos5l_decap_8
XANTENNA__01__A N4END[15] VPWR VGND sg13cmos5l_antennanp
XFILLER_10_116 VPWR VGND sg13cmos5l_decap_8
XFILLER_12_23 VPWR VGND sg13cmos5l_decap_8
XFILLER_5_6 VPWR VGND sg13cmos5l_fill_1
X_64_ FrameData_O[7] FrameData[7] VPWR VGND sg13cmos5l_buf_1
XFILLER_5_186 VPWR VGND sg13cmos5l_decap_8
XFILLER_9_35 VPWR VGND sg13cmos5l_decap_8
X_47_ S2BEG[2] N2MID[5] VPWR VGND sg13cmos5l_buf_1
XANTENNA__13__X S4BEG[12] VPWR VGND sg13cmos5l_antennanp
XFILLER_11_211 VPWR VGND sg13cmos5l_decap_8
XFILLER_11_222 VPWR VGND sg13cmos5l_fill_2
XFILLER_1_0 VPWR VGND sg13cmos5l_fill_2
XANTENNA__08__X S4BEG[7] VPWR VGND sg13cmos5l_antennanp
XANTENNA__04__A N4END[12] VPWR VGND sg13cmos5l_antennanp
XFILLER_15_12 VPWR VGND sg13cmos5l_fill_2
XFILLER_15_34 VPWR VGND sg13cmos5l_decap_8
XFILLER_16_122 VPWR VGND sg13cmos5l_decap_8
XFILLER_16_188 VPWR VGND sg13cmos5l_fill_2
XFILLER_13_158 VPWR VGND sg13cmos5l_decap_8
XANTENNA__21__X S2BEGb[4] VPWR VGND sg13cmos5l_antennanp
XFILLER_12_191 VPWR VGND sg13cmos5l_decap_8
X_80_ FrameData_O[23] FrameData[23] VPWR VGND sg13cmos5l_buf_1
XFILLER_8_162 VPWR VGND sg13cmos5l_decap_8
XFILLER_12_79 VPWR VGND sg13cmos5l_decap_8
XANTENNA__16__X S4BEG[15] VPWR VGND sg13cmos5l_antennanp
XFILLER_5_165 VPWR VGND sg13cmos5l_decap_8
X_63_ FrameData_O[6] FrameData[6] VPWR VGND sg13cmos5l_buf_1
XANTENNA__12__A N4END[4] VPWR VGND sg13cmos5l_antennanp
XFILLER_2_135 VPWR VGND sg13cmos5l_decap_8
X_46_ S2BEG[1] N2MID[6] VPWR VGND sg13cmos5l_buf_1
XFILLER_9_14 VPWR VGND sg13cmos5l_fill_1
XANTENNA__07__A N4END[9] VPWR VGND sg13cmos5l_antennanp
X_29_ FrameStrobe_O[4] FrameStrobe[4] VPWR VGND sg13cmos5l_buf_1
XFILLER_4_219 VPWR VGND sg13cmos5l_decap_4
XANTENNA__24__X S2BEGb[7] VPWR VGND sg13cmos5l_antennanp
XFILLER_6_59 VPWR VGND sg13cmos5l_decap_8
XFILLER_13_6 VPWR VGND sg13cmos5l_fill_1
XANTENNA__19__X S2BEGb[2] VPWR VGND sg13cmos5l_antennanp
XANTENNA__20__A N2END[4] VPWR VGND sg13cmos5l_antennanp
XFILLER_0_222 VPWR VGND sg13cmos5l_fill_2
XFILLER_16_112 VPWR VGND sg13cmos5l_decap_8
XFILLER_16_167 VPWR VGND sg13cmos5l_fill_1
XANTENNA__15__A N4END[1] VPWR VGND sg13cmos5l_antennanp
XFILLER_13_137 VPWR VGND sg13cmos5l_decap_8
XFILLER_9_119 VPWR VGND sg13cmos5l_decap_8
XFILLER_12_170 VPWR VGND sg13cmos5l_decap_8
XFILLER_8_141 VPWR VGND sg13cmos5l_decap_8
XANTENNA__32__X FrameStrobe_O[7] VPWR VGND sg13cmos5l_antennanp
XFILLER_12_58 VPWR VGND sg13cmos5l_decap_8
XFILLER_5_144 VPWR VGND sg13cmos5l_decap_8
X_62_ FrameData_O[5] FrameData[5] VPWR VGND sg13cmos5l_buf_1
XFILLER_4_92 VPWR VGND sg13cmos5l_fill_2
XFILLER_2_169 VPWR VGND sg13cmos5l_fill_1
XFILLER_2_158 VPWR VGND sg13cmos5l_decap_4
XFILLER_2_125 VPWR VGND sg13cmos5l_decap_4
XANTENNA__27__X FrameStrobe_O[2] VPWR VGND sg13cmos5l_antennanp
XFILLER_1_180 VPWR VGND sg13cmos5l_decap_4
X_45_ S2BEG[0] N2MID[7] VPWR VGND sg13cmos5l_buf_1
XANTENNA__23__A N2END[1] VPWR VGND sg13cmos5l_antennanp
Xclkload0 clkload0/Y clkload0/A VPWR VGND sg13cmos5l_inv_1
X_28_ FrameStrobe_O[3] FrameStrobe[3] VPWR VGND sg13cmos5l_buf_1
XANTENNA__18__A N2END[6] VPWR VGND sg13cmos5l_antennanp
XANTENNA__40__X FrameStrobe_O[15] VPWR VGND sg13cmos5l_antennanp
XFILLER_6_38 VPWR VGND sg13cmos5l_decap_8
XFILLER_0_201 VPWR VGND sg13cmos5l_decap_8
XFILLER_15_69 VPWR VGND sg13cmos5l_decap_8
XANTENNA__35__X FrameStrobe_O[10] VPWR VGND sg13cmos5l_antennanp
XFILLER_16_102 VPWR VGND sg13cmos5l_decap_8
XFILLER_16_146 VPWR VGND sg13cmos5l_decap_8
XFILLER_7_92 VPWR VGND sg13cmos5l_decap_8
XANTENNA__31__A FrameStrobe[6] VPWR VGND sg13cmos5l_antennanp
XFILLER_13_116 VPWR VGND sg13cmos5l_decap_8
XFILLER_3_39 VPWR VGND sg13cmos5l_fill_1
XFILLER_8_197 VPWR VGND sg13cmos5l_decap_8
XFILLER_8_120 VPWR VGND sg13cmos5l_decap_8
XANTENNA__26__A FrameStrobe[1] VPWR VGND sg13cmos5l_antennanp
XFILLER_12_37 VPWR VGND sg13cmos5l_decap_8
X_61_ FrameData_O[4] FrameData[4] VPWR VGND sg13cmos5l_buf_1
XFILLER_5_123 VPWR VGND sg13cmos5l_decap_8
XFILLER_2_104 VPWR VGND sg13cmos5l_fill_2
XANTENNA__43__X FrameStrobe_O[18] VPWR VGND sg13cmos5l_antennanp
XFILLER_9_49 VPWR VGND sg13cmos5l_decap_8
XFILLER_3_6 VPWR VGND sg13cmos5l_fill_1
X_44_ FrameStrobe_O[19] FrameStrobe[19] VPWR VGND sg13cmos5l_buf_1
XANTENNA__38__X FrameStrobe_O[13] VPWR VGND sg13cmos5l_antennanp
XFILLER_7_207 VPWR VGND sg13cmos5l_decap_8
X_27_ FrameStrobe_O[2] FrameStrobe[2] VPWR VGND sg13cmos5l_buf_1
XANTENNA__34__A FrameStrobe[9] VPWR VGND sg13cmos5l_antennanp
XFILLER_10_81 VPWR VGND sg13cmos5l_decap_8
XFILLER_15_48 VPWR VGND sg13cmos5l_decap_8
XANTENNA__29__A FrameStrobe[4] VPWR VGND sg13cmos5l_antennanp
XANTENNA__51__X S2BEG[6] VPWR VGND sg13cmos5l_antennanp
XFILLER_7_71 VPWR VGND sg13cmos5l_decap_8
XANTENNA__46__X S2BEG[1] VPWR VGND sg13cmos5l_antennanp
XFILLER_8_176 VPWR VGND sg13cmos5l_decap_8
XFILLER_10_109 VPWR VGND sg13cmos5l_decap_8
XANTENNA__42__A FrameStrobe[17] VPWR VGND sg13cmos5l_antennanp
X_60_ FrameData_O[3] FrameData[3] VPWR VGND sg13cmos5l_buf_1
XFILLER_5_179 VPWR VGND sg13cmos5l_decap_8
XFILLER_5_102 VPWR VGND sg13cmos5l_decap_8
XFILLER_4_61 VPWR VGND sg13cmos5l_decap_4
XANTENNA__37__A FrameStrobe[12] VPWR VGND sg13cmos5l_antennanp
XFILLER_13_81 VPWR VGND sg13cmos5l_decap_8
XFILLER_9_28 VPWR VGND sg13cmos5l_decap_8
XFILLER_2_149 VPWR VGND sg13cmos5l_decap_4
X_43_ FrameStrobe_O[18] FrameStrobe[18] VPWR VGND sg13cmos5l_buf_1
XFILLER_11_204 VPWR VGND sg13cmos5l_decap_8
XANTENNA__54__X S1BEG[1] VPWR VGND sg13cmos5l_antennanp
X_26_ FrameStrobe_O[1] FrameStrobe[1] VPWR VGND sg13cmos5l_buf_1
XANTENNA__49__X S2BEG[4] VPWR VGND sg13cmos5l_antennanp
XANTENNA__50__A N2MID[2] VPWR VGND sg13cmos5l_antennanp
XFILLER_10_60 VPWR VGND sg13cmos5l_decap_8
XFILLER_15_27 VPWR VGND sg13cmos5l_decap_8
X_09_ S4BEG[8] N4END[7] VPWR VGND sg13cmos5l_buf_1
XANTENNA__45__A N2MID[7] VPWR VGND sg13cmos5l_antennanp
XFILLER_15_170 VPWR VGND sg13cmos5l_fill_1
XFILLER_7_50 VPWR VGND sg13cmos5l_decap_8
XANTENNA__62__X FrameData_O[5] VPWR VGND sg13cmos5l_antennanp
XFILLER_12_184 VPWR VGND sg13cmos5l_decap_8
XFILLER_8_155 VPWR VGND sg13cmos5l_decap_8
XANTENNA__57__X FrameData_O[0] VPWR VGND sg13cmos5l_antennanp
XFILLER_5_158 VPWR VGND sg13cmos5l_decap_8
XFILLER_4_73 VPWR VGND sg13cmos5l_decap_4
XFILLER_4_51 VPWR VGND sg13cmos5l_fill_1
XFILLER_4_191 VPWR VGND sg13cmos5l_decap_8
XANTENNA__53__A N1END[3] VPWR VGND sg13cmos5l_antennanp
XFILLER_2_106 VPWR VGND sg13cmos5l_fill_1
XFILLER_13_60 VPWR VGND sg13cmos5l_decap_8
X_42_ FrameStrobe_O[17] FrameStrobe[17] VPWR VGND sg13cmos5l_buf_1
XFILLER_1_194 VPWR VGND sg13cmos5l_decap_4
XANTENNA__48__A N2MID[4] VPWR VGND sg13cmos5l_antennanp
XANTENNA__70__X FrameData_O[13] VPWR VGND sg13cmos5l_antennanp
XFILLER_6_220 VPWR VGND sg13cmos5l_decap_4
X_25_ FrameStrobe_O[0] FrameStrobe[0] VPWR VGND sg13cmos5l_buf_1
XFILLER_1_96 VPWR VGND sg13cmos5l_fill_2
XFILLER_1_85 VPWR VGND sg13cmos5l_fill_1
XFILLER_1_52 VPWR VGND sg13cmos5l_fill_2
XFILLER_3_223 VPWR VGND sg13cmos5l_fill_1
XFILLER_3_212 VPWR VGND sg13cmos5l_decap_8
XANTENNA__65__X FrameData_O[8] VPWR VGND sg13cmos5l_antennanp
X_08_ S4BEG[7] N4END[8] VPWR VGND sg13cmos5l_buf_1
XFILLER_0_215 VPWR VGND sg13cmos5l_decap_8
XANTENNA__61__A FrameData[4] VPWR VGND sg13cmos5l_antennanp
XANTENNA__56__A N1END[0] VPWR VGND sg13cmos5l_antennanp
XFILLER_12_163 VPWR VGND sg13cmos5l_decap_8
XFILLER_8_134 VPWR VGND sg13cmos5l_decap_8
XFILLER_16_82 VPWR VGND sg13cmos5l_decap_8
XFILLER_5_137 VPWR VGND sg13cmos5l_decap_8
XANTENNA__73__X FrameData_O[16] VPWR VGND sg13cmos5l_antennanp
XFILLER_4_85 VPWR VGND sg13cmos5l_decap_8
XFILLER_4_30 VPWR VGND sg13cmos5l_fill_2
XFILLER_4_170 VPWR VGND sg13cmos5l_decap_8
XFILLER_2_118 VPWR VGND sg13cmos5l_fill_2
XANTENNA__68__X FrameData_O[11] VPWR VGND sg13cmos5l_antennanp
X_41_ FrameStrobe_O[16] FrameStrobe[16] VPWR VGND sg13cmos5l_buf_1
XFILLER_1_151 VPWR VGND sg13cmos5l_fill_2
XANTENNA__64__A FrameData[7] VPWR VGND sg13cmos5l_antennanp
X_24_ S2BEGb[7] N2END[0] VPWR VGND sg13cmos5l_buf_1
XANTENNA__59__A FrameData[2] VPWR VGND sg13cmos5l_antennanp
XANTENNA__81__X FrameData_O[24] VPWR VGND sg13cmos5l_antennanp
XFILLER_10_95 VPWR VGND sg13cmos5l_decap_8
X_07_ S4BEG[6] N4END[9] VPWR VGND sg13cmos5l_buf_1
XANTENNA__76__X FrameData_O[19] VPWR VGND sg13cmos5l_antennanp
XFILLER_16_139 VPWR VGND sg13cmos5l_decap_8
XFILLER_13_109 VPWR VGND sg13cmos5l_decap_8
XFILLER_7_85 VPWR VGND sg13cmos5l_decap_8
XANTENNA__72__A FrameData[15] VPWR VGND sg13cmos5l_antennanp
XFILLER_12_142 VPWR VGND sg13cmos5l_decap_8
XFILLER_12_19 VPWR VGND sg13cmos5l_fill_1
XFILLER_8_113 VPWR VGND sg13cmos5l_decap_8
XFILLER_7_190 VPWR VGND sg13cmos5l_decap_8
XFILLER_5_116 VPWR VGND sg13cmos5l_decap_8
XANTENNA__67__A FrameData[10] VPWR VGND sg13cmos5l_antennanp
XFILLER_4_97 VPWR VGND sg13cmos5l_decap_8
XFILLER_13_95 VPWR VGND sg13cmos5l_decap_8
X_40_ FrameStrobe_O[15] FrameStrobe[15] VPWR VGND sg13cmos5l_buf_1
XFILLER_1_174 VPWR VGND sg13cmos5l_fill_2
XANTENNA__84__X FrameData_O[27] VPWR VGND sg13cmos5l_antennanp
XFILLER_11_218 VPWR VGND sg13cmos5l_decap_4
XANTENNA__79__X FrameData_O[22] VPWR VGND sg13cmos5l_antennanp
XANTENNA__80__A FrameData[23] VPWR VGND sg13cmos5l_antennanp
X_23_ S2BEGb[6] N2END[1] VPWR VGND sg13cmos5l_buf_1
Xclkbuf_1_1__f_UserCLK _00_/A clkbuf_0_UserCLK/X VPWR VGND sg13cmos5l_buf_16
XANTENNA__75__A FrameData[18] VPWR VGND sg13cmos5l_antennanp
XFILLER_10_74 VPWR VGND sg13cmos5l_decap_8
X_06_ S4BEG[5] N4END[10] VPWR VGND sg13cmos5l_buf_1
XFILLER_7_64 VPWR VGND sg13cmos5l_decap_8
XFILLER_7_20 VPWR VGND sg13cmos5l_fill_2
XANTENNA__87__X FrameData_O[30] VPWR VGND sg13cmos5l_antennanp
XFILLER_12_121 VPWR VGND sg13cmos5l_decap_8
XFILLER_12_198 VPWR VGND sg13cmos5l_decap_8
XFILLER_8_169 VPWR VGND sg13cmos5l_decap_8
XFILLER_16_73 VPWR VGND sg13cmos5l_decap_4
XANTENNA__83__A FrameData[26] VPWR VGND sg13cmos5l_antennanp
XFILLER_4_65 VPWR VGND sg13cmos5l_fill_2
XFILLER_4_32 VPWR VGND sg13cmos5l_fill_1
XANTENNA__78__A FrameData[21] VPWR VGND sg13cmos5l_antennanp
XFILLER_13_74 VPWR VGND sg13cmos5l_decap_8
XFILLER_14_205 VPWR VGND sg13cmos5l_fill_2
X_22_ S2BEGb[5] N2END[2] VPWR VGND sg13cmos5l_buf_1
XFILLER_10_53 VPWR VGND sg13cmos5l_decap_8
X_05_ S4BEG[4] N4END[11] VPWR VGND sg13cmos5l_buf_1
XANTENNA__86__A FrameData[29] VPWR VGND sg13cmos5l_antennanp
XFILLER_15_152 VPWR VGND sg13cmos5l_decap_8
XFILLER_7_43 VPWR VGND sg13cmos5l_decap_8
XFILLER_12_100 VPWR VGND sg13cmos5l_decap_8
XFILLER_12_177 VPWR VGND sg13cmos5l_decap_8
XFILLER_8_148 VPWR VGND sg13cmos5l_decap_8
XFILLER_16_96 VPWR VGND sg13cmos5l_fill_2
XFILLER_4_77 VPWR VGND sg13cmos5l_fill_1
XFILLER_4_55 VPWR VGND sg13cmos5l_fill_2
XFILLER_4_22 VPWR VGND sg13cmos5l_fill_2
XFILLER_4_184 VPWR VGND sg13cmos5l_decap_8
XFILLER_13_53 VPWR VGND sg13cmos5l_decap_8
XFILLER_14_217 VPWR VGND sg13cmos5l_decap_8
XFILLER_9_210 VPWR VGND sg13cmos5l_decap_8
XFILLER_1_198 VPWR VGND sg13cmos5l_fill_1
XFILLER_1_187 VPWR VGND sg13cmos5l_decap_8
XFILLER_1_176 VPWR VGND sg13cmos5l_fill_1
XFILLER_1_143 VPWR VGND sg13cmos5l_fill_1
XFILLER_1_132 VPWR VGND sg13cmos5l_fill_1
X_21_ S2BEGb[4] N2END[3] VPWR VGND sg13cmos5l_buf_1
XFILLER_6_213 VPWR VGND sg13cmos5l_decap_8
XFILLER_1_89 VPWR VGND sg13cmos5l_decap_8
XFILLER_10_32 VPWR VGND sg13cmos5l_decap_8
XFILLER_3_205 VPWR VGND sg13cmos5l_decap_8
X_04_ S4BEG[3] N4END[12] VPWR VGND sg13cmos5l_buf_1
XFILLER_0_208 VPWR VGND sg13cmos5l_decap_8
XFILLER_15_175 VPWR VGND sg13cmos5l_fill_1
XFILLER_7_99 VPWR VGND sg13cmos5l_decap_8
XFILLER_12_156 VPWR VGND sg13cmos5l_decap_8
XFILLER_16_42 VPWR VGND sg13cmos5l_decap_8
XFILLER_8_127 VPWR VGND sg13cmos5l_decap_8
XFILLER_4_163 VPWR VGND sg13cmos5l_decap_8
XFILLER_4_130 VPWR VGND sg13cmos5l_fill_2
XFILLER_13_32 VPWR VGND sg13cmos5l_decap_8
XFILLER_1_166 VPWR VGND sg13cmos5l_fill_2
X_20_ S2BEGb[3] N2END[4] VPWR VGND sg13cmos5l_buf_1
XFILLER_10_88 VPWR VGND sg13cmos5l_decap_8
X_03_ S4BEG[2] N4END[13] VPWR VGND sg13cmos5l_buf_1
XANTENNA__00__X UserCLKo VPWR VGND sg13cmos5l_antennanp
XFILLER_15_132 VPWR VGND sg13cmos5l_decap_8
Xclkbuf_1_0__f_UserCLK clkload0/A clkbuf_0_UserCLK/X VPWR VGND sg13cmos5l_buf_16
XFILLER_7_78 VPWR VGND sg13cmos5l_decap_8
XFILLER_7_12 VPWR VGND sg13cmos5l_fill_1
XFILLER_12_135 VPWR VGND sg13cmos5l_decap_8
XFILLER_16_10 VPWR VGND sg13cmos5l_fill_1
XFILLER_16_65 VPWR VGND sg13cmos5l_decap_4
XFILLER_8_106 VPWR VGND sg13cmos5l_decap_8
XFILLER_16_98 VPWR VGND sg13cmos5l_fill_1
XFILLER_11_190 VPWR VGND sg13cmos5l_decap_8
XFILLER_7_183 VPWR VGND sg13cmos5l_decap_8
XFILLER_5_109 VPWR VGND sg13cmos5l_decap_8
XFILLER_4_142 VPWR VGND sg13cmos5l_decap_8
XFILLER_13_88 VPWR VGND sg13cmos5l_decap_8
XFILLER_1_101 VPWR VGND sg13cmos5l_decap_8
XANTENNA__03__X S4BEG[2] VPWR VGND sg13cmos5l_antennanp
XFILLER_10_67 VPWR VGND sg13cmos5l_decap_8
X_79_ FrameData_O[22] FrameData[22] VPWR VGND sg13cmos5l_buf_1
X_02_ S4BEG[1] N4END[14] VPWR VGND sg13cmos5l_buf_1
XFILLER_15_111 VPWR VGND sg13cmos5l_decap_8
XFILLER_15_166 VPWR VGND sg13cmos5l_decap_4
XFILLER_7_57 VPWR VGND sg13cmos5l_decap_8
XFILLER_12_114 VPWR VGND sg13cmos5l_decap_8
XFILLER_16_33 VPWR VGND sg13cmos5l_decap_4
XFILLER_16_77 VPWR VGND sg13cmos5l_fill_2
XANTENNA__11__X S4BEG[10] VPWR VGND sg13cmos5l_antennanp
XFILLER_7_162 VPWR VGND sg13cmos5l_decap_8
XANTENNA__06__X S4BEG[5] VPWR VGND sg13cmos5l_antennanp
XFILLER_4_47 VPWR VGND sg13cmos5l_decap_4
XFILLER_4_198 VPWR VGND sg13cmos5l_decap_8
XFILLER_4_14 VPWR VGND sg13cmos5l_fill_1
XFILLER_4_110 VPWR VGND sg13cmos5l_decap_4
XANTENNA__02__A N4END[14] VPWR VGND sg13cmos5l_antennanp
XFILLER_13_67 VPWR VGND sg13cmos5l_decap_8
XFILLER_10_223 VPWR VGND sg13cmos5l_fill_1
X_78_ FrameData_O[21] FrameData[21] VPWR VGND sg13cmos5l_buf_1
XANTENNA__14__X S4BEG[13] VPWR VGND sg13cmos5l_antennanp
XFILLER_10_46 VPWR VGND sg13cmos5l_decap_8
XFILLER_3_219 VPWR VGND sg13cmos5l_decap_4
X_01_ S4BEG[0] N4END[15] VPWR VGND sg13cmos5l_buf_1
XANTENNA__10__A N4END[6] VPWR VGND sg13cmos5l_antennanp
XFILLER_2_80 VPWR VGND sg13cmos5l_fill_2
XANTENNA__09__X S4BEG[8] VPWR VGND sg13cmos5l_antennanp
XFILLER_7_36 VPWR VGND sg13cmos5l_decap_8
XANTENNA__05__A N4END[11] VPWR VGND sg13cmos5l_antennanp
XFILLER_16_56 VPWR VGND sg13cmos5l_fill_2
XFILLER_16_89 VPWR VGND sg13cmos5l_decap_8
XFILLER_7_141 VPWR VGND sg13cmos5l_decap_8
XANTENNA__22__X S2BEGb[5] VPWR VGND sg13cmos5l_antennanp
XFILLER_4_37 VPWR VGND sg13cmos5l_decap_8
XFILLER_4_177 VPWR VGND sg13cmos5l_decap_8
XFILLER_13_46 VPWR VGND sg13cmos5l_decap_8
XFILLER_8_6 VPWR VGND sg13cmos5l_fill_1
XFILLER_1_136 VPWR VGND sg13cmos5l_decap_8
XFILLER_1_125 VPWR VGND sg13cmos5l_decap_8
XANTENNA__17__X S2BEGb[0] VPWR VGND sg13cmos5l_antennanp
XFILLER_13_221 VPWR VGND sg13cmos5l_fill_2
XFILLER_9_203 VPWR VGND sg13cmos5l_decap_8
XANTENNA__13__A N4END[3] VPWR VGND sg13cmos5l_antennanp
XFILLER_10_202 VPWR VGND sg13cmos5l_decap_8
XFILLER_6_206 VPWR VGND sg13cmos5l_decap_8
XFILLER_1_16 VPWR VGND sg13cmos5l_fill_2
X_77_ FrameData_O[20] FrameData[20] VPWR VGND sg13cmos5l_buf_1
XANTENNA__08__A N4END[8] VPWR VGND sg13cmos5l_antennanp
XFILLER_10_14 VPWR VGND sg13cmos5l_fill_1
XFILLER_10_25 VPWR VGND sg13cmos5l_decap_8
XANTENNA__30__X FrameStrobe_O[5] VPWR VGND sg13cmos5l_antennanp
X_00_ UserCLKo _00_/A VPWR VGND sg13cmos5l_buf_1
XFILLER_2_92 VPWR VGND sg13cmos5l_fill_1
XANTENNA__25__X FrameStrobe_O[0] VPWR VGND sg13cmos5l_antennanp
XFILLER_15_146 VPWR VGND sg13cmos5l_fill_2
XANTENNA__21__A N2END[3] VPWR VGND sg13cmos5l_antennanp
XFILLER_12_149 VPWR VGND sg13cmos5l_decap_8
XFILLER_16_24 VPWR VGND sg13cmos5l_decap_4
XFILLER_7_120 VPWR VGND sg13cmos5l_decap_8
XANTENNA__16__A N4END[0] VPWR VGND sg13cmos5l_antennanp
XFILLER_4_156 VPWR VGND sg13cmos5l_decap_8
XFILLER_4_123 VPWR VGND sg13cmos5l_fill_2
XFILLER_13_25 VPWR VGND sg13cmos5l_decap_8
XANTENNA__33__X FrameStrobe_O[8] VPWR VGND sg13cmos5l_antennanp
XFILLER_13_200 VPWR VGND sg13cmos5l_decap_8
XFILLER_5_81 VPWR VGND sg13cmos5l_decap_8
XANTENNA__28__X FrameStrobe_O[3] VPWR VGND sg13cmos5l_antennanp
X_76_ FrameData_O[19] FrameData[19] VPWR VGND sg13cmos5l_buf_1
XANTENNA__24__A N2END[0] VPWR VGND sg13cmos5l_antennanp
X_59_ FrameData_O[2] FrameData[2] VPWR VGND sg13cmos5l_buf_1
XANTENNA__19__A N2END[5] VPWR VGND sg13cmos5l_antennanp
XANTENNA__41__X FrameStrobe_O[16] VPWR VGND sg13cmos5l_antennanp
XFILLER_15_125 VPWR VGND sg13cmos5l_decap_8
XFILLER_7_16 VPWR VGND sg13cmos5l_decap_4
XFILLER_14_191 VPWR VGND sg13cmos5l_fill_1
XFILLER_12_128 VPWR VGND sg13cmos5l_decap_8
XFILLER_16_14 VPWR VGND sg13cmos5l_fill_1
XFILLER_16_69 VPWR VGND sg13cmos5l_fill_1
XANTENNA__36__X FrameStrobe_O[11] VPWR VGND sg13cmos5l_antennanp
XFILLER_11_183 VPWR VGND sg13cmos5l_decap_8
XFILLER_7_176 VPWR VGND sg13cmos5l_decap_8
XFILLER_8_92 VPWR VGND sg13cmos5l_decap_8
XANTENNA__32__A FrameStrobe[7] VPWR VGND sg13cmos5l_antennanp
XFILLER_4_135 VPWR VGND sg13cmos5l_decap_8
XFILLER_12_0 VPWR VGND sg13cmos5l_fill_2
XANTENNA__27__A FrameStrobe[2] VPWR VGND sg13cmos5l_antennanp
XFILLER_13_223 VPWR VGND sg13cmos5l_fill_1
XFILLER_0_160 VPWR VGND sg13cmos5l_fill_1
XFILLER_0_182 VPWR VGND sg13cmos5l_fill_2
XFILLER_5_60 VPWR VGND sg13cmos5l_decap_8
XANTENNA__44__X FrameStrobe_O[19] VPWR VGND sg13cmos5l_antennanp
X_75_ FrameData_O[18] FrameData[18] VPWR VGND sg13cmos5l_buf_1
XANTENNA__39__X FrameStrobe_O[14] VPWR VGND sg13cmos5l_antennanp
XANTENNA__40__A FrameStrobe[15] VPWR VGND sg13cmos5l_antennanp
XFILLER_2_222 VPWR VGND sg13cmos5l_fill_2
X_58_ FrameData_O[1] FrameData[1] VPWR VGND sg13cmos5l_buf_1
XANTENNA__35__A FrameStrobe[10] VPWR VGND sg13cmos5l_antennanp
XFILLER_15_104 VPWR VGND sg13cmos5l_decap_8
XFILLER_15_148 VPWR VGND sg13cmos5l_fill_1
XFILLER_11_92 VPWR VGND sg13cmos5l_decap_8
XFILLER_14_170 VPWR VGND sg13cmos5l_decap_4
XFILLER_14_181 VPWR VGND sg13cmos5l_fill_2
XFILLER_12_107 VPWR VGND sg13cmos5l_decap_8
XFILLER_16_37 VPWR VGND sg13cmos5l_fill_2
XANTENNA__52__X S2BEG[7] VPWR VGND sg13cmos5l_antennanp
XFILLER_11_162 VPWR VGND sg13cmos5l_decap_8
XFILLER_7_155 VPWR VGND sg13cmos5l_decap_8
XFILLER_8_71 VPWR VGND sg13cmos5l_decap_8
XANTENNA__47__X S2BEG[2] VPWR VGND sg13cmos5l_antennanp
XFILLER_4_18 VPWR VGND sg13cmos5l_fill_1
XFILLER_4_125 VPWR VGND sg13cmos5l_fill_1
XFILLER_4_114 VPWR VGND sg13cmos5l_fill_2
XFILLER_16_210 VPWR VGND sg13cmos5l_fill_2
XFILLER_3_191 VPWR VGND sg13cmos5l_decap_8
XANTENNA__43__A FrameStrobe[18] VPWR VGND sg13cmos5l_antennanp
XFILLER_0_194 VPWR VGND sg13cmos5l_decap_8
XFILLER_9_217 VPWR VGND sg13cmos5l_decap_8
XFILLER_10_216 VPWR VGND sg13cmos5l_decap_8
XANTENNA__38__A FrameStrobe[13] VPWR VGND sg13cmos5l_antennanp
XANTENNA__60__X FrameData_O[3] VPWR VGND sg13cmos5l_antennanp
XFILLER_14_70 VPWR VGND sg13cmos5l_decap_8
XFILLER_10_39 VPWR VGND sg13cmos5l_decap_8
X_74_ FrameData_O[17] FrameData[17] VPWR VGND sg13cmos5l_buf_1
XFILLER_2_201 VPWR VGND sg13cmos5l_decap_8
XANTENNA__55__X S1BEG[2] VPWR VGND sg13cmos5l_antennanp
XFILLER_2_62 VPWR VGND sg13cmos5l_decap_4
XFILLER_2_51 VPWR VGND sg13cmos5l_decap_4
X_57_ FrameData_O[0] FrameData[0] VPWR VGND sg13cmos5l_buf_1
XANTENNA__51__A N2MID[1] VPWR VGND sg13cmos5l_antennanp
XFILLER_11_71 VPWR VGND sg13cmos5l_decap_8
XFILLER_7_29 VPWR VGND sg13cmos5l_decap_8
XFILLER_16_49 VPWR VGND sg13cmos5l_decap_8
XANTENNA__46__A N2MID[6] VPWR VGND sg13cmos5l_antennanp
XFILLER_11_141 VPWR VGND sg13cmos5l_decap_8
XFILLER_7_134 VPWR VGND sg13cmos5l_decap_8
XFILLER_8_50 VPWR VGND sg13cmos5l_decap_8
XFILLER_4_104 VPWR VGND sg13cmos5l_fill_2
XANTENNA__63__X FrameData_O[6] VPWR VGND sg13cmos5l_antennanp
XFILLER_16_222 VPWR VGND sg13cmos5l_fill_2
XFILLER_3_170 VPWR VGND sg13cmos5l_decap_8
XFILLER_13_39 VPWR VGND sg13cmos5l_decap_8
XFILLER_1_118 VPWR VGND sg13cmos5l_decap_8
XANTENNA__58__X FrameData_O[1] VPWR VGND sg13cmos5l_antennanp
XFILLER_13_214 VPWR VGND sg13cmos5l_decap_8
XFILLER_5_95 VPWR VGND sg13cmos5l_decap_8
XANTENNA__54__A N1END[2] VPWR VGND sg13cmos5l_antennanp
X_73_ FrameData_O[16] FrameData[16] VPWR VGND sg13cmos5l_buf_1
XFILLER_5_210 VPWR VGND sg13cmos5l_decap_8
XANTENNA__49__A N2MID[3] VPWR VGND sg13cmos5l_antennanp
XANTENNA__71__X FrameData_O[14] VPWR VGND sg13cmos5l_antennanp
X_56_ S1BEG[3] N1END[0] VPWR VGND sg13cmos5l_buf_1
XFILLER_2_85 VPWR VGND sg13cmos5l_decap_8
XFILLER_2_41 VPWR VGND sg13cmos5l_fill_1
XANTENNA__66__X FrameData_O[9] VPWR VGND sg13cmos5l_antennanp
XFILLER_11_50 VPWR VGND sg13cmos5l_decap_8
XFILLER_15_139 VPWR VGND sg13cmos5l_decap_8
XFILLER_14_183 VPWR VGND sg13cmos5l_fill_1
XFILLER_16_28 VPWR VGND sg13cmos5l_fill_2
X_39_ FrameStrobe_O[14] FrameStrobe[14] VPWR VGND sg13cmos5l_buf_1
XANTENNA__62__A FrameData[5] VPWR VGND sg13cmos5l_antennanp
XFILLER_11_120 VPWR VGND sg13cmos5l_decap_8
XFILLER_11_197 VPWR VGND sg13cmos5l_decap_8
XFILLER_7_113 VPWR VGND sg13cmos5l_decap_8
XANTENNA__57__A FrameData[0] VPWR VGND sg13cmos5l_antennanp
XFILLER_16_201 VPWR VGND sg13cmos5l_fill_2
XFILLER_4_149 VPWR VGND sg13cmos5l_decap_8
XFILLER_1_108 VPWR VGND sg13cmos5l_decap_8
XFILLER_0_141 VPWR VGND sg13cmos5l_fill_1
XANTENNA__74__X FrameData_O[17] VPWR VGND sg13cmos5l_antennanp
XFILLER_5_74 VPWR VGND sg13cmos5l_decap_8
XANTENNA__69__X FrameData_O[12] VPWR VGND sg13cmos5l_antennanp
XANTENNA__70__A FrameData[13] VPWR VGND sg13cmos5l_antennanp
X_72_ FrameData_O[15] FrameData[15] VPWR VGND sg13cmos5l_buf_1
XANTENNA__65__A FrameData[8] VPWR VGND sg13cmos5l_antennanp
X_55_ S1BEG[2] N1END[1] VPWR VGND sg13cmos5l_buf_1
XFILLER_2_97 VPWR VGND sg13cmos5l_decap_8
XFILLER_15_118 VPWR VGND sg13cmos5l_decap_8
XANTENNA__82__X FrameData_O[25] VPWR VGND sg13cmos5l_antennanp
XFILLER_14_195 VPWR VGND sg13cmos5l_decap_4
X_38_ FrameStrobe_O[13] FrameStrobe[13] VPWR VGND sg13cmos5l_buf_1
XANTENNA__77__X FrameData_O[20] VPWR VGND sg13cmos5l_antennanp
XFILLER_11_176 VPWR VGND sg13cmos5l_decap_8
XFILLER_7_169 VPWR VGND sg13cmos5l_decap_8
XFILLER_8_85 VPWR VGND sg13cmos5l_decap_8
XANTENNA__73__A FrameData[16] VPWR VGND sg13cmos5l_antennanp
XFILLER_4_106 VPWR VGND sg13cmos5l_fill_1
XANTENNA__68__A FrameData[11] VPWR VGND sg13cmos5l_antennanp
XFILLER_0_131 VPWR VGND sg13cmos5l_fill_2
XFILLER_5_53 VPWR VGND sg13cmos5l_decap_8
XANTENNA__85__X FrameData_O[28] VPWR VGND sg13cmos5l_antennanp
XFILLER_14_84 VPWR VGND sg13cmos5l_decap_4
X_71_ FrameData_O[14] FrameData[14] VPWR VGND sg13cmos5l_buf_1
XANTENNA__81__A FrameData[24] VPWR VGND sg13cmos5l_antennanp
XFILLER_2_215 VPWR VGND sg13cmos5l_decap_8
X_54_ S1BEG[1] N1END[2] VPWR VGND sg13cmos5l_buf_1
XFILLER_2_76 VPWR VGND sg13cmos5l_decap_4
XANTENNA__76__A FrameData[19] VPWR VGND sg13cmos5l_antennanp
XFILLER_11_85 VPWR VGND sg13cmos5l_decap_8
XFILLER_14_163 VPWR VGND sg13cmos5l_decap_8
X_37_ FrameStrobe_O[12] FrameStrobe[12] VPWR VGND sg13cmos5l_buf_1
XFILLER_11_155 VPWR VGND sg13cmos5l_decap_8
XFILLER_7_148 VPWR VGND sg13cmos5l_decap_8
XFILLER_8_64 VPWR VGND sg13cmos5l_decap_8
XFILLER_6_192 VPWR VGND sg13cmos5l_decap_8
XANTENNA__88__X FrameData_O[31] VPWR VGND sg13cmos5l_antennanp
XFILLER_3_184 VPWR VGND sg13cmos5l_decap_8
XANTENNA__84__A FrameData[27] VPWR VGND sg13cmos5l_antennanp
XFILLER_5_21 VPWR VGND sg13cmos5l_fill_1
XFILLER_10_209 VPWR VGND sg13cmos5l_decap_8
XFILLER_5_32 VPWR VGND sg13cmos5l_decap_8
XANTENNA__79__A FrameData[22] VPWR VGND sg13cmos5l_antennanp
XFILLER_14_63 VPWR VGND sg13cmos5l_decap_8
XFILLER_14_96 VPWR VGND sg13cmos5l_decap_8
X_70_ FrameData_O[13] FrameData[13] VPWR VGND sg13cmos5l_buf_1
X_53_ S1BEG[0] N1END[3] VPWR VGND sg13cmos5l_buf_1
XFILLER_2_55 VPWR VGND sg13cmos5l_fill_1
XFILLER_2_33 VPWR VGND sg13cmos5l_fill_2
XFILLER_11_64 VPWR VGND sg13cmos5l_decap_8
XFILLER_14_131 VPWR VGND sg13cmos5l_decap_8
X_36_ FrameStrobe_O[11] FrameStrobe[11] VPWR VGND sg13cmos5l_buf_1
XFILLER_11_134 VPWR VGND sg13cmos5l_decap_8
XFILLER_7_127 VPWR VGND sg13cmos5l_decap_8
XANTENNA__87__A FrameData[30] VPWR VGND sg13cmos5l_antennanp
XFILLER_8_43 VPWR VGND sg13cmos5l_decap_8
XFILLER_6_171 VPWR VGND sg13cmos5l_decap_8
X_19_ S2BEGb[2] N2END[5] VPWR VGND sg13cmos5l_buf_1
XFILLER_3_163 VPWR VGND sg13cmos5l_decap_8
XFILLER_3_141 VPWR VGND sg13cmos5l_fill_1
XFILLER_3_130 VPWR VGND sg13cmos5l_decap_8
XFILLER_13_207 VPWR VGND sg13cmos5l_decap_8
XFILLER_0_111 VPWR VGND sg13cmos5l_decap_4
XFILLER_8_211 VPWR VGND sg13cmos5l_decap_8
XFILLER_8_222 VPWR VGND sg13cmos5l_fill_2
XFILLER_5_88 VPWR VGND sg13cmos5l_decap_8
XFILLER_14_20 VPWR VGND sg13cmos5l_fill_1
XFILLER_14_31 VPWR VGND sg13cmos5l_decap_8
XFILLER_5_203 VPWR VGND sg13cmos5l_decap_8
X_52_ S2BEG[7] N2MID[0] VPWR VGND sg13cmos5l_buf_1
XFILLER_2_45 VPWR VGND sg13cmos5l_fill_2
XFILLER_11_43 VPWR VGND sg13cmos5l_decap_8
XFILLER_14_110 VPWR VGND sg13cmos5l_decap_8
XFILLER_14_187 VPWR VGND sg13cmos5l_fill_1
X_35_ FrameStrobe_O[10] FrameStrobe[10] VPWR VGND sg13cmos5l_buf_1
XFILLER_11_113 VPWR VGND sg13cmos5l_decap_8
XFILLER_7_106 VPWR VGND sg13cmos5l_decap_8
XFILLER_8_99 VPWR VGND sg13cmos5l_decap_8
XFILLER_8_22 VPWR VGND sg13cmos5l_decap_8
XFILLER_6_150 VPWR VGND sg13cmos5l_decap_8
X_18_ S2BEGb[1] N2END[6] VPWR VGND sg13cmos5l_buf_1
XFILLER_0_145 VPWR VGND sg13cmos5l_fill_1
XFILLER_5_67 VPWR VGND sg13cmos5l_decap_8
X_51_ S2BEG[6] N2MID[1] VPWR VGND sg13cmos5l_buf_1
XFILLER_11_22 VPWR VGND sg13cmos5l_decap_8
XFILLER_11_99 VPWR VGND sg13cmos5l_decap_8
X_34_ FrameStrobe_O[9] FrameStrobe[9] VPWR VGND sg13cmos5l_buf_1
XANTENNA__01__X S4BEG[0] VPWR VGND sg13cmos5l_antennanp
XFILLER_11_169 VPWR VGND sg13cmos5l_decap_8
X_17_ S2BEGb[0] N2END[7] VPWR VGND sg13cmos5l_buf_1
XFILLER_8_78 VPWR VGND sg13cmos5l_decap_8
XFILLER_3_198 VPWR VGND sg13cmos5l_decap_8
XFILLER_5_46 VPWR VGND sg13cmos5l_decap_8
XFILLER_14_11 VPWR VGND sg13cmos5l_fill_2
XFILLER_14_77 VPWR VGND sg13cmos5l_decap_8
XFILLER_14_88 VPWR VGND sg13cmos5l_fill_1
XANTENNA__04__X S4BEG[3] VPWR VGND sg13cmos5l_antennanp
XFILLER_2_208 VPWR VGND sg13cmos5l_decap_8
X_50_ S2BEG[5] N2MID[2] VPWR VGND sg13cmos5l_buf_1
XFILLER_9_0 VPWR VGND sg13cmos5l_fill_1
XFILLER_2_14 VPWR VGND sg13cmos5l_fill_1
XANTENNA__00__A clkload0/A VPWR VGND sg13cmos5l_antennanp
XFILLER_11_78 VPWR VGND sg13cmos5l_decap_8
XFILLER_14_145 VPWR VGND sg13cmos5l_decap_8
XFILLER_14_156 VPWR VGND sg13cmos5l_decap_8
X_33_ FrameStrobe_O[8] FrameStrobe[8] VPWR VGND sg13cmos5l_buf_1
XFILLER_9_182 VPWR VGND sg13cmos5l_decap_8
XFILLER_11_148 VPWR VGND sg13cmos5l_decap_8
X_16_ S4BEG[15] N4END[0] VPWR VGND sg13cmos5l_buf_1
XFILLER_8_57 VPWR VGND sg13cmos5l_decap_8
XFILLER_6_185 VPWR VGND sg13cmos5l_decap_8
XFILLER_16_218 VPWR VGND sg13cmos5l_decap_4
XANTENNA__12__X S4BEG[11] VPWR VGND sg13cmos5l_antennanp
XFILLER_3_177 VPWR VGND sg13cmos5l_decap_8
XANTENNA__07__X S4BEG[6] VPWR VGND sg13cmos5l_antennanp
XFILLER_5_25 VPWR VGND sg13cmos5l_decap_8
XANTENNA__03__A N4END[13] VPWR VGND sg13cmos5l_antennanp
XFILLER_14_45 VPWR VGND sg13cmos5l_decap_4
XFILLER_14_56 VPWR VGND sg13cmos5l_decap_8
XFILLER_5_217 VPWR VGND sg13cmos5l_decap_8
XANTENNA__20__X S2BEGb[3] VPWR VGND sg13cmos5l_antennanp
XFILLER_11_57 VPWR VGND sg13cmos5l_decap_8
XANTENNA__15__X S4BEG[14] VPWR VGND sg13cmos5l_antennanp
XFILLER_14_124 VPWR VGND sg13cmos5l_decap_8
X_32_ FrameStrobe_O[7] FrameStrobe[7] VPWR VGND sg13cmos5l_buf_1
XFILLER_9_161 VPWR VGND sg13cmos5l_decap_8
XANTENNA__11__A N4END[5] VPWR VGND sg13cmos5l_antennanp
XFILLER_11_127 VPWR VGND sg13cmos5l_decap_8
XFILLER_10_193 VPWR VGND sg13cmos5l_fill_1
X_15_ S4BEG[14] N4END[1] VPWR VGND sg13cmos5l_buf_1
XFILLER_8_36 VPWR VGND sg13cmos5l_decap_8
XFILLER_6_164 VPWR VGND sg13cmos5l_decap_8
XANTENNA__06__A N4END[10] VPWR VGND sg13cmos5l_antennanp
XFILLER_3_156 VPWR VGND sg13cmos5l_decap_8
XFILLER_3_123 VPWR VGND sg13cmos5l_decap_8
XANTENNA__23__X S2BEGb[6] VPWR VGND sg13cmos5l_antennanp
XFILLER_0_115 VPWR VGND sg13cmos5l_fill_2
XFILLER_8_204 VPWR VGND sg13cmos5l_decap_8
XFILLER_14_24 VPWR VGND sg13cmos5l_decap_8
XANTENNA__18__X S2BEGb[1] VPWR VGND sg13cmos5l_antennanp
XFILLER_6_80 VPWR VGND sg13cmos5l_decap_8
XANTENNA__14__A N4END[2] VPWR VGND sg13cmos5l_antennanp
XFILLER_1_221 VPWR VGND sg13cmos5l_fill_2
XFILLER_1_210 VPWR VGND sg13cmos5l_fill_1
XANTENNA__09__A N4END[7] VPWR VGND sg13cmos5l_antennanp
XFILLER_11_36 VPWR VGND sg13cmos5l_decap_8
XFILLER_14_103 VPWR VGND sg13cmos5l_decap_8
XANTENNA__31__X FrameStrobe_O[6] VPWR VGND sg13cmos5l_antennanp
X_31_ FrameStrobe_O[6] FrameStrobe[6] VPWR VGND sg13cmos5l_buf_1
XFILLER_9_140 VPWR VGND sg13cmos5l_decap_8
XFILLER_11_106 VPWR VGND sg13cmos5l_decap_8
XANTENNA__26__X FrameStrobe_O[1] VPWR VGND sg13cmos5l_antennanp
XFILLER_10_172 VPWR VGND sg13cmos5l_decap_8
XFILLER_8_15 VPWR VGND sg13cmos5l_fill_1
XFILLER_6_143 VPWR VGND sg13cmos5l_decap_8
X_14_ S4BEG[13] N4END[2] VPWR VGND sg13cmos5l_buf_1
XANTENNA__22__A N2END[2] VPWR VGND sg13cmos5l_antennanp
XFILLER_3_102 VPWR VGND sg13cmos5l_decap_8
XFILLER_0_71 VPWR VGND sg13cmos5l_fill_1
XFILLER_0_82 VPWR VGND sg13cmos5l_fill_2
XANTENNA__17__A N2END[7] VPWR VGND sg13cmos5l_antennanp
XFILLER_12_212 VPWR VGND sg13cmos5l_decap_8
XFILLER_12_223 VPWR VGND sg13cmos5l_fill_1
XFILLER_9_91 VPWR VGND sg13cmos5l_decap_8
XANTENNA__34__X FrameStrobe_O[9] VPWR VGND sg13cmos5l_antennanp
XANTENNA__29__X FrameStrobe_O[4] VPWR VGND sg13cmos5l_antennanp
XANTENNA__30__A FrameStrobe[5] VPWR VGND sg13cmos5l_antennanp
XFILLER_2_28 VPWR VGND sg13cmos5l_fill_2
XFILLER_15_90 VPWR VGND sg13cmos5l_decap_8
XANTENNA__25__A FrameStrobe[0] VPWR VGND sg13cmos5l_antennanp
X_30_ FrameStrobe_O[5] FrameStrobe[5] VPWR VGND sg13cmos5l_buf_1
XFILLER_7_0 VPWR VGND sg13cmos5l_fill_1
XFILLER_9_196 VPWR VGND sg13cmos5l_decap_8
XFILLER_3_71 VPWR VGND sg13cmos5l_decap_8
XANTENNA__42__X FrameStrobe_O[17] VPWR VGND sg13cmos5l_antennanp
XFILLER_10_151 VPWR VGND sg13cmos5l_decap_8
XFILLER_6_199 VPWR VGND sg13cmos5l_decap_8
XFILLER_6_122 VPWR VGND sg13cmos5l_decap_8
X_13_ S4BEG[12] N4END[3] VPWR VGND sg13cmos5l_buf_1
XANTENNA__37__X FrameStrobe_O[12] VPWR VGND sg13cmos5l_antennanp
XFILLER_0_106 VPWR VGND sg13cmos5l_fill_2
XFILLER_0_61 VPWR VGND sg13cmos5l_fill_2
XFILLER_0_94 VPWR VGND sg13cmos5l_fill_2
XFILLER_9_70 VPWR VGND sg13cmos5l_decap_8
XANTENNA__33__A FrameStrobe[8] VPWR VGND sg13cmos5l_antennanp
XFILLER_5_39 VPWR VGND sg13cmos5l_decap_8
XANTENNA__28__A FrameStrobe[3] VPWR VGND sg13cmos5l_antennanp
XANTENNA__50__X S2BEG[5] VPWR VGND sg13cmos5l_antennanp
XFILLER_1_223 VPWR VGND sg13cmos5l_fill_1
XANTENNA__45__X S2BEG[0] VPWR VGND sg13cmos5l_antennanp
XANTENNA__41__A FrameStrobe[16] VPWR VGND sg13cmos5l_antennanp
XFILLER_13_193 VPWR VGND sg13cmos5l_decap_8
XFILLER_9_175 VPWR VGND sg13cmos5l_decap_8
XFILLER_3_50 VPWR VGND sg13cmos5l_decap_8
XANTENNA__36__A FrameStrobe[11] VPWR VGND sg13cmos5l_antennanp
XFILLER_10_130 VPWR VGND sg13cmos5l_decap_8
XFILLER_6_101 VPWR VGND sg13cmos5l_decap_8
X_12_ S4BEG[11] N4END[4] VPWR VGND sg13cmos5l_buf_1
XFILLER_6_178 VPWR VGND sg13cmos5l_decap_8
XFILLER_3_137 VPWR VGND sg13cmos5l_decap_4
XANTENNA__53__X S1BEG[0] VPWR VGND sg13cmos5l_antennanp
XFILLER_0_84 VPWR VGND sg13cmos5l_fill_1
XANTENNA__48__X S2BEG[3] VPWR VGND sg13cmos5l_antennanp
XFILLER_8_218 VPWR VGND sg13cmos5l_decap_4
XANTENNA__44__A FrameStrobe[19] VPWR VGND sg13cmos5l_antennanp
XFILLER_14_16 VPWR VGND sg13cmos5l_fill_1
XFILLER_14_38 VPWR VGND sg13cmos5l_decap_8
XFILLER_6_94 VPWR VGND sg13cmos5l_decap_8
XANTENNA__39__A FrameStrobe[14] VPWR VGND sg13cmos5l_antennanp
XANTENNA__61__X FrameData_O[4] VPWR VGND sg13cmos5l_antennanp
XFILLER_14_117 VPWR VGND sg13cmos5l_decap_8
XANTENNA__56__X S1BEG[3] VPWR VGND sg13cmos5l_antennanp
XFILLER_13_172 VPWR VGND sg13cmos5l_decap_8
X_88_ FrameData_O[31] FrameData[31] VPWR VGND sg13cmos5l_buf_1
XFILLER_9_154 VPWR VGND sg13cmos5l_decap_8
XANTENNA__52__A N2MID[0] VPWR VGND sg13cmos5l_antennanp
XFILLER_10_186 VPWR VGND sg13cmos5l_decap_8
XFILLER_10_197 VPWR VGND sg13cmos5l_fill_2
XFILLER_12_93 VPWR VGND sg13cmos5l_decap_8
X_11_ S4BEG[10] N4END[5] VPWR VGND sg13cmos5l_buf_1
XFILLER_8_29 VPWR VGND sg13cmos5l_decap_8
XFILLER_6_157 VPWR VGND sg13cmos5l_decap_8
XANTENNA__47__A N2MID[5] VPWR VGND sg13cmos5l_antennanp
XFILLER_15_201 VPWR VGND sg13cmos5l_decap_4
XFILLER_15_223 VPWR VGND sg13cmos5l_fill_1
XFILLER_3_149 VPWR VGND sg13cmos5l_decap_8
XFILLER_3_116 VPWR VGND sg13cmos5l_decap_8
XANTENNA__64__X FrameData_O[7] VPWR VGND sg13cmos5l_antennanp
XANTENNA__59__X FrameData_O[2] VPWR VGND sg13cmos5l_antennanp
XANTENNA__60__A FrameData[3] VPWR VGND sg13cmos5l_antennanp
XFILLER_6_73 VPWR VGND sg13cmos5l_decap_8
XANTENNA__55__A N1END[1] VPWR VGND sg13cmos5l_antennanp
XFILLER_1_214 VPWR VGND sg13cmos5l_decap_8
XFILLER_11_29 VPWR VGND sg13cmos5l_decap_8
XANTENNA__72__X FrameData_O[15] VPWR VGND sg13cmos5l_antennanp
XFILLER_13_151 VPWR VGND sg13cmos5l_decap_8
XFILLER_9_133 VPWR VGND sg13cmos5l_decap_8
X_87_ FrameData_O[30] FrameData[30] VPWR VGND sg13cmos5l_buf_1
XFILLER_3_96 VPWR VGND sg13cmos5l_fill_2
XFILLER_3_85 VPWR VGND sg13cmos5l_decap_8
XANTENNA__67__X FrameData_O[10] VPWR VGND sg13cmos5l_antennanp
XFILLER_10_165 VPWR VGND sg13cmos5l_decap_8
XFILLER_12_72 VPWR VGND sg13cmos5l_decap_8
X_10_ S4BEG[9] N4END[6] VPWR VGND sg13cmos5l_buf_1
XFILLER_6_136 VPWR VGND sg13cmos5l_decap_8
XANTENNA__63__A FrameData[6] VPWR VGND sg13cmos5l_antennanp
XFILLER_0_75 VPWR VGND sg13cmos5l_decap_8
XFILLER_9_84 VPWR VGND sg13cmos5l_decap_8
XFILLER_2_194 VPWR VGND sg13cmos5l_decap_8
XFILLER_12_205 VPWR VGND sg13cmos5l_decap_8
XANTENNA__58__A FrameData[1] VPWR VGND sg13cmos5l_antennanp
XANTENNA__80__X FrameData_O[23] VPWR VGND sg13cmos5l_antennanp
XANTENNA__75__X FrameData_O[18] VPWR VGND sg13cmos5l_antennanp
XFILLER_4_223 VPWR VGND sg13cmos5l_fill_1
XFILLER_4_212 VPWR VGND sg13cmos5l_decap_8
XFILLER_6_52 VPWR VGND sg13cmos5l_decap_8
XANTENNA__71__A FrameData[14] VPWR VGND sg13cmos5l_antennanp
XFILLER_15_83 VPWR VGND sg13cmos5l_decap_8
XFILLER_16_160 VPWR VGND sg13cmos5l_decap_8
XFILLER_16_171 VPWR VGND sg13cmos5l_decap_4
XFILLER_16_182 VPWR VGND sg13cmos5l_fill_2
XANTENNA__66__A FrameData[9] VPWR VGND sg13cmos5l_antennanp
XFILLER_13_130 VPWR VGND sg13cmos5l_decap_8
XFILLER_9_189 VPWR VGND sg13cmos5l_decap_8
XFILLER_9_112 VPWR VGND sg13cmos5l_decap_8
X_86_ FrameData_O[29] FrameData[29] VPWR VGND sg13cmos5l_buf_1
XFILLER_3_64 VPWR VGND sg13cmos5l_decap_8
XFILLER_10_144 VPWR VGND sg13cmos5l_decap_8
XFILLER_12_51 VPWR VGND sg13cmos5l_decap_8
XFILLER_6_115 VPWR VGND sg13cmos5l_decap_8
XANTENNA__83__X FrameData_O[26] VPWR VGND sg13cmos5l_antennanp
X_69_ FrameData_O[12] FrameData[12] VPWR VGND sg13cmos5l_buf_1
XANTENNA__78__X FrameData_O[21] VPWR VGND sg13cmos5l_antennanp
XFILLER_2_173 VPWR VGND sg13cmos5l_decap_8
Xclkbuf_0_UserCLK clkbuf_0_UserCLK/X UserCLK VPWR VGND sg13cmos5l_buf_16
XFILLER_9_63 VPWR VGND sg13cmos5l_decap_8
XANTENNA__74__A FrameData[17] VPWR VGND sg13cmos5l_antennanp
XFILLER_7_221 VPWR VGND sg13cmos5l_fill_2
XANTENNA__69__A FrameData[12] VPWR VGND sg13cmos5l_antennanp
XFILLER_6_31 VPWR VGND sg13cmos5l_decap_8
XANTENNA__86__X FrameData_O[29] VPWR VGND sg13cmos5l_antennanp
XFILLER_15_62 VPWR VGND sg13cmos5l_decap_4
XANTENNA__82__A FrameData[25] VPWR VGND sg13cmos5l_antennanp
XFILLER_13_186 VPWR VGND sg13cmos5l_decap_8
X_85_ FrameData_O[28] FrameData[28] VPWR VGND sg13cmos5l_buf_1
XFILLER_9_168 VPWR VGND sg13cmos5l_decap_8
XFILLER_8_190 VPWR VGND sg13cmos5l_decap_8
XFILLER_3_98 VPWR VGND sg13cmos5l_fill_1
XFILLER_3_43 VPWR VGND sg13cmos5l_decap_8
XFILLER_10_123 VPWR VGND sg13cmos5l_decap_8
XFILLER_12_30 VPWR VGND sg13cmos5l_decap_8
XANTENNA__77__A FrameData[20] VPWR VGND sg13cmos5l_antennanp
XFILLER_5_193 VPWR VGND sg13cmos5l_decap_8
X_68_ FrameData_O[11] FrameData[11] VPWR VGND sg13cmos5l_buf_1
XFILLER_0_66 VPWR VGND sg13cmos5l_fill_1
XFILLER_9_42 VPWR VGND sg13cmos5l_decap_8
XFILLER_7_200 VPWR VGND sg13cmos5l_decap_8
XANTENNA__85__A FrameData[28] VPWR VGND sg13cmos5l_antennanp
XFILLER_6_87 VPWR VGND sg13cmos5l_decap_8
XFILLER_1_206 VPWR VGND sg13cmos5l_decap_4
XFILLER_15_41 VPWR VGND sg13cmos5l_decap_8
XFILLER_13_165 VPWR VGND sg13cmos5l_decap_8
X_84_ FrameData_O[27] FrameData[27] VPWR VGND sg13cmos5l_buf_1
XFILLER_9_147 VPWR VGND sg13cmos5l_decap_8
XFILLER_3_11 VPWR VGND sg13cmos5l_fill_2
XFILLER_10_102 VPWR VGND sg13cmos5l_decap_8
XFILLER_10_179 VPWR VGND sg13cmos5l_decap_8
XFILLER_12_86 VPWR VGND sg13cmos5l_decap_8
X_67_ FrameData_O[10] FrameData[10] VPWR VGND sg13cmos5l_buf_1
XFILLER_5_172 VPWR VGND sg13cmos5l_decap_8
XFILLER_3_109 VPWR VGND sg13cmos5l_decap_8
XANTENNA__88__A FrameData[31] VPWR VGND sg13cmos5l_antennanp
XFILLER_15_205 VPWR VGND sg13cmos5l_fill_1
XFILLER_2_153 VPWR VGND sg13cmos5l_fill_2
XFILLER_2_142 VPWR VGND sg13cmos5l_decap_8
XFILLER_2_120 VPWR VGND sg13cmos5l_fill_1
XFILLER_0_89 VPWR VGND sg13cmos5l_fill_2
XFILLER_9_98 VPWR VGND sg13cmos5l_decap_8
XFILLER_9_21 VPWR VGND sg13cmos5l_decap_8
XFILLER_12_219 VPWR VGND sg13cmos5l_decap_4
XFILLER_7_223 VPWR VGND sg13cmos5l_fill_1
XFILLER_6_66 VPWR VGND sg13cmos5l_decap_8
XFILLER_15_97 VPWR VGND sg13cmos5l_decap_8
.ends
