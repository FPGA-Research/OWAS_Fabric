* NGSPICE file created from NPU_SLICE.ext - technology: ihp-sg13cmos5l

* Black-box entry subcircuit for sg13cmos5l_antennanp abstract view
.subckt sg13cmos5l_antennanp A VDD VSS
.ends

* Black-box entry subcircuit for latch abstract view
.subckt latch Q D VSS VDD GATE
.ends

* Black-box entry subcircuit for sg13cmos5l_decap_4 abstract view
.subckt sg13cmos5l_decap_4 VDD VSS
.ends

* Black-box entry subcircuit for sg13cmos5l_fill_2 abstract view
.subckt sg13cmos5l_fill_2 VDD VSS
.ends

* Black-box entry subcircuit for sg13cmos5l_mux2_1 abstract view
.subckt sg13cmos5l_mux2_1 X A0 A1 S VDD VSS
.ends

* Black-box entry subcircuit for sg13cmos5l_fill_1 abstract view
.subckt sg13cmos5l_fill_1 VDD VSS
.ends

* Black-box entry subcircuit for sg13cmos5l_mux4_1 abstract view
.subckt sg13cmos5l_mux4_1 X A0 A1 A2 A3 S0 S1 VDD VSS
.ends

* Black-box entry subcircuit for sg13cmos5l_decap_8 abstract view
.subckt sg13cmos5l_decap_8 VDD VSS
.ends

* Black-box entry subcircuit for sg13cmos5l_buf_1 abstract view
.subckt sg13cmos5l_buf_1 X A VDD VSS
.ends

* Black-box entry subcircuit for sg13cmos5l_tiehi abstract view
.subckt sg13cmos5l_tiehi L_HI VDD VSS
.ends

* Black-box entry subcircuit for sg13cmos5l_dfrbpq_1 abstract view
.subckt sg13cmos5l_dfrbpq_1 Q CLK D RESET_B VDD VSS
.ends

* Black-box entry subcircuit for sg13cmos5l_tielo abstract view
.subckt sg13cmos5l_tielo L_LO VDD VSS
.ends

* Black-box entry subcircuit for sg13cmos5l_or2_1 abstract view
.subckt sg13cmos5l_or2_1 X A B VDD VSS
.ends

* Black-box entry subcircuit for sg13cmos5l_nor2b_1 abstract view
.subckt sg13cmos5l_nor2b_1 Y A B_N VDD VSS
.ends

.subckt NPU_SLICE FAB_USER_CLK NPU_ACT_ADDR0 NPU_ACT_ADDR1 NPU_ACT_ADDR2 NPU_ACT_ADDR3
+ NPU_ACT_ADDR4 NPU_ACT_ADDR5 NPU_ACT_ADDR6 NPU_ACT_ADDR7 NPU_ACT_ADDR8 NPU_ACT_RDATA0
+ NPU_ACT_RDATA1 NPU_ACT_RDATA2 NPU_ACT_RDATA3 NPU_ACT_RDATA4 NPU_ACT_RDATA5 NPU_ACT_RDATA6
+ NPU_ACT_RDATA7 NPU_ACT_WDATA0 NPU_ACT_WDATA1 NPU_ACT_WDATA2 NPU_ACT_WDATA3 NPU_ACT_WDATA4
+ NPU_ACT_WDATA5 NPU_ACT_WDATA6 NPU_ACT_WDATA7 NPU_ACT_WE NPU_OUT_ACT0 NPU_OUT_ACT1
+ NPU_OUT_ACT2 NPU_OUT_ACT3 NPU_OUT_ACT4 NPU_OUT_ACT5 NPU_OUT_ACT6 NPU_OUT_ACT7 NPU_WEIGHT_IN0
+ NPU_WEIGHT_IN1 NPU_WEIGHT_IN2 NPU_WEIGHT_IN3 NPU_WEIGHT_IN4 NPU_WEIGHT_IN5 NPU_WEIGHT_IN6
+ NPU_WEIGHT_IN7 NPU_WEIGHT_SHIFT_EN NPU_XBAR_SEL0 NPU_XBAR_SEL1 NPU_XBAR_SEL2 NPU_XBAR_SEL3
+ Tile_X0Y0_E1END[0] Tile_X0Y0_E1END[1] Tile_X0Y0_E1END[2] Tile_X0Y0_E1END[3] Tile_X0Y0_E2END[0]
+ Tile_X0Y0_E2END[1] Tile_X0Y0_E2END[2] Tile_X0Y0_E2END[3] Tile_X0Y0_E2END[4] Tile_X0Y0_E2END[5]
+ Tile_X0Y0_E2END[6] Tile_X0Y0_E2END[7] Tile_X0Y0_E2MID[0] Tile_X0Y0_E2MID[1] Tile_X0Y0_E2MID[2]
+ Tile_X0Y0_E2MID[3] Tile_X0Y0_E2MID[4] Tile_X0Y0_E2MID[5] Tile_X0Y0_E2MID[6] Tile_X0Y0_E2MID[7]
+ Tile_X0Y0_E6END[0] Tile_X0Y0_E6END[10] Tile_X0Y0_E6END[11] Tile_X0Y0_E6END[1] Tile_X0Y0_E6END[2]
+ Tile_X0Y0_E6END[3] Tile_X0Y0_E6END[4] Tile_X0Y0_E6END[5] Tile_X0Y0_E6END[6] Tile_X0Y0_E6END[7]
+ Tile_X0Y0_E6END[8] Tile_X0Y0_E6END[9] Tile_X0Y0_EE4END[0] Tile_X0Y0_EE4END[10] Tile_X0Y0_EE4END[11]
+ Tile_X0Y0_EE4END[12] Tile_X0Y0_EE4END[13] Tile_X0Y0_EE4END[14] Tile_X0Y0_EE4END[15]
+ Tile_X0Y0_EE4END[1] Tile_X0Y0_EE4END[2] Tile_X0Y0_EE4END[3] Tile_X0Y0_EE4END[4]
+ Tile_X0Y0_EE4END[5] Tile_X0Y0_EE4END[6] Tile_X0Y0_EE4END[7] Tile_X0Y0_EE4END[8]
+ Tile_X0Y0_EE4END[9] Tile_X0Y0_FrameData[0] Tile_X0Y0_FrameData[10] Tile_X0Y0_FrameData[11]
+ Tile_X0Y0_FrameData[12] Tile_X0Y0_FrameData[13] Tile_X0Y0_FrameData[14] Tile_X0Y0_FrameData[15]
+ Tile_X0Y0_FrameData[16] Tile_X0Y0_FrameData[17] Tile_X0Y0_FrameData[18] Tile_X0Y0_FrameData[19]
+ Tile_X0Y0_FrameData[1] Tile_X0Y0_FrameData[20] Tile_X0Y0_FrameData[21] Tile_X0Y0_FrameData[22]
+ Tile_X0Y0_FrameData[23] Tile_X0Y0_FrameData[24] Tile_X0Y0_FrameData[25] Tile_X0Y0_FrameData[26]
+ Tile_X0Y0_FrameData[27] Tile_X0Y0_FrameData[28] Tile_X0Y0_FrameData[29] Tile_X0Y0_FrameData[2]
+ Tile_X0Y0_FrameData[30] Tile_X0Y0_FrameData[31] Tile_X0Y0_FrameData[3] Tile_X0Y0_FrameData[4]
+ Tile_X0Y0_FrameData[5] Tile_X0Y0_FrameData[6] Tile_X0Y0_FrameData[7] Tile_X0Y0_FrameData[8]
+ Tile_X0Y0_FrameData[9] Tile_X0Y0_FrameData_O[0] Tile_X0Y0_FrameData_O[10] Tile_X0Y0_FrameData_O[11]
+ Tile_X0Y0_FrameData_O[12] Tile_X0Y0_FrameData_O[13] Tile_X0Y0_FrameData_O[14] Tile_X0Y0_FrameData_O[15]
+ Tile_X0Y0_FrameData_O[16] Tile_X0Y0_FrameData_O[17] Tile_X0Y0_FrameData_O[18] Tile_X0Y0_FrameData_O[19]
+ Tile_X0Y0_FrameData_O[1] Tile_X0Y0_FrameData_O[20] Tile_X0Y0_FrameData_O[21] Tile_X0Y0_FrameData_O[22]
+ Tile_X0Y0_FrameData_O[23] Tile_X0Y0_FrameData_O[24] Tile_X0Y0_FrameData_O[25] Tile_X0Y0_FrameData_O[26]
+ Tile_X0Y0_FrameData_O[27] Tile_X0Y0_FrameData_O[28] Tile_X0Y0_FrameData_O[29] Tile_X0Y0_FrameData_O[2]
+ Tile_X0Y0_FrameData_O[30] Tile_X0Y0_FrameData_O[31] Tile_X0Y0_FrameData_O[3] Tile_X0Y0_FrameData_O[4]
+ Tile_X0Y0_FrameData_O[5] Tile_X0Y0_FrameData_O[6] Tile_X0Y0_FrameData_O[7] Tile_X0Y0_FrameData_O[8]
+ Tile_X0Y0_FrameData_O[9] Tile_X0Y0_FrameStrobe_O[0] Tile_X0Y0_FrameStrobe_O[10]
+ Tile_X0Y0_FrameStrobe_O[11] Tile_X0Y0_FrameStrobe_O[12] Tile_X0Y0_FrameStrobe_O[13]
+ Tile_X0Y0_FrameStrobe_O[14] Tile_X0Y0_FrameStrobe_O[15] Tile_X0Y0_FrameStrobe_O[16]
+ Tile_X0Y0_FrameStrobe_O[17] Tile_X0Y0_FrameStrobe_O[18] Tile_X0Y0_FrameStrobe_O[19]
+ Tile_X0Y0_FrameStrobe_O[1] Tile_X0Y0_FrameStrobe_O[2] Tile_X0Y0_FrameStrobe_O[3]
+ Tile_X0Y0_FrameStrobe_O[4] Tile_X0Y0_FrameStrobe_O[5] Tile_X0Y0_FrameStrobe_O[6]
+ Tile_X0Y0_FrameStrobe_O[7] Tile_X0Y0_FrameStrobe_O[8] Tile_X0Y0_FrameStrobe_O[9]
+ Tile_X0Y0_N1BEG[0] Tile_X0Y0_N1BEG[1] Tile_X0Y0_N1BEG[2] Tile_X0Y0_N1BEG[3] Tile_X0Y0_N2BEG[0]
+ Tile_X0Y0_N2BEG[1] Tile_X0Y0_N2BEG[2] Tile_X0Y0_N2BEG[3] Tile_X0Y0_N2BEG[4] Tile_X0Y0_N2BEG[5]
+ Tile_X0Y0_N2BEG[6] Tile_X0Y0_N2BEG[7] Tile_X0Y0_N2BEGb[0] Tile_X0Y0_N2BEGb[1] Tile_X0Y0_N2BEGb[2]
+ Tile_X0Y0_N2BEGb[3] Tile_X0Y0_N2BEGb[4] Tile_X0Y0_N2BEGb[5] Tile_X0Y0_N2BEGb[6]
+ Tile_X0Y0_N2BEGb[7] Tile_X0Y0_N4BEG[0] Tile_X0Y0_N4BEG[10] Tile_X0Y0_N4BEG[11] Tile_X0Y0_N4BEG[12]
+ Tile_X0Y0_N4BEG[13] Tile_X0Y0_N4BEG[14] Tile_X0Y0_N4BEG[15] Tile_X0Y0_N4BEG[1] Tile_X0Y0_N4BEG[2]
+ Tile_X0Y0_N4BEG[3] Tile_X0Y0_N4BEG[4] Tile_X0Y0_N4BEG[5] Tile_X0Y0_N4BEG[6] Tile_X0Y0_N4BEG[7]
+ Tile_X0Y0_N4BEG[8] Tile_X0Y0_N4BEG[9] Tile_X0Y0_S1END[0] Tile_X0Y0_S1END[1] Tile_X0Y0_S1END[2]
+ Tile_X0Y0_S1END[3] Tile_X0Y0_S2END[0] Tile_X0Y0_S2END[1] Tile_X0Y0_S2END[2] Tile_X0Y0_S2END[3]
+ Tile_X0Y0_S2END[4] Tile_X0Y0_S2END[5] Tile_X0Y0_S2END[6] Tile_X0Y0_S2END[7] Tile_X0Y0_S2MID[0]
+ Tile_X0Y0_S2MID[1] Tile_X0Y0_S2MID[2] Tile_X0Y0_S2MID[3] Tile_X0Y0_S2MID[4] Tile_X0Y0_S2MID[5]
+ Tile_X0Y0_S2MID[6] Tile_X0Y0_S2MID[7] Tile_X0Y0_S4END[0] Tile_X0Y0_S4END[10] Tile_X0Y0_S4END[11]
+ Tile_X0Y0_S4END[12] Tile_X0Y0_S4END[13] Tile_X0Y0_S4END[14] Tile_X0Y0_S4END[15]
+ Tile_X0Y0_S4END[1] Tile_X0Y0_S4END[2] Tile_X0Y0_S4END[3] Tile_X0Y0_S4END[4] Tile_X0Y0_S4END[5]
+ Tile_X0Y0_S4END[6] Tile_X0Y0_S4END[7] Tile_X0Y0_S4END[8] Tile_X0Y0_S4END[9] Tile_X0Y0_UserCLK
+ Tile_X0Y0_UserCLKo Tile_X0Y0_W1BEG[0] Tile_X0Y0_W1BEG[1] Tile_X0Y0_W1BEG[2] Tile_X0Y0_W1BEG[3]
+ Tile_X0Y0_W2BEG[0] Tile_X0Y0_W2BEG[1] Tile_X0Y0_W2BEG[2] Tile_X0Y0_W2BEG[3] Tile_X0Y0_W2BEG[4]
+ Tile_X0Y0_W2BEG[5] Tile_X0Y0_W2BEG[6] Tile_X0Y0_W2BEG[7] Tile_X0Y0_W2BEGb[0] Tile_X0Y0_W2BEGb[1]
+ Tile_X0Y0_W2BEGb[2] Tile_X0Y0_W2BEGb[3] Tile_X0Y0_W2BEGb[4] Tile_X0Y0_W2BEGb[5]
+ Tile_X0Y0_W2BEGb[6] Tile_X0Y0_W2BEGb[7] Tile_X0Y0_W6BEG[0] Tile_X0Y0_W6BEG[10] Tile_X0Y0_W6BEG[11]
+ Tile_X0Y0_W6BEG[1] Tile_X0Y0_W6BEG[2] Tile_X0Y0_W6BEG[3] Tile_X0Y0_W6BEG[4] Tile_X0Y0_W6BEG[5]
+ Tile_X0Y0_W6BEG[6] Tile_X0Y0_W6BEG[7] Tile_X0Y0_W6BEG[8] Tile_X0Y0_W6BEG[9] Tile_X0Y0_WW4BEG[0]
+ Tile_X0Y0_WW4BEG[10] Tile_X0Y0_WW4BEG[11] Tile_X0Y0_WW4BEG[12] Tile_X0Y0_WW4BEG[13]
+ Tile_X0Y0_WW4BEG[14] Tile_X0Y0_WW4BEG[15] Tile_X0Y0_WW4BEG[1] Tile_X0Y0_WW4BEG[2]
+ Tile_X0Y0_WW4BEG[3] Tile_X0Y0_WW4BEG[4] Tile_X0Y0_WW4BEG[5] Tile_X0Y0_WW4BEG[6]
+ Tile_X0Y0_WW4BEG[7] Tile_X0Y0_WW4BEG[8] Tile_X0Y0_WW4BEG[9] Tile_X0Y1_E1END[0] Tile_X0Y1_E1END[1]
+ Tile_X0Y1_E1END[2] Tile_X0Y1_E1END[3] Tile_X0Y1_E2END[0] Tile_X0Y1_E2END[1] Tile_X0Y1_E2END[2]
+ Tile_X0Y1_E2END[3] Tile_X0Y1_E2END[4] Tile_X0Y1_E2END[5] Tile_X0Y1_E2END[6] Tile_X0Y1_E2END[7]
+ Tile_X0Y1_E2MID[0] Tile_X0Y1_E2MID[1] Tile_X0Y1_E2MID[2] Tile_X0Y1_E2MID[3] Tile_X0Y1_E2MID[4]
+ Tile_X0Y1_E2MID[5] Tile_X0Y1_E2MID[6] Tile_X0Y1_E2MID[7] Tile_X0Y1_E6END[0] Tile_X0Y1_E6END[10]
+ Tile_X0Y1_E6END[11] Tile_X0Y1_E6END[1] Tile_X0Y1_E6END[2] Tile_X0Y1_E6END[3] Tile_X0Y1_E6END[4]
+ Tile_X0Y1_E6END[5] Tile_X0Y1_E6END[6] Tile_X0Y1_E6END[7] Tile_X0Y1_E6END[8] Tile_X0Y1_E6END[9]
+ Tile_X0Y1_EE4END[0] Tile_X0Y1_EE4END[10] Tile_X0Y1_EE4END[11] Tile_X0Y1_EE4END[12]
+ Tile_X0Y1_EE4END[13] Tile_X0Y1_EE4END[14] Tile_X0Y1_EE4END[15] Tile_X0Y1_EE4END[1]
+ Tile_X0Y1_EE4END[2] Tile_X0Y1_EE4END[3] Tile_X0Y1_EE4END[4] Tile_X0Y1_EE4END[5]
+ Tile_X0Y1_EE4END[6] Tile_X0Y1_EE4END[7] Tile_X0Y1_EE4END[8] Tile_X0Y1_EE4END[9]
+ Tile_X0Y1_FrameData[0] Tile_X0Y1_FrameData[10] Tile_X0Y1_FrameData[11] Tile_X0Y1_FrameData[12]
+ Tile_X0Y1_FrameData[13] Tile_X0Y1_FrameData[14] Tile_X0Y1_FrameData[15] Tile_X0Y1_FrameData[16]
+ Tile_X0Y1_FrameData[17] Tile_X0Y1_FrameData[18] Tile_X0Y1_FrameData[19] Tile_X0Y1_FrameData[1]
+ Tile_X0Y1_FrameData[20] Tile_X0Y1_FrameData[21] Tile_X0Y1_FrameData[22] Tile_X0Y1_FrameData[23]
+ Tile_X0Y1_FrameData[24] Tile_X0Y1_FrameData[25] Tile_X0Y1_FrameData[26] Tile_X0Y1_FrameData[27]
+ Tile_X0Y1_FrameData[28] Tile_X0Y1_FrameData[29] Tile_X0Y1_FrameData[2] Tile_X0Y1_FrameData[30]
+ Tile_X0Y1_FrameData[31] Tile_X0Y1_FrameData[3] Tile_X0Y1_FrameData[4] Tile_X0Y1_FrameData[5]
+ Tile_X0Y1_FrameData[6] Tile_X0Y1_FrameData[7] Tile_X0Y1_FrameData[8] Tile_X0Y1_FrameData[9]
+ Tile_X0Y1_FrameData_O[0] Tile_X0Y1_FrameData_O[10] Tile_X0Y1_FrameData_O[11] Tile_X0Y1_FrameData_O[12]
+ Tile_X0Y1_FrameData_O[13] Tile_X0Y1_FrameData_O[14] Tile_X0Y1_FrameData_O[15] Tile_X0Y1_FrameData_O[16]
+ Tile_X0Y1_FrameData_O[17] Tile_X0Y1_FrameData_O[18] Tile_X0Y1_FrameData_O[19] Tile_X0Y1_FrameData_O[1]
+ Tile_X0Y1_FrameData_O[20] Tile_X0Y1_FrameData_O[21] Tile_X0Y1_FrameData_O[22] Tile_X0Y1_FrameData_O[23]
+ Tile_X0Y1_FrameData_O[24] Tile_X0Y1_FrameData_O[25] Tile_X0Y1_FrameData_O[26] Tile_X0Y1_FrameData_O[27]
+ Tile_X0Y1_FrameData_O[28] Tile_X0Y1_FrameData_O[29] Tile_X0Y1_FrameData_O[2] Tile_X0Y1_FrameData_O[30]
+ Tile_X0Y1_FrameData_O[31] Tile_X0Y1_FrameData_O[3] Tile_X0Y1_FrameData_O[4] Tile_X0Y1_FrameData_O[5]
+ Tile_X0Y1_FrameData_O[6] Tile_X0Y1_FrameData_O[7] Tile_X0Y1_FrameData_O[8] Tile_X0Y1_FrameData_O[9]
+ Tile_X0Y1_FrameStrobe[0] Tile_X0Y1_FrameStrobe[10] Tile_X0Y1_FrameStrobe[11] Tile_X0Y1_FrameStrobe[12]
+ Tile_X0Y1_FrameStrobe[13] Tile_X0Y1_FrameStrobe[14] Tile_X0Y1_FrameStrobe[15] Tile_X0Y1_FrameStrobe[16]
+ Tile_X0Y1_FrameStrobe[17] Tile_X0Y1_FrameStrobe[18] Tile_X0Y1_FrameStrobe[19] Tile_X0Y1_FrameStrobe[1]
+ Tile_X0Y1_FrameStrobe[2] Tile_X0Y1_FrameStrobe[3] Tile_X0Y1_FrameStrobe[4] Tile_X0Y1_FrameStrobe[5]
+ Tile_X0Y1_FrameStrobe[6] Tile_X0Y1_FrameStrobe[7] Tile_X0Y1_FrameStrobe[8] Tile_X0Y1_FrameStrobe[9]
+ Tile_X0Y1_N1END[0] Tile_X0Y1_N1END[1] Tile_X0Y1_N1END[2] Tile_X0Y1_N1END[3] Tile_X0Y1_N2END[0]
+ Tile_X0Y1_N2END[1] Tile_X0Y1_N2END[2] Tile_X0Y1_N2END[3] Tile_X0Y1_N2END[4] Tile_X0Y1_N2END[5]
+ Tile_X0Y1_N2END[6] Tile_X0Y1_N2END[7] Tile_X0Y1_N2MID[0] Tile_X0Y1_N2MID[1] Tile_X0Y1_N2MID[2]
+ Tile_X0Y1_N2MID[3] Tile_X0Y1_N2MID[4] Tile_X0Y1_N2MID[5] Tile_X0Y1_N2MID[6] Tile_X0Y1_N2MID[7]
+ Tile_X0Y1_N4END[0] Tile_X0Y1_N4END[10] Tile_X0Y1_N4END[11] Tile_X0Y1_N4END[12] Tile_X0Y1_N4END[13]
+ Tile_X0Y1_N4END[14] Tile_X0Y1_N4END[15] Tile_X0Y1_N4END[1] Tile_X0Y1_N4END[2] Tile_X0Y1_N4END[3]
+ Tile_X0Y1_N4END[4] Tile_X0Y1_N4END[5] Tile_X0Y1_N4END[6] Tile_X0Y1_N4END[7] Tile_X0Y1_N4END[8]
+ Tile_X0Y1_N4END[9] Tile_X0Y1_S1BEG[0] Tile_X0Y1_S1BEG[1] Tile_X0Y1_S1BEG[2] Tile_X0Y1_S1BEG[3]
+ Tile_X0Y1_S2BEG[0] Tile_X0Y1_S2BEG[1] Tile_X0Y1_S2BEG[2] Tile_X0Y1_S2BEG[3] Tile_X0Y1_S2BEG[4]
+ Tile_X0Y1_S2BEG[5] Tile_X0Y1_S2BEG[6] Tile_X0Y1_S2BEG[7] Tile_X0Y1_S2BEGb[0] Tile_X0Y1_S2BEGb[1]
+ Tile_X0Y1_S2BEGb[2] Tile_X0Y1_S2BEGb[3] Tile_X0Y1_S2BEGb[4] Tile_X0Y1_S2BEGb[5]
+ Tile_X0Y1_S2BEGb[6] Tile_X0Y1_S2BEGb[7] Tile_X0Y1_S4BEG[0] Tile_X0Y1_S4BEG[10] Tile_X0Y1_S4BEG[11]
+ Tile_X0Y1_S4BEG[12] Tile_X0Y1_S4BEG[13] Tile_X0Y1_S4BEG[14] Tile_X0Y1_S4BEG[15]
+ Tile_X0Y1_S4BEG[1] Tile_X0Y1_S4BEG[2] Tile_X0Y1_S4BEG[3] Tile_X0Y1_S4BEG[4] Tile_X0Y1_S4BEG[5]
+ Tile_X0Y1_S4BEG[6] Tile_X0Y1_S4BEG[7] Tile_X0Y1_S4BEG[8] Tile_X0Y1_S4BEG[9] Tile_X0Y1_UserCLK
+ Tile_X0Y1_UserCLKo Tile_X0Y1_W1BEG[0] Tile_X0Y1_W1BEG[1] Tile_X0Y1_W1BEG[2] Tile_X0Y1_W1BEG[3]
+ Tile_X0Y1_W2BEG[0] Tile_X0Y1_W2BEG[1] Tile_X0Y1_W2BEG[2] Tile_X0Y1_W2BEG[3] Tile_X0Y1_W2BEG[4]
+ Tile_X0Y1_W2BEG[5] Tile_X0Y1_W2BEG[6] Tile_X0Y1_W2BEG[7] Tile_X0Y1_W2BEGb[0] Tile_X0Y1_W2BEGb[1]
+ Tile_X0Y1_W2BEGb[2] Tile_X0Y1_W2BEGb[3] Tile_X0Y1_W2BEGb[4] Tile_X0Y1_W2BEGb[5]
+ Tile_X0Y1_W2BEGb[6] Tile_X0Y1_W2BEGb[7] Tile_X0Y1_W6BEG[0] Tile_X0Y1_W6BEG[10] Tile_X0Y1_W6BEG[11]
+ Tile_X0Y1_W6BEG[1] Tile_X0Y1_W6BEG[2] Tile_X0Y1_W6BEG[3] Tile_X0Y1_W6BEG[4] Tile_X0Y1_W6BEG[5]
+ Tile_X0Y1_W6BEG[6] Tile_X0Y1_W6BEG[7] Tile_X0Y1_W6BEG[8] Tile_X0Y1_W6BEG[9] Tile_X0Y1_WW4BEG[0]
+ Tile_X0Y1_WW4BEG[10] Tile_X0Y1_WW4BEG[11] Tile_X0Y1_WW4BEG[12] Tile_X0Y1_WW4BEG[13]
+ Tile_X0Y1_WW4BEG[14] Tile_X0Y1_WW4BEG[15] Tile_X0Y1_WW4BEG[1] Tile_X0Y1_WW4BEG[2]
+ Tile_X0Y1_WW4BEG[3] Tile_X0Y1_WW4BEG[4] Tile_X0Y1_WW4BEG[5] Tile_X0Y1_WW4BEG[6]
+ Tile_X0Y1_WW4BEG[7] Tile_X0Y1_WW4BEG[8] Tile_X0Y1_WW4BEG[9] VGND VPWR
XANTENNA__1151__A0 Tile_X0Y1_EE4END[8] VPWR VGND sg13cmos5l_antennanp
X_0367_ _0367_/Q Tile_X0Y1_FrameData[11] VGND VPWR Tile_X0Y1_FrameStrobe[0] latch
X_0298_ _0298_/Q Tile_X0Y0_FrameData[18] VGND VPWR Tile_X0Y1_FrameStrobe[6] latch
XANTENNA__1206__A1 Tile_X0Y1_N4END[3] VPWR VGND sg13cmos5l_antennanp
XFILLER_52_29 VPWR VGND sg13cmos5l_decap_4
XANTENNA__0125__D Tile_X0Y0_FrameData[31] VPWR VGND sg13cmos5l_antennanp
XFILLER_117_33 VPWR VGND sg13cmos5l_fill_2
XFILLER_26_63 VPWR VGND sg13cmos5l_decap_4
XFILLER_93_69 VPWR VGND sg13cmos5l_fill_2
XANTENNA__0180__GATE Tile_X0Y1_FrameStrobe[2] VPWR VGND sg13cmos5l_antennanp
XANTENNA__0195__GATE Tile_X0Y1_FrameStrobe[3] VPWR VGND sg13cmos5l_antennanp
XANTENNA__0900__X Tile_X0Y1_S2BEGb[0] VPWR VGND sg13cmos5l_antennanp
XANTENNA__1133__A0 Tile_X0Y1_E1END[2] VPWR VGND sg13cmos5l_antennanp
XFILLER_3_78 VPWR VGND sg13cmos5l_fill_2
X_0221_ _0221_/Q Tile_X0Y0_FrameData[31] VGND VPWR Tile_X0Y1_FrameStrobe[4] latch
X_0152_ _0152_/Q Tile_X0Y0_FrameData[4] VGND VPWR Tile_X0Y1_FrameStrobe[1] latch
XFILLER_95_147 VPWR VGND sg13cmos5l_fill_2
XANTENNA__0133__GATE Tile_X0Y1_FrameStrobe[1] VPWR VGND sg13cmos5l_antennanp
X_0083_ _0916_/A _1019_/X _1020_/X _0284_/Q VPWR VGND sg13cmos5l_mux2_1
XANTENNA__0148__GATE Tile_X0Y1_FrameStrobe[1] VPWR VGND sg13cmos5l_antennanp
XANTENNA__0810__X Tile_X0Y0_FrameStrobe_O[7] VPWR VGND sg13cmos5l_antennanp
XFILLER_66_0 VPWR VGND sg13cmos5l_fill_1
X_0985_ _0985_/X Tile_X0Y1_EE4END[3] Tile_X0Y1_EE4END[11] Tile_X0Y1_E6END[3] _1206_/X
+ _0428_/Q _0427_/Q VPWR VGND sg13cmos5l_mux4_1
XANTENNA__1124__A0 Tile_X0Y1_E1END[1] VPWR VGND sg13cmos5l_antennanp
X_0419_ _0419_/Q Tile_X0Y1_FrameData[23] VGND VPWR Tile_X0Y1_FrameStrobe[2] latch
XFILLER_86_147 VPWR VGND sg13cmos5l_decap_8
XANTENNA__0621__CLK Tile_X0Y1_UserCLK VPWR VGND sg13cmos5l_antennanp
XFILLER_10_103 VPWR VGND sg13cmos5l_fill_1
XANTENNA__0720__X Tile_X0Y0_W1BEG[1] VPWR VGND sg13cmos5l_antennanp
XFILLER_88_47 VPWR VGND sg13cmos5l_fill_1
XANTENNA__1115__A0 Tile_X0Y1_E1END[3] VPWR VGND sg13cmos5l_antennanp
XFILLER_77_169 VPWR VGND sg13cmos5l_fill_1
XANTENNA__1197__A3 Tile_X0Y0_S2MID[2] VPWR VGND sg13cmos5l_antennanp
X_0770_ Tile_X0Y0_WW4BEG[3] _1050_/X VPWR VGND sg13cmos5l_buf_1
XANTENNA__0644__CLK Tile_X0Y1_UserCLK VPWR VGND sg13cmos5l_antennanp
XANTENNA__1106__A0 Tile_X0Y1_E2MID[4] VPWR VGND sg13cmos5l_antennanp
XFILLER_68_103 VPWR VGND sg13cmos5l_decap_8
X_1184_ _1184_/X _0649_/Q _1209_/X _1213_/X _1196_/X _0448_/Q _0447_/Q VPWR VGND sg13cmos5l_mux4_1
X_0204_ _0204_/Q Tile_X0Y0_FrameData[16] VGND VPWR Tile_X0Y1_FrameStrobe[3] latch
X_0135_ _0135_/Q Tile_X0Y0_FrameData[21] VGND VPWR Tile_X0Y1_FrameStrobe[1] latch
XANTENNA__0805__X Tile_X0Y0_FrameStrobe_O[2] VPWR VGND sg13cmos5l_antennanp
X_0968_ Tile_X0Y1_WW4BEG[11] _1174_/X VPWR VGND sg13cmos5l_buf_1
XANTENNA__0403__D Tile_X0Y1_FrameData[7] VPWR VGND sg13cmos5l_antennanp
X_0899_ Tile_X0Y1_S2BEG[7] _1134_/X VPWR VGND sg13cmos5l_buf_1
XFILLER_90_59 VPWR VGND sg13cmos5l_fill_2
XFILLER_90_26 VPWR VGND sg13cmos5l_decap_8
XANTENNA__0313__D Tile_X0Y0_FrameData[3] VPWR VGND sg13cmos5l_antennanp
XANTENNA__0608__GATE Tile_X0Y1_FrameStrobe[8] VPWR VGND sg13cmos5l_antennanp
XFILLER_73_161 VPWR VGND sg13cmos5l_fill_2
X_0822_ Tile_X0Y0_FrameStrobe_O[19] Tile_X0Y1_FrameStrobe[19] VPWR VGND sg13cmos5l_buf_1
XANTENNA__0223__D Tile_X0Y0_FrameData[29] VPWR VGND sg13cmos5l_antennanp
X_0753_ Tile_X0Y0_N4BEG[2] Tile_X0Y1_N4END[10] VPWR VGND sg13cmos5l_buf_1
X_0684_ _0684_/L_HI VPWR VGND sg13cmos5l_tiehi
XFILLER_29_0 VPWR VGND sg13cmos5l_fill_2
X_1098_ _1098_/X _1109_/X Tile_X0Y1_N2MID[6] Tile_X0Y0_S2MID[6] Tile_X0Y0_S2END[6]
+ _0104_/Q _0103_/Q VPWR VGND sg13cmos5l_mux4_1
X_1167_ _1167_/X _0644_/Q _0648_/Q _1214_/X _1198_/X _0482_/Q _0481_/Q VPWR VGND sg13cmos5l_mux4_1
X_0118_ _0118_/Q Tile_X0Y0_FrameData[6] VGND VPWR Tile_X0Y1_FrameStrobe[0] latch
XANTENNA__0133__D Tile_X0Y0_FrameData[23] VPWR VGND sg13cmos5l_antennanp
XANTENNA__0594__GATE Tile_X0Y1_FrameStrobe[7] VPWR VGND sg13cmos5l_antennanp
XFILLER_109_78 VPWR VGND sg13cmos5l_fill_1
XANTENNA__1097__A2 Tile_X0Y0_S2MID[5] VPWR VGND sg13cmos5l_antennanp
XFILLER_85_48 VPWR VGND sg13cmos5l_decap_4
XANTENNA__0308__D Tile_X0Y0_FrameData[8] VPWR VGND sg13cmos5l_antennanp
XANTENNA__0532__GATE Tile_X0Y1_FrameStrobe[5] VPWR VGND sg13cmos5l_antennanp
XANTENNA__0547__GATE Tile_X0Y1_FrameStrobe[6] VPWR VGND sg13cmos5l_antennanp
XANTENNA__1021__A2 Tile_X0Y0_E6END[5] VPWR VGND sg13cmos5l_antennanp
XFILLER_50_95 VPWR VGND sg13cmos5l_fill_2
XFILLER_38_106 VPWR VGND sg13cmos5l_decap_8
XANTENNA__0218__D Tile_X0Y0_FrameData[2] VPWR VGND sg13cmos5l_antennanp
XANTENNA__1088__A2 Tile_X0Y0_S1END[0] VPWR VGND sg13cmos5l_antennanp
X_1021_ _1021_/X Tile_X0Y0_E1END[1] Tile_X0Y0_EE4END[13] Tile_X0Y0_E6END[5] _1089_/X
+ _0283_/Q _0282_/Q VPWR VGND sg13cmos5l_mux4_1
X_0805_ Tile_X0Y0_FrameStrobe_O[2] Tile_X0Y1_FrameStrobe[2] VPWR VGND sg13cmos5l_buf_1
X_0736_ Tile_X0Y0_W2BEGb[5] _1044_/X VPWR VGND sg13cmos5l_buf_1
X_0667_ _0667_/L_HI VPWR VGND sg13cmos5l_tiehi
X_0598_ _0598_/Q Tile_X0Y1_FrameData[4] VGND VPWR Tile_X0Y1_FrameStrobe[7] latch
XANTENNA__1079__A2 Tile_X0Y0_S1END[3] VPWR VGND sg13cmos5l_antennanp
XFILLER_55_29 VPWR VGND sg13cmos5l_fill_2
X_1219_ _1219_/X Tile_X0Y0_E2MID[7] Tile_X0Y0_E2END[7] Tile_X0Y0_E6END[8] _1092_/X
+ _0302_/Q _0301_/Q VPWR VGND sg13cmos5l_mux4_1
XANTENNA__0128__D Tile_X0Y0_FrameData[28] VPWR VGND sg13cmos5l_antennanp
XFILLER_111_46 VPWR VGND sg13cmos5l_fill_2
XANTENNA__1003__A2 Tile_X0Y0_E6END[7] VPWR VGND sg13cmos5l_antennanp
XFILLER_106_133 VPWR VGND sg13cmos5l_fill_1
XFILLER_20_54 VPWR VGND sg13cmos5l_fill_1
XANTENNA__0471__GATE Tile_X0Y1_FrameStrobe[3] VPWR VGND sg13cmos5l_antennanp
XANTENNA__0486__GATE Tile_X0Y1_FrameStrobe[4] VPWR VGND sg13cmos5l_antennanp
XANTENNA__0903__X Tile_X0Y1_S2BEGb[3] VPWR VGND sg13cmos5l_antennanp
XFILLER_61_94 VPWR VGND sg13cmos5l_fill_1
XFILLER_6_12 VPWR VGND sg13cmos5l_fill_2
XANTENNA__0501__D Tile_X0Y1_FrameData[5] VPWR VGND sg13cmos5l_antennanp
X_0521_ _0521_/Q Tile_X0Y1_FrameData[17] VGND VPWR Tile_X0Y1_FrameStrobe[5] latch
X_0452_ _0452_/Q Tile_X0Y1_FrameData[22] VGND VPWR Tile_X0Y1_FrameStrobe[3] latch
XANTENNA__0424__GATE Tile_X0Y1_FrameStrobe[2] VPWR VGND sg13cmos5l_antennanp
X_0383_ _0383_/Q Tile_X0Y1_FrameData[27] VGND VPWR Tile_X0Y1_FrameStrobe[1] latch
XANTENNA__0439__GATE Tile_X0Y1_FrameStrobe[2] VPWR VGND sg13cmos5l_antennanp
X_1004_ _1004_/X Tile_X0Y0_E2MID[6] Tile_X0Y0_E2END[6] Tile_X0Y0_E6END[6] _1093_/X
+ _0336_/Q _0335_/Q VPWR VGND sg13cmos5l_mux4_1
XFILLER_96_0 VPWR VGND sg13cmos5l_fill_1
XANTENNA__0813__X Tile_X0Y0_FrameStrobe_O[10] VPWR VGND sg13cmos5l_antennanp
XANTENNA__0992__A1 Tile_X0Y1_EE4END[10] VPWR VGND sg13cmos5l_antennanp
XANTENNA__1233__A2 Tile_X0Y0_E6END[2] VPWR VGND sg13cmos5l_antennanp
XANTENNA__0411__D Tile_X0Y1_FrameData[31] VPWR VGND sg13cmos5l_antennanp
X_0719_ Tile_X0Y0_W1BEG[0] _1027_/X VPWR VGND sg13cmos5l_buf_1
XANTENNA__0723__X Tile_X0Y0_W2BEG[0] VPWR VGND sg13cmos5l_antennanp
XANTENNA__1224__A2 Tile_X0Y0_E2END[2] VPWR VGND sg13cmos5l_antennanp
XFILLER_31_53 VPWR VGND sg13cmos5l_fill_2
XANTENNA__0321__D Tile_X0Y0_FrameData[27] VPWR VGND sg13cmos5l_antennanp
XANTENNA__0983__A1 Tile_X0Y1_EE4END[9] VPWR VGND sg13cmos5l_antennanp
XFILLER_16_131 VPWR VGND sg13cmos5l_fill_1
XANTENNA__0974__A1 Tile_X0Y0_E2END[1] VPWR VGND sg13cmos5l_antennanp
XANTENNA__0231__D Tile_X0Y0_FrameData[21] VPWR VGND sg13cmos5l_antennanp
XANTENNA__0363__GATE Tile_X0Y1_FrameStrobe[0] VPWR VGND sg13cmos5l_antennanp
X_0504_ _0504_/Q Tile_X0Y1_FrameData[2] VGND VPWR Tile_X0Y1_FrameStrobe[4] latch
X_0435_ _0435_/Q Tile_X0Y1_FrameData[7] VGND VPWR Tile_X0Y1_FrameStrobe[2] latch
XFILLER_98_145 VPWR VGND sg13cmos5l_decap_8
XFILLER_98_123 VPWR VGND sg13cmos5l_fill_1
XANTENNA__0378__GATE Tile_X0Y1_FrameStrobe[0] VPWR VGND sg13cmos5l_antennanp
XANTENNA__0808__X Tile_X0Y0_FrameStrobe_O[5] VPWR VGND sg13cmos5l_antennanp
X_0366_ _0366_/Q Tile_X0Y1_FrameData[12] VGND VPWR Tile_X0Y1_FrameStrobe[0] latch
X_0297_ _0297_/Q Tile_X0Y0_FrameData[19] VGND VPWR Tile_X0Y1_FrameStrobe[6] latch
XANTENNA__0301__GATE Tile_X0Y1_FrameStrobe[6] VPWR VGND sg13cmos5l_antennanp
XANTENNA__0316__GATE Tile_X0Y1_FrameStrobe[6] VPWR VGND sg13cmos5l_antennanp
XANTENNA__0406__D Tile_X0Y1_FrameData[4] VPWR VGND sg13cmos5l_antennanp
XANTENNA__0141__D Tile_X0Y0_FrameData[15] VPWR VGND sg13cmos5l_antennanp
XFILLER_89_112 VPWR VGND sg13cmos5l_fill_2
XANTENNA__0718__X Tile_X0Y0_UserCLKo VPWR VGND sg13cmos5l_antennanp
XFILLER_93_26 VPWR VGND sg13cmos5l_decap_4
XFILLER_89_156 VPWR VGND sg13cmos5l_fill_2
XFILLER_77_38 VPWR VGND sg13cmos5l_decap_8
XFILLER_26_42 VPWR VGND sg13cmos5l_decap_8
XANTENNA__0316__D Tile_X0Y0_FrameData[0] VPWR VGND sg13cmos5l_antennanp
XFILLER_47_9 VPWR VGND sg13cmos5l_decap_8
XANTENNA__1133__A1 Tile_X0Y1_E2MID[1] VPWR VGND sg13cmos5l_antennanp
X_0220_ _0220_/Q Tile_X0Y0_FrameData[0] VGND VPWR Tile_X0Y1_FrameStrobe[3] latch
X_0151_ _0151_/Q Tile_X0Y0_FrameData[5] VGND VPWR Tile_X0Y1_FrameStrobe[1] latch
X_0082_ _0763_/A _1011_/X _1012_/X _0320_/Q VPWR VGND sg13cmos5l_mux2_1
XFILLER_83_70 VPWR VGND sg13cmos5l_fill_1
XANTENNA__0226__D Tile_X0Y0_FrameData[26] VPWR VGND sg13cmos5l_antennanp
XANTENNA__0804__A Tile_X0Y1_FrameStrobe[1] VPWR VGND sg13cmos5l_antennanp
X_0984_ _0984_/X Tile_X0Y1_EE4END[2] Tile_X0Y1_EE4END[10] Tile_X0Y1_E6END[2] _1205_/X
+ _0430_/Q _0429_/Q VPWR VGND sg13cmos5l_mux4_1
XFILLER_83_92 VPWR VGND sg13cmos5l_decap_8
XFILLER_59_0 VPWR VGND sg13cmos5l_fill_2
XANTENNA__1124__A1 Tile_X0Y1_E6END[9] VPWR VGND sg13cmos5l_antennanp
X_0418_ _0418_/Q Tile_X0Y1_FrameData[24] VGND VPWR Tile_X0Y1_FrameStrobe[2] latch
X_0349_ _0349_/Q Tile_X0Y1_FrameData[29] VGND VPWR Tile_X0Y1_FrameStrobe[0] latch
XFILLER_86_126 VPWR VGND sg13cmos5l_decap_8
XANTENNA__0240__GATE Tile_X0Y1_FrameStrobe[4] VPWR VGND sg13cmos5l_antennanp
XANTENNA__0136__D Tile_X0Y0_FrameData[20] VPWR VGND sg13cmos5l_antennanp
XANTENNA__0255__GATE Tile_X0Y1_FrameStrobe[5] VPWR VGND sg13cmos5l_antennanp
XFILLER_10_148 VPWR VGND sg13cmos5l_fill_2
XFILLER_10_159 VPWR VGND sg13cmos5l_fill_1
XFILLER_12_77 VPWR VGND sg13cmos5l_fill_2
XFILLER_77_126 VPWR VGND sg13cmos5l_decap_8
XANTENNA__0208__GATE Tile_X0Y1_FrameStrobe[3] VPWR VGND sg13cmos5l_antennanp
XANTENNA__1115__A1 Tile_X0Y1_EE4END[3] VPWR VGND sg13cmos5l_antennanp
XFILLER_37_52 VPWR VGND sg13cmos5l_decap_4
XANTENNA__0911__X Tile_X0Y1_S4BEG[3] VPWR VGND sg13cmos5l_antennanp
XFILLER_5_152 VPWR VGND sg13cmos5l_fill_1
XANTENNA__1106__A1 Tile_X0Y1_E2END[4] VPWR VGND sg13cmos5l_antennanp
X_0203_ _0203_/Q Tile_X0Y0_FrameData[17] VGND VPWR Tile_X0Y1_FrameStrobe[3] latch
XFILLER_78_81 VPWR VGND sg13cmos5l_fill_1
XFILLER_78_70 VPWR VGND sg13cmos5l_decap_4
X_1183_ _1183_/X _0648_/Q _1210_/X _1214_/X _1195_/X _0450_/Q _0449_/Q VPWR VGND sg13cmos5l_mux4_1
X_0134_ _0134_/Q Tile_X0Y0_FrameData[22] VGND VPWR Tile_X0Y1_FrameStrobe[1] latch
XANTENNA__0821__X Tile_X0Y0_FrameStrobe_O[18] VPWR VGND sg13cmos5l_antennanp
XANTENNA__1042__A0 Tile_X0Y0_EE4END[10] VPWR VGND sg13cmos5l_antennanp
X_0967_ Tile_X0Y1_WW4BEG[10] _1173_/X VPWR VGND sg13cmos5l_buf_1
X_0898_ Tile_X0Y1_S2BEG[6] _1133_/X VPWR VGND sg13cmos5l_buf_1
XANTENNA__0194__GATE Tile_X0Y1_FrameStrobe[3] VPWR VGND sg13cmos5l_antennanp
XFILLER_23_43 VPWR VGND sg13cmos5l_fill_2
XANTENNA__0731__X Tile_X0Y0_W2BEGb[0] VPWR VGND sg13cmos5l_antennanp
XANTENNA__1033__A0 Tile_X0Y0_EE4END[6] VPWR VGND sg13cmos5l_antennanp
XANTENNA__0132__GATE Tile_X0Y1_FrameStrobe[1] VPWR VGND sg13cmos5l_antennanp
XFILLER_48_84 VPWR VGND sg13cmos5l_decap_8
XANTENNA__0147__GATE Tile_X0Y1_FrameStrobe[1] VPWR VGND sg13cmos5l_antennanp
XANTENNA__0906__X Tile_X0Y1_S2BEGb[6] VPWR VGND sg13cmos5l_antennanp
XFILLER_0_14 VPWR VGND sg13cmos5l_fill_1
XANTENNA__0504__D Tile_X0Y1_FrameData[2] VPWR VGND sg13cmos5l_antennanp
XANTENNA__0611__CLK Tile_X0Y1_UserCLK VPWR VGND sg13cmos5l_antennanp
X_0821_ Tile_X0Y0_FrameStrobe_O[18] Tile_X0Y1_FrameStrobe[18] VPWR VGND sg13cmos5l_buf_1
X_0752_ Tile_X0Y0_N4BEG[1] Tile_X0Y1_N4END[9] VPWR VGND sg13cmos5l_buf_1
XFILLER_80_82 VPWR VGND sg13cmos5l_decap_4
XFILLER_50_4 VPWR VGND sg13cmos5l_fill_1
X_0683_ _0683_/L_HI VPWR VGND sg13cmos5l_tiehi
X_1235_ _1235_/X Tile_X0Y0_E1END[1] Tile_X0Y0_E6END[1] _1101_/X _1235_/A3 _0152_/Q
+ _0151_/Q VPWR VGND sg13cmos5l_mux4_1
X_1166_ _1166_/X _0647_/Q _0651_/Q _1215_/X _1199_/X _0484_/Q _0483_/Q VPWR VGND sg13cmos5l_mux4_1
XANTENNA__0816__X Tile_X0Y0_FrameStrobe_O[13] VPWR VGND sg13cmos5l_antennanp
XFILLER_60_19 VPWR VGND sg13cmos5l_decap_8
X_1097_ _1097_/X _1108_/X Tile_X0Y1_N2MID[5] Tile_X0Y0_S2MID[5] Tile_X0Y0_S2END[5]
+ _0106_/Q _0105_/Q VPWR VGND sg13cmos5l_mux4_1
X_0117_ _0117_/Q Tile_X0Y0_FrameData[7] VGND VPWR Tile_X0Y1_FrameStrobe[0] latch
XANTENNA__0414__D Tile_X0Y1_FrameData[28] VPWR VGND sg13cmos5l_antennanp
XANTENNA__1015__A0 Tile_X0Y0_E1END[2] VPWR VGND sg13cmos5l_antennanp
XFILLER_69_28 VPWR VGND sg13cmos5l_fill_2
XFILLER_47_107 VPWR VGND sg13cmos5l_decap_4
XANTENNA__0726__X Tile_X0Y0_W2BEG[3] VPWR VGND sg13cmos5l_antennanp
XANTENNA__1097__A3 Tile_X0Y0_S2END[5] VPWR VGND sg13cmos5l_antennanp
XFILLER_70_121 VPWR VGND sg13cmos5l_fill_2
XANTENNA__0324__D Tile_X0Y0_FrameData[24] VPWR VGND sg13cmos5l_antennanp
XANTENNA__0634__CLK Tile_X0Y1_UserCLK VPWR VGND sg13cmos5l_antennanp
XANTENNA__1006__A0 Tile_X0Y0_E2MID[4] VPWR VGND sg13cmos5l_antennanp
XANTENNA__1088__A3 Tile_X0Y0_S4END[0] VPWR VGND sg13cmos5l_antennanp
X_1020_ _1020_/X _1087_/X _1083_/X _1075_/X _1096_/X _0286_/Q _0285_/Q VPWR VGND sg13cmos5l_mux4_1
XFILLER_91_70 VPWR VGND sg13cmos5l_fill_2
XANTENNA__0234__D Tile_X0Y0_FrameData[18] VPWR VGND sg13cmos5l_antennanp
XANTENNA__0812__A Tile_X0Y1_FrameStrobe[9] VPWR VGND sg13cmos5l_antennanp
X_0804_ Tile_X0Y0_FrameStrobe_O[1] Tile_X0Y1_FrameStrobe[1] VPWR VGND sg13cmos5l_buf_1
X_0735_ Tile_X0Y0_W2BEGb[4] _1043_/X VPWR VGND sg13cmos5l_buf_1
XFILLER_115_178 VPWR VGND sg13cmos5l_fill_2
XFILLER_41_0 VPWR VGND sg13cmos5l_fill_2
X_0666_ _0666_/L_HI VPWR VGND sg13cmos5l_tiehi
X_0597_ _0597_/Q Tile_X0Y1_FrameData[5] VGND VPWR Tile_X0Y1_FrameStrobe[7] latch
XANTENNA__0409__D Tile_X0Y1_FrameData[1] VPWR VGND sg13cmos5l_antennanp
XANTENNA__0607__GATE Tile_X0Y1_FrameStrobe[8] VPWR VGND sg13cmos5l_antennanp
XANTENNA__1079__A3 Tile_X0Y0_S4END[3] VPWR VGND sg13cmos5l_antennanp
X_1218_ _1218_/X Tile_X0Y1_N1END[3] Tile_X0Y1_N4END[3] _1230_/X Tile_X0Y0_S4END[7]
+ _0372_/Q _0371_/Q VPWR VGND sg13cmos5l_mux4_1
X_1149_ _1149_/X Tile_X0Y1_E2END[2] _0646_/Q _1197_/X _1200_/X _0518_/Q _0517_/Q VPWR
+ VGND sg13cmos5l_mux4_1
XANTENNA__0144__D Tile_X0Y0_FrameData[12] VPWR VGND sg13cmos5l_antennanp
XFILLER_20_11 VPWR VGND sg13cmos5l_fill_1
XFILLER_20_66 VPWR VGND sg13cmos5l_decap_8
XFILLER_20_99 VPWR VGND sg13cmos5l_fill_2
XFILLER_29_42 VPWR VGND sg13cmos5l_fill_1
XANTENNA__0319__D Tile_X0Y0_FrameData[29] VPWR VGND sg13cmos5l_antennanp
XANTENNA__1227__A0 Tile_X0Y0_E1END[0] VPWR VGND sg13cmos5l_antennanp
XFILLER_61_73 VPWR VGND sg13cmos5l_decap_4
XFILLER_77_9 VPWR VGND sg13cmos5l_fill_1
XFILLER_112_126 VPWR VGND sg13cmos5l_fill_2
X_0520_ _0520_/Q Tile_X0Y1_FrameData[18] VGND VPWR Tile_X0Y1_FrameStrobe[5] latch
X_0451_ _0451_/Q Tile_X0Y1_FrameData[23] VGND VPWR Tile_X0Y1_FrameStrobe[3] latch
X_0382_ _0382_/Q Tile_X0Y1_FrameData[28] VGND VPWR Tile_X0Y1_FrameStrobe[1] latch
XANTENNA__0229__D Tile_X0Y0_FrameData[23] VPWR VGND sg13cmos5l_antennanp
XANTENNA__0807__A Tile_X0Y1_FrameStrobe[4] VPWR VGND sg13cmos5l_antennanp
XFILLER_19_162 VPWR VGND sg13cmos5l_decap_4
X_1003_ _1003_/X Tile_X0Y0_E2MID[7] Tile_X0Y0_E2END[7] Tile_X0Y0_E6END[7] _1092_/X
+ _0338_/Q _0337_/Q VPWR VGND sg13cmos5l_mux4_1
XANTENNA__0593__GATE Tile_X0Y1_FrameStrobe[7] VPWR VGND sg13cmos5l_antennanp
XANTENNA__1218__A0 Tile_X0Y1_N1END[3] VPWR VGND sg13cmos5l_antennanp
XFILLER_89_0 VPWR VGND sg13cmos5l_fill_2
XANTENNA__0992__A2 Tile_X0Y1_E6END[10] VPWR VGND sg13cmos5l_antennanp
X_0718_ Tile_X0Y0_UserCLKo Tile_X0Y0_UserCLK VPWR VGND sg13cmos5l_buf_1
XANTENNA__0531__GATE Tile_X0Y1_FrameStrobe[5] VPWR VGND sg13cmos5l_antennanp
X_0649_ _0649_/Q Tile_X0Y1_UserCLK NPU_ACT_RDATA5 _0657_/L_HI VPWR VGND sg13cmos5l_dfrbpq_1
XANTENNA__0139__D Tile_X0Y0_FrameData[17] VPWR VGND sg13cmos5l_antennanp
XANTENNA__0546__GATE Tile_X0Y1_FrameStrobe[6] VPWR VGND sg13cmos5l_antennanp
XANTENNA__1209__A0 Tile_X0Y1_N1END[2] VPWR VGND sg13cmos5l_antennanp
XANTENNA__0983__A2 Tile_X0Y1_E6END[1] VPWR VGND sg13cmos5l_antennanp
XFILLER_15_77 VPWR VGND sg13cmos5l_fill_2
XANTENNA__0602__D Tile_X0Y1_FrameData[0] VPWR VGND sg13cmos5l_antennanp
XFILLER_103_2 VPWR VGND sg13cmos5l_fill_1
XANTENNA__0914__X Tile_X0Y1_S4BEG[6] VPWR VGND sg13cmos5l_antennanp
XANTENNA__1215__A3 Tile_X0Y0_S4END[4] VPWR VGND sg13cmos5l_antennanp
XFILLER_31_179 VPWR VGND sg13cmos5l_fill_1
XANTENNA__0512__D Tile_X0Y1_FrameData[26] VPWR VGND sg13cmos5l_antennanp
XFILLER_100_107 VPWR VGND sg13cmos5l_decap_4
X_0503_ _0503_/Q Tile_X0Y1_FrameData[3] VGND VPWR Tile_X0Y1_FrameStrobe[4] latch
X_0434_ _0434_/Q Tile_X0Y1_FrameData[8] VGND VPWR Tile_X0Y1_FrameStrobe[2] latch
X_0365_ _0365_/Q Tile_X0Y1_FrameData[13] VGND VPWR Tile_X0Y1_FrameStrobe[0] latch
XANTENNA__0824__X Tile_X0Y1_FrameData_O[0] VPWR VGND sg13cmos5l_antennanp
X_0296_ _0296_/Q Tile_X0Y0_FrameData[20] VGND VPWR Tile_X0Y1_FrameStrobe[6] latch
XANTENNA__1206__A3 Tile_X0Y0_S4END[7] VPWR VGND sg13cmos5l_antennanp
XANTENNA__0422__D Tile_X0Y1_FrameData[20] VPWR VGND sg13cmos5l_antennanp
XANTENNA__0470__GATE Tile_X0Y1_FrameStrobe[3] VPWR VGND sg13cmos5l_antennanp
XANTENNA__0485__GATE Tile_X0Y1_FrameStrobe[4] VPWR VGND sg13cmos5l_antennanp
XANTENNA__0734__X Tile_X0Y0_W2BEGb[3] VPWR VGND sg13cmos5l_antennanp
XFILLER_13_146 VPWR VGND sg13cmos5l_decap_8
XANTENNA__0332__D Tile_X0Y0_FrameData[16] VPWR VGND sg13cmos5l_antennanp
XANTENNA__0423__GATE Tile_X0Y1_FrameStrobe[2] VPWR VGND sg13cmos5l_antennanp
XANTENNA__0438__GATE Tile_X0Y1_FrameStrobe[2] VPWR VGND sg13cmos5l_antennanp
XANTENNA__0910__A Tile_X0Y0_S4END[10] VPWR VGND sg13cmos5l_antennanp
XANTENNA__0909__X Tile_X0Y1_S4BEG[1] VPWR VGND sg13cmos5l_antennanp
XANTENNA__1133__A2 Tile_X0Y1_E2END[1] VPWR VGND sg13cmos5l_antennanp
XFILLER_67_50 VPWR VGND sg13cmos5l_decap_4
XANTENNA__0507__D Tile_X0Y1_FrameData[31] VPWR VGND sg13cmos5l_antennanp
X_0150_ _0150_/Q Tile_X0Y0_FrameData[6] VGND VPWR Tile_X0Y1_FrameStrobe[1] latch
X_0081_ _0764_/A _1013_/X _1014_/X _0317_/Q VPWR VGND sg13cmos5l_mux2_1
XFILLER_83_60 VPWR VGND sg13cmos5l_fill_1
X_0983_ _0983_/X Tile_X0Y1_EE4END[1] Tile_X0Y1_EE4END[9] Tile_X0Y1_E6END[1] _1204_/X
+ _0432_/Q _0431_/Q VPWR VGND sg13cmos5l_mux4_1
XANTENNA__0242__D Tile_X0Y0_FrameData[10] VPWR VGND sg13cmos5l_antennanp
XANTENNA__0820__A Tile_X0Y1_FrameStrobe[17] VPWR VGND sg13cmos5l_antennanp
XANTENNA__0819__X Tile_X0Y0_FrameStrobe_O[16] VPWR VGND sg13cmos5l_antennanp
XFILLER_103_15 VPWR VGND sg13cmos5l_fill_2
X_0417_ _0417_/Q Tile_X0Y1_FrameData[25] VGND VPWR Tile_X0Y1_FrameStrobe[2] latch
X_0348_ _0348_/Q Tile_X0Y1_FrameData[30] VGND VPWR Tile_X0Y1_FrameStrobe[0] latch
XANTENNA__0417__D Tile_X0Y1_FrameData[25] VPWR VGND sg13cmos5l_antennanp
X_0279_ _0279_/Q Tile_X0Y0_FrameData[5] VGND VPWR Tile_X0Y1_FrameStrobe[5] latch
XANTENNA__0152__D Tile_X0Y0_FrameData[4] VPWR VGND sg13cmos5l_antennanp
XFILLER_12_45 VPWR VGND sg13cmos5l_decap_8
XANTENNA__0729__X Tile_X0Y0_W2BEG[6] VPWR VGND sg13cmos5l_antennanp
XFILLER_88_38 VPWR VGND sg13cmos5l_decap_4
XFILLER_77_149 VPWR VGND sg13cmos5l_fill_1
XFILLER_77_138 VPWR VGND sg13cmos5l_fill_1
XANTENNA__1115__A2 Tile_X0Y1_E6END[11] VPWR VGND sg13cmos5l_antennanp
XFILLER_92_108 VPWR VGND sg13cmos5l_decap_8
XANTENNA__0327__D Tile_X0Y0_FrameData[21] VPWR VGND sg13cmos5l_antennanp
XANTENNA__0362__GATE Tile_X0Y1_FrameStrobe[0] VPWR VGND sg13cmos5l_antennanp
XANTENNA__0300__GATE Tile_X0Y1_FrameStrobe[6] VPWR VGND sg13cmos5l_antennanp
XANTENNA__0377__GATE Tile_X0Y1_FrameStrobe[0] VPWR VGND sg13cmos5l_antennanp
XANTENNA__0315__GATE Tile_X0Y1_FrameStrobe[6] VPWR VGND sg13cmos5l_antennanp
XANTENNA__1106__A2 Tile_X0Y1_E6END[4] VPWR VGND sg13cmos5l_antennanp
X_1182_ _1182_/X Tile_X0Y1_N4END[3] Tile_X0Y0_S4END[7] _1211_/X _1215_/X _0452_/Q
+ _0451_/Q VPWR VGND sg13cmos5l_mux4_1
X_0202_ _0202_/Q Tile_X0Y0_FrameData[18] VGND VPWR Tile_X0Y1_FrameStrobe[3] latch
X_0133_ _0133_/Q Tile_X0Y0_FrameData[23] VGND VPWR Tile_X0Y1_FrameStrobe[1] latch
XANTENNA__0237__D Tile_X0Y0_FrameData[15] VPWR VGND sg13cmos5l_antennanp
XANTENNA__0815__A Tile_X0Y1_FrameStrobe[12] VPWR VGND sg13cmos5l_antennanp
XFILLER_91_152 VPWR VGND sg13cmos5l_fill_2
X_0897_ Tile_X0Y1_S2BEG[5] _1132_/X VPWR VGND sg13cmos5l_buf_1
X_0966_ Tile_X0Y1_WW4BEG[9] _1172_/X VPWR VGND sg13cmos5l_buf_1
XFILLER_82_141 VPWR VGND sg13cmos5l_decap_8
XANTENNA__0147__D Tile_X0Y0_FrameData[9] VPWR VGND sg13cmos5l_antennanp
XFILLER_65_108 VPWR VGND sg13cmos5l_fill_1
XANTENNA__0093__CLK Tile_X0Y1_UserCLK VPWR VGND sg13cmos5l_antennanp
XANTENNA__0922__X Tile_X0Y1_S4BEG[14] VPWR VGND sg13cmos5l_antennanp
X_0820_ Tile_X0Y0_FrameStrobe_O[17] Tile_X0Y1_FrameStrobe[17] VPWR VGND sg13cmos5l_buf_1
X_0751_ Tile_X0Y0_N4BEG[0] Tile_X0Y1_N4END[8] VPWR VGND sg13cmos5l_buf_1
XFILLER_9_57 VPWR VGND sg13cmos5l_decap_8
XANTENNA__0520__D Tile_X0Y1_FrameData[18] VPWR VGND sg13cmos5l_antennanp
XFILLER_29_2 VPWR VGND sg13cmos5l_fill_1
X_0682_ _0682_/L_HI VPWR VGND sg13cmos5l_tiehi
XANTENNA__0254__GATE Tile_X0Y1_FrameStrobe[5] VPWR VGND sg13cmos5l_antennanp
X_1096_ _1096_/X _1107_/X Tile_X0Y1_N2MID[4] Tile_X0Y0_S2MID[4] Tile_X0Y0_S2END[4]
+ _0108_/Q _0107_/Q VPWR VGND sg13cmos5l_mux4_1
X_1234_ _1234_/X Tile_X0Y0_E1END[2] Tile_X0Y0_E6END[2] _1102_/X _1234_/A3 _0150_/Q
+ _0149_/Q VPWR VGND sg13cmos5l_mux4_1
X_1165_ _1165_/X _0646_/Q _0650_/Q _1216_/X _1200_/X _0486_/Q _0485_/Q VPWR VGND sg13cmos5l_mux4_1
X_0116_ _0116_/Q Tile_X0Y0_FrameData[8] VGND VPWR Tile_X0Y1_FrameStrobe[0] latch
XANTENNA__0269__GATE Tile_X0Y1_FrameStrobe[5] VPWR VGND sg13cmos5l_antennanp
XANTENNA__0832__X Tile_X0Y1_FrameData_O[8] VPWR VGND sg13cmos5l_antennanp
XANTENNA__0207__GATE Tile_X0Y1_FrameStrobe[3] VPWR VGND sg13cmos5l_antennanp
XANTENNA__0430__D Tile_X0Y1_FrameData[12] VPWR VGND sg13cmos5l_antennanp
XANTENNA__1015__A1 Tile_X0Y0_EE4END[2] VPWR VGND sg13cmos5l_antennanp
XFILLER_109_69 VPWR VGND sg13cmos5l_fill_2
X_0949_ Tile_X0Y1_W6BEG[4] _1183_/X VPWR VGND sg13cmos5l_buf_1
XFILLER_55_163 VPWR VGND sg13cmos5l_fill_1
XANTENNA__0605__D Tile_X0Y1_FrameData[27] VPWR VGND sg13cmos5l_antennanp
XANTENNA__0742__X Tile_X0Y0_W6BEG[3] VPWR VGND sg13cmos5l_antennanp
XANTENNA__1006__A1 Tile_X0Y0_E2END[4] VPWR VGND sg13cmos5l_antennanp
XANTENNA__0340__D Tile_X0Y0_FrameData[8] VPWR VGND sg13cmos5l_antennanp
XFILLER_59_40 VPWR VGND sg13cmos5l_fill_1
XANTENNA__0917__X Tile_X0Y1_S4BEG[9] VPWR VGND sg13cmos5l_antennanp
XFILLER_75_72 VPWR VGND sg13cmos5l_decap_4
XANTENNA__0515__D Tile_X0Y1_FrameData[23] VPWR VGND sg13cmos5l_antennanp
XFILLER_61_111 VPWR VGND sg13cmos5l_fill_1
XFILLER_115_102 VPWR VGND sg13cmos5l_fill_1
X_0803_ Tile_X0Y0_FrameStrobe_O[0] Tile_X0Y1_FrameStrobe[0] VPWR VGND sg13cmos5l_buf_1
X_0734_ Tile_X0Y0_W2BEGb[3] _1042_/X VPWR VGND sg13cmos5l_buf_1
X_0665_ _0665_/L_HI VPWR VGND sg13cmos5l_tiehi
XANTENNA__0193__GATE Tile_X0Y1_FrameStrobe[3] VPWR VGND sg13cmos5l_antennanp
XANTENNA__0250__D Tile_X0Y0_FrameData[2] VPWR VGND sg13cmos5l_antennanp
XANTENNA__1181__A0 Tile_X0Y1_N4END[2] VPWR VGND sg13cmos5l_antennanp
XFILLER_34_0 VPWR VGND sg13cmos5l_fill_1
X_0596_ _0596_/Q Tile_X0Y1_FrameData[6] VGND VPWR Tile_X0Y1_FrameStrobe[7] latch
XANTENNA__0827__X Tile_X0Y1_FrameData_O[3] VPWR VGND sg13cmos5l_antennanp
XFILLER_111_26 VPWR VGND sg13cmos5l_decap_4
XFILLER_71_19 VPWR VGND sg13cmos5l_fill_1
X_1079_ _1079_/X _1114_/X Tile_X0Y1_N4END[7] Tile_X0Y0_S1END[3] Tile_X0Y0_S4END[3]
+ _0118_/Q _0117_/Q VPWR VGND sg13cmos5l_mux4_1
X_1217_ _1217_/X Tile_X0Y1_N1END[2] Tile_X0Y1_N4END[2] _1229_/X Tile_X0Y0_S4END[6]
+ _0374_/Q _0373_/Q VPWR VGND sg13cmos5l_mux4_1
X_1148_ _1148_/X Tile_X0Y1_E2MID[3] _0645_/Q _1196_/X _1201_/X _0520_/Q _0519_/Q VPWR
+ VGND sg13cmos5l_mux4_1
XANTENNA__0131__GATE Tile_X0Y1_FrameStrobe[1] VPWR VGND sg13cmos5l_antennanp
XANTENNA__0425__D Tile_X0Y1_FrameData[17] VPWR VGND sg13cmos5l_antennanp
XANTENNA__0995__A0 Tile_X0Y1_E1END[1] VPWR VGND sg13cmos5l_antennanp
XANTENNA__0146__GATE Tile_X0Y1_FrameStrobe[1] VPWR VGND sg13cmos5l_antennanp
XANTENNA__0160__D Tile_X0Y0_FrameData[28] VPWR VGND sg13cmos5l_antennanp
XANTENNA__0737__X Tile_X0Y0_W2BEGb[6] VPWR VGND sg13cmos5l_antennanp
XANTENNA__0335__D Tile_X0Y0_FrameData[13] VPWR VGND sg13cmos5l_antennanp
XANTENNA__0913__A Tile_X0Y0_S4END[13] VPWR VGND sg13cmos5l_antennanp
XANTENNA__1227__A1 Tile_X0Y0_E6END[8] VPWR VGND sg13cmos5l_antennanp
XANTENNA__0986__A0 Tile_X0Y1_EE4END[4] VPWR VGND sg13cmos5l_antennanp
X_0450_ _0450_/Q Tile_X0Y1_FrameData[24] VGND VPWR Tile_X0Y1_FrameStrobe[3] latch
X_0381_ _0381_/Q Tile_X0Y1_FrameData[29] VGND VPWR Tile_X0Y1_FrameStrobe[1] latch
X_1002_ _1002_/X Tile_X0Y0_E1END[3] Tile_X0Y0_E6END[7] _1079_/X _1078_/X _0340_/Q
+ _0339_/Q VPWR VGND sg13cmos5l_mux4_1
XANTENNA__0245__D Tile_X0Y0_FrameData[7] VPWR VGND sg13cmos5l_antennanp
XANTENNA__0823__A Tile_X0Y1_UserCLK VPWR VGND sg13cmos5l_antennanp
XANTENNA__0977__A0 Tile_X0Y0_E2MID[4] VPWR VGND sg13cmos5l_antennanp
XANTENNA__1218__A1 Tile_X0Y1_N4END[3] VPWR VGND sg13cmos5l_antennanp
X_0717_ _0974_/A3 VPWR VGND sg13cmos5l_tielo
X_0648_ _0648_/Q Tile_X0Y1_UserCLK NPU_ACT_RDATA4 _0675_/L_HI VPWR VGND sg13cmos5l_dfrbpq_1
XANTENNA__0624__CLK Tile_X0Y1_UserCLK VPWR VGND sg13cmos5l_antennanp
XFILLER_106_37 VPWR VGND sg13cmos5l_fill_1
X_0579_ _0579_/Q Tile_X0Y1_FrameData[23] VGND VPWR Tile_X0Y1_FrameStrobe[7] latch
XANTENNA__0155__D Tile_X0Y0_FrameData[1] VPWR VGND sg13cmos5l_antennanp
XANTENNA__1209__A1 Tile_X0Y1_N4END[2] VPWR VGND sg13cmos5l_antennanp
XFILLER_40_169 VPWR VGND sg13cmos5l_fill_2
XANTENNA__1145__A0 Tile_X0Y1_N1END[2] VPWR VGND sg13cmos5l_antennanp
XANTENNA__0908__A Tile_X0Y0_S4END[8] VPWR VGND sg13cmos5l_antennanp
XFILLER_31_114 VPWR VGND sg13cmos5l_fill_2
XFILLER_72_84 VPWR VGND sg13cmos5l_fill_2
XANTENNA__0606__GATE Tile_X0Y1_FrameStrobe[8] VPWR VGND sg13cmos5l_antennanp
XANTENNA__0647__CLK Tile_X0Y1_UserCLK VPWR VGND sg13cmos5l_antennanp
XANTENNA__0930__X Tile_X0Y1_W2BEG[1] VPWR VGND sg13cmos5l_antennanp
X_0502_ _0502_/Q Tile_X0Y1_FrameData[4] VGND VPWR Tile_X0Y1_FrameStrobe[4] latch
XANTENNA__0818__A Tile_X0Y1_FrameStrobe[15] VPWR VGND sg13cmos5l_antennanp
X_0433_ _0433_/Q Tile_X0Y1_FrameData[9] VGND VPWR Tile_X0Y1_FrameStrobe[2] latch
X_0364_ _0364_/Q Tile_X0Y1_FrameData[14] VGND VPWR Tile_X0Y1_FrameStrobe[0] latch
X_0295_ _0295_/Q Tile_X0Y0_FrameData[21] VGND VPWR Tile_X0Y1_FrameStrobe[6] latch
XFILLER_98_169 VPWR VGND sg13cmos5l_fill_2
XANTENNA__0840__X Tile_X0Y1_FrameData_O[16] VPWR VGND sg13cmos5l_antennanp
XANTENNA__1127__A0 Tile_X0Y1_E2MID[7] VPWR VGND sg13cmos5l_antennanp
XFILLER_89_136 VPWR VGND sg13cmos5l_fill_2
XFILLER_89_125 VPWR VGND sg13cmos5l_decap_8
XFILLER_26_99 VPWR VGND sg13cmos5l_decap_8
XANTENNA__0750__X Tile_X0Y0_W6BEG[11] VPWR VGND sg13cmos5l_antennanp
XFILLER_101_0 VPWR VGND sg13cmos5l_decap_4
XANTENNA__0592__GATE Tile_X0Y1_FrameStrobe[7] VPWR VGND sg13cmos5l_antennanp
XFILLER_95_128 VPWR VGND sg13cmos5l_fill_1
XFILLER_95_117 VPWR VGND sg13cmos5l_decap_4
XANTENNA__0925__X Tile_X0Y1_W1BEG[0] VPWR VGND sg13cmos5l_antennanp
X_0080_ _0923_/A _1141_/X _1142_/X _0531_/Q VPWR VGND sg13cmos5l_mux2_1
XANTENNA__0523__D Tile_X0Y1_FrameData[15] VPWR VGND sg13cmos5l_antennanp
XANTENNA__0530__GATE Tile_X0Y1_FrameStrobe[5] VPWR VGND sg13cmos5l_antennanp
X_0982_ _0982_/X Tile_X0Y1_EE4END[0] Tile_X0Y1_EE4END[8] Tile_X0Y1_E6END[0] _1203_/X
+ _0434_/Q _0433_/Q VPWR VGND sg13cmos5l_mux4_1
XANTENNA__0545__GATE Tile_X0Y1_FrameStrobe[6] VPWR VGND sg13cmos5l_antennanp
XANTENNA__1109__A0 Tile_X0Y1_E2MID[1] VPWR VGND sg13cmos5l_antennanp
XANTENNA__0835__X Tile_X0Y1_FrameData_O[11] VPWR VGND sg13cmos5l_antennanp
X_0416_ _0416_/Q Tile_X0Y1_FrameData[26] VGND VPWR Tile_X0Y1_FrameStrobe[2] latch
X_0347_ _0347_/Q Tile_X0Y0_FrameData[31] VGND VPWR Tile_X0Y1_FrameStrobe[0] latch
X_0278_ _0278_/Q Tile_X0Y0_FrameData[6] VGND VPWR Tile_X0Y1_FrameStrobe[5] latch
XANTENNA__0433__D Tile_X0Y1_FrameData[9] VPWR VGND sg13cmos5l_antennanp
XFILLER_77_117 VPWR VGND sg13cmos5l_fill_2
XANTENNA__0608__D Tile_X0Y1_FrameData[30] VPWR VGND sg13cmos5l_antennanp
XANTENNA__0745__X Tile_X0Y0_W6BEG[6] VPWR VGND sg13cmos5l_antennanp
XANTENNA__0343__D Tile_X0Y0_FrameData[5] VPWR VGND sg13cmos5l_antennanp
XFILLER_52_9 VPWR VGND sg13cmos5l_fill_1
XANTENNA__0518__D Tile_X0Y1_FrameData[20] VPWR VGND sg13cmos5l_antennanp
X_1181_ _1181_/X Tile_X0Y1_N4END[2] Tile_X0Y0_S4END[6] _1212_/X _1216_/X _0454_/Q
+ _0453_/Q VPWR VGND sg13cmos5l_mux4_1
X_0201_ _0201_/Q Tile_X0Y0_FrameData[19] VGND VPWR Tile_X0Y1_FrameStrobe[3] latch
X_0132_ _0132_/Q Tile_X0Y0_FrameData[24] VGND VPWR Tile_X0Y1_FrameStrobe[1] latch
XANTENNA__0253__D Tile_X0Y0_FrameData[31] VPWR VGND sg13cmos5l_antennanp
XANTENNA__0484__GATE Tile_X0Y1_FrameStrobe[4] VPWR VGND sg13cmos5l_antennanp
XANTENNA__0831__A Tile_X0Y1_FrameData[7] VPWR VGND sg13cmos5l_antennanp
X_0896_ Tile_X0Y1_S2BEG[4] _1131_/X VPWR VGND sg13cmos5l_buf_1
X_0965_ Tile_X0Y1_WW4BEG[8] _1171_/X VPWR VGND sg13cmos5l_buf_1
XANTENNA__0422__GATE Tile_X0Y1_FrameStrobe[2] VPWR VGND sg13cmos5l_antennanp
XANTENNA__0499__GATE Tile_X0Y1_FrameStrobe[4] VPWR VGND sg13cmos5l_antennanp
XFILLER_114_15 VPWR VGND sg13cmos5l_decap_8
XFILLER_4_91 VPWR VGND sg13cmos5l_decap_8
XFILLER_59_139 VPWR VGND sg13cmos5l_fill_2
XANTENNA__0428__D Tile_X0Y1_FrameData[14] VPWR VGND sg13cmos5l_antennanp
XANTENNA__0437__GATE Tile_X0Y1_FrameStrobe[2] VPWR VGND sg13cmos5l_antennanp
XANTENNA__0163__D Tile_X0Y0_FrameData[25] VPWR VGND sg13cmos5l_antennanp
XFILLER_23_56 VPWR VGND sg13cmos5l_decap_4
XANTENNA__0338__D Tile_X0Y0_FrameData[10] VPWR VGND sg13cmos5l_antennanp
XFILLER_73_142 VPWR VGND sg13cmos5l_fill_1
X_0750_ Tile_X0Y0_W6BEG[11] _1074_/X VPWR VGND sg13cmos5l_buf_1
X_0681_ _0681_/L_HI VPWR VGND sg13cmos5l_tiehi
XFILLER_56_109 VPWR VGND sg13cmos5l_fill_1
X_1233_ _1233_/X Tile_X0Y0_EE4END[2] Tile_X0Y0_EE4END[10] Tile_X0Y0_E6END[2] _1090_/X
+ _0174_/Q _0173_/Q VPWR VGND sg13cmos5l_mux4_1
XANTENNA__0248__D Tile_X0Y0_FrameData[4] VPWR VGND sg13cmos5l_antennanp
XANTENNA__0826__A Tile_X0Y1_FrameData[2] VPWR VGND sg13cmos5l_antennanp
XFILLER_64_131 VPWR VGND sg13cmos5l_fill_2
X_1095_ _1095_/X _1106_/X Tile_X0Y1_N2MID[3] Tile_X0Y0_S2MID[3] Tile_X0Y0_S2END[3]
+ _0110_/Q _0109_/Q VPWR VGND sg13cmos5l_mux4_1
X_1164_ _1164_/X _0645_/Q _0649_/Q _1217_/X _1201_/X _0488_/Q _0487_/Q VPWR VGND sg13cmos5l_mux4_1
X_0115_ _0115_/Q Tile_X0Y0_FrameData[9] VGND VPWR Tile_X0Y1_FrameStrobe[0] latch
XANTENNA__1015__A2 Tile_X0Y0_E6END[10] VPWR VGND sg13cmos5l_antennanp
X_0948_ Tile_X0Y1_W6BEG[3] _1182_/X VPWR VGND sg13cmos5l_buf_1
XFILLER_109_37 VPWR VGND sg13cmos5l_decap_4
X_0879_ Tile_X0Y0_FrameData_O[23] Tile_X0Y0_FrameData[23] VPWR VGND sg13cmos5l_buf_1
XANTENNA__0361__GATE Tile_X0Y1_FrameStrobe[0] VPWR VGND sg13cmos5l_antennanp
XANTENNA__0158__D Tile_X0Y0_FrameData[30] VPWR VGND sg13cmos5l_antennanp
XANTENNA__0376__GATE Tile_X0Y1_FrameStrobe[0] VPWR VGND sg13cmos5l_antennanp
XANTENNA__0314__GATE Tile_X0Y1_FrameStrobe[6] VPWR VGND sg13cmos5l_antennanp
XANTENNA__1006__A2 Tile_X0Y0_E6END[4] VPWR VGND sg13cmos5l_antennanp
XFILLER_50_43 VPWR VGND sg13cmos5l_fill_1
XFILLER_50_65 VPWR VGND sg13cmos5l_decap_4
XANTENNA__0329__GATE Tile_X0Y1_FrameStrobe[7] VPWR VGND sg13cmos5l_antennanp
XFILLER_15_9 VPWR VGND sg13cmos5l_fill_2
XANTENNA__0933__X Tile_X0Y1_W2BEG[4] VPWR VGND sg13cmos5l_antennanp
X_0802_ Tile_X0Y0_N1BEG[3] _1002_/X VPWR VGND sg13cmos5l_buf_1
XANTENNA__0531__D Tile_X0Y1_FrameData[7] VPWR VGND sg13cmos5l_antennanp
XFILLER_115_158 VPWR VGND sg13cmos5l_fill_1
XFILLER_41_2 VPWR VGND sg13cmos5l_fill_1
X_0733_ Tile_X0Y0_W2BEGb[2] _1041_/X VPWR VGND sg13cmos5l_buf_1
X_0664_ _0664_/L_HI VPWR VGND sg13cmos5l_tiehi
XANTENNA__1181__A1 Tile_X0Y0_S4END[6] VPWR VGND sg13cmos5l_antennanp
XFILLER_37_142 VPWR VGND sg13cmos5l_fill_1
X_1216_ _1216_/X Tile_X0Y1_N1END[1] Tile_X0Y1_N4END[1] _1228_/X Tile_X0Y0_S4END[5]
+ _0376_/Q _0375_/Q VPWR VGND sg13cmos5l_mux4_1
X_0595_ _0595_/Q Tile_X0Y1_FrameData[7] VGND VPWR Tile_X0Y1_FrameStrobe[7] latch
XANTENNA__0843__X Tile_X0Y1_FrameData_O[19] VPWR VGND sg13cmos5l_antennanp
XFILLER_52_178 VPWR VGND sg13cmos5l_fill_2
X_1078_ _1078_/X _1114_/X Tile_X0Y0_E6END[3] Tile_X0Y0_S1END[3] _1078_/A3 _0094_/Q
+ _0347_/Q VPWR VGND sg13cmos5l_mux4_1
X_1147_ _1147_/X Tile_X0Y1_E2MID[0] _0644_/Q _1195_/X _1202_/X _0522_/Q _0521_/Q VPWR
+ VGND sg13cmos5l_mux4_1
XANTENNA__0441__D Tile_X0Y1_FrameData[1] VPWR VGND sg13cmos5l_antennanp
XANTENNA__0995__A1 Tile_X0Y1_EE4END[5] VPWR VGND sg13cmos5l_antennanp
XFILLER_29_33 VPWR VGND sg13cmos5l_decap_8
XFILLER_45_21 VPWR VGND sg13cmos5l_fill_1
XANTENNA__0753__X Tile_X0Y0_N4BEG[2] VPWR VGND sg13cmos5l_antennanp
XANTENNA__0986__A1 Tile_X0Y1_EE4END[12] VPWR VGND sg13cmos5l_antennanp
XFILLER_101_60 VPWR VGND sg13cmos5l_fill_2
XFILLER_45_98 VPWR VGND sg13cmos5l_decap_8
XFILLER_61_20 VPWR VGND sg13cmos5l_fill_1
XANTENNA__0253__GATE Tile_X0Y1_FrameStrobe[5] VPWR VGND sg13cmos5l_antennanp
XANTENNA__0268__GATE Tile_X0Y1_FrameStrobe[5] VPWR VGND sg13cmos5l_antennanp
XANTENNA__0351__D Tile_X0Y1_FrameData[27] VPWR VGND sg13cmos5l_antennanp
XFILLER_112_106 VPWR VGND sg13cmos5l_fill_2
XANTENNA__0928__X Tile_X0Y1_W1BEG[3] VPWR VGND sg13cmos5l_antennanp
XFILLER_19_120 VPWR VGND sg13cmos5l_fill_1
X_0380_ _0380_/Q Tile_X0Y1_FrameData[30] VGND VPWR Tile_X0Y1_FrameStrobe[1] latch
XANTENNA__0206__GATE Tile_X0Y1_FrameStrobe[3] VPWR VGND sg13cmos5l_antennanp
XANTENNA__0526__D Tile_X0Y1_FrameData[12] VPWR VGND sg13cmos5l_antennanp
XFILLER_34_101 VPWR VGND sg13cmos5l_fill_2
X_1001_ _1001_/X Tile_X0Y0_E1END[2] Tile_X0Y0_E6END[6] _1077_/X _1102_/X _0342_/Q
+ _0341_/Q VPWR VGND sg13cmos5l_mux4_1
XANTENNA__0612__Q NPU_WEIGHT_IN2 VPWR VGND sg13cmos5l_antennanp
XANTENNA__0977__A1 Tile_X0Y0_E2END[4] VPWR VGND sg13cmos5l_antennanp
XFILLER_89_2 VPWR VGND sg13cmos5l_fill_1
XANTENNA__0261__D Tile_X0Y0_FrameData[23] VPWR VGND sg13cmos5l_antennanp
X_0716_ _0975_/A3 VPWR VGND sg13cmos5l_tielo
X_0647_ _0647_/Q Tile_X0Y1_UserCLK NPU_ACT_RDATA3 _0677_/L_HI VPWR VGND sg13cmos5l_dfrbpq_1
X_0578_ _0578_/Q Tile_X0Y1_FrameData[24] VGND VPWR Tile_X0Y1_FrameStrobe[7] latch
XANTENNA__0838__X Tile_X0Y1_FrameData_O[14] VPWR VGND sg13cmos5l_antennanp
XANTENNA__0436__D Tile_X0Y1_FrameData[6] VPWR VGND sg13cmos5l_antennanp
XANTENNA__0171__D Tile_X0Y0_FrameData[17] VPWR VGND sg13cmos5l_antennanp
XANTENNA__0748__X Tile_X0Y0_W6BEG[9] VPWR VGND sg13cmos5l_antennanp
XANTENNA__0346__D Tile_X0Y0_FrameData[2] VPWR VGND sg13cmos5l_antennanp
XANTENNA__0924__A Tile_X0Y1_UserCLK VPWR VGND sg13cmos5l_antennanp
XANTENNA__0192__GATE Tile_X0Y1_FrameStrobe[3] VPWR VGND sg13cmos5l_antennanp
X_0501_ _0501_/Q Tile_X0Y1_FrameData[5] VGND VPWR Tile_X0Y1_FrameStrobe[4] latch
X_0432_ _0432_/Q Tile_X0Y1_FrameData[10] VGND VPWR Tile_X0Y1_FrameStrobe[2] latch
XANTENNA__0130__GATE Tile_X0Y1_FrameStrobe[1] VPWR VGND sg13cmos5l_antennanp
XANTENNA__0145__GATE Tile_X0Y1_FrameStrobe[1] VPWR VGND sg13cmos5l_antennanp
X_0363_ _0363_/Q Tile_X0Y1_FrameData[15] VGND VPWR Tile_X0Y1_FrameStrobe[0] latch
X_0294_ _0294_/Q Tile_X0Y0_FrameData[22] VGND VPWR Tile_X0Y1_FrameStrobe[6] latch
XANTENNA__0256__D Tile_X0Y0_FrameData[28] VPWR VGND sg13cmos5l_antennanp
XANTENNA__0834__A Tile_X0Y1_FrameData[10] VPWR VGND sg13cmos5l_antennanp
XFILLER_94_0 VPWR VGND sg13cmos5l_fill_1
XFILLER_117_15 VPWR VGND sg13cmos5l_fill_2
XFILLER_89_104 VPWR VGND sg13cmos5l_decap_4
XANTENNA__1127__A1 Tile_X0Y1_E2END[7] VPWR VGND sg13cmos5l_antennanp
XANTENNA__0166__D Tile_X0Y0_FrameData[22] VPWR VGND sg13cmos5l_antennanp
XFILLER_26_56 VPWR VGND sg13cmos5l_decap_8
XFILLER_26_67 VPWR VGND sg13cmos5l_fill_2
XANTENNA__1063__A0 Tile_X0Y1_N4END[4] VPWR VGND sg13cmos5l_antennanp
XFILLER_42_88 VPWR VGND sg13cmos5l_fill_1
X_0981_ _0981_/X Tile_X0Y0_E1END[0] Tile_X0Y0_E6END[0] _1100_/X _0981_/A3 _0154_/Q
+ _0153_/Q VPWR VGND sg13cmos5l_mux4_1
XANTENNA__0614__CLK Tile_X0Y1_UserCLK VPWR VGND sg13cmos5l_antennanp
XANTENNA__0941__X Tile_X0Y1_W2BEGb[4] VPWR VGND sg13cmos5l_antennanp
XANTENNA__0829__A Tile_X0Y1_FrameData[5] VPWR VGND sg13cmos5l_antennanp
XANTENNA__1109__A1 Tile_X0Y1_E2END[1] VPWR VGND sg13cmos5l_antennanp
X_0415_ _0415_/Q Tile_X0Y1_FrameData[27] VGND VPWR Tile_X0Y1_FrameStrobe[2] latch
XFILLER_103_17 VPWR VGND sg13cmos5l_fill_1
X_0346_ _0346_/Q Tile_X0Y0_FrameData[2] VGND VPWR Tile_X0Y1_FrameStrobe[7] latch
X_0277_ _0277_/Q Tile_X0Y0_FrameData[7] VGND VPWR Tile_X0Y1_FrameStrobe[5] latch
XFILLER_94_151 VPWR VGND sg13cmos5l_fill_2
XANTENNA__0099__GATE Tile_X0Y1_FrameStrobe[0] VPWR VGND sg13cmos5l_antennanp
XANTENNA__0851__X Tile_X0Y1_FrameData_O[27] VPWR VGND sg13cmos5l_antennanp
XANTENNA__1045__A0 Tile_X0Y0_EE4END[13] VPWR VGND sg13cmos5l_antennanp
XANTENNA__0605__GATE Tile_X0Y1_FrameStrobe[8] VPWR VGND sg13cmos5l_antennanp
XANTENNA__0637__CLK Tile_X0Y1_UserCLK VPWR VGND sg13cmos5l_antennanp
XFILLER_53_54 VPWR VGND sg13cmos5l_fill_2
XFILLER_53_87 VPWR VGND sg13cmos5l_fill_2
XANTENNA__0761__X Tile_X0Y0_N4BEG[10] VPWR VGND sg13cmos5l_antennanp
XANTENNA__1036__A0 Tile_X0Y0_EE4END[15] VPWR VGND sg13cmos5l_antennanp
XANTENNA__0936__X Tile_X0Y1_W2BEG[7] VPWR VGND sg13cmos5l_antennanp
X_1180_ _1180_/X Tile_X0Y1_N4END[1] Tile_X0Y0_S4END[5] _1213_/X _1217_/X _0456_/Q
+ _0455_/Q VPWR VGND sg13cmos5l_mux4_1
X_0200_ _0200_/Q Tile_X0Y0_FrameData[20] VGND VPWR Tile_X0Y1_FrameStrobe[3] latch
X_0131_ _0131_/Q Tile_X0Y0_FrameData[25] VGND VPWR Tile_X0Y1_FrameStrobe[1] latch
XFILLER_94_61 VPWR VGND sg13cmos5l_decap_8
XFILLER_76_162 VPWR VGND sg13cmos5l_fill_2
XANTENNA__0534__D Tile_X0Y1_FrameData[4] VPWR VGND sg13cmos5l_antennanp
X_0964_ Tile_X0Y1_WW4BEG[7] _1170_/X VPWR VGND sg13cmos5l_buf_1
XANTENNA__0620__Q NPU_ACT_WDATA2 VPWR VGND sg13cmos5l_antennanp
X_0895_ Tile_X0Y1_S2BEG[3] _1130_/X VPWR VGND sg13cmos5l_buf_1
XANTENNA__0846__X Tile_X0Y1_FrameData_O[22] VPWR VGND sg13cmos5l_antennanp
X_0329_ _0329_/Q Tile_X0Y0_FrameData[19] VGND VPWR Tile_X0Y1_FrameStrobe[7] latch
XANTENNA__0444__D Tile_X0Y1_FrameData[30] VPWR VGND sg13cmos5l_antennanp
XANTENNA__0591__GATE Tile_X0Y1_FrameStrobe[7] VPWR VGND sg13cmos5l_antennanp
XFILLER_2_136 VPWR VGND sg13cmos5l_fill_2
XFILLER_48_21 VPWR VGND sg13cmos5l_fill_1
XANTENNA__0544__GATE Tile_X0Y1_FrameStrobe[6] VPWR VGND sg13cmos5l_antennanp
XANTENNA__0756__X Tile_X0Y0_N4BEG[5] VPWR VGND sg13cmos5l_antennanp
XFILLER_73_110 VPWR VGND sg13cmos5l_decap_4
XANTENNA__0354__D Tile_X0Y1_FrameData[24] VPWR VGND sg13cmos5l_antennanp
XANTENNA__0559__GATE Tile_X0Y1_FrameStrobe[6] VPWR VGND sg13cmos5l_antennanp
XANTENNA__1009__A0 Tile_X0Y0_E2MID[1] VPWR VGND sg13cmos5l_antennanp
XFILLER_9_48 VPWR VGND sg13cmos5l_fill_2
X_0680_ _0680_/L_HI VPWR VGND sg13cmos5l_tiehi
XFILLER_89_61 VPWR VGND sg13cmos5l_fill_1
XANTENNA__0529__D Tile_X0Y1_FrameData[9] VPWR VGND sg13cmos5l_antennanp
XFILLER_49_140 VPWR VGND sg13cmos5l_fill_2
X_1232_ _1232_/X Tile_X0Y0_EE4END[1] Tile_X0Y0_EE4END[9] Tile_X0Y0_E6END[1] _1089_/X
+ _0176_/Q _0175_/Q VPWR VGND sg13cmos5l_mux4_1
XFILLER_64_121 VPWR VGND sg13cmos5l_decap_8
X_1094_ _1094_/X _1105_/X Tile_X0Y1_N2MID[2] Tile_X0Y0_S2MID[2] Tile_X0Y0_S2END[2]
+ _0112_/Q _0111_/Q VPWR VGND sg13cmos5l_mux4_1
X_1163_ _1163_/X _0644_/Q _0648_/Q _1218_/X _1202_/X _0490_/Q _0489_/Q VPWR VGND sg13cmos5l_mux4_1
X_0114_ _0114_/Q Tile_X0Y0_FrameData[10] VGND VPWR Tile_X0Y1_FrameStrobe[0] latch
XANTENNA__0264__D Tile_X0Y0_FrameData[20] VPWR VGND sg13cmos5l_antennanp
XANTENNA__0615__Q NPU_WEIGHT_IN5 VPWR VGND sg13cmos5l_antennanp
XANTENNA__0842__A Tile_X0Y1_FrameData[18] VPWR VGND sg13cmos5l_antennanp
XFILLER_118_145 VPWR VGND sg13cmos5l_fill_1
X_0947_ Tile_X0Y1_W6BEG[2] _1181_/X VPWR VGND sg13cmos5l_buf_1
X_0878_ Tile_X0Y0_FrameData_O[22] Tile_X0Y0_FrameData[22] VPWR VGND sg13cmos5l_buf_1
XANTENNA__0439__D Tile_X0Y1_FrameData[3] VPWR VGND sg13cmos5l_antennanp
XANTENNA__0174__D Tile_X0Y0_FrameData[14] VPWR VGND sg13cmos5l_antennanp
XANTENNA__0752__A Tile_X0Y1_N4END[9] VPWR VGND sg13cmos5l_antennanp
XANTENNA__0349__D Tile_X0Y1_FrameData[29] VPWR VGND sg13cmos5l_antennanp
XFILLER_59_20 VPWR VGND sg13cmos5l_decap_8
XANTENNA__0483__GATE Tile_X0Y1_FrameStrobe[4] VPWR VGND sg13cmos5l_antennanp
XFILLER_61_102 VPWR VGND sg13cmos5l_decap_8
XANTENNA__0421__GATE Tile_X0Y1_FrameStrobe[2] VPWR VGND sg13cmos5l_antennanp
XANTENNA__0498__GATE Tile_X0Y1_FrameStrobe[4] VPWR VGND sg13cmos5l_antennanp
XFILLER_61_179 VPWR VGND sg13cmos5l_fill_1
X_0801_ Tile_X0Y0_N1BEG[2] _1001_/X VPWR VGND sg13cmos5l_buf_1
XANTENNA__0436__GATE Tile_X0Y1_FrameStrobe[2] VPWR VGND sg13cmos5l_antennanp
X_0732_ Tile_X0Y0_W2BEGb[1] _1040_/X VPWR VGND sg13cmos5l_buf_1
X_0663_ _0663_/L_HI VPWR VGND sg13cmos5l_tiehi
X_0594_ _0594_/Q Tile_X0Y1_FrameData[8] VGND VPWR Tile_X0Y1_FrameStrobe[7] latch
XANTENNA__0259__D Tile_X0Y0_FrameData[25] VPWR VGND sg13cmos5l_antennanp
XANTENNA__0837__A Tile_X0Y1_FrameData[13] VPWR VGND sg13cmos5l_antennanp
XFILLER_37_110 VPWR VGND sg13cmos5l_fill_2
X_1215_ _1215_/X Tile_X0Y1_N1END[0] Tile_X0Y1_N4END[0] _1227_/X Tile_X0Y0_S4END[4]
+ _0378_/Q _0377_/Q VPWR VGND sg13cmos5l_mux4_1
X_1146_ _1146_/X Tile_X0Y1_N1END[3] _1230_/X _0645_/Q _0648_/Q _0524_/Q _0523_/Q VPWR
+ VGND sg13cmos5l_mux4_1
XFILLER_111_39 VPWR VGND sg13cmos5l_decap_8
XFILLER_52_113 VPWR VGND sg13cmos5l_fill_2
X_1077_ _1077_/X _1113_/X Tile_X0Y1_N4END[6] Tile_X0Y0_S1END[2] Tile_X0Y0_S4END[2]
+ _0120_/Q _0119_/Q VPWR VGND sg13cmos5l_mux4_1
XANTENNA__0995__A2 Tile_X0Y1_EE4END[13] VPWR VGND sg13cmos5l_antennanp
XFILLER_20_47 VPWR VGND sg13cmos5l_decap_8
XFILLER_29_12 VPWR VGND sg13cmos5l_fill_1
XANTENNA__0169__D Tile_X0Y0_FrameData[19] VPWR VGND sg13cmos5l_antennanp
XFILLER_43_135 VPWR VGND sg13cmos5l_fill_1
XANTENNA__0986__A2 Tile_X0Y1_E6END[4] VPWR VGND sg13cmos5l_antennanp
XFILLER_43_179 VPWR VGND sg13cmos5l_fill_1
X_1000_ _1000_/X Tile_X0Y0_E1END[1] Tile_X0Y0_E6END[5] _1076_/X _1101_/X _0344_/Q
+ _0343_/Q VPWR VGND sg13cmos5l_mux4_1
XANTENNA__0944__X Tile_X0Y1_W2BEGb[7] VPWR VGND sg13cmos5l_antennanp
XANTENNA__1218__A3 Tile_X0Y0_S4END[7] VPWR VGND sg13cmos5l_antennanp
XANTENNA__0360__GATE Tile_X0Y1_FrameStrobe[0] VPWR VGND sg13cmos5l_antennanp
XANTENNA__0542__D Tile_X0Y1_FrameData[28] VPWR VGND sg13cmos5l_antennanp
X_0715_ _0976_/A3 VPWR VGND sg13cmos5l_tielo
XANTENNA__0375__GATE Tile_X0Y1_FrameStrobe[0] VPWR VGND sg13cmos5l_antennanp
XFILLER_103_118 VPWR VGND sg13cmos5l_decap_4
X_0646_ _0646_/Q Tile_X0Y1_UserCLK NPU_ACT_RDATA2 _0678_/L_HI VPWR VGND sg13cmos5l_dfrbpq_1
X_0577_ _0577_/Q Tile_X0Y1_FrameData[25] VGND VPWR Tile_X0Y1_FrameStrobe[7] latch
XANTENNA__0313__GATE Tile_X0Y1_FrameStrobe[6] VPWR VGND sg13cmos5l_antennanp
XANTENNA__0854__X Tile_X0Y1_FrameData_O[30] VPWR VGND sg13cmos5l_antennanp
X_1129_ _1129_/X Tile_X0Y1_E2MID[5] Tile_X0Y1_E2END[5] Tile_X0Y1_E6END[10] _1197_/X
+ _0554_/Q _0553_/Q VPWR VGND sg13cmos5l_mux4_1
XANTENNA__0328__GATE Tile_X0Y1_FrameStrobe[7] VPWR VGND sg13cmos5l_antennanp
XANTENNA__0452__D Tile_X0Y1_FrameData[22] VPWR VGND sg13cmos5l_antennanp
XANTENNA__1090__A1 Tile_X0Y1_N4END[6] VPWR VGND sg13cmos5l_antennanp
XANTENNA__1209__A3 Tile_X0Y0_S4END[6] VPWR VGND sg13cmos5l_antennanp
XFILLER_25_179 VPWR VGND sg13cmos5l_fill_1
XFILLER_31_13 VPWR VGND sg13cmos5l_fill_1
XANTENNA__0764__X Tile_X0Y0_N4BEG[13] VPWR VGND sg13cmos5l_antennanp
XFILLER_16_168 VPWR VGND sg13cmos5l_fill_2
XFILLER_72_42 VPWR VGND sg13cmos5l_decap_8
XFILLER_72_86 VPWR VGND sg13cmos5l_fill_1
XANTENNA__0362__D Tile_X0Y1_FrameData[16] VPWR VGND sg13cmos5l_antennanp
XANTENNA__1081__A1 Tile_X0Y1_N4END[6] VPWR VGND sg13cmos5l_antennanp
XANTENNA__0939__X Tile_X0Y1_W2BEGb[2] VPWR VGND sg13cmos5l_antennanp
X_0500_ _0500_/Q Tile_X0Y1_FrameData[6] VGND VPWR Tile_X0Y1_FrameStrobe[4] latch
X_0431_ _0431_/Q Tile_X0Y1_FrameData[11] VGND VPWR Tile_X0Y1_FrameStrobe[2] latch
X_0362_ _0362_/Q Tile_X0Y1_FrameData[16] VGND VPWR Tile_X0Y1_FrameStrobe[0] latch
XANTENNA__0537__D Tile_X0Y1_FrameData[1] VPWR VGND sg13cmos5l_antennanp
X_0293_ _0293_/Q Tile_X0Y0_FrameData[23] VGND VPWR Tile_X0Y1_FrameStrobe[6] latch
XANTENNA__0272__D Tile_X0Y0_FrameData[12] VPWR VGND sg13cmos5l_antennanp
XANTENNA__0623__Q NPU_ACT_WDATA5 VPWR VGND sg13cmos5l_antennanp
XFILLER_22_138 VPWR VGND sg13cmos5l_decap_8
XANTENNA__0850__A Tile_X0Y1_FrameData[26] VPWR VGND sg13cmos5l_antennanp
XFILLER_117_27 VPWR VGND sg13cmos5l_fill_2
XANTENNA__0252__GATE Tile_X0Y1_FrameStrobe[4] VPWR VGND sg13cmos5l_antennanp
XANTENNA__0849__X Tile_X0Y1_FrameData_O[25] VPWR VGND sg13cmos5l_antennanp
XANTENNA__1127__A2 Tile_X0Y1_E6END[8] VPWR VGND sg13cmos5l_antennanp
X_0629_ NPU_ACT_ADDR3 Tile_X0Y1_UserCLK _0976_/X _0682_/L_HI VPWR VGND sg13cmos5l_dfrbpq_1
XANTENNA__0267__GATE Tile_X0Y1_FrameStrobe[5] VPWR VGND sg13cmos5l_antennanp
XANTENNA__0447__D Tile_X0Y1_FrameData[27] VPWR VGND sg13cmos5l_antennanp
XANTENNA__0182__D Tile_X0Y0_FrameData[6] VPWR VGND sg13cmos5l_antennanp
XANTENNA__1063__A1 Tile_X0Y0_S4END[0] VPWR VGND sg13cmos5l_antennanp
XFILLER_42_23 VPWR VGND sg13cmos5l_fill_2
XANTENNA__0205__GATE Tile_X0Y1_FrameStrobe[3] VPWR VGND sg13cmos5l_antennanp
XANTENNA__0759__X Tile_X0Y0_N4BEG[8] VPWR VGND sg13cmos5l_antennanp
XANTENNA__0357__D Tile_X0Y1_FrameData[21] VPWR VGND sg13cmos5l_antennanp
XFILLER_67_75 VPWR VGND sg13cmos5l_fill_1
XFILLER_83_41 VPWR VGND sg13cmos5l_fill_2
X_0980_ _0980_/X Tile_X0Y0_E2MID[7] Tile_X0Y0_E2END[7] _1099_/X _0980_/A3 _0156_/Q
+ _0155_/Q VPWR VGND sg13cmos5l_mux4_1
XANTENNA__1109__A2 Tile_X0Y1_E6END[1] VPWR VGND sg13cmos5l_antennanp
X_0414_ _0414_/Q Tile_X0Y1_FrameData[28] VGND VPWR Tile_X0Y1_FrameStrobe[2] latch
X_0345_ _0345_/Q Tile_X0Y0_FrameData[3] VGND VPWR Tile_X0Y1_FrameStrobe[7] latch
XFILLER_86_119 VPWR VGND sg13cmos5l_decap_8
XANTENNA__0267__D Tile_X0Y0_FrameData[17] VPWR VGND sg13cmos5l_antennanp
XANTENNA__0618__Q NPU_ACT_WDATA0 VPWR VGND sg13cmos5l_antennanp
XANTENNA__0845__A Tile_X0Y1_FrameData[21] VPWR VGND sg13cmos5l_antennanp
XFILLER_103_29 VPWR VGND sg13cmos5l_fill_2
X_0276_ _0276_/Q Tile_X0Y0_FrameData[8] VGND VPWR Tile_X0Y1_FrameStrobe[5] latch
XANTENNA__0177__D Tile_X0Y0_FrameData[11] VPWR VGND sg13cmos5l_antennanp
XANTENNA__0191__GATE Tile_X0Y1_FrameStrobe[3] VPWR VGND sg13cmos5l_antennanp
XANTENNA__0755__A Tile_X0Y1_N4END[12] VPWR VGND sg13cmos5l_antennanp
XFILLER_37_23 VPWR VGND sg13cmos5l_fill_1
XFILLER_85_130 VPWR VGND sg13cmos5l_decap_8
XFILLER_53_99 VPWR VGND sg13cmos5l_fill_2
XANTENNA__0144__GATE Tile_X0Y1_FrameStrobe[1] VPWR VGND sg13cmos5l_antennanp
XANTENNA__0640__D NPU_OUT_ACT4 VPWR VGND sg13cmos5l_antennanp
XANTENNA__0159__GATE Tile_X0Y1_FrameStrobe[2] VPWR VGND sg13cmos5l_antennanp
XFILLER_76_152 VPWR VGND sg13cmos5l_fill_1
X_0130_ _0130_/Q Tile_X0Y0_FrameData[26] VGND VPWR Tile_X0Y1_FrameStrobe[1] latch
XFILLER_94_73 VPWR VGND sg13cmos5l_decap_4
XFILLER_91_166 VPWR VGND sg13cmos5l_fill_1
XFILLER_91_100 VPWR VGND sg13cmos5l_decap_4
XANTENNA__0952__X Tile_X0Y1_W6BEG[7] VPWR VGND sg13cmos5l_antennanp
XANTENNA__1027__A1 Tile_X0Y0_S1END[0] VPWR VGND sg13cmos5l_antennanp
X_0894_ Tile_X0Y1_S2BEG[2] _1129_/X VPWR VGND sg13cmos5l_buf_1
X_0963_ Tile_X0Y1_WW4BEG[6] _1169_/X VPWR VGND sg13cmos5l_buf_1
XANTENNA__0550__D Tile_X0Y1_FrameData[20] VPWR VGND sg13cmos5l_antennanp
X_0328_ _0328_/Q Tile_X0Y0_FrameData[20] VGND VPWR Tile_X0Y1_FrameStrobe[7] latch
XANTENNA__0862__X Tile_X0Y0_FrameData_O[6] VPWR VGND sg13cmos5l_antennanp
XFILLER_23_36 VPWR VGND sg13cmos5l_decap_8
X_0259_ _0259_/Q Tile_X0Y0_FrameData[25] VGND VPWR Tile_X0Y1_FrameStrobe[5] latch
XFILLER_82_155 VPWR VGND sg13cmos5l_fill_1
XANTENNA__0460__D Tile_X0Y1_FrameData[14] VPWR VGND sg13cmos5l_antennanp
XFILLER_2_148 VPWR VGND sg13cmos5l_fill_2
XFILLER_48_33 VPWR VGND sg13cmos5l_fill_2
XFILLER_104_61 VPWR VGND sg13cmos5l_fill_1
XFILLER_104_83 VPWR VGND sg13cmos5l_fill_2
XFILLER_73_155 VPWR VGND sg13cmos5l_fill_2
XANTENNA__0772__X Tile_X0Y0_WW4BEG[5] VPWR VGND sg13cmos5l_antennanp
XANTENNA__1009__A1 Tile_X0Y0_E2END[1] VPWR VGND sg13cmos5l_antennanp
XFILLER_80_42 VPWR VGND sg13cmos5l_decap_4
XANTENNA__0098__GATE Tile_X0Y1_FrameStrobe[0] VPWR VGND sg13cmos5l_antennanp
XANTENNA__0370__D Tile_X0Y1_FrameData[8] VPWR VGND sg13cmos5l_antennanp
XANTENNA__1193__A0 Tile_X0Y1_N1END[2] VPWR VGND sg13cmos5l_antennanp
XANTENNA__0947__X Tile_X0Y1_W6BEG[2] VPWR VGND sg13cmos5l_antennanp
X_1231_ _1231_/X Tile_X0Y0_EE4END[0] Tile_X0Y0_EE4END[8] Tile_X0Y0_E6END[0] _1088_/X
+ _0178_/Q _0177_/Q VPWR VGND sg13cmos5l_mux4_1
X_1162_ _1162_/X Tile_X0Y1_E2MID[5] _0651_/Q _1195_/X _1202_/X _0492_/Q _0491_/Q VPWR
+ VGND sg13cmos5l_mux4_1
XANTENNA__0545__D Tile_X0Y1_FrameData[25] VPWR VGND sg13cmos5l_antennanp
X_1093_ _1093_/X _1104_/X Tile_X0Y1_N2MID[1] Tile_X0Y0_S2MID[1] Tile_X0Y0_S2END[1]
+ _0114_/Q _0113_/Q VPWR VGND sg13cmos5l_mux4_1
X_0113_ _0113_/Q Tile_X0Y0_FrameData[11] VGND VPWR Tile_X0Y1_FrameStrobe[0] latch
XANTENNA__0280__D Tile_X0Y0_FrameData[4] VPWR VGND sg13cmos5l_antennanp
XANTENNA__0631__Q NPU_ACT_ADDR5 VPWR VGND sg13cmos5l_antennanp
X_0877_ Tile_X0Y0_FrameData_O[21] Tile_X0Y0_FrameData[21] VPWR VGND sg13cmos5l_buf_1
X_0946_ Tile_X0Y1_W6BEG[1] _1180_/X VPWR VGND sg13cmos5l_buf_1
XANTENNA__0604__GATE Tile_X0Y1_FrameStrobe[8] VPWR VGND sg13cmos5l_antennanp
XANTENNA__0627__CLK Tile_X0Y1_UserCLK VPWR VGND sg13cmos5l_antennanp
XANTENNA__0857__X Tile_X0Y0_FrameData_O[1] VPWR VGND sg13cmos5l_antennanp
XANTENNA__0455__D Tile_X0Y1_FrameData[19] VPWR VGND sg13cmos5l_antennanp
XANTENNA__0998__A0 Tile_X0Y0_EE4END[3] VPWR VGND sg13cmos5l_antennanp
XFILLER_70_136 VPWR VGND sg13cmos5l_fill_2
XANTENNA__0190__D Tile_X0Y0_FrameData[30] VPWR VGND sg13cmos5l_antennanp
XFILLER_109_157 VPWR VGND sg13cmos5l_fill_1
XFILLER_109_168 VPWR VGND sg13cmos5l_fill_2
XFILLER_109_179 VPWR VGND sg13cmos5l_fill_1
XANTENNA__0767__X Tile_X0Y0_WW4BEG[0] VPWR VGND sg13cmos5l_antennanp
XANTENNA__0365__D Tile_X0Y1_FrameData[13] VPWR VGND sg13cmos5l_antennanp
XANTENNA__0989__A0 Tile_X0Y1_EE4END[7] VPWR VGND sg13cmos5l_antennanp
XFILLER_61_158 VPWR VGND sg13cmos5l_fill_2
X_0800_ Tile_X0Y0_N1BEG[1] _1000_/X VPWR VGND sg13cmos5l_buf_1
X_0731_ Tile_X0Y0_W2BEGb[0] _1039_/X VPWR VGND sg13cmos5l_buf_1
XFILLER_115_138 VPWR VGND sg13cmos5l_fill_2
X_0662_ _0662_/L_HI VPWR VGND sg13cmos5l_tiehi
X_0593_ _0593_/Q Tile_X0Y1_FrameData[9] VGND VPWR Tile_X0Y1_FrameStrobe[7] latch
XANTENNA__0590__GATE Tile_X0Y1_FrameStrobe[7] VPWR VGND sg13cmos5l_antennanp
XFILLER_111_18 VPWR VGND sg13cmos5l_fill_1
X_1214_ _1214_/X Tile_X0Y1_N1END[3] Tile_X0Y1_N4END[3] _1230_/X Tile_X0Y0_S4END[7]
+ _0380_/Q _0379_/Q VPWR VGND sg13cmos5l_mux4_1
X_1145_ _1145_/X Tile_X0Y1_N1END[2] _1229_/X _0644_/Q _0649_/Q _0526_/Q _0525_/Q VPWR
+ VGND sg13cmos5l_mux4_1
XANTENNA__0275__D Tile_X0Y0_FrameData[9] VPWR VGND sg13cmos5l_antennanp
XANTENNA__0626__Q NPU_ACT_ADDR0 VPWR VGND sg13cmos5l_antennanp
XANTENNA__0853__A Tile_X0Y1_FrameData[29] VPWR VGND sg13cmos5l_antennanp
XFILLER_52_147 VPWR VGND sg13cmos5l_fill_1
X_1076_ _1076_/X _1112_/X Tile_X0Y1_N4END[5] Tile_X0Y0_S1END[1] Tile_X0Y0_S4END[1]
+ _0122_/Q _0121_/Q VPWR VGND sg13cmos5l_mux4_1
XANTENNA__0543__GATE Tile_X0Y1_FrameStrobe[6] VPWR VGND sg13cmos5l_antennanp
XANTENNA__1157__A0 Tile_X0Y1_E2END[3] VPWR VGND sg13cmos5l_antennanp
XFILLER_105_9 VPWR VGND sg13cmos5l_decap_8
X_0929_ Tile_X0Y1_W2BEG[0] _1147_/X VPWR VGND sg13cmos5l_buf_1
XANTENNA__0558__GATE Tile_X0Y1_FrameStrobe[6] VPWR VGND sg13cmos5l_antennanp
XFILLER_29_46 VPWR VGND sg13cmos5l_decap_4
XANTENNA__0185__D Tile_X0Y0_FrameData[3] VPWR VGND sg13cmos5l_antennanp
XFILLER_117_0 VPWR VGND sg13cmos5l_fill_2
XFILLER_61_77 VPWR VGND sg13cmos5l_fill_1
XANTENNA__1148__A0 Tile_X0Y1_E2MID[3] VPWR VGND sg13cmos5l_antennanp
XFILLER_19_111 VPWR VGND sg13cmos5l_decap_8
XFILLER_19_155 VPWR VGND sg13cmos5l_decap_8
XFILLER_19_177 VPWR VGND sg13cmos5l_fill_2
XFILLER_20_9 VPWR VGND sg13cmos5l_fill_2
XFILLER_34_103 VPWR VGND sg13cmos5l_fill_1
XANTENNA__0095__D Tile_X0Y0_FrameData[29] VPWR VGND sg13cmos5l_antennanp
XANTENNA__0960__X Tile_X0Y1_WW4BEG[3] VPWR VGND sg13cmos5l_antennanp
XANTENNA__1139__A0 Tile_X0Y1_E1END[2] VPWR VGND sg13cmos5l_antennanp
X_0714_ _0977_/A3 VPWR VGND sg13cmos5l_tielo
X_0645_ _0645_/Q Tile_X0Y1_UserCLK NPU_ACT_RDATA1 _0676_/L_HI VPWR VGND sg13cmos5l_dfrbpq_1
XANTENNA__0848__A Tile_X0Y1_FrameData[24] VPWR VGND sg13cmos5l_antennanp
XFILLER_32_0 VPWR VGND sg13cmos5l_fill_2
X_0576_ _0576_/Q Tile_X0Y1_FrameData[26] VGND VPWR Tile_X0Y1_FrameStrobe[7] latch
X_1059_ _1059_/X _0636_/Q _0640_/Q _1091_/X _1095_/X _0210_/Q _0209_/Q VPWR VGND sg13cmos5l_mux4_1
X_1128_ _1128_/X Tile_X0Y1_E2MID[6] Tile_X0Y1_E2END[6] Tile_X0Y1_E6END[9] _1196_/X
+ _0556_/Q _0555_/Q VPWR VGND sg13cmos5l_mux4_1
XANTENNA__0091__Q NPU_XBAR_SEL1 VPWR VGND sg13cmos5l_antennanp
XANTENNA__0870__X Tile_X0Y0_FrameData_O[14] VPWR VGND sg13cmos5l_antennanp
XANTENNA__1090__A2 Tile_X0Y0_S1END[2] VPWR VGND sg13cmos5l_antennanp
XANTENNA__0482__GATE Tile_X0Y1_FrameStrobe[4] VPWR VGND sg13cmos5l_antennanp
XANTENNA__0497__GATE Tile_X0Y1_FrameStrobe[4] VPWR VGND sg13cmos5l_antennanp
XANTENNA__0420__GATE Tile_X0Y1_FrameStrobe[2] VPWR VGND sg13cmos5l_antennanp
XANTENNA__0758__A Tile_X0Y1_N4END[15] VPWR VGND sg13cmos5l_antennanp
XFILLER_56_66 VPWR VGND sg13cmos5l_fill_2
XANTENNA__0435__GATE Tile_X0Y1_FrameStrobe[2] VPWR VGND sg13cmos5l_antennanp
XANTENNA__0643__D NPU_OUT_ACT7 VPWR VGND sg13cmos5l_antennanp
XANTENNA__0780__X Tile_X0Y0_WW4BEG[13] VPWR VGND sg13cmos5l_antennanp
XANTENNA__1081__A2 Tile_X0Y0_S1END[2] VPWR VGND sg13cmos5l_antennanp
X_0430_ _0430_/Q Tile_X0Y1_FrameData[12] VGND VPWR Tile_X0Y1_FrameStrobe[2] latch
X_0361_ _0361_/Q Tile_X0Y1_FrameData[17] VGND VPWR Tile_X0Y1_FrameStrobe[0] latch
XANTENNA__0955__X Tile_X0Y1_W6BEG[10] VPWR VGND sg13cmos5l_antennanp
X_0292_ _0292_/Q Tile_X0Y0_FrameData[24] VGND VPWR Tile_X0Y1_FrameStrobe[6] latch
XANTENNA__0553__D Tile_X0Y1_FrameData[17] VPWR VGND sg13cmos5l_antennanp
X_0628_ NPU_ACT_ADDR2 Tile_X0Y1_UserCLK _0975_/X _0683_/L_HI VPWR VGND sg13cmos5l_dfrbpq_1
XFILLER_7_93 VPWR VGND sg13cmos5l_decap_8
XFILLER_7_82 VPWR VGND sg13cmos5l_decap_4
XANTENNA__0865__X Tile_X0Y0_FrameData_O[9] VPWR VGND sg13cmos5l_antennanp
X_0559_ _0559_/Q Tile_X0Y1_FrameData[11] VGND VPWR Tile_X0Y1_FrameStrobe[6] latch
XANTENNA__0463__D Tile_X0Y1_FrameData[11] VPWR VGND sg13cmos5l_antennanp
XFILLER_42_13 VPWR VGND sg13cmos5l_fill_2
XFILLER_67_54 VPWR VGND sg13cmos5l_fill_1
XFILLER_67_65 VPWR VGND sg13cmos5l_fill_1
XANTENNA__0374__GATE Tile_X0Y1_FrameStrobe[0] VPWR VGND sg13cmos5l_antennanp
XANTENNA__0638__D NPU_OUT_ACT2 VPWR VGND sg13cmos5l_antennanp
XANTENNA__0775__X Tile_X0Y0_WW4BEG[8] VPWR VGND sg13cmos5l_antennanp
XFILLER_83_53 VPWR VGND sg13cmos5l_fill_2
XANTENNA__0373__D Tile_X0Y1_FrameData[5] VPWR VGND sg13cmos5l_antennanp
XANTENNA__0389__GATE Tile_X0Y1_FrameStrobe[1] VPWR VGND sg13cmos5l_antennanp
XANTENNA__0312__GATE Tile_X0Y1_FrameStrobe[6] VPWR VGND sg13cmos5l_antennanp
XANTENNA__0327__GATE Tile_X0Y1_FrameStrobe[7] VPWR VGND sg13cmos5l_antennanp
XANTENNA__0548__D Tile_X0Y1_FrameData[22] VPWR VGND sg13cmos5l_antennanp
X_0413_ _0413_/Q Tile_X0Y1_FrameData[29] VGND VPWR Tile_X0Y1_FrameStrobe[2] latch
X_0344_ _0344_/Q Tile_X0Y0_FrameData[4] VGND VPWR Tile_X0Y1_FrameStrobe[7] latch
X_0275_ _0275_/Q Tile_X0Y0_FrameData[9] VGND VPWR Tile_X0Y1_FrameStrobe[5] latch
XANTENNA__0283__D Tile_X0Y0_FrameData[1] VPWR VGND sg13cmos5l_antennanp
XANTENNA__0634__Q NPU_ACT_ADDR8 VPWR VGND sg13cmos5l_antennanp
XANTENNA__0861__A Tile_X0Y0_FrameData[5] VPWR VGND sg13cmos5l_antennanp
XANTENNA__0458__D Tile_X0Y1_FrameData[16] VPWR VGND sg13cmos5l_antennanp
XANTENNA__0193__D Tile_X0Y0_FrameData[27] VPWR VGND sg13cmos5l_antennanp
XFILLER_53_56 VPWR VGND sg13cmos5l_fill_1
XANTENNA__0368__D Tile_X0Y1_FrameData[10] VPWR VGND sg13cmos5l_antennanp
XANTENNA__0251__GATE Tile_X0Y1_FrameStrobe[4] VPWR VGND sg13cmos5l_antennanp
X_0893_ Tile_X0Y1_S2BEG[1] _1128_/X VPWR VGND sg13cmos5l_buf_1
X_0962_ Tile_X0Y1_WW4BEG[5] _1168_/X VPWR VGND sg13cmos5l_buf_1
XANTENNA__0266__GATE Tile_X0Y1_FrameStrobe[5] VPWR VGND sg13cmos5l_antennanp
XANTENNA__0278__D Tile_X0Y0_FrameData[6] VPWR VGND sg13cmos5l_antennanp
XANTENNA__0629__Q NPU_ACT_ADDR3 VPWR VGND sg13cmos5l_antennanp
XANTENNA__0856__A Tile_X0Y0_FrameData[0] VPWR VGND sg13cmos5l_antennanp
XFILLER_114_29 VPWR VGND sg13cmos5l_decap_4
X_0327_ _0327_/Q Tile_X0Y0_FrameData[21] VGND VPWR Tile_X0Y1_FrameStrobe[7] latch
X_0258_ _0258_/Q Tile_X0Y0_FrameData[26] VGND VPWR Tile_X0Y1_FrameStrobe[5] latch
XANTENNA__0204__GATE Tile_X0Y1_FrameStrobe[3] VPWR VGND sg13cmos5l_antennanp
X_0189_ _0189_/Q Tile_X0Y0_FrameData[31] VGND VPWR Tile_X0Y1_FrameStrobe[3] latch
XANTENNA__0219__GATE Tile_X0Y1_FrameStrobe[3] VPWR VGND sg13cmos5l_antennanp
XANTENNA__0188__D Tile_X0Y0_FrameData[0] VPWR VGND sg13cmos5l_antennanp
XFILLER_48_12 VPWR VGND sg13cmos5l_decap_8
XFILLER_58_142 VPWR VGND sg13cmos5l_decap_8
XFILLER_64_55 VPWR VGND sg13cmos5l_fill_2
XANTENNA__0651__D NPU_ACT_RDATA7 VPWR VGND sg13cmos5l_antennanp
XANTENNA__1009__A2 Tile_X0Y0_E6END[1] VPWR VGND sg13cmos5l_antennanp
XANTENNA__1193__A1 Tile_X0Y1_E6END[2] VPWR VGND sg13cmos5l_antennanp
XANTENNA__0098__D Tile_X0Y0_FrameData[26] VPWR VGND sg13cmos5l_antennanp
X_1092_ _1092_/X _1103_/X Tile_X0Y1_N2MID[0] Tile_X0Y0_S2MID[0] Tile_X0Y0_S2END[0]
+ _0116_/Q _0115_/Q VPWR VGND sg13cmos5l_mux4_1
X_1230_ _1230_/X Tile_X0Y0_E1END[3] Tile_X0Y0_E6END[11] _1079_/X _1078_/X _0304_/Q
+ _0303_/Q VPWR VGND sg13cmos5l_mux4_1
X_1161_ _1161_/X Tile_X0Y1_E2MID[2] _0650_/Q _1196_/X _1201_/X _0494_/Q _0493_/Q VPWR
+ VGND sg13cmos5l_mux4_1
X_0112_ _0112_/Q Tile_X0Y0_FrameData[12] VGND VPWR Tile_X0Y1_FrameStrobe[0] latch
XANTENNA__0963__X Tile_X0Y1_WW4BEG[6] VPWR VGND sg13cmos5l_antennanp
XANTENNA__0190__GATE Tile_X0Y1_FrameStrobe[3] VPWR VGND sg13cmos5l_antennanp
XANTENNA__0561__D Tile_X0Y1_FrameData[9] VPWR VGND sg13cmos5l_antennanp
X_0876_ Tile_X0Y0_FrameData_O[20] Tile_X0Y0_FrameData[20] VPWR VGND sg13cmos5l_buf_1
X_0945_ Tile_X0Y1_W6BEG[0] _1179_/X VPWR VGND sg13cmos5l_buf_1
XFILLER_18_26 VPWR VGND sg13cmos5l_decap_4
XANTENNA__0143__GATE Tile_X0Y1_FrameStrobe[1] VPWR VGND sg13cmos5l_antennanp
XANTENNA__0873__X Tile_X0Y0_FrameData_O[17] VPWR VGND sg13cmos5l_antennanp
XFILLER_34_14 VPWR VGND sg13cmos5l_fill_1
XANTENNA__0158__GATE Tile_X0Y1_FrameStrobe[2] VPWR VGND sg13cmos5l_antennanp
XANTENNA__0471__D Tile_X0Y1_FrameData[3] VPWR VGND sg13cmos5l_antennanp
XANTENNA__0998__A1 Tile_X0Y0_EE4END[11] VPWR VGND sg13cmos5l_antennanp
XFILLER_109_103 VPWR VGND sg13cmos5l_fill_2
XFILLER_59_44 VPWR VGND sg13cmos5l_fill_2
XANTENNA__0646__D NPU_ACT_RDATA2 VPWR VGND sg13cmos5l_antennanp
XANTENNA__0783__X Tile_X0Y0_N2BEGb[0] VPWR VGND sg13cmos5l_antennanp
XANTENNA__0989__A1 Tile_X0Y1_EE4END[15] VPWR VGND sg13cmos5l_antennanp
XANTENNA__0381__D Tile_X0Y1_FrameData[29] VPWR VGND sg13cmos5l_antennanp
X_0730_ Tile_X0Y0_W2BEG[7] _1038_/X VPWR VGND sg13cmos5l_buf_1
X_0661_ _0661_/L_HI VPWR VGND sg13cmos5l_tiehi
XANTENNA__0958__X Tile_X0Y1_WW4BEG[1] VPWR VGND sg13cmos5l_antennanp
X_1213_ _1213_/X Tile_X0Y1_N1END[2] Tile_X0Y1_N4END[2] _1229_/X Tile_X0Y0_S4END[6]
+ _0382_/Q _0381_/Q VPWR VGND sg13cmos5l_mux4_1
X_0592_ _0592_/Q Tile_X0Y1_FrameData[10] VGND VPWR Tile_X0Y1_FrameStrobe[7] latch
XANTENNA__0556__D Tile_X0Y1_FrameData[14] VPWR VGND sg13cmos5l_antennanp
X_1075_ _1075_/X _1111_/X Tile_X0Y1_N4END[4] Tile_X0Y0_S1END[0] Tile_X0Y0_S4END[0]
+ _0124_/Q _0123_/Q VPWR VGND sg13cmos5l_mux4_1
X_1144_ _1144_/X Tile_X0Y1_N1END[1] _1228_/X _0647_/Q _0650_/Q _0528_/Q _0527_/Q VPWR
+ VGND sg13cmos5l_mux4_1
XANTENNA__0291__D Tile_X0Y0_FrameData[25] VPWR VGND sg13cmos5l_antennanp
XANTENNA__0868__X Tile_X0Y0_FrameData_O[12] VPWR VGND sg13cmos5l_antennanp
XFILLER_20_16 VPWR VGND sg13cmos5l_fill_2
X_0859_ Tile_X0Y0_FrameData_O[3] Tile_X0Y0_FrameData[3] VPWR VGND sg13cmos5l_buf_1
X_0928_ Tile_X0Y1_W1BEG[3] _1146_/X VPWR VGND sg13cmos5l_buf_1
XANTENNA__0089__Q NPU_ACT_WE VPWR VGND sg13cmos5l_antennanp
XANTENNA__0097__GATE Tile_X0Y1_FrameStrobe[0] VPWR VGND sg13cmos5l_antennanp
XANTENNA__0466__D Tile_X0Y1_FrameData[8] VPWR VGND sg13cmos5l_antennanp
XFILLER_101_30 VPWR VGND sg13cmos5l_fill_2
XANTENNA__0778__X Tile_X0Y0_WW4BEG[11] VPWR VGND sg13cmos5l_antennanp
XFILLER_10_82 VPWR VGND sg13cmos5l_fill_2
XANTENNA__0376__D Tile_X0Y1_FrameData[2] VPWR VGND sg13cmos5l_antennanp
XFILLER_34_148 VPWR VGND sg13cmos5l_fill_1
XANTENNA__0603__GATE Tile_X0Y1_FrameStrobe[0] VPWR VGND sg13cmos5l_antennanp
XANTENNA__0617__CLK Tile_X0Y1_UserCLK VPWR VGND sg13cmos5l_antennanp
XANTENNA__1139__A1 Tile_X0Y1_EE4END[14] VPWR VGND sg13cmos5l_antennanp
X_0713_ _0978_/A3 VPWR VGND sg13cmos5l_tielo
X_0644_ _0644_/Q Tile_X0Y1_UserCLK NPU_ACT_RDATA0 _0671_/L_HI VPWR VGND sg13cmos5l_dfrbpq_1
XFILLER_25_0 VPWR VGND sg13cmos5l_decap_4
X_0575_ _0575_/Q Tile_X0Y1_FrameData[27] VGND VPWR Tile_X0Y1_FrameStrobe[7] latch
XANTENNA__0286__D Tile_X0Y0_FrameData[30] VPWR VGND sg13cmos5l_antennanp
XANTENNA__0864__A Tile_X0Y0_FrameData[8] VPWR VGND sg13cmos5l_antennanp
X_1058_ _1058_/X _0639_/Q _0643_/Q _1087_/X _1096_/X _0212_/Q _0211_/Q VPWR VGND sg13cmos5l_mux4_1
X_1127_ _1127_/X Tile_X0Y1_E2MID[7] Tile_X0Y1_E2END[7] Tile_X0Y1_E6END[8] _1195_/X
+ _0558_/Q _0557_/Q VPWR VGND sg13cmos5l_mux4_1
XANTENNA__1090__A3 Tile_X0Y0_S4END[2] VPWR VGND sg13cmos5l_antennanp
XANTENNA__0196__D Tile_X0Y0_FrameData[24] VPWR VGND sg13cmos5l_antennanp
XFILLER_56_45 VPWR VGND sg13cmos5l_fill_2
XANTENNA__1066__A0 Tile_X0Y1_N4END[7] VPWR VGND sg13cmos5l_antennanp
XANTENNA__1081__A3 Tile_X0Y0_S4END[2] VPWR VGND sg13cmos5l_antennanp
X_0360_ _0360_/Q Tile_X0Y1_FrameData[18] VGND VPWR Tile_X0Y1_FrameStrobe[0] latch
X_0291_ _0291_/Q Tile_X0Y0_FrameData[25] VGND VPWR Tile_X0Y1_FrameStrobe[6] latch
XANTENNA__0542__GATE Tile_X0Y1_FrameStrobe[6] VPWR VGND sg13cmos5l_antennanp
XANTENNA__0971__X Tile_X0Y1_WW4BEG[14] VPWR VGND sg13cmos5l_antennanp
XANTENNA__0557__GATE Tile_X0Y1_FrameStrobe[6] VPWR VGND sg13cmos5l_antennanp
XFILLER_7_50 VPWR VGND sg13cmos5l_fill_1
XANTENNA__0859__A Tile_X0Y0_FrameData[3] VPWR VGND sg13cmos5l_antennanp
X_0627_ NPU_ACT_ADDR1 Tile_X0Y1_UserCLK _0974_/X _0684_/L_HI VPWR VGND sg13cmos5l_dfrbpq_1
X_0558_ _0558_/Q Tile_X0Y1_FrameData[12] VGND VPWR Tile_X0Y1_FrameStrobe[6] latch
XFILLER_89_118 VPWR VGND sg13cmos5l_decap_8
X_0489_ _0489_/Q Tile_X0Y1_FrameData[17] VGND VPWR Tile_X0Y1_FrameStrobe[4] latch
XFILLER_97_162 VPWR VGND sg13cmos5l_fill_2
XANTENNA__0881__X Tile_X0Y0_FrameData_O[25] VPWR VGND sg13cmos5l_antennanp
XANTENNA__1220__A0 Tile_X0Y0_E2MID[6] VPWR VGND sg13cmos5l_antennanp
XFILLER_101_4 VPWR VGND sg13cmos5l_fill_2
XFILLER_88_151 VPWR VGND sg13cmos5l_fill_1
XANTENNA__0791__X Tile_X0Y0_N2BEG[0] VPWR VGND sg13cmos5l_antennanp
XANTENNA__1039__A0 Tile_X0Y0_EE4END[6] VPWR VGND sg13cmos5l_antennanp
XANTENNA__1211__A0 Tile_X0Y1_N1END[0] VPWR VGND sg13cmos5l_antennanp
X_0412_ _0412_/Q Tile_X0Y1_FrameData[30] VGND VPWR Tile_X0Y1_FrameStrobe[2] latch
XANTENNA__0481__GATE Tile_X0Y1_FrameStrobe[4] VPWR VGND sg13cmos5l_antennanp
XANTENNA__0966__X Tile_X0Y1_WW4BEG[9] VPWR VGND sg13cmos5l_antennanp
X_0343_ _0343_/Q Tile_X0Y0_FrameData[5] VGND VPWR Tile_X0Y1_FrameStrobe[7] latch
X_0274_ _0274_/Q Tile_X0Y0_FrameData[10] VGND VPWR Tile_X0Y1_FrameStrobe[5] latch
XANTENNA__0496__GATE Tile_X0Y1_FrameStrobe[4] VPWR VGND sg13cmos5l_antennanp
XANTENNA__0564__D Tile_X0Y1_FrameData[6] VPWR VGND sg13cmos5l_antennanp
XFILLER_92_0 VPWR VGND sg13cmos5l_fill_1
XANTENNA__1202__A0 Tile_X0Y1_N2MID[7] VPWR VGND sg13cmos5l_antennanp
XANTENNA__0434__GATE Tile_X0Y1_FrameStrobe[2] VPWR VGND sg13cmos5l_antennanp
XANTENNA__0876__X Tile_X0Y0_FrameData_O[20] VPWR VGND sg13cmos5l_antennanp
XANTENNA__0449__GATE Tile_X0Y1_FrameStrobe[3] VPWR VGND sg13cmos5l_antennanp
XANTENNA__0474__D Tile_X0Y1_FrameData[0] VPWR VGND sg13cmos5l_antennanp
XFILLER_118_83 VPWR VGND sg13cmos5l_fill_1
XANTENNA__0649__D NPU_ACT_RDATA5 VPWR VGND sg13cmos5l_antennanp
XANTENNA__0786__X Tile_X0Y0_N2BEGb[3] VPWR VGND sg13cmos5l_antennanp
XFILLER_76_143 VPWR VGND sg13cmos5l_fill_2
XFILLER_76_121 VPWR VGND sg13cmos5l_fill_2
XANTENNA__0384__D Tile_X0Y1_FrameData[26] VPWR VGND sg13cmos5l_antennanp
X_0961_ Tile_X0Y1_WW4BEG[4] _1167_/X VPWR VGND sg13cmos5l_buf_1
XFILLER_91_179 VPWR VGND sg13cmos5l_fill_1
X_0892_ Tile_X0Y1_S2BEG[0] _1127_/X VPWR VGND sg13cmos5l_buf_1
XANTENNA__0559__D Tile_X0Y1_FrameData[11] VPWR VGND sg13cmos5l_antennanp
XANTENNA__0294__D Tile_X0Y0_FrameData[22] VPWR VGND sg13cmos5l_antennanp
XFILLER_67_165 VPWR VGND sg13cmos5l_fill_1
X_0326_ _0326_/Q Tile_X0Y0_FrameData[22] VGND VPWR Tile_X0Y1_FrameStrobe[7] latch
X_0257_ _0257_/Q Tile_X0Y0_FrameData[27] VGND VPWR Tile_X0Y1_FrameStrobe[5] latch
X_0188_ _0188_/Q Tile_X0Y0_FrameData[0] VGND VPWR Tile_X0Y1_FrameStrobe[2] latch
XFILLER_82_124 VPWR VGND sg13cmos5l_decap_4
XANTENNA__0872__A Tile_X0Y0_FrameData[16] VPWR VGND sg13cmos5l_antennanp
XANTENNA__0373__GATE Tile_X0Y1_FrameStrobe[0] VPWR VGND sg13cmos5l_antennanp
XANTENNA__0388__GATE Tile_X0Y1_FrameStrobe[1] VPWR VGND sg13cmos5l_antennanp
XANTENNA__0469__D Tile_X0Y1_FrameData[5] VPWR VGND sg13cmos5l_antennanp
XFILLER_64_12 VPWR VGND sg13cmos5l_fill_2
XANTENNA__0311__GATE Tile_X0Y1_FrameStrobe[6] VPWR VGND sg13cmos5l_antennanp
XFILLER_104_85 VPWR VGND sg13cmos5l_fill_1
XFILLER_64_34 VPWR VGND sg13cmos5l_fill_1
XFILLER_64_45 VPWR VGND sg13cmos5l_fill_2
XFILLER_73_179 VPWR VGND sg13cmos5l_fill_1
XANTENNA__0326__GATE Tile_X0Y1_FrameStrobe[7] VPWR VGND sg13cmos5l_antennanp
XANTENNA__0650__CLK Tile_X0Y1_UserCLK VPWR VGND sg13cmos5l_antennanp
XANTENNA__0379__D Tile_X0Y1_FrameData[31] VPWR VGND sg13cmos5l_antennanp
X_1091_ _1091_/X _1114_/X Tile_X0Y1_N4END[7] Tile_X0Y0_S1END[3] Tile_X0Y0_S4END[3]
+ _0142_/Q _0141_/Q VPWR VGND sg13cmos5l_mux4_1
X_1160_ _1160_/X _0649_/Q _1197_/X _1200_/X _1194_/X _0496_/Q _0495_/Q VPWR VGND sg13cmos5l_mux4_1
X_0111_ _0111_/Q Tile_X0Y0_FrameData[13] VGND VPWR Tile_X0Y1_FrameStrobe[0] latch
X_0944_ Tile_X0Y1_W2BEGb[7] _1162_/X VPWR VGND sg13cmos5l_buf_1
XFILLER_55_0 VPWR VGND sg13cmos5l_fill_1
X_0875_ Tile_X0Y0_FrameData_O[19] Tile_X0Y0_FrameData[19] VPWR VGND sg13cmos5l_buf_1
XANTENNA__0289__D Tile_X0Y0_FrameData[27] VPWR VGND sg13cmos5l_antennanp
XANTENNA__0867__A Tile_X0Y0_FrameData[11] VPWR VGND sg13cmos5l_antennanp
XANTENNA__0998__A2 Tile_X0Y0_E6END[3] VPWR VGND sg13cmos5l_antennanp
XFILLER_55_179 VPWR VGND sg13cmos5l_fill_1
X_0309_ _0309_/Q Tile_X0Y0_FrameData[7] VGND VPWR Tile_X0Y1_FrameStrobe[6] latch
XFILLER_50_69 VPWR VGND sg13cmos5l_fill_2
XANTENNA__0199__D Tile_X0Y0_FrameData[21] VPWR VGND sg13cmos5l_antennanp
XFILLER_117_170 VPWR VGND sg13cmos5l_fill_1
XANTENNA__0250__GATE Tile_X0Y1_FrameStrobe[4] VPWR VGND sg13cmos5l_antennanp
XFILLER_46_124 VPWR VGND sg13cmos5l_fill_1
XANTENNA__0265__GATE Tile_X0Y1_FrameStrobe[5] VPWR VGND sg13cmos5l_antennanp
XANTENNA__0989__A2 Tile_X0Y1_E6END[7] VPWR VGND sg13cmos5l_antennanp
X_0660_ _0660_/L_HI VPWR VGND sg13cmos5l_tiehi
X_0591_ _0591_/Q Tile_X0Y1_FrameData[11] VGND VPWR Tile_X0Y1_FrameStrobe[7] latch
XANTENNA__0203__GATE Tile_X0Y1_FrameStrobe[3] VPWR VGND sg13cmos5l_antennanp
X_1212_ _1212_/X Tile_X0Y1_N1END[1] Tile_X0Y1_N4END[1] _1228_/X Tile_X0Y0_S4END[5]
+ _0384_/Q _0383_/Q VPWR VGND sg13cmos5l_mux4_1
XANTENNA__0218__GATE Tile_X0Y1_FrameStrobe[3] VPWR VGND sg13cmos5l_antennanp
X_1074_ _1074_/X _0639_/Q _1088_/X _1087_/X _1099_/X _0180_/Q _0179_/Q VPWR VGND sg13cmos5l_mux4_1
X_1143_ _1143_/X Tile_X0Y1_N1END[0] _1227_/X _0646_/Q _0651_/Q _0530_/Q _0529_/Q VPWR
+ VGND sg13cmos5l_mux4_1
XANTENNA__0572__D Tile_X0Y1_FrameData[30] VPWR VGND sg13cmos5l_antennanp
X_0927_ Tile_X0Y1_W1BEG[2] _1145_/X VPWR VGND sg13cmos5l_buf_1
X_0858_ Tile_X0Y0_FrameData_O[2] Tile_X0Y0_FrameData[2] VPWR VGND sg13cmos5l_buf_1
X_0789_ Tile_X0Y0_N2BEGb[6] _1109_/X VPWR VGND sg13cmos5l_buf_1
XANTENNA__0884__X Tile_X0Y0_FrameData_O[28] VPWR VGND sg13cmos5l_antennanp
XFILLER_45_14 VPWR VGND sg13cmos5l_fill_1
XANTENNA__0482__D Tile_X0Y1_FrameData[24] VPWR VGND sg13cmos5l_antennanp
XANTENNA__1093__A1 Tile_X0Y1_N2MID[1] VPWR VGND sg13cmos5l_antennanp
XFILLER_43_127 VPWR VGND sg13cmos5l_fill_2
XFILLER_105_140 VPWR VGND sg13cmos5l_fill_2
XFILLER_105_151 VPWR VGND sg13cmos5l_fill_2
XFILLER_10_94 VPWR VGND sg13cmos5l_decap_8
XANTENNA__0794__X Tile_X0Y0_N2BEG[3] VPWR VGND sg13cmos5l_antennanp
XFILLER_19_179 VPWR VGND sg13cmos5l_fill_1
XANTENNA__0392__D Tile_X0Y1_FrameData[18] VPWR VGND sg13cmos5l_antennanp
XANTENNA__1084__A1 Tile_X0Y1_N4END[7] VPWR VGND sg13cmos5l_antennanp
XFILLER_35_91 VPWR VGND sg13cmos5l_fill_1
XANTENNA__0142__GATE Tile_X0Y1_FrameStrobe[1] VPWR VGND sg13cmos5l_antennanp
XANTENNA__0969__X Tile_X0Y1_WW4BEG[12] VPWR VGND sg13cmos5l_antennanp
XANTENNA__1139__A2 Tile_X0Y1_E6END[6] VPWR VGND sg13cmos5l_antennanp
X_0712_ _1191_/A3 VPWR VGND sg13cmos5l_tielo
X_0643_ _0643_/Q Tile_X0Y1_UserCLK NPU_OUT_ACT7 _0673_/L_HI VPWR VGND sg13cmos5l_dfrbpq_1
X_0574_ _0574_/Q Tile_X0Y1_FrameData[28] VGND VPWR Tile_X0Y1_FrameStrobe[7] latch
XANTENNA__0157__GATE Tile_X0Y1_FrameStrobe[2] VPWR VGND sg13cmos5l_antennanp
XANTENNA__0567__D Tile_X0Y1_FrameData[3] VPWR VGND sg13cmos5l_antennanp
XFILLER_18_0 VPWR VGND sg13cmos5l_decap_4
X_1126_ _1126_/X Tile_X0Y1_E1END[3] Tile_X0Y1_E6END[11] _1218_/X _1194_/X _0560_/Q
+ _0559_/Q VPWR VGND sg13cmos5l_mux4_1
XANTENNA__0880__A Tile_X0Y0_FrameData[24] VPWR VGND sg13cmos5l_antennanp
XANTENNA__1075__A1 Tile_X0Y1_N4END[4] VPWR VGND sg13cmos5l_antennanp
X_1057_ _1057_/X _0638_/Q _0642_/Q _1086_/X _1097_/X _0214_/Q _0213_/Q VPWR VGND sg13cmos5l_mux4_1
XANTENNA__0879__X Tile_X0Y0_FrameData_O[23] VPWR VGND sg13cmos5l_antennanp
XFILLER_56_13 VPWR VGND sg13cmos5l_fill_2
XANTENNA__0477__D Tile_X0Y1_FrameData[29] VPWR VGND sg13cmos5l_antennanp
XFILLER_56_68 VPWR VGND sg13cmos5l_fill_1
XANTENNA__1066__A1 Tile_X0Y0_S4END[3] VPWR VGND sg13cmos5l_antennanp
XFILLER_72_56 VPWR VGND sg13cmos5l_decap_8
XANTENNA__0789__X Tile_X0Y0_N2BEGb[6] VPWR VGND sg13cmos5l_antennanp
XFILLER_21_71 VPWR VGND sg13cmos5l_fill_2
XFILLER_98_119 VPWR VGND sg13cmos5l_decap_4
XANTENNA__0387__D Tile_X0Y1_FrameData[23] VPWR VGND sg13cmos5l_antennanp
X_0290_ _0290_/Q Tile_X0Y0_FrameData[26] VGND VPWR Tile_X0Y1_FrameStrobe[6] latch
XANTENNA__0096__GATE Tile_X0Y1_FrameStrobe[0] VPWR VGND sg13cmos5l_antennanp
X_0626_ NPU_ACT_ADDR0 Tile_X0Y1_UserCLK _0973_/X _0685_/L_HI VPWR VGND sg13cmos5l_dfrbpq_1
X_0557_ _0557_/Q Tile_X0Y1_FrameData[13] VGND VPWR Tile_X0Y1_FrameStrobe[6] latch
XFILLER_89_108 VPWR VGND sg13cmos5l_fill_1
XANTENNA__0297__D Tile_X0Y0_FrameData[19] VPWR VGND sg13cmos5l_antennanp
XANTENNA__0875__A Tile_X0Y0_FrameData[19] VPWR VGND sg13cmos5l_antennanp
XFILLER_26_49 VPWR VGND sg13cmos5l_decap_8
X_1109_ _1109_/X Tile_X0Y1_E2MID[1] Tile_X0Y1_E2END[1] Tile_X0Y1_E6END[1] _1201_/X
+ _0582_/Q _0581_/Q VPWR VGND sg13cmos5l_mux4_1
X_0488_ _0488_/Q Tile_X0Y1_FrameData[18] VGND VPWR Tile_X0Y1_FrameStrobe[4] latch
XANTENNA__1220__A1 Tile_X0Y0_E2END[6] VPWR VGND sg13cmos5l_antennanp
XANTENNA__0602__GATE Tile_X0Y1_FrameStrobe[7] VPWR VGND sg13cmos5l_antennanp
XFILLER_107_85 VPWR VGND sg13cmos5l_fill_1
XFILLER_83_99 VPWR VGND sg13cmos5l_decap_8
XFILLER_83_55 VPWR VGND sg13cmos5l_fill_1
XANTENNA__1211__A1 Tile_X0Y1_N4END[0] VPWR VGND sg13cmos5l_antennanp
XFILLER_8_178 VPWR VGND sg13cmos5l_fill_2
XFILLER_8_123 VPWR VGND sg13cmos5l_fill_2
X_0411_ _0411_/Q Tile_X0Y1_FrameData[31] VGND VPWR Tile_X0Y1_FrameStrobe[2] latch
X_0342_ _0342_/Q Tile_X0Y0_FrameData[6] VGND VPWR Tile_X0Y1_FrameStrobe[7] latch
X_0273_ _0273_/Q Tile_X0Y0_FrameData[11] VGND VPWR Tile_X0Y1_FrameStrobe[5] latch
XFILLER_94_111 VPWR VGND sg13cmos5l_fill_2
XFILLER_85_0 VPWR VGND sg13cmos5l_decap_4
XANTENNA__0580__D Tile_X0Y1_FrameData[22] VPWR VGND sg13cmos5l_antennanp
XANTENNA__1202__A1 Tile_X0Y1_N2END[7] VPWR VGND sg13cmos5l_antennanp
X_0609_ _0609_/Q Tile_X0Y1_FrameData[31] VGND VPWR Tile_X0Y1_FrameStrobe[8] latch
XFILLER_85_100 VPWR VGND sg13cmos5l_fill_2
XANTENNA__0892__X Tile_X0Y1_S2BEG[0] VPWR VGND sg13cmos5l_antennanp
XFILLER_53_47 VPWR VGND sg13cmos5l_decap_8
XANTENNA__0490__D Tile_X0Y1_FrameData[16] VPWR VGND sg13cmos5l_antennanp
XANTENNA__0541__GATE Tile_X0Y1_FrameStrobe[6] VPWR VGND sg13cmos5l_antennanp
XFILLER_118_73 VPWR VGND sg13cmos5l_fill_1
XFILLER_78_22 VPWR VGND sg13cmos5l_decap_4
XANTENNA__0556__GATE Tile_X0Y1_FrameStrobe[6] VPWR VGND sg13cmos5l_antennanp
XFILLER_94_43 VPWR VGND sg13cmos5l_decap_4
X_0960_ Tile_X0Y1_WW4BEG[3] _1166_/X VPWR VGND sg13cmos5l_buf_1
XANTENNA__0509__GATE Tile_X0Y1_FrameStrobe[5] VPWR VGND sg13cmos5l_antennanp
XANTENNA__1196__A0 Tile_X0Y1_N2MID[1] VPWR VGND sg13cmos5l_antennanp
X_0891_ Tile_X0Y1_S1BEG[3] _1126_/X VPWR VGND sg13cmos5l_buf_1
XFILLER_4_170 VPWR VGND sg13cmos5l_fill_1
X_0325_ _0325_/Q Tile_X0Y0_FrameData[23] VGND VPWR Tile_X0Y1_FrameStrobe[7] latch
XANTENNA__0575__D Tile_X0Y1_FrameData[27] VPWR VGND sg13cmos5l_antennanp
X_0256_ _0256_/Q Tile_X0Y0_FrameData[28] VGND VPWR Tile_X0Y1_FrameStrobe[5] latch
X_0187_ _0187_/Q Tile_X0Y0_FrameData[1] VGND VPWR Tile_X0Y1_FrameStrobe[2] latch
XANTENNA__0887__X Tile_X0Y0_FrameData_O[31] VPWR VGND sg13cmos5l_antennanp
XFILLER_2_118 VPWR VGND sg13cmos5l_fill_1
XANTENNA__0485__D Tile_X0Y1_FrameData[21] VPWR VGND sg13cmos5l_antennanp
XFILLER_58_111 VPWR VGND sg13cmos5l_fill_2
XFILLER_73_103 VPWR VGND sg13cmos5l_decap_8
XFILLER_73_114 VPWR VGND sg13cmos5l_fill_1
XANTENNA__1111__A0 Tile_X0Y1_E1END[0] VPWR VGND sg13cmos5l_antennanp
XFILLER_9_19 VPWR VGND sg13cmos5l_fill_1
XANTENNA__0480__GATE Tile_X0Y1_FrameStrobe[4] VPWR VGND sg13cmos5l_antennanp
XANTENNA__0495__GATE Tile_X0Y1_FrameStrobe[4] VPWR VGND sg13cmos5l_antennanp
XANTENNA__0797__X Tile_X0Y0_N2BEG[6] VPWR VGND sg13cmos5l_antennanp
XFILLER_36_9 VPWR VGND sg13cmos5l_fill_1
XANTENNA__0395__D Tile_X0Y1_FrameData[15] VPWR VGND sg13cmos5l_antennanp
XFILLER_64_114 VPWR VGND sg13cmos5l_decap_8
X_1090_ _1090_/X _1113_/X Tile_X0Y1_N4END[6] Tile_X0Y0_S1END[2] Tile_X0Y0_S4END[2]
+ _0144_/Q _0143_/Q VPWR VGND sg13cmos5l_mux4_1
X_0110_ _0110_/Q Tile_X0Y0_FrameData[14] VGND VPWR Tile_X0Y1_FrameStrobe[0] latch
XANTENNA__0433__GATE Tile_X0Y1_FrameStrobe[2] VPWR VGND sg13cmos5l_antennanp
X_0874_ Tile_X0Y0_FrameData_O[18] Tile_X0Y0_FrameData[18] VPWR VGND sg13cmos5l_buf_1
X_0943_ Tile_X0Y1_W2BEGb[6] _1161_/X VPWR VGND sg13cmos5l_buf_1
XANTENNA__0448__GATE Tile_X0Y1_FrameStrobe[3] VPWR VGND sg13cmos5l_antennanp
XFILLER_118_149 VPWR VGND sg13cmos5l_fill_1
X_0308_ _0308_/Q Tile_X0Y0_FrameData[8] VGND VPWR Tile_X0Y1_FrameStrobe[6] latch
XANTENNA__0883__A Tile_X0Y0_FrameData[27] VPWR VGND sg13cmos5l_antennanp
XFILLER_34_27 VPWR VGND sg13cmos5l_decap_8
X_0239_ _0239_/Q Tile_X0Y0_FrameData[13] VGND VPWR Tile_X0Y1_FrameStrobe[4] latch
XFILLER_109_149 VPWR VGND sg13cmos5l_fill_1
XFILLER_115_41 VPWR VGND sg13cmos5l_fill_1
XFILLER_115_74 VPWR VGND sg13cmos5l_fill_2
XFILLER_115_85 VPWR VGND sg13cmos5l_fill_2
XFILLER_24_82 VPWR VGND sg13cmos5l_fill_2
XFILLER_91_66 VPWR VGND sg13cmos5l_decap_4
X_0590_ _0590_/Q Tile_X0Y1_FrameData[12] VGND VPWR Tile_X0Y1_FrameStrobe[7] latch
XFILLER_49_90 VPWR VGND sg13cmos5l_fill_2
X_1211_ _1211_/X Tile_X0Y1_N1END[0] Tile_X0Y1_N4END[0] _1227_/X Tile_X0Y0_S4END[4]
+ _0386_/Q _0385_/Q VPWR VGND sg13cmos5l_mux4_1
X_1142_ _1142_/X _1210_/X _1214_/X _1218_/X _1202_/X _0533_/Q _0532_/Q VPWR VGND sg13cmos5l_mux4_1
XANTENNA__0372__GATE Tile_X0Y1_FrameStrobe[0] VPWR VGND sg13cmos5l_antennanp
X_1073_ _1073_/X _0638_/Q _1089_/X _1086_/X _1098_/X _0182_/Q _0181_/Q VPWR VGND sg13cmos5l_mux4_1
XANTENNA__0387__GATE Tile_X0Y1_FrameStrobe[1] VPWR VGND sg13cmos5l_antennanp
XFILLER_20_18 VPWR VGND sg13cmos5l_fill_1
X_0857_ Tile_X0Y0_FrameData_O[1] Tile_X0Y0_FrameData[1] VPWR VGND sg13cmos5l_buf_1
X_0926_ Tile_X0Y1_W1BEG[1] _1144_/X VPWR VGND sg13cmos5l_buf_1
XANTENNA__0310__GATE Tile_X0Y1_FrameStrobe[6] VPWR VGND sg13cmos5l_antennanp
XANTENNA__0878__A Tile_X0Y0_FrameData[22] VPWR VGND sg13cmos5l_antennanp
X_0788_ Tile_X0Y0_N2BEGb[5] _1108_/X VPWR VGND sg13cmos5l_buf_1
XANTENNA__0325__GATE Tile_X0Y1_FrameStrobe[7] VPWR VGND sg13cmos5l_antennanp
XANTENNA__0640__CLK Tile_X0Y1_UserCLK VPWR VGND sg13cmos5l_antennanp
XANTENNA__1093__A2 Tile_X0Y0_S2MID[1] VPWR VGND sg13cmos5l_antennanp
XFILLER_101_76 VPWR VGND sg13cmos5l_fill_2
XFILLER_86_11 VPWR VGND sg13cmos5l_fill_2
XANTENNA__1084__A2 Tile_X0Y0_S1END[3] VPWR VGND sg13cmos5l_antennanp
X_0711_ _0980_/A3 VPWR VGND sg13cmos5l_tielo
X_0642_ _0642_/Q Tile_X0Y1_UserCLK NPU_OUT_ACT6 _0674_/L_HI VPWR VGND sg13cmos5l_dfrbpq_1
X_0573_ _0573_/Q Tile_X0Y1_FrameData[29] VGND VPWR Tile_X0Y1_FrameStrobe[7] latch
X_1125_ _1125_/X Tile_X0Y1_E1END[2] Tile_X0Y1_E6END[10] _1217_/X _1193_/X _0562_/Q
+ _0561_/Q VPWR VGND sg13cmos5l_mux4_1
XANTENNA__0583__D Tile_X0Y1_FrameData[19] VPWR VGND sg13cmos5l_antennanp
XANTENNA__1075__A2 Tile_X0Y0_S1END[0] VPWR VGND sg13cmos5l_antennanp
X_1056_ _1056_/X _0637_/Q _0641_/Q _1085_/X _1098_/X _0216_/Q _0215_/Q VPWR VGND sg13cmos5l_mux4_1
XFILLER_103_9 VPWR VGND sg13cmos5l_fill_2
X_0909_ Tile_X0Y1_S4BEG[1] Tile_X0Y0_S4END[9] VPWR VGND sg13cmos5l_buf_1
XANTENNA__0264__GATE Tile_X0Y1_FrameStrobe[5] VPWR VGND sg13cmos5l_antennanp
XANTENNA__0895__X Tile_X0Y1_S2BEG[3] VPWR VGND sg13cmos5l_antennanp
XANTENNA__0279__GATE Tile_X0Y1_FrameStrobe[5] VPWR VGND sg13cmos5l_antennanp
XANTENNA__0493__D Tile_X0Y1_FrameData[13] VPWR VGND sg13cmos5l_antennanp
XFILLER_112_31 VPWR VGND sg13cmos5l_fill_2
XFILLER_72_35 VPWR VGND sg13cmos5l_decap_8
XANTENNA__0202__GATE Tile_X0Y1_FrameStrobe[3] VPWR VGND sg13cmos5l_antennanp
XANTENNA__0217__GATE Tile_X0Y1_FrameStrobe[3] VPWR VGND sg13cmos5l_antennanp
XFILLER_21_83 VPWR VGND sg13cmos5l_fill_1
XFILLER_15_150 VPWR VGND sg13cmos5l_fill_2
XFILLER_30_120 VPWR VGND sg13cmos5l_fill_2
XFILLER_46_80 VPWR VGND sg13cmos5l_fill_1
X_0625_ NPU_ACT_WDATA7 Tile_X0Y1_UserCLK _0989_/X _0690_/L_HI VPWR VGND sg13cmos5l_dfrbpq_1
XFILLER_7_41 VPWR VGND sg13cmos5l_fill_2
XANTENNA__0578__D Tile_X0Y1_FrameData[24] VPWR VGND sg13cmos5l_antennanp
XFILLER_30_0 VPWR VGND sg13cmos5l_fill_1
X_0556_ _0556_/Q Tile_X0Y1_FrameData[14] VGND VPWR Tile_X0Y1_FrameStrobe[6] latch
X_0487_ _0487_/Q Tile_X0Y1_FrameData[19] VGND VPWR Tile_X0Y1_FrameStrobe[4] latch
X_1039_ _1039_/X Tile_X0Y0_EE4END[6] _0636_/Q _1092_/X _1099_/X _0250_/Q _0249_/Q
+ VPWR VGND sg13cmos5l_mux4_1
X_1108_ _1108_/X Tile_X0Y1_E2MID[2] Tile_X0Y1_E2END[2] Tile_X0Y1_E6END[2] _1200_/X
+ _0584_/Q _0583_/Q VPWR VGND sg13cmos5l_mux4_1
XANTENNA__1220__A2 Tile_X0Y0_E6END[9] VPWR VGND sg13cmos5l_antennanp
XFILLER_107_31 VPWR VGND sg13cmos5l_decap_4
XANTENNA__0089__CLK Tile_X0Y1_UserCLK VPWR VGND sg13cmos5l_antennanp
XANTENNA__0488__D Tile_X0Y1_FrameData[18] VPWR VGND sg13cmos5l_antennanp
XANTENNA__0141__GATE Tile_X0Y1_FrameStrobe[1] VPWR VGND sg13cmos5l_antennanp
XANTENNA__0156__GATE Tile_X0Y1_FrameStrobe[1] VPWR VGND sg13cmos5l_antennanp
XANTENNA__0398__D Tile_X0Y1_FrameData[12] VPWR VGND sg13cmos5l_antennanp
X_0410_ _0410_/Q Tile_X0Y1_FrameData[0] VGND VPWR Tile_X0Y1_FrameStrobe[1] latch
X_0341_ _0341_/Q Tile_X0Y0_FrameData[7] VGND VPWR Tile_X0Y1_FrameStrobe[7] latch
XFILLER_94_101 VPWR VGND sg13cmos5l_decap_8
XANTENNA__0109__GATE Tile_X0Y1_FrameStrobe[0] VPWR VGND sg13cmos5l_antennanp
X_0272_ _0272_/Q Tile_X0Y0_FrameData[12] VGND VPWR Tile_X0Y1_FrameStrobe[5] latch
XFILLER_78_0 VPWR VGND sg13cmos5l_fill_1
X_0608_ _0608_/Q Tile_X0Y1_FrameData[30] VGND VPWR Tile_X0Y1_FrameStrobe[8] latch
XANTENNA__0101__D Tile_X0Y0_FrameData[23] VPWR VGND sg13cmos5l_antennanp
XANTENNA__0886__A Tile_X0Y0_FrameData[30] VPWR VGND sg13cmos5l_antennanp
X_0539_ _0539_/Q Tile_X0Y1_FrameData[31] VGND VPWR Tile_X0Y1_FrameStrobe[6] latch
XFILLER_85_178 VPWR VGND sg13cmos5l_fill_2
XFILLER_91_148 VPWR VGND sg13cmos5l_decap_4
XFILLER_91_126 VPWR VGND sg13cmos5l_fill_1
XFILLER_91_104 VPWR VGND sg13cmos5l_fill_1
XANTENNA__0095__GATE Tile_X0Y1_FrameStrobe[0] VPWR VGND sg13cmos5l_antennanp
X_0890_ Tile_X0Y1_S1BEG[2] _1125_/X VPWR VGND sg13cmos5l_buf_1
XANTENNA__1196__A1 Tile_X0Y1_N2END[1] VPWR VGND sg13cmos5l_antennanp
XFILLER_67_178 VPWR VGND sg13cmos5l_fill_2
X_0324_ _0324_/Q Tile_X0Y0_FrameData[24] VGND VPWR Tile_X0Y1_FrameStrobe[7] latch
X_0255_ _0255_/Q Tile_X0Y0_FrameData[29] VGND VPWR Tile_X0Y1_FrameStrobe[5] latch
X_0186_ _0186_/Q Tile_X0Y0_FrameData[2] VGND VPWR Tile_X0Y1_FrameStrobe[2] latch
XANTENNA__0591__D Tile_X0Y1_FrameData[11] VPWR VGND sg13cmos5l_antennanp
XANTENNA__0601__GATE Tile_X0Y1_FrameStrobe[7] VPWR VGND sg13cmos5l_antennanp
XFILLER_23_29 VPWR VGND sg13cmos5l_decap_8
XANTENNA__1111__A1 Tile_X0Y1_E6END[4] VPWR VGND sg13cmos5l_antennanp
XFILLER_64_47 VPWR VGND sg13cmos5l_fill_1
XFILLER_80_46 VPWR VGND sg13cmos5l_fill_1
XFILLER_80_35 VPWR VGND sg13cmos5l_decap_8
XFILLER_8_0 VPWR VGND sg13cmos5l_fill_2
XFILLER_89_22 VPWR VGND sg13cmos5l_decap_8
XANTENNA__1102__A1 Tile_X0Y0_E6END[2] VPWR VGND sg13cmos5l_antennanp
X_0873_ Tile_X0Y0_FrameData_O[17] Tile_X0Y0_FrameData[17] VPWR VGND sg13cmos5l_buf_1
X_0942_ Tile_X0Y1_W2BEGb[5] _1160_/X VPWR VGND sg13cmos5l_buf_1
XANTENNA__0586__D Tile_X0Y1_FrameData[16] VPWR VGND sg13cmos5l_antennanp
X_0307_ _0307_/Q Tile_X0Y0_FrameData[9] VGND VPWR Tile_X0Y1_FrameStrobe[6] latch
X_0238_ _0238_/Q Tile_X0Y0_FrameData[14] VGND VPWR Tile_X0Y1_FrameStrobe[4] latch
XANTENNA__0540__GATE Tile_X0Y1_FrameStrobe[6] VPWR VGND sg13cmos5l_antennanp
XFILLER_70_129 VPWR VGND sg13cmos5l_fill_1
X_0169_ _0169_/Q Tile_X0Y0_FrameData[19] VGND VPWR Tile_X0Y1_FrameStrobe[2] latch
XANTENNA__0555__GATE Tile_X0Y1_FrameStrobe[6] VPWR VGND sg13cmos5l_antennanp
XANTENNA__0898__X Tile_X0Y1_S2BEG[6] VPWR VGND sg13cmos5l_antennanp
XFILLER_117_150 VPWR VGND sg13cmos5l_fill_1
XANTENNA__0496__D Tile_X0Y1_FrameData[10] VPWR VGND sg13cmos5l_antennanp
XANTENNA__0508__GATE Tile_X0Y1_FrameStrobe[5] VPWR VGND sg13cmos5l_antennanp
XFILLER_54_170 VPWR VGND sg13cmos5l_fill_1
X_1072_ _1072_/X _0637_/Q _1090_/X _1085_/X _1097_/X _0184_/Q _0183_/Q VPWR VGND sg13cmos5l_mux4_1
X_1210_ _1210_/X Tile_X0Y1_N1END[3] Tile_X0Y1_N4END[3] _1230_/X Tile_X0Y0_S4END[7]
+ _0388_/Q _0387_/Q VPWR VGND sg13cmos5l_mux4_1
X_1141_ _1141_/X Tile_X0Y1_E1END[3] Tile_X0Y1_EE4END[15] Tile_X0Y1_E6END[7] _1206_/X
+ _0533_/Q _0532_/Q VPWR VGND sg13cmos5l_mux4_1
XANTENNA__1011__A0 Tile_X0Y0_E1END[0] VPWR VGND sg13cmos5l_antennanp
XFILLER_60_0 VPWR VGND sg13cmos5l_fill_1
X_0856_ Tile_X0Y0_FrameData_O[0] Tile_X0Y0_FrameData[0] VPWR VGND sg13cmos5l_buf_1
X_0925_ Tile_X0Y1_W1BEG[0] _1143_/X VPWR VGND sg13cmos5l_buf_1
X_0787_ Tile_X0Y0_N2BEGb[4] _1107_/X VPWR VGND sg13cmos5l_buf_1
XFILLER_29_17 VPWR VGND sg13cmos5l_fill_2
XANTENNA__0494__GATE Tile_X0Y1_FrameStrobe[4] VPWR VGND sg13cmos5l_antennanp
XANTENNA__1093__A3 Tile_X0Y0_S2END[1] VPWR VGND sg13cmos5l_antennanp
XANTENNA__1002__A0 Tile_X0Y0_E1END[3] VPWR VGND sg13cmos5l_antennanp
XFILLER_10_30 VPWR VGND sg13cmos5l_fill_2
XANTENNA__0432__GATE Tile_X0Y1_FrameStrobe[2] VPWR VGND sg13cmos5l_antennanp
XFILLER_86_89 VPWR VGND sg13cmos5l_fill_2
XFILLER_86_67 VPWR VGND sg13cmos5l_fill_1
XANTENNA__0447__GATE Tile_X0Y1_FrameStrobe[3] VPWR VGND sg13cmos5l_antennanp
XANTENNA__1084__A3 Tile_X0Y0_S4END[3] VPWR VGND sg13cmos5l_antennanp
XFILLER_34_118 VPWR VGND sg13cmos5l_fill_2
XFILLER_35_60 VPWR VGND sg13cmos5l_fill_2
XFILLER_35_82 VPWR VGND sg13cmos5l_decap_8
X_0710_ _0979_/A3 VPWR VGND sg13cmos5l_tielo
X_0641_ _0641_/Q Tile_X0Y1_UserCLK NPU_OUT_ACT5 _0672_/L_HI VPWR VGND sg13cmos5l_dfrbpq_1
XFILLER_111_101 VPWR VGND sg13cmos5l_fill_2
XFILLER_111_145 VPWR VGND sg13cmos5l_fill_2
X_0572_ _0572_/Q Tile_X0Y1_FrameData[30] VGND VPWR Tile_X0Y1_FrameStrobe[7] latch
X_1055_ _1055_/X _0636_/Q _0640_/Q _1084_/X _1099_/X _0218_/Q _0217_/Q VPWR VGND sg13cmos5l_mux4_1
X_1124_ _1124_/X Tile_X0Y1_E1END[1] Tile_X0Y1_E6END[9] _1216_/X _1192_/X _0564_/Q
+ _0563_/Q VPWR VGND sg13cmos5l_mux4_1
XANTENNA__1075__A3 Tile_X0Y0_S4END[0] VPWR VGND sg13cmos5l_antennanp
XANTENNA__1232__A0 Tile_X0Y0_EE4END[1] VPWR VGND sg13cmos5l_antennanp
XFILLER_31_18 VPWR VGND sg13cmos5l_decap_8
XANTENNA__0104__D Tile_X0Y0_FrameData[20] VPWR VGND sg13cmos5l_antennanp
X_0908_ Tile_X0Y1_S4BEG[0] Tile_X0Y0_S4END[8] VPWR VGND sg13cmos5l_buf_1
X_0839_ Tile_X0Y1_FrameData_O[15] Tile_X0Y1_FrameData[15] VPWR VGND sg13cmos5l_buf_1
XFILLER_102_178 VPWR VGND sg13cmos5l_fill_2
XFILLER_56_59 VPWR VGND sg13cmos5l_fill_1
XFILLER_112_87 VPWR VGND sg13cmos5l_fill_1
XANTENNA__1223__A0 Tile_X0Y0_E1END[0] VPWR VGND sg13cmos5l_antennanp
XFILLER_21_62 VPWR VGND sg13cmos5l_fill_2
XANTENNA__0371__GATE Tile_X0Y1_FrameStrobe[0] VPWR VGND sg13cmos5l_antennanp
XFILLER_108_0 VPWR VGND sg13cmos5l_fill_2
XFILLER_21_95 VPWR VGND sg13cmos5l_decap_4
XANTENNA__0386__GATE Tile_X0Y1_FrameStrobe[1] VPWR VGND sg13cmos5l_antennanp
XANTENNA__1214__A0 Tile_X0Y1_N1END[3] VPWR VGND sg13cmos5l_antennanp
XANTENNA__0324__GATE Tile_X0Y1_FrameStrobe[7] VPWR VGND sg13cmos5l_antennanp
XANTENNA__0630__CLK Tile_X0Y1_UserCLK VPWR VGND sg13cmos5l_antennanp
X_0624_ NPU_ACT_WDATA6 Tile_X0Y1_UserCLK _0988_/X _0691_/L_HI VPWR VGND sg13cmos5l_dfrbpq_1
XANTENNA__0339__GATE Tile_X0Y1_FrameStrobe[7] VPWR VGND sg13cmos5l_antennanp
XFILLER_23_0 VPWR VGND sg13cmos5l_fill_2
X_0555_ _0555_/Q Tile_X0Y1_FrameData[15] VGND VPWR Tile_X0Y1_FrameStrobe[6] latch
X_0486_ _0486_/Q Tile_X0Y1_FrameData[20] VGND VPWR Tile_X0Y1_FrameStrobe[4] latch
XANTENNA__0594__D Tile_X0Y1_FrameData[8] VPWR VGND sg13cmos5l_antennanp
X_1038_ _1038_/X Tile_X0Y0_EE4END[5] _0643_/Q _1092_/X _1099_/X _0252_/Q _0251_/Q
+ VPWR VGND sg13cmos5l_mux4_1
X_1107_ _1107_/X Tile_X0Y1_E2MID[3] Tile_X0Y1_E2END[3] Tile_X0Y1_E6END[3] _1199_/X
+ _0586_/Q _0585_/Q VPWR VGND sg13cmos5l_mux4_1
XANTENNA__1205__A0 Tile_X0Y1_N1END[2] VPWR VGND sg13cmos5l_antennanp
XFILLER_83_68 VPWR VGND sg13cmos5l_fill_2
XFILLER_12_110 VPWR VGND sg13cmos5l_fill_2
XFILLER_8_136 VPWR VGND sg13cmos5l_fill_2
XANTENNA__1211__A3 Tile_X0Y0_S4END[4] VPWR VGND sg13cmos5l_antennanp
XFILLER_32_83 VPWR VGND sg13cmos5l_fill_2
X_0340_ _0340_/Q Tile_X0Y0_FrameData[8] VGND VPWR Tile_X0Y1_FrameStrobe[7] latch
X_0271_ _0271_/Q Tile_X0Y0_FrameData[13] VGND VPWR Tile_X0Y1_FrameStrobe[5] latch
XFILLER_94_113 VPWR VGND sg13cmos5l_fill_1
XFILLER_79_154 VPWR VGND sg13cmos5l_fill_1
XANTENNA__0263__GATE Tile_X0Y1_FrameStrobe[5] VPWR VGND sg13cmos5l_antennanp
XANTENNA__0278__GATE Tile_X0Y1_FrameStrobe[5] VPWR VGND sg13cmos5l_antennanp
XANTENNA__0589__D Tile_X0Y1_FrameData[13] VPWR VGND sg13cmos5l_antennanp
XANTENNA__1202__A3 Tile_X0Y0_S2MID[7] VPWR VGND sg13cmos5l_antennanp
X_0607_ _0607_/Q Tile_X0Y1_FrameData[29] VGND VPWR Tile_X0Y1_FrameStrobe[8] latch
X_0538_ _0538_/Q Tile_X0Y1_FrameData[0] VGND VPWR Tile_X0Y1_FrameStrobe[5] latch
XANTENNA__0201__GATE Tile_X0Y1_FrameStrobe[3] VPWR VGND sg13cmos5l_antennanp
XANTENNA__0216__GATE Tile_X0Y1_FrameStrobe[3] VPWR VGND sg13cmos5l_antennanp
X_0469_ _0469_/Q Tile_X0Y1_FrameData[5] VGND VPWR Tile_X0Y1_FrameStrobe[3] latch
XANTENNA__0499__D Tile_X0Y1_FrameData[7] VPWR VGND sg13cmos5l_antennanp
XFILLER_76_102 VPWR VGND sg13cmos5l_decap_8
XFILLER_76_179 VPWR VGND sg13cmos5l_fill_1
XFILLER_43_82 VPWR VGND sg13cmos5l_fill_1
XANTENNA__0202__D Tile_X0Y0_FrameData[18] VPWR VGND sg13cmos5l_antennanp
X_0323_ _0323_/Q Tile_X0Y0_FrameData[25] VGND VPWR Tile_X0Y1_FrameStrobe[7] latch
X_0254_ _0254_/Q Tile_X0Y0_FrameData[30] VGND VPWR Tile_X0Y1_FrameStrobe[5] latch
X_0185_ _0185_/Q Tile_X0Y0_FrameData[3] VGND VPWR Tile_X0Y1_FrameStrobe[2] latch
XFILLER_82_116 VPWR VGND sg13cmos5l_fill_1
XFILLER_90_160 VPWR VGND sg13cmos5l_fill_2
XFILLER_90_0 VPWR VGND sg13cmos5l_fill_2
XANTENNA__0112__D Tile_X0Y0_FrameData[12] VPWR VGND sg13cmos5l_antennanp
XANTENNA__0140__GATE Tile_X0Y1_FrameStrobe[1] VPWR VGND sg13cmos5l_antennanp
XANTENNA__0155__GATE Tile_X0Y1_FrameStrobe[1] VPWR VGND sg13cmos5l_antennanp
XANTENNA__0108__GATE Tile_X0Y1_FrameStrobe[0] VPWR VGND sg13cmos5l_antennanp
XFILLER_13_85 VPWR VGND sg13cmos5l_fill_2
XANTENNA__1102__A2 Tile_X0Y0_S1END[2] VPWR VGND sg13cmos5l_antennanp
X_0941_ Tile_X0Y1_W2BEGb[4] _1159_/X VPWR VGND sg13cmos5l_buf_1
XFILLER_70_80 VPWR VGND sg13cmos5l_fill_1
XFILLER_70_91 VPWR VGND sg13cmos5l_fill_2
X_0872_ Tile_X0Y0_FrameData_O[16] Tile_X0Y0_FrameData[16] VPWR VGND sg13cmos5l_buf_1
X_0306_ _0306_/Q Tile_X0Y0_FrameData[10] VGND VPWR Tile_X0Y1_FrameStrobe[6] latch
X_0237_ _0237_/Q Tile_X0Y0_FrameData[15] VGND VPWR Tile_X0Y1_FrameStrobe[4] latch
X_0168_ _0168_/Q Tile_X0Y0_FrameData[20] VGND VPWR Tile_X0Y1_FrameStrobe[2] latch
XANTENNA__0107__D Tile_X0Y0_FrameData[17] VPWR VGND sg13cmos5l_antennanp
XFILLER_109_129 VPWR VGND sg13cmos5l_fill_2
X_0099_ _0099_/Q Tile_X0Y0_FrameData[25] VGND VPWR Tile_X0Y1_FrameStrobe[0] latch
XANTENNA__0094__GATE Tile_X0Y1_FrameStrobe[0] VPWR VGND sg13cmos5l_antennanp
XFILLER_115_21 VPWR VGND sg13cmos5l_fill_1
XANTENNA__1096__A1 Tile_X0Y1_N2MID[4] VPWR VGND sg13cmos5l_antennanp
XFILLER_54_160 VPWR VGND sg13cmos5l_fill_1
XFILLER_61_119 VPWR VGND sg13cmos5l_fill_2
XFILLER_24_62 VPWR VGND sg13cmos5l_fill_1
XANTENNA__0600__GATE Tile_X0Y1_FrameStrobe[7] VPWR VGND sg13cmos5l_antennanp
XANTENNA__1087__A1 Tile_X0Y1_N4END[4] VPWR VGND sg13cmos5l_antennanp
X_1071_ _1071_/X _0636_/Q _1091_/X _1084_/X _1096_/X _0186_/Q _0185_/Q VPWR VGND sg13cmos5l_mux4_1
X_1140_ _1140_/X _1209_/X _1213_/X _1217_/X _1201_/X _0536_/Q _0535_/Q VPWR VGND sg13cmos5l_mux4_1
XFILLER_60_130 VPWR VGND sg13cmos5l_fill_1
XFILLER_60_163 VPWR VGND sg13cmos5l_decap_4
X_0924_ Tile_X0Y1_UserCLKo Tile_X0Y1_UserCLK VPWR VGND sg13cmos5l_buf_1
XANTENNA__1011__A1 Tile_X0Y0_EE4END[0] VPWR VGND sg13cmos5l_antennanp
XFILLER_53_0 VPWR VGND sg13cmos5l_fill_2
X_0855_ Tile_X0Y1_FrameData_O[31] Tile_X0Y1_FrameData[31] VPWR VGND sg13cmos5l_buf_1
X_0786_ Tile_X0Y0_N2BEGb[3] _1106_/X VPWR VGND sg13cmos5l_buf_1
XANTENNA__0597__D Tile_X0Y1_FrameData[5] VPWR VGND sg13cmos5l_antennanp
XFILLER_28_105 VPWR VGND sg13cmos5l_fill_2
XANTENNA__1078__A1 Tile_X0Y0_E6END[3] VPWR VGND sg13cmos5l_antennanp
XFILLER_101_78 VPWR VGND sg13cmos5l_fill_1
XANTENNA__1002__A1 Tile_X0Y0_E6END[7] VPWR VGND sg13cmos5l_antennanp
XFILLER_10_75 VPWR VGND sg13cmos5l_decap_8
XFILLER_86_13 VPWR VGND sg13cmos5l_fill_1
XANTENNA__0300__D Tile_X0Y0_FrameData[16] VPWR VGND sg13cmos5l_antennanp
XFILLER_89_9 VPWR VGND sg13cmos5l_decap_8
X_0640_ _0640_/Q Tile_X0Y1_UserCLK NPU_OUT_ACT4 _0667_/L_HI VPWR VGND sg13cmos5l_dfrbpq_1
X_0571_ _0571_/Q Tile_X0Y1_FrameData[31] VGND VPWR Tile_X0Y1_FrameStrobe[7] latch
XANTENNA__0210__D Tile_X0Y0_FrameData[10] VPWR VGND sg13cmos5l_antennanp
XFILLER_111_168 VPWR VGND sg13cmos5l_fill_2
XFILLER_111_179 VPWR VGND sg13cmos5l_fill_1
XANTENNA__0554__GATE Tile_X0Y1_FrameStrobe[6] VPWR VGND sg13cmos5l_antennanp
X_1054_ _1054_/X _0639_/Q _0643_/Q _1083_/X _1092_/X _0220_/Q _0219_/Q VPWR VGND sg13cmos5l_mux4_1
X_1123_ _1123_/X Tile_X0Y1_E1END[0] Tile_X0Y1_E6END[8] _1215_/X _1191_/X _0566_/Q
+ _0565_/Q VPWR VGND sg13cmos5l_mux4_1
XANTENNA__0569__GATE Tile_X0Y1_FrameStrobe[6] VPWR VGND sg13cmos5l_antennanp
XANTENNA__1232__A1 Tile_X0Y0_EE4END[9] VPWR VGND sg13cmos5l_antennanp
X_0907_ Tile_X0Y1_S2BEGb[7] _1226_/X VPWR VGND sg13cmos5l_buf_1
XANTENNA__0507__GATE Tile_X0Y1_FrameStrobe[5] VPWR VGND sg13cmos5l_antennanp
XANTENNA__0991__A0 Tile_X0Y1_EE4END[1] VPWR VGND sg13cmos5l_antennanp
X_0838_ Tile_X0Y1_FrameData_O[14] Tile_X0Y1_FrameData[14] VPWR VGND sg13cmos5l_buf_1
X_0769_ Tile_X0Y0_WW4BEG[2] _1049_/X VPWR VGND sg13cmos5l_buf_1
XANTENNA__0120__D Tile_X0Y0_FrameData[4] VPWR VGND sg13cmos5l_antennanp
XFILLER_102_146 VPWR VGND sg13cmos5l_fill_2
XFILLER_112_33 VPWR VGND sg13cmos5l_fill_1
XANTENNA__0982__A0 Tile_X0Y1_EE4END[0] VPWR VGND sg13cmos5l_antennanp
XANTENNA__1223__A1 Tile_X0Y0_E2MID[3] VPWR VGND sg13cmos5l_antennanp
XFILLER_46_71 VPWR VGND sg13cmos5l_decap_8
XANTENNA__0205__D Tile_X0Y0_FrameData[15] VPWR VGND sg13cmos5l_antennanp
XANTENNA__1214__A1 Tile_X0Y1_N4END[3] VPWR VGND sg13cmos5l_antennanp
XANTENNA__0973__A0 Tile_X0Y0_E2MID[0] VPWR VGND sg13cmos5l_antennanp
X_0623_ NPU_ACT_WDATA5 Tile_X0Y1_UserCLK _0987_/X _0692_/L_HI VPWR VGND sg13cmos5l_dfrbpq_1
X_0554_ _0554_/Q Tile_X0Y1_FrameData[16] VGND VPWR Tile_X0Y1_FrameStrobe[6] latch
XANTENNA__0493__GATE Tile_X0Y1_FrameStrobe[4] VPWR VGND sg13cmos5l_antennanp
XANTENNA__1150__A0 Tile_X0Y1_EE4END[4] VPWR VGND sg13cmos5l_antennanp
XFILLER_16_0 VPWR VGND sg13cmos5l_fill_1
X_1106_ _1106_/X Tile_X0Y1_E2MID[4] Tile_X0Y1_E2END[4] Tile_X0Y1_E6END[4] _1198_/X
+ _0588_/Q _0587_/Q VPWR VGND sg13cmos5l_mux4_1
X_0485_ _0485_/Q Tile_X0Y1_FrameData[21] VGND VPWR Tile_X0Y1_FrameStrobe[4] latch
XFILLER_97_144 VPWR VGND sg13cmos5l_fill_2
X_1037_ _1037_/X Tile_X0Y0_EE4END[4] _0642_/Q _1093_/X _1098_/X _0254_/Q _0253_/Q
+ VPWR VGND sg13cmos5l_mux4_1
XANTENNA__0115__D Tile_X0Y0_FrameData[9] VPWR VGND sg13cmos5l_antennanp
XANTENNA__0431__GATE Tile_X0Y1_FrameStrobe[2] VPWR VGND sg13cmos5l_antennanp
XANTENNA__1205__A1 Tile_X0Y1_N4END[2] VPWR VGND sg13cmos5l_antennanp
XANTENNA__0446__GATE Tile_X0Y1_FrameStrobe[3] VPWR VGND sg13cmos5l_antennanp
XFILLER_88_122 VPWR VGND sg13cmos5l_decap_4
XANTENNA__1141__A0 Tile_X0Y1_E1END[3] VPWR VGND sg13cmos5l_antennanp
XFILLER_83_25 VPWR VGND sg13cmos5l_decap_4
XFILLER_12_100 VPWR VGND sg13cmos5l_fill_1
XFILLER_79_100 VPWR VGND sg13cmos5l_decap_8
XANTENNA__1132__A0 Tile_X0Y1_E1END[1] VPWR VGND sg13cmos5l_antennanp
X_0270_ _0270_/Q Tile_X0Y0_FrameData[14] VGND VPWR Tile_X0Y1_FrameStrobe[5] latch
XFILLER_73_91 VPWR VGND sg13cmos5l_fill_1
XANTENNA__1199__A0 Tile_X0Y1_N2MID[4] VPWR VGND sg13cmos5l_antennanp
XANTENNA__0800__X Tile_X0Y0_N1BEG[1] VPWR VGND sg13cmos5l_antennanp
X_0606_ _0606_/Q Tile_X0Y1_FrameData[28] VGND VPWR Tile_X0Y1_FrameStrobe[8] latch
X_0537_ _0537_/Q Tile_X0Y1_FrameData[1] VGND VPWR Tile_X0Y1_FrameStrobe[5] latch
XANTENNA__1123__A0 Tile_X0Y1_E1END[0] VPWR VGND sg13cmos5l_antennanp
XFILLER_53_17 VPWR VGND sg13cmos5l_fill_2
X_0468_ _0468_/Q Tile_X0Y1_FrameData[6] VGND VPWR Tile_X0Y1_FrameStrobe[3] latch
X_0399_ _0399_/Q Tile_X0Y1_FrameData[11] VGND VPWR Tile_X0Y1_FrameStrobe[1] latch
XANTENNA__0370__GATE Tile_X0Y1_FrameStrobe[0] VPWR VGND sg13cmos5l_antennanp
XANTENNA__0385__GATE Tile_X0Y1_FrameStrobe[1] VPWR VGND sg13cmos5l_antennanp
XANTENNA__1114__A0 Tile_X0Y1_E1END[3] VPWR VGND sg13cmos5l_antennanp
XFILLER_94_68 VPWR VGND sg13cmos5l_fill_1
XFILLER_76_136 VPWR VGND sg13cmos5l_decap_8
XANTENNA__0323__GATE Tile_X0Y1_FrameStrobe[7] VPWR VGND sg13cmos5l_antennanp
XANTENNA__0338__GATE Tile_X0Y1_FrameStrobe[7] VPWR VGND sg13cmos5l_antennanp
XANTENNA__0620__CLK Tile_X0Y1_UserCLK VPWR VGND sg13cmos5l_antennanp
XANTENNA__1196__A3 Tile_X0Y0_S2MID[1] VPWR VGND sg13cmos5l_antennanp
XFILLER_4_55 VPWR VGND sg13cmos5l_fill_2
X_0322_ _0322_/Q Tile_X0Y0_FrameData[26] VGND VPWR Tile_X0Y1_FrameStrobe[7] latch
XANTENNA__1105__A0 Tile_X0Y1_E2MID[5] VPWR VGND sg13cmos5l_antennanp
XFILLER_67_136 VPWR VGND sg13cmos5l_decap_4
X_0253_ _0253_/Q Tile_X0Y0_FrameData[31] VGND VPWR Tile_X0Y1_FrameStrobe[5] latch
X_0184_ _0184_/Q Tile_X0Y0_FrameData[4] VGND VPWR Tile_X0Y1_FrameStrobe[2] latch
XFILLER_82_128 VPWR VGND sg13cmos5l_fill_2
XFILLER_83_0 VPWR VGND sg13cmos5l_fill_1
XANTENNA__0643__CLK Tile_X0Y1_UserCLK VPWR VGND sg13cmos5l_antennanp
XFILLER_58_136 VPWR VGND sg13cmos5l_fill_2
XFILLER_64_38 VPWR VGND sg13cmos5l_fill_1
XFILLER_13_42 VPWR VGND sg13cmos5l_decap_4
XANTENNA__0303__D Tile_X0Y0_FrameData[13] VPWR VGND sg13cmos5l_antennanp
XFILLER_89_57 VPWR VGND sg13cmos5l_decap_4
XANTENNA__0262__GATE Tile_X0Y1_FrameStrobe[5] VPWR VGND sg13cmos5l_antennanp
XFILLER_49_169 VPWR VGND sg13cmos5l_fill_2
XANTENNA__0200__GATE Tile_X0Y1_FrameStrobe[3] VPWR VGND sg13cmos5l_antennanp
XANTENNA__0277__GATE Tile_X0Y1_FrameStrobe[5] VPWR VGND sg13cmos5l_antennanp
XFILLER_54_71 VPWR VGND sg13cmos5l_fill_1
XFILLER_54_93 VPWR VGND sg13cmos5l_fill_1
X_0940_ Tile_X0Y1_W2BEGb[3] _1158_/X VPWR VGND sg13cmos5l_buf_1
XANTENNA__0213__D Tile_X0Y0_FrameData[7] VPWR VGND sg13cmos5l_antennanp
XANTENNA__0215__GATE Tile_X0Y1_FrameStrobe[3] VPWR VGND sg13cmos5l_antennanp
XFILLER_118_108 VPWR VGND sg13cmos5l_fill_1
X_0871_ Tile_X0Y0_FrameData_O[15] Tile_X0Y0_FrameData[15] VPWR VGND sg13cmos5l_buf_1
X_0305_ _0305_/Q Tile_X0Y0_FrameData[11] VGND VPWR Tile_X0Y1_FrameStrobe[6] latch
XFILLER_34_19 VPWR VGND sg13cmos5l_fill_1
X_0236_ _0236_/Q Tile_X0Y0_FrameData[16] VGND VPWR Tile_X0Y1_FrameStrobe[4] latch
X_0167_ _0167_/Q Tile_X0Y0_FrameData[21] VGND VPWR Tile_X0Y1_FrameStrobe[2] latch
X_0098_ _0098_/Q Tile_X0Y0_FrameData[26] VGND VPWR Tile_X0Y1_FrameStrobe[0] latch
XANTENNA__0123__D Tile_X0Y0_FrameData[1] VPWR VGND sg13cmos5l_antennanp
XFILLER_117_141 VPWR VGND sg13cmos5l_fill_1
XFILLER_59_27 VPWR VGND sg13cmos5l_decap_4
XFILLER_46_117 VPWR VGND sg13cmos5l_fill_1
XANTENNA__1096__A2 Tile_X0Y0_S2MID[4] VPWR VGND sg13cmos5l_antennanp
XFILLER_61_109 VPWR VGND sg13cmos5l_fill_2
XFILLER_91_36 VPWR VGND sg13cmos5l_fill_1
XFILLER_37_106 VPWR VGND sg13cmos5l_decap_4
XFILLER_49_71 VPWR VGND sg13cmos5l_decap_4
XANTENNA__1087__A2 Tile_X0Y0_S1END[0] VPWR VGND sg13cmos5l_antennanp
X_1070_ _1070_/X _0643_/Q _1087_/X _1083_/X _1095_/X _0188_/Q _0187_/Q VPWR VGND sg13cmos5l_mux4_1
XANTENNA__0208__D Tile_X0Y0_FrameData[12] VPWR VGND sg13cmos5l_antennanp
X_0854_ Tile_X0Y1_FrameData_O[30] Tile_X0Y1_FrameData[30] VPWR VGND sg13cmos5l_buf_1
X_0923_ Tile_X0Y1_S4BEG[15] _0923_/A VPWR VGND sg13cmos5l_buf_1
XANTENNA__0154__GATE Tile_X0Y1_FrameStrobe[1] VPWR VGND sg13cmos5l_antennanp
XANTENNA__1011__A2 Tile_X0Y0_E6END[8] VPWR VGND sg13cmos5l_antennanp
XFILLER_114_133 VPWR VGND sg13cmos5l_fill_1
XFILLER_114_166 VPWR VGND sg13cmos5l_fill_1
XFILLER_46_0 VPWR VGND sg13cmos5l_fill_2
X_0785_ Tile_X0Y0_N2BEGb[2] _1105_/X VPWR VGND sg13cmos5l_buf_1
XANTENNA__0169__GATE Tile_X0Y1_FrameStrobe[2] VPWR VGND sg13cmos5l_antennanp
XFILLER_45_29 VPWR VGND sg13cmos5l_decap_4
XANTENNA__0107__GATE Tile_X0Y1_FrameStrobe[0] VPWR VGND sg13cmos5l_antennanp
XANTENNA__0118__D Tile_X0Y0_FrameData[6] VPWR VGND sg13cmos5l_antennanp
XANTENNA__1078__A2 Tile_X0Y0_S1END[3] VPWR VGND sg13cmos5l_antennanp
X_1199_ _1199_/X Tile_X0Y1_N2MID[4] Tile_X0Y1_N2END[4] _1223_/X Tile_X0Y0_S2MID[4]
+ _0362_/Q _0361_/Q VPWR VGND sg13cmos5l_mux4_1
X_0219_ _0219_/Q Tile_X0Y0_FrameData[1] VGND VPWR Tile_X0Y1_FrameStrobe[3] latch
XFILLER_105_100 VPWR VGND sg13cmos5l_decap_8
XFILLER_10_32 VPWR VGND sg13cmos5l_fill_1
XFILLER_19_139 VPWR VGND sg13cmos5l_fill_2
XFILLER_42_131 VPWR VGND sg13cmos5l_fill_2
X_0570_ _0570_/Q Tile_X0Y1_FrameData[0] VGND VPWR Tile_X0Y1_FrameStrobe[6] latch
XFILLER_18_4 VPWR VGND sg13cmos5l_fill_1
X_1122_ _1122_/X _1207_/X _1211_/X _1215_/X _1195_/X _0578_/Q _0577_/Q VPWR VGND sg13cmos5l_mux4_1
X_1053_ _1053_/X _0638_/Q _0642_/Q _1082_/X _1093_/X _0222_/Q _0221_/Q VPWR VGND sg13cmos5l_mux4_1
XANTENNA__0803__X Tile_X0Y0_FrameStrobe_O[0] VPWR VGND sg13cmos5l_antennanp
XANTENNA__0991__A1 Tile_X0Y1_EE4END[9] VPWR VGND sg13cmos5l_antennanp
XANTENNA__1232__A2 Tile_X0Y0_E6END[1] VPWR VGND sg13cmos5l_antennanp
X_0906_ Tile_X0Y1_S2BEGb[6] _1225_/X VPWR VGND sg13cmos5l_buf_1
X_0837_ Tile_X0Y1_FrameData_O[13] Tile_X0Y1_FrameData[13] VPWR VGND sg13cmos5l_buf_1
XANTENNA__0401__D Tile_X0Y1_FrameData[9] VPWR VGND sg13cmos5l_antennanp
XFILLER_102_103 VPWR VGND sg13cmos5l_fill_1
X_0768_ Tile_X0Y0_WW4BEG[1] _1048_/X VPWR VGND sg13cmos5l_buf_1
X_0699_ _0981_/A3 VPWR VGND sg13cmos5l_tielo
XANTENNA__1223__A2 Tile_X0Y0_E2END[3] VPWR VGND sg13cmos5l_antennanp
XFILLER_24_142 VPWR VGND sg13cmos5l_fill_1
XANTENNA__0982__A1 Tile_X0Y1_EE4END[8] VPWR VGND sg13cmos5l_antennanp
XFILLER_108_2 VPWR VGND sg13cmos5l_fill_1
XFILLER_97_46 VPWR VGND sg13cmos5l_fill_1
XANTENNA__0311__D Tile_X0Y0_FrameData[5] VPWR VGND sg13cmos5l_antennanp
XANTENNA__0973__A1 Tile_X0Y0_E2END[0] VPWR VGND sg13cmos5l_antennanp
XANTENNA__0221__D Tile_X0Y0_FrameData[31] VPWR VGND sg13cmos5l_antennanp
X_0622_ NPU_ACT_WDATA4 Tile_X0Y1_UserCLK _0986_/X _0663_/L_HI VPWR VGND sg13cmos5l_dfrbpq_1
X_0553_ _0553_/Q Tile_X0Y1_FrameData[17] VGND VPWR Tile_X0Y1_FrameStrobe[6] latch
X_0484_ _0484_/Q Tile_X0Y1_FrameData[22] VGND VPWR Tile_X0Y1_FrameStrobe[4] latch
X_1105_ _1105_/X Tile_X0Y1_E2MID[5] Tile_X0Y1_E2END[5] Tile_X0Y1_E6END[5] _1197_/X
+ _0590_/Q _0589_/Q VPWR VGND sg13cmos5l_mux4_1
XFILLER_21_178 VPWR VGND sg13cmos5l_fill_2
XFILLER_42_19 VPWR VGND sg13cmos5l_decap_4
X_1036_ _1036_/X Tile_X0Y0_EE4END[15] _0641_/Q _1094_/X _1097_/X _0256_/Q _0255_/Q
+ VPWR VGND sg13cmos5l_mux4_1
XANTENNA__0131__D Tile_X0Y0_FrameData[25] VPWR VGND sg13cmos5l_antennanp
XANTENNA__1141__A1 Tile_X0Y1_EE4END[15] VPWR VGND sg13cmos5l_antennanp
XFILLER_16_53 VPWR VGND sg13cmos5l_decap_4
XFILLER_83_37 VPWR VGND sg13cmos5l_decap_4
XANTENNA__0306__D Tile_X0Y0_FrameData[10] VPWR VGND sg13cmos5l_antennanp
XFILLER_12_112 VPWR VGND sg13cmos5l_fill_1
XFILLER_32_30 VPWR VGND sg13cmos5l_decap_4
XFILLER_8_116 VPWR VGND sg13cmos5l_decap_4
XANTENNA__0553__GATE Tile_X0Y1_FrameStrobe[6] VPWR VGND sg13cmos5l_antennanp
XANTENNA__0568__GATE Tile_X0Y1_FrameStrobe[6] VPWR VGND sg13cmos5l_antennanp
XANTENNA__1132__A1 Tile_X0Y1_E2MID[2] VPWR VGND sg13cmos5l_antennanp
XANTENNA__0216__D Tile_X0Y0_FrameData[4] VPWR VGND sg13cmos5l_antennanp
XANTENNA__0506__GATE Tile_X0Y1_FrameStrobe[4] VPWR VGND sg13cmos5l_antennanp
XFILLER_85_4 VPWR VGND sg13cmos5l_fill_1
XANTENNA__1199__A1 Tile_X0Y1_N2END[4] VPWR VGND sg13cmos5l_antennanp
X_0605_ _0605_/Q Tile_X0Y1_FrameData[27] VGND VPWR Tile_X0Y1_FrameStrobe[8] latch
X_0536_ _0536_/Q Tile_X0Y1_FrameData[2] VGND VPWR Tile_X0Y1_FrameStrobe[5] latch
X_0467_ _0467_/Q Tile_X0Y1_FrameData[7] VGND VPWR Tile_X0Y1_FrameStrobe[3] latch
XFILLER_85_137 VPWR VGND sg13cmos5l_decap_4
XANTENNA__1123__A1 Tile_X0Y1_E6END[8] VPWR VGND sg13cmos5l_antennanp
X_1019_ _1019_/X Tile_X0Y0_E1END[0] Tile_X0Y0_EE4END[12] Tile_X0Y0_E6END[4] _1088_/X
+ _0286_/Q _0285_/Q VPWR VGND sg13cmos5l_mux4_1
X_0398_ _0398_/Q Tile_X0Y1_FrameData[12] VGND VPWR Tile_X0Y1_FrameStrobe[1] latch
XANTENNA__0126__D Tile_X0Y0_FrameData[30] VPWR VGND sg13cmos5l_antennanp
XFILLER_78_59 VPWR VGND sg13cmos5l_fill_1
XFILLER_78_26 VPWR VGND sg13cmos5l_fill_1
XANTENNA__1114__A1 Tile_X0Y1_E6END[7] VPWR VGND sg13cmos5l_antennanp
XFILLER_27_52 VPWR VGND sg13cmos5l_decap_8
XFILLER_94_36 VPWR VGND sg13cmos5l_decap_8
XFILLER_43_51 VPWR VGND sg13cmos5l_fill_2
XANTENNA__0492__GATE Tile_X0Y1_FrameStrobe[4] VPWR VGND sg13cmos5l_antennanp
XANTENNA__0901__X Tile_X0Y1_S2BEGb[1] VPWR VGND sg13cmos5l_antennanp
X_0321_ _0321_/Q Tile_X0Y0_FrameData[27] VGND VPWR Tile_X0Y1_FrameStrobe[7] latch
XANTENNA__0430__GATE Tile_X0Y1_FrameStrobe[2] VPWR VGND sg13cmos5l_antennanp
XANTENNA__0445__GATE Tile_X0Y1_FrameStrobe[3] VPWR VGND sg13cmos5l_antennanp
XANTENNA__1105__A1 Tile_X0Y1_E2END[5] VPWR VGND sg13cmos5l_antennanp
X_0252_ _0252_/Q Tile_X0Y0_FrameData[0] VGND VPWR Tile_X0Y1_FrameStrobe[4] latch
X_0183_ _0183_/Q Tile_X0Y0_FrameData[5] VGND VPWR Tile_X0Y1_FrameStrobe[2] latch
XFILLER_84_80 VPWR VGND sg13cmos5l_fill_2
XFILLER_90_2 VPWR VGND sg13cmos5l_fill_1
XFILLER_76_0 VPWR VGND sg13cmos5l_fill_1
XANTENNA__0811__X Tile_X0Y0_FrameStrobe_O[8] VPWR VGND sg13cmos5l_antennanp
XANTENNA__1041__A0 Tile_X0Y0_EE4END[9] VPWR VGND sg13cmos5l_antennanp
XFILLER_48_29 VPWR VGND sg13cmos5l_decap_4
X_0519_ _0519_/Q Tile_X0Y1_FrameData[19] VGND VPWR Tile_X0Y1_FrameStrobe[5] latch
XANTENNA__0721__X Tile_X0Y0_W1BEG[2] VPWR VGND sg13cmos5l_antennanp
XANTENNA__1032__A0 Tile_X0Y0_EE4END[5] VPWR VGND sg13cmos5l_antennanp
XFILLER_13_87 VPWR VGND sg13cmos5l_fill_1
XFILLER_64_107 VPWR VGND sg13cmos5l_decap_8
X_0870_ Tile_X0Y0_FrameData_O[14] Tile_X0Y0_FrameData[14] VPWR VGND sg13cmos5l_buf_1
XANTENNA__1023__A0 Tile_X0Y0_E1END[2] VPWR VGND sg13cmos5l_antennanp
XFILLER_55_118 VPWR VGND sg13cmos5l_decap_4
XFILLER_55_129 VPWR VGND sg13cmos5l_decap_4
X_0304_ _0304_/Q Tile_X0Y0_FrameData[12] VGND VPWR Tile_X0Y1_FrameStrobe[6] latch
X_0235_ _0235_/Q Tile_X0Y0_FrameData[17] VGND VPWR Tile_X0Y1_FrameStrobe[4] latch
XANTENNA__0384__GATE Tile_X0Y1_FrameStrobe[1] VPWR VGND sg13cmos5l_antennanp
XANTENNA__0806__X Tile_X0Y0_FrameStrobe_O[3] VPWR VGND sg13cmos5l_antennanp
XFILLER_63_162 VPWR VGND sg13cmos5l_fill_2
X_0166_ _0166_/Q Tile_X0Y0_FrameData[22] VGND VPWR Tile_X0Y1_FrameStrobe[2] latch
X_0097_ _0097_/Q Tile_X0Y0_FrameData[27] VGND VPWR Tile_X0Y1_FrameStrobe[0] latch
XANTENNA__0322__GATE Tile_X0Y1_FrameStrobe[7] VPWR VGND sg13cmos5l_antennanp
XANTENNA__0399__GATE Tile_X0Y1_FrameStrobe[1] VPWR VGND sg13cmos5l_antennanp
XANTENNA__0404__D Tile_X0Y1_FrameData[6] VPWR VGND sg13cmos5l_antennanp
XANTENNA__0610__CLK Tile_X0Y1_UserCLK VPWR VGND sg13cmos5l_antennanp
X_0999_ _0999_/X Tile_X0Y0_E1END[0] Tile_X0Y0_E6END[4] _1075_/X _1100_/X _0346_/Q
+ _0345_/Q VPWR VGND sg13cmos5l_mux4_1
XANTENNA__0337__GATE Tile_X0Y1_FrameStrobe[7] VPWR VGND sg13cmos5l_antennanp
XFILLER_115_45 VPWR VGND sg13cmos5l_fill_2
XANTENNA__1096__A3 Tile_X0Y0_S2END[4] VPWR VGND sg13cmos5l_antennanp
XFILLER_115_67 VPWR VGND sg13cmos5l_fill_1
XFILLER_91_59 VPWR VGND sg13cmos5l_decap_8
XANTENNA__0314__D Tile_X0Y0_FrameData[2] VPWR VGND sg13cmos5l_antennanp
XANTENNA__1005__A0 Tile_X0Y0_E2MID[5] VPWR VGND sg13cmos5l_antennanp
XFILLER_40_30 VPWR VGND sg13cmos5l_fill_1
XFILLER_27_9 VPWR VGND sg13cmos5l_fill_1
XANTENNA__1087__A3 Tile_X0Y0_S4END[0] VPWR VGND sg13cmos5l_antennanp
XFILLER_60_154 VPWR VGND sg13cmos5l_fill_2
XANTENNA__0224__D Tile_X0Y0_FrameData[28] VPWR VGND sg13cmos5l_antennanp
XANTENNA__0633__CLK Tile_X0Y1_UserCLK VPWR VGND sg13cmos5l_antennanp
X_0853_ Tile_X0Y1_FrameData_O[29] Tile_X0Y1_FrameData[29] VPWR VGND sg13cmos5l_buf_1
X_0922_ Tile_X0Y1_S4BEG[14] _0922_/A VPWR VGND sg13cmos5l_buf_1
XFILLER_39_0 VPWR VGND sg13cmos5l_decap_4
X_0784_ Tile_X0Y0_N2BEGb[1] _1104_/X VPWR VGND sg13cmos5l_buf_1
XFILLER_28_107 VPWR VGND sg13cmos5l_fill_1
XFILLER_45_19 VPWR VGND sg13cmos5l_fill_2
X_1198_ _1198_/X Tile_X0Y1_N2MID[3] Tile_X0Y1_N2END[3] _1222_/X Tile_X0Y0_S2MID[3]
+ _0364_/Q _0363_/Q VPWR VGND sg13cmos5l_mux4_1
X_0218_ _0218_/Q Tile_X0Y0_FrameData[2] VGND VPWR Tile_X0Y1_FrameStrobe[3] latch
XANTENNA__1235__A0 Tile_X0Y0_E1END[1] VPWR VGND sg13cmos5l_antennanp
X_0149_ _0149_/Q Tile_X0Y0_FrameData[7] VGND VPWR Tile_X0Y1_FrameStrobe[1] latch
XANTENNA__0134__D Tile_X0Y0_FrameData[22] VPWR VGND sg13cmos5l_antennanp
XANTENNA__0261__GATE Tile_X0Y1_FrameStrobe[5] VPWR VGND sg13cmos5l_antennanp
XANTENNA__0276__GATE Tile_X0Y1_FrameStrobe[5] VPWR VGND sg13cmos5l_antennanp
XFILLER_19_118 VPWR VGND sg13cmos5l_fill_2
XANTENNA__0214__GATE Tile_X0Y1_FrameStrobe[3] VPWR VGND sg13cmos5l_antennanp
XANTENNA__0309__D Tile_X0Y0_FrameData[7] VPWR VGND sg13cmos5l_antennanp
XFILLER_35_52 VPWR VGND sg13cmos5l_fill_1
XFILLER_42_110 VPWR VGND sg13cmos5l_decap_8
XANTENNA__0229__GATE Tile_X0Y1_FrameStrobe[4] VPWR VGND sg13cmos5l_antennanp
XANTENNA__1226__A0 Tile_X0Y0_E1END[3] VPWR VGND sg13cmos5l_antennanp
XFILLER_35_96 VPWR VGND sg13cmos5l_fill_2
XFILLER_111_115 VPWR VGND sg13cmos5l_fill_1
X_1052_ _1052_/X _0637_/Q _0641_/Q _1081_/X _1094_/X _0224_/Q _0223_/Q VPWR VGND sg13cmos5l_mux4_1
X_1121_ _1121_/X Tile_X0Y1_E1END[0] Tile_X0Y1_EE4END[0] Tile_X0Y1_E6END[8] _1203_/X
+ _0578_/Q _0577_/Q VPWR VGND sg13cmos5l_mux4_1
XANTENNA__0219__D Tile_X0Y0_FrameData[1] VPWR VGND sg13cmos5l_antennanp
XANTENNA__1217__A0 Tile_X0Y1_N1END[2] VPWR VGND sg13cmos5l_antennanp
XANTENNA__0991__A2 Tile_X0Y1_E6END[9] VPWR VGND sg13cmos5l_antennanp
X_0905_ Tile_X0Y1_S2BEGb[5] _1224_/X VPWR VGND sg13cmos5l_buf_1
X_0836_ Tile_X0Y1_FrameData_O[12] Tile_X0Y1_FrameData[12] VPWR VGND sg13cmos5l_buf_1
X_0767_ Tile_X0Y0_WW4BEG[0] _1047_/X VPWR VGND sg13cmos5l_buf_1
XFILLER_102_126 VPWR VGND sg13cmos5l_decap_8
X_0698_ _0698_/L_HI VPWR VGND sg13cmos5l_tiehi
XANTENNA__0129__D Tile_X0Y0_FrameData[27] VPWR VGND sg13cmos5l_antennanp
XFILLER_72_28 VPWR VGND sg13cmos5l_decap_8
XANTENNA__1208__A0 Tile_X0Y1_N1END[1] VPWR VGND sg13cmos5l_antennanp
XANTENNA__0982__A2 Tile_X0Y1_E6END[0] VPWR VGND sg13cmos5l_antennanp
XFILLER_97_58 VPWR VGND sg13cmos5l_fill_1
XANTENNA__0153__GATE Tile_X0Y1_FrameStrobe[1] VPWR VGND sg13cmos5l_antennanp
XANTENNA__0168__GATE Tile_X0Y1_FrameStrobe[2] VPWR VGND sg13cmos5l_antennanp
XANTENNA__0904__X Tile_X0Y1_S2BEGb[4] VPWR VGND sg13cmos5l_antennanp
XFILLER_62_50 VPWR VGND sg13cmos5l_fill_1
XANTENNA__1214__A3 Tile_X0Y0_S4END[7] VPWR VGND sg13cmos5l_antennanp
X_0621_ NPU_ACT_WDATA3 Tile_X0Y1_UserCLK _0985_/X _0662_/L_HI VPWR VGND sg13cmos5l_dfrbpq_1
XANTENNA__0106__GATE Tile_X0Y1_FrameStrobe[0] VPWR VGND sg13cmos5l_antennanp
XANTENNA__0502__D Tile_X0Y1_FrameData[4] VPWR VGND sg13cmos5l_antennanp
X_0552_ _0552_/Q Tile_X0Y1_FrameData[18] VGND VPWR Tile_X0Y1_FrameStrobe[6] latch
X_0483_ _0483_/Q Tile_X0Y1_FrameData[23] VGND VPWR Tile_X0Y1_FrameStrobe[4] latch
XFILLER_97_146 VPWR VGND sg13cmos5l_fill_1
X_1035_ _1035_/X Tile_X0Y0_EE4END[8] _0640_/Q _1095_/X _1096_/X _0258_/Q _0257_/Q
+ VPWR VGND sg13cmos5l_mux4_1
X_1104_ _1104_/X Tile_X0Y1_E2MID[6] Tile_X0Y1_E2END[6] Tile_X0Y1_E6END[6] _1196_/X
+ _0592_/Q _0591_/Q VPWR VGND sg13cmos5l_mux4_1
XANTENNA__0814__X Tile_X0Y0_FrameStrobe_O[11] VPWR VGND sg13cmos5l_antennanp
XANTENNA__1205__A3 Tile_X0Y0_S4END[6] VPWR VGND sg13cmos5l_antennanp
XANTENNA__0412__D Tile_X0Y1_FrameData[30] VPWR VGND sg13cmos5l_antennanp
XFILLER_107_35 VPWR VGND sg13cmos5l_fill_1
X_0819_ Tile_X0Y0_FrameStrobe_O[16] Tile_X0Y1_FrameStrobe[16] VPWR VGND sg13cmos5l_buf_1
XANTENNA__1141__A2 Tile_X0Y1_E6END[7] VPWR VGND sg13cmos5l_antennanp
XFILLER_67_28 VPWR VGND sg13cmos5l_fill_1
XFILLER_88_179 VPWR VGND sg13cmos5l_fill_1
XANTENNA__0724__X Tile_X0Y0_W2BEG[1] VPWR VGND sg13cmos5l_antennanp
XFILLER_12_124 VPWR VGND sg13cmos5l_fill_1
XFILLER_32_64 VPWR VGND sg13cmos5l_decap_4
XANTENNA__0322__D Tile_X0Y0_FrameData[26] VPWR VGND sg13cmos5l_antennanp
XANTENNA__1132__A2 Tile_X0Y1_E2END[2] VPWR VGND sg13cmos5l_antennanp
XFILLER_73_82 VPWR VGND sg13cmos5l_decap_8
XANTENNA__0232__D Tile_X0Y0_FrameData[20] VPWR VGND sg13cmos5l_antennanp
XANTENNA__0810__A Tile_X0Y1_FrameStrobe[7] VPWR VGND sg13cmos5l_antennanp
X_0604_ _0604_/Q Tile_X0Y1_FrameData[26] VGND VPWR Tile_X0Y1_FrameStrobe[8] latch
XANTENNA__0809__X Tile_X0Y0_FrameStrobe_O[6] VPWR VGND sg13cmos5l_antennanp
XFILLER_21_0 VPWR VGND sg13cmos5l_decap_4
X_0535_ _0535_/Q Tile_X0Y1_FrameData[3] VGND VPWR Tile_X0Y1_FrameStrobe[5] latch
X_0466_ _0466_/Q Tile_X0Y1_FrameData[8] VGND VPWR Tile_X0Y1_FrameStrobe[3] latch
X_0397_ _0397_/Q Tile_X0Y1_FrameData[13] VGND VPWR Tile_X0Y1_FrameStrobe[1] latch
XANTENNA__0407__D Tile_X0Y1_FrameData[3] VPWR VGND sg13cmos5l_antennanp
X_1018_ _1018_/X _1084_/X _1080_/X _1079_/X _1095_/X _0313_/Q _0312_/Q VPWR VGND sg13cmos5l_mux4_1
XANTENNA__0142__D Tile_X0Y0_FrameData[14] VPWR VGND sg13cmos5l_antennanp
XFILLER_76_116 VPWR VGND sg13cmos5l_fill_1
XANTENNA__0719__X Tile_X0Y0_W1BEG[0] VPWR VGND sg13cmos5l_antennanp
XANTENNA__0317__D Tile_X0Y0_FrameData[31] VPWR VGND sg13cmos5l_antennanp
XFILLER_43_30 VPWR VGND sg13cmos5l_fill_1
XANTENNA__1105__A2 Tile_X0Y1_E6END[5] VPWR VGND sg13cmos5l_antennanp
XFILLER_4_68 VPWR VGND sg13cmos5l_fill_2
X_0320_ _0320_/Q Tile_X0Y0_FrameData[28] VGND VPWR Tile_X0Y1_FrameStrobe[7] latch
X_0251_ _0251_/Q Tile_X0Y0_FrameData[1] VGND VPWR Tile_X0Y1_FrameStrobe[4] latch
XANTENNA__0227__D Tile_X0Y0_FrameData[25] VPWR VGND sg13cmos5l_antennanp
X_0182_ _0182_/Q Tile_X0Y0_FrameData[6] VGND VPWR Tile_X0Y1_FrameStrobe[2] latch
XANTENNA__0805__A Tile_X0Y1_FrameStrobe[2] VPWR VGND sg13cmos5l_antennanp
XFILLER_48_19 VPWR VGND sg13cmos5l_fill_2
X_0518_ _0518_/Q Tile_X0Y1_FrameData[20] VGND VPWR Tile_X0Y1_FrameStrobe[5] latch
XFILLER_58_149 VPWR VGND sg13cmos5l_decap_8
X_0449_ _0449_/Q Tile_X0Y1_FrameData[25] VGND VPWR Tile_X0Y1_FrameStrobe[3] latch
XANTENNA__0137__D Tile_X0Y0_FrameData[19] VPWR VGND sg13cmos5l_antennanp
XANTENNA__0552__GATE Tile_X0Y1_FrameStrobe[6] VPWR VGND sg13cmos5l_antennanp
XANTENNA__0567__GATE Tile_X0Y1_FrameStrobe[6] VPWR VGND sg13cmos5l_antennanp
XFILLER_13_55 VPWR VGND sg13cmos5l_fill_2
XANTENNA__0505__GATE Tile_X0Y1_FrameStrobe[4] VPWR VGND sg13cmos5l_antennanp
XANTENNA__0600__D Tile_X0Y1_FrameData[2] VPWR VGND sg13cmos5l_antennanp
XANTENNA__1099__A1 Tile_X0Y1_N2MID[7] VPWR VGND sg13cmos5l_antennanp
XFILLER_57_160 VPWR VGND sg13cmos5l_fill_2
XANTENNA__0912__X Tile_X0Y1_S4BEG[4] VPWR VGND sg13cmos5l_antennanp
XANTENNA__1023__A1 Tile_X0Y0_EE4END[14] VPWR VGND sg13cmos5l_antennanp
XANTENNA__0510__D Tile_X0Y1_FrameData[28] VPWR VGND sg13cmos5l_antennanp
XFILLER_48_160 VPWR VGND sg13cmos5l_fill_2
X_0303_ _0303_/Q Tile_X0Y0_FrameData[13] VGND VPWR Tile_X0Y1_FrameStrobe[6] latch
X_0234_ _0234_/Q Tile_X0Y0_FrameData[18] VGND VPWR Tile_X0Y1_FrameStrobe[4] latch
X_0165_ _0165_/Q Tile_X0Y0_FrameData[23] VGND VPWR Tile_X0Y1_FrameStrobe[2] latch
X_0096_ _0096_/Q Tile_X0Y0_FrameData[28] VGND VPWR Tile_X0Y1_FrameStrobe[0] latch
XANTENNA__0092__CLK Tile_X0Y1_UserCLK VPWR VGND sg13cmos5l_antennanp
XANTENNA__0822__X Tile_X0Y0_FrameStrobe_O[19] VPWR VGND sg13cmos5l_antennanp
X_0998_ _0998_/X Tile_X0Y0_EE4END[3] Tile_X0Y0_EE4END[11] Tile_X0Y0_E6END[3] _1091_/X
+ _0172_/Q _0171_/Q VPWR VGND sg13cmos5l_mux4_1
XANTENNA__0420__D Tile_X0Y1_FrameData[22] VPWR VGND sg13cmos5l_antennanp
XFILLER_115_13 VPWR VGND sg13cmos5l_fill_1
XANTENNA__0491__GATE Tile_X0Y1_FrameStrobe[4] VPWR VGND sg13cmos5l_antennanp
XFILLER_54_141 VPWR VGND sg13cmos5l_fill_1
XANTENNA__0732__X Tile_X0Y0_W2BEGb[1] VPWR VGND sg13cmos5l_antennanp
XANTENNA__0330__D Tile_X0Y0_FrameData[18] VPWR VGND sg13cmos5l_antennanp
XANTENNA__0444__GATE Tile_X0Y1_FrameStrobe[3] VPWR VGND sg13cmos5l_antennanp
XANTENNA__1005__A1 Tile_X0Y0_E2END[5] VPWR VGND sg13cmos5l_antennanp
XFILLER_40_42 VPWR VGND sg13cmos5l_fill_2
XFILLER_40_97 VPWR VGND sg13cmos5l_fill_2
XANTENNA__0459__GATE Tile_X0Y1_FrameStrobe[3] VPWR VGND sg13cmos5l_antennanp
XFILLER_37_119 VPWR VGND sg13cmos5l_fill_2
XANTENNA__0907__X Tile_X0Y1_S2BEGb[7] VPWR VGND sg13cmos5l_antennanp
XFILLER_60_122 VPWR VGND sg13cmos5l_fill_1
XFILLER_60_177 VPWR VGND sg13cmos5l_fill_2
X_0921_ Tile_X0Y1_S4BEG[13] _0921_/A VPWR VGND sg13cmos5l_buf_1
XFILLER_81_71 VPWR VGND sg13cmos5l_decap_8
XANTENNA__0505__D Tile_X0Y1_FrameData[1] VPWR VGND sg13cmos5l_antennanp
X_0852_ Tile_X0Y1_FrameData_O[28] Tile_X0Y1_FrameData[28] VPWR VGND sg13cmos5l_buf_1
X_0783_ Tile_X0Y0_N2BEGb[0] _1103_/X VPWR VGND sg13cmos5l_buf_1
XANTENNA__0240__D Tile_X0Y0_FrameData[12] VPWR VGND sg13cmos5l_antennanp
XANTENNA__1180__A0 Tile_X0Y1_N4END[1] VPWR VGND sg13cmos5l_antennanp
XFILLER_46_2 VPWR VGND sg13cmos5l_fill_1
XANTENNA__0817__X Tile_X0Y0_FrameStrobe_O[14] VPWR VGND sg13cmos5l_antennanp
XFILLER_36_130 VPWR VGND sg13cmos5l_fill_2
X_1197_ _1197_/X Tile_X0Y1_N2MID[2] Tile_X0Y1_N2END[2] _1221_/X Tile_X0Y0_S2MID[2]
+ _0366_/Q _0365_/Q VPWR VGND sg13cmos5l_mux4_1
X_0217_ _0217_/Q Tile_X0Y0_FrameData[3] VGND VPWR Tile_X0Y1_FrameStrobe[3] latch
X_0148_ _0148_/Q Tile_X0Y0_FrameData[8] VGND VPWR Tile_X0Y1_FrameStrobe[1] latch
XANTENNA__0415__D Tile_X0Y1_FrameData[27] VPWR VGND sg13cmos5l_antennanp
XANTENNA__0994__A0 Tile_X0Y1_E1END[0] VPWR VGND sg13cmos5l_antennanp
XANTENNA__1235__A1 Tile_X0Y0_E6END[1] VPWR VGND sg13cmos5l_antennanp
X_0079_ _0922_/A _1139_/X _1140_/X _0534_/Q VPWR VGND sg13cmos5l_mux2_1
XANTENNA__0150__D Tile_X0Y0_FrameData[6] VPWR VGND sg13cmos5l_antennanp
XFILLER_105_124 VPWR VGND sg13cmos5l_fill_1
XANTENNA__0727__X Tile_X0Y0_W2BEG[4] VPWR VGND sg13cmos5l_antennanp
XANTENNA__1226__A1 Tile_X0Y0_E2MID[0] VPWR VGND sg13cmos5l_antennanp
XANTENNA__0325__D Tile_X0Y0_FrameData[23] VPWR VGND sg13cmos5l_antennanp
XANTENNA__0985__A0 Tile_X0Y1_EE4END[3] VPWR VGND sg13cmos5l_antennanp
XANTENNA__0383__GATE Tile_X0Y1_FrameStrobe[1] VPWR VGND sg13cmos5l_antennanp
XANTENNA__0321__GATE Tile_X0Y1_FrameStrobe[7] VPWR VGND sg13cmos5l_antennanp
XANTENNA__0398__GATE Tile_X0Y1_FrameStrobe[1] VPWR VGND sg13cmos5l_antennanp
XANTENNA__1162__A0 Tile_X0Y1_E2MID[5] VPWR VGND sg13cmos5l_antennanp
X_1051_ _1051_/X _0636_/Q _0640_/Q _1080_/X _1095_/X _0226_/Q _0225_/Q VPWR VGND sg13cmos5l_mux4_1
X_1120_ _1120_/X _1208_/X _1212_/X _1216_/X _1196_/X _0575_/Q _0574_/Q VPWR VGND sg13cmos5l_mux4_1
XANTENNA__0235__D Tile_X0Y0_FrameData[17] VPWR VGND sg13cmos5l_antennanp
XANTENNA__0336__GATE Tile_X0Y1_FrameStrobe[7] VPWR VGND sg13cmos5l_antennanp
XANTENNA__0813__A Tile_X0Y1_FrameStrobe[10] VPWR VGND sg13cmos5l_antennanp
XANTENNA__0976__A0 Tile_X0Y0_E2MID[3] VPWR VGND sg13cmos5l_antennanp
XANTENNA__1217__A1 Tile_X0Y1_N4END[2] VPWR VGND sg13cmos5l_antennanp
X_0904_ Tile_X0Y1_S2BEGb[4] _1223_/X VPWR VGND sg13cmos5l_buf_1
XFILLER_51_0 VPWR VGND sg13cmos5l_fill_1
X_0835_ Tile_X0Y1_FrameData_O[11] Tile_X0Y1_FrameData[11] VPWR VGND sg13cmos5l_buf_1
X_0766_ Tile_X0Y0_N4BEG[15] _0766_/A VPWR VGND sg13cmos5l_buf_1
X_0697_ _0697_/L_HI VPWR VGND sg13cmos5l_tiehi
XFILLER_112_69 VPWR VGND sg13cmos5l_fill_2
XANTENNA__0145__D Tile_X0Y0_FrameData[11] VPWR VGND sg13cmos5l_antennanp
XANTENNA__1208__A1 Tile_X0Y1_N4END[1] VPWR VGND sg13cmos5l_antennanp
XFILLER_21_55 VPWR VGND sg13cmos5l_decap_8
XFILLER_21_88 VPWR VGND sg13cmos5l_decap_8
XANTENNA__0623__CLK Tile_X0Y1_UserCLK VPWR VGND sg13cmos5l_antennanp
XANTENNA__1144__A0 Tile_X0Y1_N1END[1] VPWR VGND sg13cmos5l_antennanp
XANTENNA__0920__X Tile_X0Y1_S4BEG[12] VPWR VGND sg13cmos5l_antennanp
X_0620_ NPU_ACT_WDATA2 Tile_X0Y1_UserCLK _0984_/X _0661_/L_HI VPWR VGND sg13cmos5l_dfrbpq_1
X_0551_ _0551_/Q Tile_X0Y1_FrameData[19] VGND VPWR Tile_X0Y1_FrameStrobe[6] latch
XANTENNA__1135__A0 Tile_X0Y1_E1END[0] VPWR VGND sg13cmos5l_antennanp
X_0482_ _0482_/Q Tile_X0Y1_FrameData[24] VGND VPWR Tile_X0Y1_FrameStrobe[4] latch
XFILLER_97_136 VPWR VGND sg13cmos5l_fill_1
XFILLER_87_92 VPWR VGND sg13cmos5l_fill_2
XANTENNA__0260__GATE Tile_X0Y1_FrameStrobe[5] VPWR VGND sg13cmos5l_antennanp
XANTENNA__0808__A Tile_X0Y1_FrameStrobe[5] VPWR VGND sg13cmos5l_antennanp
X_1034_ _1034_/X Tile_X0Y0_EE4END[7] _0639_/Q _1095_/X _1096_/X _0260_/Q _0259_/Q
+ VPWR VGND sg13cmos5l_mux4_1
X_1103_ _1103_/X Tile_X0Y1_E2MID[7] Tile_X0Y1_E2END[7] Tile_X0Y1_E6END[7] _1195_/X
+ _0594_/Q _0593_/Q VPWR VGND sg13cmos5l_mux4_1
XANTENNA__0275__GATE Tile_X0Y1_FrameStrobe[5] VPWR VGND sg13cmos5l_antennanp
XFILLER_99_0 VPWR VGND sg13cmos5l_fill_2
XANTENNA__0213__GATE Tile_X0Y1_FrameStrobe[3] VPWR VGND sg13cmos5l_antennanp
XANTENNA__0646__CLK Tile_X0Y1_UserCLK VPWR VGND sg13cmos5l_antennanp
XANTENNA__0830__X Tile_X0Y1_FrameData_O[6] VPWR VGND sg13cmos5l_antennanp
X_0818_ Tile_X0Y0_FrameStrobe_O[15] Tile_X0Y1_FrameStrobe[15] VPWR VGND sg13cmos5l_buf_1
X_0749_ Tile_X0Y0_W6BEG[10] _1073_/X VPWR VGND sg13cmos5l_buf_1
XFILLER_88_147 VPWR VGND sg13cmos5l_fill_1
XANTENNA__0228__GATE Tile_X0Y1_FrameStrobe[4] VPWR VGND sg13cmos5l_antennanp
XANTENNA__0718__A Tile_X0Y0_UserCLK VPWR VGND sg13cmos5l_antennanp
XANTENNA__1126__A0 Tile_X0Y1_E1END[3] VPWR VGND sg13cmos5l_antennanp
XANTENNA__0603__D Tile_X0Y1_FrameData[31] VPWR VGND sg13cmos5l_antennanp
XANTENNA__0740__X Tile_X0Y0_W6BEG[1] VPWR VGND sg13cmos5l_antennanp
XANTENNA__1117__A0 Tile_X0Y1_E1END[2] VPWR VGND sg13cmos5l_antennanp
XANTENNA__0915__X Tile_X0Y1_S4BEG[7] VPWR VGND sg13cmos5l_antennanp
XANTENNA__1199__A3 Tile_X0Y0_S2MID[4] VPWR VGND sg13cmos5l_antennanp
XFILLER_7_140 VPWR VGND sg13cmos5l_fill_2
XANTENNA__0513__D Tile_X0Y1_FrameData[25] VPWR VGND sg13cmos5l_antennanp
X_0603_ _0603_/Q Tile_X0Y1_FrameData[31] VGND VPWR Tile_X0Y1_FrameStrobe[0] latch
X_0534_ _0534_/Q Tile_X0Y1_FrameData[4] VGND VPWR Tile_X0Y1_FrameStrobe[5] latch
XANTENNA__1108__A0 Tile_X0Y1_E2MID[2] VPWR VGND sg13cmos5l_antennanp
X_0465_ _0465_/Q Tile_X0Y1_FrameData[9] VGND VPWR Tile_X0Y1_FrameStrobe[3] latch
X_0396_ _0396_/Q Tile_X0Y1_FrameData[14] VGND VPWR Tile_X0Y1_FrameStrobe[1] latch
XFILLER_85_106 VPWR VGND sg13cmos5l_decap_8
XANTENNA__0825__X Tile_X0Y1_FrameData_O[1] VPWR VGND sg13cmos5l_antennanp
X_1017_ _1017_/X Tile_X0Y0_E1END[3] Tile_X0Y0_EE4END[3] Tile_X0Y0_E6END[11] _1091_/X
+ _0313_/Q _0312_/Q VPWR VGND sg13cmos5l_mux4_1
XANTENNA__0152__GATE Tile_X0Y1_FrameStrobe[1] VPWR VGND sg13cmos5l_antennanp
XANTENNA__0423__D Tile_X0Y1_FrameData[19] VPWR VGND sg13cmos5l_antennanp
XANTENNA__0167__GATE Tile_X0Y1_FrameStrobe[2] VPWR VGND sg13cmos5l_antennanp
XANTENNA__0735__X Tile_X0Y0_W2BEGb[4] VPWR VGND sg13cmos5l_antennanp
XFILLER_84_150 VPWR VGND sg13cmos5l_decap_8
XANTENNA__0105__GATE Tile_X0Y1_FrameStrobe[0] VPWR VGND sg13cmos5l_antennanp
XFILLER_43_53 VPWR VGND sg13cmos5l_fill_1
XFILLER_43_75 VPWR VGND sg13cmos5l_decap_8
XANTENNA__0333__D Tile_X0Y0_FrameData[15] VPWR VGND sg13cmos5l_antennanp
XANTENNA__0911__A Tile_X0Y0_S4END[11] VPWR VGND sg13cmos5l_antennanp
XFILLER_67_128 VPWR VGND sg13cmos5l_fill_1
X_0250_ _0250_/Q Tile_X0Y0_FrameData[2] VGND VPWR Tile_X0Y1_FrameStrobe[4] latch
X_0181_ _0181_/Q Tile_X0Y0_FrameData[7] VGND VPWR Tile_X0Y1_FrameStrobe[2] latch
XFILLER_82_109 VPWR VGND sg13cmos5l_decap_8
XANTENNA__0508__D Tile_X0Y1_FrameData[30] VPWR VGND sg13cmos5l_antennanp
XANTENNA__0243__D Tile_X0Y0_FrameData[9] VPWR VGND sg13cmos5l_antennanp
XANTENNA__0821__A Tile_X0Y1_FrameStrobe[18] VPWR VGND sg13cmos5l_antennanp
XFILLER_58_106 VPWR VGND sg13cmos5l_fill_2
X_0517_ _0517_/Q Tile_X0Y1_FrameData[21] VGND VPWR Tile_X0Y1_FrameStrobe[5] latch
XANTENNA__0418__D Tile_X0Y1_FrameData[24] VPWR VGND sg13cmos5l_antennanp
XFILLER_104_59 VPWR VGND sg13cmos5l_fill_2
X_0448_ _0448_/Q Tile_X0Y1_FrameData[26] VGND VPWR Tile_X0Y1_FrameStrobe[3] latch
X_0379_ _0379_/Q Tile_X0Y1_FrameData[31] VGND VPWR Tile_X0Y1_FrameStrobe[1] latch
XANTENNA__0153__D Tile_X0Y0_FrameData[3] VPWR VGND sg13cmos5l_antennanp
XFILLER_89_16 VPWR VGND sg13cmos5l_fill_2
XANTENNA__1099__A2 Tile_X0Y0_S2MID[7] VPWR VGND sg13cmos5l_antennanp
XFILLER_1_168 VPWR VGND sg13cmos5l_fill_2
XFILLER_38_31 VPWR VGND sg13cmos5l_fill_1
XANTENNA__0328__D Tile_X0Y0_FrameData[20] VPWR VGND sg13cmos5l_antennanp
XANTENNA__1023__A2 Tile_X0Y0_E6END[6] VPWR VGND sg13cmos5l_antennanp
XFILLER_70_73 VPWR VGND sg13cmos5l_decap_8
X_0302_ _0302_/Q Tile_X0Y0_FrameData[14] VGND VPWR Tile_X0Y1_FrameStrobe[6] latch
XFILLER_79_93 VPWR VGND sg13cmos5l_decap_8
XANTENNA__0238__D Tile_X0Y0_FrameData[14] VPWR VGND sg13cmos5l_antennanp
X_0233_ _0233_/Q Tile_X0Y0_FrameData[19] VGND VPWR Tile_X0Y1_FrameStrobe[4] latch
X_0164_ _0164_/Q Tile_X0Y0_FrameData[24] VGND VPWR Tile_X0Y1_FrameStrobe[2] latch
XANTENNA__0816__A Tile_X0Y1_FrameStrobe[13] VPWR VGND sg13cmos5l_antennanp
X_0095_ _0095_/Q Tile_X0Y0_FrameData[29] VGND VPWR Tile_X0Y1_FrameStrobe[0] latch
XFILLER_81_0 VPWR VGND sg13cmos5l_decap_4
X_0997_ _0997_/X Tile_X0Y1_E1END[3] Tile_X0Y1_EE4END[7] Tile_X0Y1_EE4END[15] _1218_/X
+ _0404_/Q _0403_/Q VPWR VGND sg13cmos5l_mux4_1
XANTENNA__0148__D Tile_X0Y0_FrameData[8] VPWR VGND sg13cmos5l_antennanp
XFILLER_91_28 VPWR VGND sg13cmos5l_fill_1
XANTENNA__1005__A2 Tile_X0Y0_E6END[5] VPWR VGND sg13cmos5l_antennanp
XFILLER_108_144 VPWR VGND sg13cmos5l_fill_1
XFILLER_49_30 VPWR VGND sg13cmos5l_decap_8
XANTENNA__0923__X Tile_X0Y1_S4BEG[15] VPWR VGND sg13cmos5l_antennanp
XFILLER_60_101 VPWR VGND sg13cmos5l_fill_1
XFILLER_60_167 VPWR VGND sg13cmos5l_fill_1
X_0920_ Tile_X0Y1_S4BEG[12] _0920_/A VPWR VGND sg13cmos5l_buf_1
XANTENNA__0521__D Tile_X0Y1_FrameData[17] VPWR VGND sg13cmos5l_antennanp
XANTENNA__0551__GATE Tile_X0Y1_FrameStrobe[6] VPWR VGND sg13cmos5l_antennanp
X_0851_ Tile_X0Y1_FrameData_O[27] Tile_X0Y1_FrameData[27] VPWR VGND sg13cmos5l_buf_1
X_0782_ Tile_X0Y0_WW4BEG[15] _1062_/X VPWR VGND sg13cmos5l_buf_1
XANTENNA__0566__GATE Tile_X0Y1_FrameStrobe[6] VPWR VGND sg13cmos5l_antennanp
XANTENNA__1180__A1 Tile_X0Y0_S4END[5] VPWR VGND sg13cmos5l_antennanp
X_1196_ _1196_/X Tile_X0Y1_N2MID[1] Tile_X0Y1_N2END[1] _1220_/X Tile_X0Y0_S2MID[1]
+ _0368_/Q _0367_/Q VPWR VGND sg13cmos5l_mux4_1
X_0216_ _0216_/Q Tile_X0Y0_FrameData[4] VGND VPWR Tile_X0Y1_FrameStrobe[3] latch
X_0147_ _0147_/Q Tile_X0Y0_FrameData[9] VGND VPWR Tile_X0Y1_FrameStrobe[1] latch
X_0078_ _0921_/A _1137_/X _1138_/X _0537_/Q VPWR VGND sg13cmos5l_mux2_1
XANTENNA__0504__GATE Tile_X0Y1_FrameStrobe[4] VPWR VGND sg13cmos5l_antennanp
XANTENNA__0833__X Tile_X0Y1_FrameData_O[9] VPWR VGND sg13cmos5l_antennanp
XANTENNA__0994__A1 Tile_X0Y1_EE4END[4] VPWR VGND sg13cmos5l_antennanp
XANTENNA__0431__D Tile_X0Y1_FrameData[11] VPWR VGND sg13cmos5l_antennanp
XANTENNA__0519__GATE Tile_X0Y1_FrameStrobe[5] VPWR VGND sg13cmos5l_antennanp
XFILLER_105_169 VPWR VGND sg13cmos5l_fill_2
XANTENNA__0606__D Tile_X0Y1_FrameData[28] VPWR VGND sg13cmos5l_antennanp
XANTENNA__0743__X Tile_X0Y0_W6BEG[4] VPWR VGND sg13cmos5l_antennanp
XANTENNA__1226__A2 Tile_X0Y0_E2END[0] VPWR VGND sg13cmos5l_antennanp
XFILLER_35_98 VPWR VGND sg13cmos5l_fill_1
XANTENNA__0341__D Tile_X0Y0_FrameData[7] VPWR VGND sg13cmos5l_antennanp
XANTENNA__0985__A1 Tile_X0Y1_EE4END[11] VPWR VGND sg13cmos5l_antennanp
XFILLER_51_75 VPWR VGND sg13cmos5l_fill_2
XANTENNA__0918__X Tile_X0Y1_S4BEG[10] VPWR VGND sg13cmos5l_antennanp
XFILLER_33_145 VPWR VGND sg13cmos5l_fill_1
X_1050_ _1050_/X _0639_/Q _0643_/Q _1075_/X _1096_/X _0228_/Q _0227_/Q VPWR VGND sg13cmos5l_mux4_1
XANTENNA__0516__D Tile_X0Y1_FrameData[22] VPWR VGND sg13cmos5l_antennanp
XANTENNA__0976__A1 Tile_X0Y0_E2END[3] VPWR VGND sg13cmos5l_antennanp
XFILLER_33_178 VPWR VGND sg13cmos5l_fill_2
X_0903_ Tile_X0Y1_S2BEGb[3] _1222_/X VPWR VGND sg13cmos5l_buf_1
X_0834_ Tile_X0Y1_FrameData_O[10] Tile_X0Y1_FrameData[10] VPWR VGND sg13cmos5l_buf_1
XFILLER_92_82 VPWR VGND sg13cmos5l_decap_8
XANTENNA__0251__D Tile_X0Y0_FrameData[1] VPWR VGND sg13cmos5l_antennanp
XANTENNA__0490__GATE Tile_X0Y1_FrameStrobe[4] VPWR VGND sg13cmos5l_antennanp
XFILLER_44_0 VPWR VGND sg13cmos5l_decap_4
X_0765_ Tile_X0Y0_N4BEG[14] _0765_/A VPWR VGND sg13cmos5l_buf_1
X_0696_ _0696_/L_HI VPWR VGND sg13cmos5l_tiehi
XANTENNA__0828__X Tile_X0Y1_FrameData_O[4] VPWR VGND sg13cmos5l_antennanp
XANTENNA__0426__D Tile_X0Y1_FrameData[16] VPWR VGND sg13cmos5l_antennanp
XANTENNA__0443__GATE Tile_X0Y1_FrameStrobe[3] VPWR VGND sg13cmos5l_antennanp
XFILLER_24_134 VPWR VGND sg13cmos5l_fill_1
X_1179_ _1179_/X Tile_X0Y1_N4END[0] Tile_X0Y0_S4END[4] _1214_/X _1218_/X _0458_/Q
+ _0457_/Q VPWR VGND sg13cmos5l_mux4_1
XANTENNA__0161__D Tile_X0Y0_FrameData[27] VPWR VGND sg13cmos5l_antennanp
XANTENNA__0458__GATE Tile_X0Y1_FrameStrobe[3] VPWR VGND sg13cmos5l_antennanp
XFILLER_21_67 VPWR VGND sg13cmos5l_decap_4
XANTENNA__0738__X Tile_X0Y0_W2BEGb[7] VPWR VGND sg13cmos5l_antennanp
XFILLER_46_31 VPWR VGND sg13cmos5l_decap_4
XANTENNA__0336__D Tile_X0Y0_FrameData[12] VPWR VGND sg13cmos5l_antennanp
XANTENNA__0914__A Tile_X0Y0_S4END[14] VPWR VGND sg13cmos5l_antennanp
X_0550_ _0550_/Q Tile_X0Y1_FrameData[20] VGND VPWR Tile_X0Y1_FrameStrobe[6] latch
XANTENNA__1135__A1 Tile_X0Y1_EE4END[12] VPWR VGND sg13cmos5l_antennanp
X_1102_ _1102_/X _1113_/X Tile_X0Y0_E6END[2] Tile_X0Y0_S1END[2] _1102_/A3 _0096_/Q
+ _0095_/Q VPWR VGND sg13cmos5l_mux4_1
X_0481_ _0481_/Q Tile_X0Y1_FrameData[25] VGND VPWR Tile_X0Y1_FrameStrobe[4] latch
XANTENNA__0246__D Tile_X0Y0_FrameData[6] VPWR VGND sg13cmos5l_antennanp
XANTENNA__0824__A Tile_X0Y1_FrameData[0] VPWR VGND sg13cmos5l_antennanp
X_1033_ _1033_/X Tile_X0Y0_EE4END[6] _0638_/Q _1094_/X _1097_/X _0262_/Q _0261_/Q
+ VPWR VGND sg13cmos5l_mux4_1
X_0817_ Tile_X0Y0_FrameStrobe_O[14] Tile_X0Y1_FrameStrobe[14] VPWR VGND sg13cmos5l_buf_1
XANTENNA__1126__A1 Tile_X0Y1_E6END[11] VPWR VGND sg13cmos5l_antennanp
X_0748_ Tile_X0Y0_W6BEG[9] _1072_/X VPWR VGND sg13cmos5l_buf_1
X_0679_ _0679_/L_HI VPWR VGND sg13cmos5l_tiehi
XFILLER_83_29 VPWR VGND sg13cmos5l_fill_1
XANTENNA__0156__D Tile_X0Y0_FrameData[0] VPWR VGND sg13cmos5l_antennanp
XANTENNA__0382__GATE Tile_X0Y1_FrameStrobe[1] VPWR VGND sg13cmos5l_antennanp
XANTENNA__0397__GATE Tile_X0Y1_FrameStrobe[1] VPWR VGND sg13cmos5l_antennanp
XANTENNA__0320__GATE Tile_X0Y1_FrameStrobe[7] VPWR VGND sg13cmos5l_antennanp
XFILLER_113_3 VPWR VGND sg13cmos5l_fill_1
XANTENNA__0335__GATE Tile_X0Y1_FrameStrobe[7] VPWR VGND sg13cmos5l_antennanp
XANTENNA__0909__A Tile_X0Y0_S4END[9] VPWR VGND sg13cmos5l_antennanp
XANTENNA__1117__A1 Tile_X0Y1_EE4END[2] VPWR VGND sg13cmos5l_antennanp
XFILLER_94_118 VPWR VGND sg13cmos5l_fill_1
XFILLER_113_80 VPWR VGND sg13cmos5l_fill_1
XFILLER_73_73 VPWR VGND sg13cmos5l_fill_2
XANTENNA__0931__X Tile_X0Y1_W2BEG[2] VPWR VGND sg13cmos5l_antennanp
XANTENNA__1108__A1 Tile_X0Y1_E2END[2] VPWR VGND sg13cmos5l_antennanp
X_0602_ _0602_/Q Tile_X0Y1_FrameData[0] VGND VPWR Tile_X0Y1_FrameStrobe[7] latch
X_0533_ _0533_/Q Tile_X0Y1_FrameData[5] VGND VPWR Tile_X0Y1_FrameStrobe[5] latch
X_0464_ _0464_/Q Tile_X0Y1_FrameData[10] VGND VPWR Tile_X0Y1_FrameStrobe[3] latch
XANTENNA__0819__A Tile_X0Y1_FrameStrobe[16] VPWR VGND sg13cmos5l_antennanp
X_0395_ _0395_/Q Tile_X0Y1_FrameData[15] VGND VPWR Tile_X0Y1_FrameStrobe[1] latch
XANTENNA__1044__A0 Tile_X0Y0_EE4END[12] VPWR VGND sg13cmos5l_antennanp
X_1016_ _1016_/X _1085_/X _1081_/X _1077_/X _1094_/X _0316_/Q _0315_/Q VPWR VGND sg13cmos5l_mux4_1
XANTENNA__0613__CLK Tile_X0Y1_UserCLK VPWR VGND sg13cmos5l_antennanp
XANTENNA__0841__X Tile_X0Y1_FrameData_O[17] VPWR VGND sg13cmos5l_antennanp
XFILLER_76_129 VPWR VGND sg13cmos5l_decap_8
XANTENNA__0751__X Tile_X0Y0_N4BEG[0] VPWR VGND sg13cmos5l_antennanp
XANTENNA__1035__A0 Tile_X0Y0_EE4END[8] VPWR VGND sg13cmos5l_antennanp
XANTENNA__0274__GATE Tile_X0Y1_FrameStrobe[5] VPWR VGND sg13cmos5l_antennanp
XFILLER_108_80 VPWR VGND sg13cmos5l_fill_1
XFILLER_111_0 VPWR VGND sg13cmos5l_decap_4
XFILLER_4_15 VPWR VGND sg13cmos5l_fill_2
XANTENNA__0289__GATE Tile_X0Y1_FrameStrobe[6] VPWR VGND sg13cmos5l_antennanp
XANTENNA__0926__X Tile_X0Y1_W1BEG[1] VPWR VGND sg13cmos5l_antennanp
XFILLER_68_95 VPWR VGND sg13cmos5l_fill_1
X_0180_ _0180_/Q Tile_X0Y0_FrameData[8] VGND VPWR Tile_X0Y1_FrameStrobe[2] latch
XFILLER_90_132 VPWR VGND sg13cmos5l_decap_8
XANTENNA__0212__GATE Tile_X0Y1_FrameStrobe[3] VPWR VGND sg13cmos5l_antennanp
XANTENNA__0636__CLK Tile_X0Y1_UserCLK VPWR VGND sg13cmos5l_antennanp
XFILLER_90_143 VPWR VGND sg13cmos5l_fill_2
XFILLER_84_94 VPWR VGND sg13cmos5l_decap_4
XANTENNA__0227__GATE Tile_X0Y1_FrameStrobe[4] VPWR VGND sg13cmos5l_antennanp
XANTENNA__0524__D Tile_X0Y1_FrameData[14] VPWR VGND sg13cmos5l_antennanp
XANTENNA__0610__Q NPU_WEIGHT_IN0 VPWR VGND sg13cmos5l_antennanp
X_0516_ _0516_/Q Tile_X0Y1_FrameData[22] VGND VPWR Tile_X0Y1_FrameStrobe[5] latch
X_0447_ _0447_/Q Tile_X0Y1_FrameData[27] VGND VPWR Tile_X0Y1_FrameStrobe[3] latch
XANTENNA__0836__X Tile_X0Y1_FrameData_O[12] VPWR VGND sg13cmos5l_antennanp
X_0378_ _0378_/Q Tile_X0Y1_FrameData[0] VGND VPWR Tile_X0Y1_FrameStrobe[0] latch
XFILLER_81_121 VPWR VGND sg13cmos5l_fill_2
XANTENNA__0434__D Tile_X0Y1_FrameData[8] VPWR VGND sg13cmos5l_antennanp
XANTENNA__1017__A0 Tile_X0Y0_E1END[3] VPWR VGND sg13cmos5l_antennanp
XFILLER_13_24 VPWR VGND sg13cmos5l_decap_4
XFILLER_13_35 VPWR VGND sg13cmos5l_decap_8
XFILLER_13_46 VPWR VGND sg13cmos5l_fill_2
XANTENNA__0609__D Tile_X0Y1_FrameData[31] VPWR VGND sg13cmos5l_antennanp
XANTENNA__0746__X Tile_X0Y0_W6BEG[7] VPWR VGND sg13cmos5l_antennanp
XANTENNA__1099__A3 Tile_X0Y0_S2END[7] VPWR VGND sg13cmos5l_antennanp
XFILLER_54_31 VPWR VGND sg13cmos5l_fill_2
XANTENNA__0344__D Tile_X0Y0_FrameData[4] VPWR VGND sg13cmos5l_antennanp
XANTENNA__1008__A0 Tile_X0Y0_E2MID[2] VPWR VGND sg13cmos5l_antennanp
X_0301_ _0301_/Q Tile_X0Y0_FrameData[15] VGND VPWR Tile_X0Y1_FrameStrobe[6] latch
XANTENNA__0151__GATE Tile_X0Y1_FrameStrobe[1] VPWR VGND sg13cmos5l_antennanp
XANTENNA__0519__D Tile_X0Y1_FrameData[19] VPWR VGND sg13cmos5l_antennanp
XFILLER_63_110 VPWR VGND sg13cmos5l_fill_1
X_0232_ _0232_/Q Tile_X0Y0_FrameData[20] VGND VPWR Tile_X0Y1_FrameStrobe[4] latch
X_0163_ _0163_/Q Tile_X0Y0_FrameData[25] VGND VPWR Tile_X0Y1_FrameStrobe[2] latch
X_0094_ _0094_/Q Tile_X0Y0_FrameData[30] VGND VPWR Tile_X0Y1_FrameStrobe[0] latch
XFILLER_95_60 VPWR VGND sg13cmos5l_decap_4
XANTENNA__0166__GATE Tile_X0Y1_FrameStrobe[2] VPWR VGND sg13cmos5l_antennanp
XANTENNA__0254__D Tile_X0Y0_FrameData[30] VPWR VGND sg13cmos5l_antennanp
XANTENNA__0832__A Tile_X0Y1_FrameData[8] VPWR VGND sg13cmos5l_antennanp
XFILLER_74_0 VPWR VGND sg13cmos5l_fill_1
X_0996_ _0996_/X Tile_X0Y1_E1END[2] Tile_X0Y1_EE4END[6] Tile_X0Y1_EE4END[14] _1217_/X
+ _0406_/Q _0405_/Q VPWR VGND sg13cmos5l_mux4_1
XFILLER_117_145 VPWR VGND sg13cmos5l_fill_1
XANTENNA__0104__GATE Tile_X0Y1_FrameStrobe[0] VPWR VGND sg13cmos5l_antennanp
XANTENNA__0429__D Tile_X0Y1_FrameData[13] VPWR VGND sg13cmos5l_antennanp
XANTENNA__0119__GATE Tile_X0Y1_FrameStrobe[0] VPWR VGND sg13cmos5l_antennanp
XANTENNA__0164__D Tile_X0Y0_FrameData[24] VPWR VGND sg13cmos5l_antennanp
XFILLER_24_78 VPWR VGND sg13cmos5l_decap_4
XFILLER_40_55 VPWR VGND sg13cmos5l_decap_8
XFILLER_40_99 VPWR VGND sg13cmos5l_fill_1
XANTENNA__0339__D Tile_X0Y0_FrameData[9] VPWR VGND sg13cmos5l_antennanp
XANTENNA__1229__A0 Tile_X0Y0_E1END[2] VPWR VGND sg13cmos5l_antennanp
XFILLER_60_179 VPWR VGND sg13cmos5l_fill_1
X_0850_ Tile_X0Y1_FrameData_O[26] Tile_X0Y1_FrameData[26] VPWR VGND sg13cmos5l_buf_1
X_0781_ Tile_X0Y0_WW4BEG[14] _1061_/X VPWR VGND sg13cmos5l_buf_1
XANTENNA__0249__D Tile_X0Y0_FrameData[3] VPWR VGND sg13cmos5l_antennanp
X_0215_ _0215_/Q Tile_X0Y0_FrameData[5] VGND VPWR Tile_X0Y1_FrameStrobe[3] latch
XANTENNA__0827__A Tile_X0Y1_FrameData[3] VPWR VGND sg13cmos5l_antennanp
XFILLER_51_179 VPWR VGND sg13cmos5l_fill_1
X_1195_ _1195_/X Tile_X0Y1_N2MID[0] Tile_X0Y1_N2END[0] _1219_/X Tile_X0Y0_S2MID[0]
+ _0370_/Q _0369_/Q VPWR VGND sg13cmos5l_mux4_1
X_0146_ _0146_/Q Tile_X0Y0_FrameData[10] VGND VPWR Tile_X0Y1_FrameStrobe[1] latch
X_0077_ _0920_/A _1135_/X _1136_/X _0540_/Q VPWR VGND sg13cmos5l_mux2_1
XANTENNA__0994__A2 Tile_X0Y1_EE4END[12] VPWR VGND sg13cmos5l_antennanp
X_0979_ _0979_/X Tile_X0Y0_E2MID[6] Tile_X0Y0_E2END[6] _1098_/X _0979_/A3 _0158_/Q
+ _0157_/Q VPWR VGND sg13cmos5l_mux4_1
XANTENNA__0159__D Tile_X0Y0_FrameData[29] VPWR VGND sg13cmos5l_antennanp
XANTENNA__0985__A2 Tile_X0Y1_E6END[3] VPWR VGND sg13cmos5l_antennanp
XFILLER_51_65 VPWR VGND sg13cmos5l_fill_1
XFILLER_51_98 VPWR VGND sg13cmos5l_fill_2
XFILLER_76_84 VPWR VGND sg13cmos5l_fill_2
XANTENNA__0934__X Tile_X0Y1_W2BEG[5] VPWR VGND sg13cmos5l_antennanp
XFILLER_76_95 VPWR VGND sg13cmos5l_decap_8
XANTENNA__0532__D Tile_X0Y1_FrameData[6] VPWR VGND sg13cmos5l_antennanp
XANTENNA__1217__A3 Tile_X0Y0_S4END[6] VPWR VGND sg13cmos5l_antennanp
X_0902_ Tile_X0Y1_S2BEGb[2] _1221_/X VPWR VGND sg13cmos5l_buf_1
X_0833_ Tile_X0Y1_FrameData_O[9] Tile_X0Y1_FrameData[9] VPWR VGND sg13cmos5l_buf_1
XFILLER_102_107 VPWR VGND sg13cmos5l_fill_1
XFILLER_37_0 VPWR VGND sg13cmos5l_fill_2
X_0764_ Tile_X0Y0_N4BEG[13] _0764_/A VPWR VGND sg13cmos5l_buf_1
X_0695_ _0695_/L_HI VPWR VGND sg13cmos5l_tiehi
XFILLER_2_92 VPWR VGND sg13cmos5l_fill_1
X_1178_ _1178_/X _0647_/Q _0651_/Q _1203_/X _1195_/X _0460_/Q _0459_/Q VPWR VGND sg13cmos5l_mux4_1
XANTENNA__0844__X Tile_X0Y1_FrameData_O[20] VPWR VGND sg13cmos5l_antennanp
XANTENNA__1208__A3 Tile_X0Y0_S4END[5] VPWR VGND sg13cmos5l_antennanp
X_0129_ _0129_/Q Tile_X0Y0_FrameData[27] VGND VPWR Tile_X0Y1_FrameStrobe[1] latch
XANTENNA__0442__D Tile_X0Y1_FrameData[0] VPWR VGND sg13cmos5l_antennanp
XANTENNA__0550__GATE Tile_X0Y1_FrameStrobe[6] VPWR VGND sg13cmos5l_antennanp
XANTENNA__0754__X Tile_X0Y0_N4BEG[3] VPWR VGND sg13cmos5l_antennanp
XANTENNA__0352__D Tile_X0Y1_FrameData[26] VPWR VGND sg13cmos5l_antennanp
XANTENNA__0565__GATE Tile_X0Y1_FrameStrobe[6] VPWR VGND sg13cmos5l_antennanp
XANTENNA__1080__A1 Tile_X0Y1_N4END[7] VPWR VGND sg13cmos5l_antennanp
XFILLER_30_138 VPWR VGND sg13cmos5l_fill_2
XANTENNA__0929__X Tile_X0Y1_W2BEG[0] VPWR VGND sg13cmos5l_antennanp
X_0480_ _0480_/Q Tile_X0Y1_FrameData[26] VGND VPWR Tile_X0Y1_FrameStrobe[4] latch
XANTENNA__0503__GATE Tile_X0Y1_FrameStrobe[4] VPWR VGND sg13cmos5l_antennanp
XANTENNA__1135__A2 Tile_X0Y1_E6END[4] VPWR VGND sg13cmos5l_antennanp
X_1032_ _1032_/X Tile_X0Y0_EE4END[5] _0637_/Q _1093_/X _1098_/X _0264_/Q _0263_/Q
+ VPWR VGND sg13cmos5l_mux4_1
X_1101_ _1101_/X _1112_/X Tile_X0Y0_E6END[1] Tile_X0Y0_S1END[1] _1101_/A3 _0098_/Q
+ _0097_/Q VPWR VGND sg13cmos5l_mux4_1
XFILLER_87_94 VPWR VGND sg13cmos5l_fill_1
XANTENNA__0518__GATE Tile_X0Y1_FrameStrobe[5] VPWR VGND sg13cmos5l_antennanp
XANTENNA__0527__D Tile_X0Y1_FrameData[11] VPWR VGND sg13cmos5l_antennanp
XFILLER_21_127 VPWR VGND sg13cmos5l_fill_2
XANTENNA__0262__D Tile_X0Y0_FrameData[22] VPWR VGND sg13cmos5l_antennanp
XANTENNA__0613__Q NPU_WEIGHT_IN3 VPWR VGND sg13cmos5l_antennanp
XANTENNA__0840__A Tile_X0Y1_FrameData[16] VPWR VGND sg13cmos5l_antennanp
X_0816_ Tile_X0Y0_FrameStrobe_O[13] Tile_X0Y1_FrameStrobe[13] VPWR VGND sg13cmos5l_buf_1
X_0747_ Tile_X0Y0_W6BEG[8] _1071_/X VPWR VGND sg13cmos5l_buf_1
XANTENNA__0839__X Tile_X0Y1_FrameData_O[15] VPWR VGND sg13cmos5l_antennanp
X_0678_ _0678_/L_HI VPWR VGND sg13cmos5l_tiehi
XANTENNA__0437__D Tile_X0Y1_FrameData[5] VPWR VGND sg13cmos5l_antennanp
XFILLER_16_46 VPWR VGND sg13cmos5l_decap_8
XFILLER_16_57 VPWR VGND sg13cmos5l_fill_1
XANTENNA__0172__D Tile_X0Y0_FrameData[16] VPWR VGND sg13cmos5l_antennanp
XFILLER_32_34 VPWR VGND sg13cmos5l_fill_2
XFILLER_8_109 VPWR VGND sg13cmos5l_decap_8
XFILLER_79_116 VPWR VGND sg13cmos5l_fill_2
XANTENNA__0749__X Tile_X0Y0_W6BEG[10] VPWR VGND sg13cmos5l_antennanp
XANTENNA__1117__A2 Tile_X0Y1_E6END[10] VPWR VGND sg13cmos5l_antennanp
XANTENNA__0347__D Tile_X0Y0_FrameData[31] VPWR VGND sg13cmos5l_antennanp
XFILLER_73_30 VPWR VGND sg13cmos5l_decap_4
X_0601_ _0601_/Q Tile_X0Y1_FrameData[1] VGND VPWR Tile_X0Y1_FrameStrobe[7] latch
XFILLER_7_131 VPWR VGND sg13cmos5l_fill_2
XFILLER_7_120 VPWR VGND sg13cmos5l_decap_8
XANTENNA__0442__GATE Tile_X0Y1_FrameStrobe[2] VPWR VGND sg13cmos5l_antennanp
XANTENNA__1108__A2 Tile_X0Y1_E6END[2] VPWR VGND sg13cmos5l_antennanp
X_0532_ _0532_/Q Tile_X0Y1_FrameData[6] VGND VPWR Tile_X0Y1_FrameStrobe[5] latch
X_0463_ _0463_/Q Tile_X0Y1_FrameData[11] VGND VPWR Tile_X0Y1_FrameStrobe[3] latch
X_0394_ _0394_/Q Tile_X0Y1_FrameData[16] VGND VPWR Tile_X0Y1_FrameStrobe[1] latch
XFILLER_98_93 VPWR VGND sg13cmos5l_fill_2
XANTENNA__0257__D Tile_X0Y0_FrameData[27] VPWR VGND sg13cmos5l_antennanp
XANTENNA__0457__GATE Tile_X0Y1_FrameStrobe[3] VPWR VGND sg13cmos5l_antennanp
XANTENNA__0835__A Tile_X0Y1_FrameData[11] VPWR VGND sg13cmos5l_antennanp
X_1015_ _1015_/X Tile_X0Y0_E1END[2] Tile_X0Y0_EE4END[2] Tile_X0Y0_E6END[10] _1090_/X
+ _0316_/Q _0315_/Q VPWR VGND sg13cmos5l_mux4_1
XFILLER_93_130 VPWR VGND sg13cmos5l_decap_8
XFILLER_94_29 VPWR VGND sg13cmos5l_decap_8
XANTENNA__0167__D Tile_X0Y0_FrameData[21] VPWR VGND sg13cmos5l_antennanp
XFILLER_104_0 VPWR VGND sg13cmos5l_fill_1
XANTENNA__0942__X Tile_X0Y1_W2BEGb[5] VPWR VGND sg13cmos5l_antennanp
XANTENNA__0381__GATE Tile_X0Y1_FrameStrobe[1] VPWR VGND sg13cmos5l_antennanp
XANTENNA__0540__D Tile_X0Y1_FrameData[30] VPWR VGND sg13cmos5l_antennanp
XANTENNA__0396__GATE Tile_X0Y1_FrameStrobe[1] VPWR VGND sg13cmos5l_antennanp
X_0515_ _0515_/Q Tile_X0Y1_FrameData[23] VGND VPWR Tile_X0Y1_FrameStrobe[5] latch
X_0446_ _0446_/Q Tile_X0Y1_FrameData[28] VGND VPWR Tile_X0Y1_FrameStrobe[3] latch
X_0377_ _0377_/Q Tile_X0Y1_FrameData[1] VGND VPWR Tile_X0Y1_FrameStrobe[0] latch
XANTENNA__0334__GATE Tile_X0Y1_FrameStrobe[7] VPWR VGND sg13cmos5l_antennanp
XANTENNA__0852__X Tile_X0Y1_FrameData_O[28] VPWR VGND sg13cmos5l_antennanp
XANTENNA__1017__A1 Tile_X0Y0_EE4END[3] VPWR VGND sg13cmos5l_antennanp
XANTENNA__0349__GATE Tile_X0Y1_FrameStrobe[0] VPWR VGND sg13cmos5l_antennanp
XANTENNA__0450__D Tile_X0Y1_FrameData[24] VPWR VGND sg13cmos5l_antennanp
XFILLER_38_99 VPWR VGND sg13cmos5l_decap_8
XFILLER_72_122 VPWR VGND sg13cmos5l_fill_1
XANTENNA__0762__X Tile_X0Y0_N4BEG[11] VPWR VGND sg13cmos5l_antennanp
XANTENNA__1008__A1 Tile_X0Y0_E2END[2] VPWR VGND sg13cmos5l_antennanp
XFILLER_110_71 VPWR VGND sg13cmos5l_fill_1
XFILLER_110_93 VPWR VGND sg13cmos5l_fill_1
XANTENNA__0360__D Tile_X0Y1_FrameData[18] VPWR VGND sg13cmos5l_antennanp
XANTENNA__0937__X Tile_X0Y1_W2BEGb[0] VPWR VGND sg13cmos5l_antennanp
XANTENNA__1192__A0 Tile_X0Y1_N1END[1] VPWR VGND sg13cmos5l_antennanp
X_0300_ _0300_/Q Tile_X0Y0_FrameData[16] VGND VPWR Tile_X0Y1_FrameStrobe[6] latch
X_0231_ _0231_/Q Tile_X0Y0_FrameData[21] VGND VPWR Tile_X0Y1_FrameStrobe[4] latch
XANTENNA__0535__D Tile_X0Y1_FrameData[3] VPWR VGND sg13cmos5l_antennanp
XFILLER_63_155 VPWR VGND sg13cmos5l_fill_1
X_0162_ _0162_/Q Tile_X0Y0_FrameData[26] VGND VPWR Tile_X0Y1_FrameStrobe[2] latch
X_0093_ NPU_XBAR_SEL3 Tile_X0Y1_UserCLK _0093_/D _0652_/L_HI VPWR VGND sg13cmos5l_dfrbpq_1
X_0995_ _0995_/X Tile_X0Y1_E1END[1] Tile_X0Y1_EE4END[5] Tile_X0Y1_EE4END[13] _1216_/X
+ _0408_/Q _0407_/Q VPWR VGND sg13cmos5l_mux4_1
XANTENNA__0270__D Tile_X0Y0_FrameData[14] VPWR VGND sg13cmos5l_antennanp
XANTENNA__0621__Q NPU_ACT_WDATA3 VPWR VGND sg13cmos5l_antennanp
XFILLER_5_70 VPWR VGND sg13cmos5l_decap_4
XANTENNA__0847__X Tile_X0Y1_FrameData_O[23] VPWR VGND sg13cmos5l_antennanp
X_0429_ _0429_/Q Tile_X0Y1_FrameData[13] VGND VPWR Tile_X0Y1_FrameStrobe[2] latch
XANTENNA__0273__GATE Tile_X0Y1_FrameStrobe[5] VPWR VGND sg13cmos5l_antennanp
XANTENNA__0445__D Tile_X0Y1_FrameData[29] VPWR VGND sg13cmos5l_antennanp
XANTENNA__0997__A0 Tile_X0Y1_E1END[3] VPWR VGND sg13cmos5l_antennanp
XANTENNA__0180__D Tile_X0Y0_FrameData[8] VPWR VGND sg13cmos5l_antennanp
XANTENNA__0288__GATE Tile_X0Y1_FrameStrobe[6] VPWR VGND sg13cmos5l_antennanp
XFILLER_108_179 VPWR VGND sg13cmos5l_fill_1
XANTENNA__0211__GATE Tile_X0Y1_FrameStrobe[3] VPWR VGND sg13cmos5l_antennanp
XANTENNA__0626__CLK Tile_X0Y1_UserCLK VPWR VGND sg13cmos5l_antennanp
XANTENNA__0757__X Tile_X0Y0_N4BEG[6] VPWR VGND sg13cmos5l_antennanp
XFILLER_49_54 VPWR VGND sg13cmos5l_fill_2
XANTENNA__0226__GATE Tile_X0Y1_FrameStrobe[4] VPWR VGND sg13cmos5l_antennanp
XANTENNA__1229__A1 Tile_X0Y0_E6END[10] VPWR VGND sg13cmos5l_antennanp
XFILLER_105_93 VPWR VGND sg13cmos5l_decap_8
XANTENNA__0355__D Tile_X0Y1_FrameData[23] VPWR VGND sg13cmos5l_antennanp
XANTENNA__0988__A0 Tile_X0Y1_EE4END[6] VPWR VGND sg13cmos5l_antennanp
X_0780_ Tile_X0Y0_WW4BEG[13] _1060_/X VPWR VGND sg13cmos5l_buf_1
XFILLER_114_105 VPWR VGND sg13cmos5l_fill_2
XFILLER_114_116 VPWR VGND sg13cmos5l_fill_2
XFILLER_39_4 VPWR VGND sg13cmos5l_fill_2
X_1194_ _1194_/X Tile_X0Y1_N1END[3] Tile_X0Y1_E6END[3] _1230_/X _1194_/A3 _0348_/Q
+ _0603_/Q VPWR VGND sg13cmos5l_mux4_1
X_0214_ _0214_/Q Tile_X0Y0_FrameData[6] VGND VPWR Tile_X0Y1_FrameStrobe[3] latch
XANTENNA__0265__D Tile_X0Y0_FrameData[19] VPWR VGND sg13cmos5l_antennanp
XANTENNA__0616__Q NPU_WEIGHT_IN6 VPWR VGND sg13cmos5l_antennanp
XANTENNA__0843__A Tile_X0Y1_FrameData[19] VPWR VGND sg13cmos5l_antennanp
XANTENNA__0979__A0 Tile_X0Y0_E2MID[6] VPWR VGND sg13cmos5l_antennanp
X_0145_ _0145_/Q Tile_X0Y0_FrameData[11] VGND VPWR Tile_X0Y1_FrameStrobe[1] latch
X_0076_ _0762_/A _1115_/X _1116_/X _0567_/Q VPWR VGND sg13cmos5l_mux2_1
XANTENNA__0649__CLK Tile_X0Y1_UserCLK VPWR VGND sg13cmos5l_antennanp
X_0978_ _0978_/X Tile_X0Y0_E2MID[5] Tile_X0Y0_E2END[5] _1097_/X _0978_/A3 _0160_/Q
+ _0159_/Q VPWR VGND sg13cmos5l_mux4_1
XANTENNA__1156__A0 Tile_X0Y1_E2MID[4] VPWR VGND sg13cmos5l_antennanp
XFILLER_19_68 VPWR VGND sg13cmos5l_fill_1
XANTENNA__0175__D Tile_X0Y0_FrameData[13] VPWR VGND sg13cmos5l_antennanp
XANTENNA__0753__A Tile_X0Y1_N4END[10] VPWR VGND sg13cmos5l_antennanp
XFILLER_35_89 VPWR VGND sg13cmos5l_fill_2
XANTENNA__0150__GATE Tile_X0Y1_FrameStrobe[1] VPWR VGND sg13cmos5l_antennanp
XANTENNA__1147__A0 Tile_X0Y1_E2MID[0] VPWR VGND sg13cmos5l_antennanp
XANTENNA__0165__GATE Tile_X0Y1_FrameStrobe[2] VPWR VGND sg13cmos5l_antennanp
XANTENNA__0103__GATE Tile_X0Y1_FrameStrobe[0] VPWR VGND sg13cmos5l_antennanp
XANTENNA__0950__X Tile_X0Y1_W6BEG[5] VPWR VGND sg13cmos5l_antennanp
X_0901_ Tile_X0Y1_S2BEGb[1] _1220_/X VPWR VGND sg13cmos5l_buf_1
X_0832_ Tile_X0Y1_FrameData_O[8] Tile_X0Y1_FrameData[8] VPWR VGND sg13cmos5l_buf_1
X_0763_ Tile_X0Y0_N4BEG[12] _0763_/A VPWR VGND sg13cmos5l_buf_1
XANTENNA__0118__GATE Tile_X0Y1_FrameStrobe[0] VPWR VGND sg13cmos5l_antennanp
XANTENNA__0838__A Tile_X0Y1_FrameData[14] VPWR VGND sg13cmos5l_antennanp
X_0694_ _0694_/L_HI VPWR VGND sg13cmos5l_tiehi
X_1177_ _1177_/X _0646_/Q _0650_/Q _1204_/X _1196_/X _0462_/Q _0461_/Q VPWR VGND sg13cmos5l_mux4_1
X_0128_ _0128_/Q Tile_X0Y0_FrameData[28] VGND VPWR Tile_X0Y1_FrameStrobe[1] latch
XANTENNA__0860__X Tile_X0Y0_FrameData_O[4] VPWR VGND sg13cmos5l_antennanp
XANTENNA__1129__A0 Tile_X0Y1_E2MID[5] VPWR VGND sg13cmos5l_antennanp
XFILLER_102_72 VPWR VGND sg13cmos5l_decap_8
XFILLER_102_94 VPWR VGND sg13cmos5l_fill_2
XFILLER_15_114 VPWR VGND sg13cmos5l_decap_4
XFILLER_15_169 VPWR VGND sg13cmos5l_fill_2
XFILLER_46_88 VPWR VGND sg13cmos5l_fill_1
XANTENNA__0770__X Tile_X0Y0_WW4BEG[3] VPWR VGND sg13cmos5l_antennanp
XANTENNA__1080__A2 Tile_X0Y0_S1END[3] VPWR VGND sg13cmos5l_antennanp
XFILLER_62_76 VPWR VGND sg13cmos5l_fill_2
XANTENNA__0945__X Tile_X0Y1_W6BEG[0] VPWR VGND sg13cmos5l_antennanp
X_1031_ _1031_/X Tile_X0Y0_EE4END[4] _0636_/Q _1092_/X _1099_/X _0266_/Q _0265_/Q
+ VPWR VGND sg13cmos5l_mux4_1
X_1100_ _1100_/X _1111_/X Tile_X0Y0_E6END[0] Tile_X0Y0_S1END[0] _1100_/A3 _0100_/Q
+ _0099_/Q VPWR VGND sg13cmos5l_mux4_1
XANTENNA__0543__D Tile_X0Y1_FrameData[27] VPWR VGND sg13cmos5l_antennanp
X_0815_ Tile_X0Y0_FrameStrobe_O[12] Tile_X0Y1_FrameStrobe[12] VPWR VGND sg13cmos5l_buf_1
X_0746_ Tile_X0Y0_W6BEG[7] _1070_/X VPWR VGND sg13cmos5l_buf_1
X_0677_ _0677_/L_HI VPWR VGND sg13cmos5l_tiehi
XANTENNA__0855__X Tile_X0Y1_FrameData_O[31] VPWR VGND sg13cmos5l_antennanp
X_1229_ _1229_/X Tile_X0Y0_E1END[2] Tile_X0Y0_E6END[10] _1077_/X _1102_/X _0306_/Q
+ _0305_/Q VPWR VGND sg13cmos5l_mux4_1
XANTENNA__0453__D Tile_X0Y1_FrameData[21] VPWR VGND sg13cmos5l_antennanp
XFILLER_32_68 VPWR VGND sg13cmos5l_fill_1
XANTENNA__0765__X Tile_X0Y0_N4BEG[14] VPWR VGND sg13cmos5l_antennanp
XANTENNA__0363__D Tile_X0Y1_FrameData[15] VPWR VGND sg13cmos5l_antennanp
XFILLER_73_64 VPWR VGND sg13cmos5l_fill_2
X_0600_ _0600_/Q Tile_X0Y1_FrameData[2] VGND VPWR Tile_X0Y1_FrameStrobe[7] latch
X_0531_ _0531_/Q Tile_X0Y1_FrameData[7] VGND VPWR Tile_X0Y1_FrameStrobe[5] latch
XFILLER_21_4 VPWR VGND sg13cmos5l_fill_2
X_0462_ _0462_/Q Tile_X0Y1_FrameData[12] VGND VPWR Tile_X0Y1_FrameStrobe[3] latch
X_0393_ _0393_/Q Tile_X0Y1_FrameData[17] VGND VPWR Tile_X0Y1_FrameStrobe[1] latch
XANTENNA__0538__D Tile_X0Y1_FrameData[0] VPWR VGND sg13cmos5l_antennanp
X_1014_ _1014_/X _1086_/X _1082_/X _1076_/X _1093_/X _0319_/Q _0318_/Q VPWR VGND sg13cmos5l_mux4_1
XANTENNA__0273__D Tile_X0Y0_FrameData[11] VPWR VGND sg13cmos5l_antennanp
XANTENNA__0624__Q NPU_ACT_WDATA6 VPWR VGND sg13cmos5l_antennanp
XANTENNA__0851__A Tile_X0Y1_FrameData[27] VPWR VGND sg13cmos5l_antennanp
XFILLER_97_0 VPWR VGND sg13cmos5l_fill_1
X_0729_ Tile_X0Y0_W2BEG[6] _1037_/X VPWR VGND sg13cmos5l_buf_1
XANTENNA__0448__D Tile_X0Y1_FrameData[26] VPWR VGND sg13cmos5l_antennanp
XANTENNA__0564__GATE Tile_X0Y1_FrameStrobe[6] VPWR VGND sg13cmos5l_antennanp
XFILLER_27_24 VPWR VGND sg13cmos5l_decap_4
XFILLER_27_35 VPWR VGND sg13cmos5l_decap_4
XFILLER_76_109 VPWR VGND sg13cmos5l_decap_8
XANTENNA__0183__D Tile_X0Y0_FrameData[5] VPWR VGND sg13cmos5l_antennanp
XANTENNA__0579__GATE Tile_X0Y1_FrameStrobe[7] VPWR VGND sg13cmos5l_antennanp
XANTENNA__0502__GATE Tile_X0Y1_FrameStrobe[4] VPWR VGND sg13cmos5l_antennanp
XFILLER_4_102 VPWR VGND sg13cmos5l_fill_1
XFILLER_4_113 VPWR VGND sg13cmos5l_fill_1
XANTENNA__0517__GATE Tile_X0Y1_FrameStrobe[5] VPWR VGND sg13cmos5l_antennanp
XFILLER_68_64 VPWR VGND sg13cmos5l_fill_1
XANTENNA__0358__D Tile_X0Y1_FrameData[20] VPWR VGND sg13cmos5l_antennanp
XFILLER_17_90 VPWR VGND sg13cmos5l_fill_1
XFILLER_75_131 VPWR VGND sg13cmos5l_decap_4
X_0514_ _0514_/Q Tile_X0Y1_FrameData[24] VGND VPWR Tile_X0Y1_FrameStrobe[5] latch
XANTENNA__0268__D Tile_X0Y0_FrameData[16] VPWR VGND sg13cmos5l_antennanp
XANTENNA__0619__Q NPU_ACT_WDATA1 VPWR VGND sg13cmos5l_antennanp
XANTENNA__0846__A Tile_X0Y1_FrameData[22] VPWR VGND sg13cmos5l_antennanp
XFILLER_104_29 VPWR VGND sg13cmos5l_fill_2
XFILLER_66_142 VPWR VGND sg13cmos5l_fill_1
X_0445_ _0445_/Q Tile_X0Y1_FrameData[29] VGND VPWR Tile_X0Y1_FrameStrobe[3] latch
X_0376_ _0376_/Q Tile_X0Y1_FrameData[2] VGND VPWR Tile_X0Y1_FrameStrobe[0] latch
XFILLER_13_15 VPWR VGND sg13cmos5l_fill_2
XFILLER_81_145 VPWR VGND sg13cmos5l_fill_2
XFILLER_81_123 VPWR VGND sg13cmos5l_fill_1
XANTENNA__1017__A2 Tile_X0Y0_E6END[11] VPWR VGND sg13cmos5l_antennanp
XANTENNA__0178__D Tile_X0Y0_FrameData[10] VPWR VGND sg13cmos5l_antennanp
XANTENNA__0756__A Tile_X0Y1_N4END[13] VPWR VGND sg13cmos5l_antennanp
XFILLER_38_67 VPWR VGND sg13cmos5l_decap_4
XFILLER_72_134 VPWR VGND sg13cmos5l_fill_1
XANTENNA__0441__GATE Tile_X0Y1_FrameStrobe[2] VPWR VGND sg13cmos5l_antennanp
XANTENNA__1008__A2 Tile_X0Y0_E6END[2] VPWR VGND sg13cmos5l_antennanp
XFILLER_70_54 VPWR VGND sg13cmos5l_fill_1
XANTENNA__0456__GATE Tile_X0Y1_FrameStrobe[3] VPWR VGND sg13cmos5l_antennanp
XANTENNA__0641__D NPU_OUT_ACT5 VPWR VGND sg13cmos5l_antennanp
XANTENNA__1192__A1 Tile_X0Y1_E6END[1] VPWR VGND sg13cmos5l_antennanp
X_0230_ _0230_/Q Tile_X0Y0_FrameData[22] VGND VPWR Tile_X0Y1_FrameStrobe[4] latch
X_0161_ _0161_/Q Tile_X0Y0_FrameData[27] VGND VPWR Tile_X0Y1_FrameStrobe[2] latch
XANTENNA__0409__GATE Tile_X0Y1_FrameStrobe[1] VPWR VGND sg13cmos5l_antennanp
XANTENNA__0953__X Tile_X0Y1_W6BEG[8] VPWR VGND sg13cmos5l_antennanp
X_0092_ NPU_XBAR_SEL2 Tile_X0Y1_UserCLK _0092_/D _0698_/L_HI VPWR VGND sg13cmos5l_dfrbpq_1
XANTENNA__0551__D Tile_X0Y1_FrameData[19] VPWR VGND sg13cmos5l_antennanp
XFILLER_117_158 VPWR VGND sg13cmos5l_fill_1
X_0994_ _0994_/X Tile_X0Y1_E1END[0] Tile_X0Y1_EE4END[4] Tile_X0Y1_EE4END[12] _1215_/X
+ _0410_/Q _0409_/Q VPWR VGND sg13cmos5l_mux4_1
XANTENNA__0863__X Tile_X0Y0_FrameData_O[7] VPWR VGND sg13cmos5l_antennanp
X_0428_ _0428_/Q Tile_X0Y1_FrameData[14] VGND VPWR Tile_X0Y1_FrameStrobe[2] latch
X_0359_ _0359_/Q Tile_X0Y1_FrameData[19] VGND VPWR Tile_X0Y1_FrameStrobe[0] latch
XANTENNA__0997__A1 Tile_X0Y1_EE4END[7] VPWR VGND sg13cmos5l_antennanp
XFILLER_24_58 VPWR VGND sg13cmos5l_decap_4
XFILLER_24_69 VPWR VGND sg13cmos5l_fill_2
XANTENNA__0461__D Tile_X0Y1_FrameData[13] VPWR VGND sg13cmos5l_antennanp
XANTENNA__0380__GATE Tile_X0Y1_FrameStrobe[1] VPWR VGND sg13cmos5l_antennanp
XANTENNA__0636__D NPU_OUT_ACT0 VPWR VGND sg13cmos5l_antennanp
XANTENNA__0773__X Tile_X0Y0_WW4BEG[6] VPWR VGND sg13cmos5l_antennanp
XFILLER_45_178 VPWR VGND sg13cmos5l_fill_2
XFILLER_60_115 VPWR VGND sg13cmos5l_fill_1
XFILLER_60_126 VPWR VGND sg13cmos5l_decap_4
XANTENNA__0371__D Tile_X0Y1_FrameData[7] VPWR VGND sg13cmos5l_antennanp
XANTENNA__0395__GATE Tile_X0Y1_FrameStrobe[1] VPWR VGND sg13cmos5l_antennanp
XANTENNA__0988__A1 Tile_X0Y1_EE4END[14] VPWR VGND sg13cmos5l_antennanp
XFILLER_14_80 VPWR VGND sg13cmos5l_decap_8
XFILLER_81_64 VPWR VGND sg13cmos5l_decap_8
XANTENNA__0948__X Tile_X0Y1_W6BEG[3] VPWR VGND sg13cmos5l_antennanp
XANTENNA__0333__GATE Tile_X0Y1_FrameStrobe[7] VPWR VGND sg13cmos5l_antennanp
XANTENNA__0546__D Tile_X0Y1_FrameData[24] VPWR VGND sg13cmos5l_antennanp
X_1193_ _1193_/X Tile_X0Y1_N1END[2] Tile_X0Y1_E6END[2] _1229_/X _1193_/A3 _0350_/Q
+ _0349_/Q VPWR VGND sg13cmos5l_mux4_1
X_0213_ _0213_/Q Tile_X0Y0_FrameData[7] VGND VPWR Tile_X0Y1_FrameStrobe[3] latch
X_0144_ _0144_/Q Tile_X0Y0_FrameData[12] VGND VPWR Tile_X0Y1_FrameStrobe[1] latch
XANTENNA__0348__GATE Tile_X0Y1_FrameStrobe[0] VPWR VGND sg13cmos5l_antennanp
XANTENNA__0979__A1 Tile_X0Y0_E2END[6] VPWR VGND sg13cmos5l_antennanp
X_0075_ _0761_/A _1117_/X _1118_/X _0570_/Q VPWR VGND sg13cmos5l_mux2_1
XANTENNA__0281__D Tile_X0Y0_FrameData[3] VPWR VGND sg13cmos5l_antennanp
XANTENNA__0632__Q NPU_ACT_ADDR6 VPWR VGND sg13cmos5l_antennanp
X_0977_ _0977_/X Tile_X0Y0_E2MID[4] Tile_X0Y0_E2END[4] _1096_/X _0977_/A3 _0162_/Q
+ _0161_/Q VPWR VGND sg13cmos5l_mux4_1
XANTENNA__0858__X Tile_X0Y0_FrameData_O[2] VPWR VGND sg13cmos5l_antennanp
XFILLER_19_36 VPWR VGND sg13cmos5l_decap_4
XFILLER_27_101 VPWR VGND sg13cmos5l_decap_8
XANTENNA__0456__D Tile_X0Y1_FrameData[18] VPWR VGND sg13cmos5l_antennanp
XFILLER_27_178 VPWR VGND sg13cmos5l_fill_2
XANTENNA__0191__D Tile_X0Y0_FrameData[29] VPWR VGND sg13cmos5l_antennanp
XANTENNA__0768__X Tile_X0Y0_WW4BEG[1] VPWR VGND sg13cmos5l_antennanp
XANTENNA__0366__D Tile_X0Y1_FrameData[12] VPWR VGND sg13cmos5l_antennanp
XFILLER_18_178 VPWR VGND sg13cmos5l_fill_2
X_0900_ Tile_X0Y1_S2BEGb[0] _1219_/X VPWR VGND sg13cmos5l_buf_1
XFILLER_92_96 VPWR VGND sg13cmos5l_decap_4
X_0831_ Tile_X0Y1_FrameData_O[7] Tile_X0Y1_FrameData[7] VPWR VGND sg13cmos5l_buf_1
X_0762_ Tile_X0Y0_N4BEG[11] _0762_/A VPWR VGND sg13cmos5l_buf_1
X_0693_ _0693_/L_HI VPWR VGND sg13cmos5l_tiehi
XANTENNA__0272__GATE Tile_X0Y1_FrameStrobe[5] VPWR VGND sg13cmos5l_antennanp
XANTENNA__0276__D Tile_X0Y0_FrameData[8] VPWR VGND sg13cmos5l_antennanp
XANTENNA__0287__GATE Tile_X0Y1_FrameStrobe[6] VPWR VGND sg13cmos5l_antennanp
XANTENNA__0627__Q NPU_ACT_ADDR1 VPWR VGND sg13cmos5l_antennanp
XANTENNA__0854__A Tile_X0Y1_FrameData[30] VPWR VGND sg13cmos5l_antennanp
XFILLER_24_126 VPWR VGND sg13cmos5l_fill_1
X_1176_ _1176_/X _0645_/Q _0649_/Q _1205_/X _1197_/X _0464_/Q _0463_/Q VPWR VGND sg13cmos5l_mux4_1
X_0127_ _0127_/Q Tile_X0Y0_FrameData[29] VGND VPWR Tile_X0Y1_FrameStrobe[1] latch
XANTENNA__0210__GATE Tile_X0Y1_FrameStrobe[3] VPWR VGND sg13cmos5l_antennanp
XANTENNA__0616__CLK Tile_X0Y1_UserCLK VPWR VGND sg13cmos5l_antennanp
XANTENNA__0225__GATE Tile_X0Y1_FrameStrobe[4] VPWR VGND sg13cmos5l_antennanp
XANTENNA__1129__A1 Tile_X0Y1_E2END[5] VPWR VGND sg13cmos5l_antennanp
XFILLER_115_9 VPWR VGND sg13cmos5l_fill_1
XFILLER_21_48 VPWR VGND sg13cmos5l_decap_8
XANTENNA__0186__D Tile_X0Y0_FrameData[2] VPWR VGND sg13cmos5l_antennanp
XANTENNA__1065__A0 Tile_X0Y1_N4END[6] VPWR VGND sg13cmos5l_antennanp
XFILLER_46_78 VPWR VGND sg13cmos5l_fill_2
XANTENNA__1080__A3 Tile_X0Y0_S4END[3] VPWR VGND sg13cmos5l_antennanp
XFILLER_11_70 VPWR VGND sg13cmos5l_fill_1
XFILLER_11_92 VPWR VGND sg13cmos5l_decap_4
XFILLER_97_129 VPWR VGND sg13cmos5l_decap_8
XFILLER_87_85 VPWR VGND sg13cmos5l_decap_8
XFILLER_87_52 VPWR VGND sg13cmos5l_fill_1
XANTENNA__0096__D Tile_X0Y0_FrameData[28] VPWR VGND sg13cmos5l_antennanp
XANTENNA__0639__CLK Tile_X0Y1_UserCLK VPWR VGND sg13cmos5l_antennanp
X_1030_ _1030_/X _1114_/X Tile_X0Y0_S1END[3] _0637_/Q _0640_/Q _0268_/Q _0267_/Q VPWR
+ VGND sg13cmos5l_mux4_1
XANTENNA__0961__X Tile_X0Y1_WW4BEG[4] VPWR VGND sg13cmos5l_antennanp
X_0814_ Tile_X0Y0_FrameStrobe_O[11] Tile_X0Y1_FrameStrobe[11] VPWR VGND sg13cmos5l_buf_1
XANTENNA__0849__A Tile_X0Y1_FrameData[25] VPWR VGND sg13cmos5l_antennanp
X_0745_ Tile_X0Y0_W6BEG[6] _1069_/X VPWR VGND sg13cmos5l_buf_1
X_0676_ _0676_/L_HI VPWR VGND sg13cmos5l_tiehi
X_1228_ _1228_/X Tile_X0Y0_E1END[1] Tile_X0Y0_E6END[9] _1076_/X _1101_/X _0308_/Q
+ _0307_/Q VPWR VGND sg13cmos5l_mux4_1
XANTENNA__0871__X Tile_X0Y0_FrameData_O[15] VPWR VGND sg13cmos5l_antennanp
X_1159_ _1159_/X Tile_X0Y1_EE4END[9] _0648_/Q _1198_/X _1199_/X _0498_/Q _0497_/Q
+ VPWR VGND sg13cmos5l_mux4_1
XANTENNA__0092__Q NPU_XBAR_SEL2 VPWR VGND sg13cmos5l_antennanp
XANTENNA__0164__GATE Tile_X0Y1_FrameStrobe[2] VPWR VGND sg13cmos5l_antennanp
XFILLER_20_162 VPWR VGND sg13cmos5l_fill_1
XANTENNA__0179__GATE Tile_X0Y1_FrameStrobe[2] VPWR VGND sg13cmos5l_antennanp
XFILLER_79_118 VPWR VGND sg13cmos5l_fill_1
XFILLER_79_107 VPWR VGND sg13cmos5l_fill_2
XANTENNA__0102__GATE Tile_X0Y1_FrameStrobe[0] VPWR VGND sg13cmos5l_antennanp
XFILLER_57_88 VPWR VGND sg13cmos5l_fill_1
XANTENNA__0117__GATE Tile_X0Y1_FrameStrobe[0] VPWR VGND sg13cmos5l_antennanp
XANTENNA__0644__D NPU_ACT_RDATA0 VPWR VGND sg13cmos5l_antennanp
XANTENNA__0781__X Tile_X0Y0_WW4BEG[14] VPWR VGND sg13cmos5l_antennanp
XANTENNA__1038__A0 Tile_X0Y0_EE4END[5] VPWR VGND sg13cmos5l_antennanp
XFILLER_7_100 VPWR VGND sg13cmos5l_fill_1
XANTENNA__1210__A0 Tile_X0Y1_N1END[3] VPWR VGND sg13cmos5l_antennanp
X_0530_ _0530_/Q Tile_X0Y1_FrameData[8] VGND VPWR Tile_X0Y1_FrameStrobe[5] latch
XFILLER_98_40 VPWR VGND sg13cmos5l_decap_8
XANTENNA__0956__X Tile_X0Y1_W6BEG[11] VPWR VGND sg13cmos5l_antennanp
X_0461_ _0461_/Q Tile_X0Y1_FrameData[13] VGND VPWR Tile_X0Y1_FrameStrobe[3] latch
X_0392_ _0392_/Q Tile_X0Y1_FrameData[18] VGND VPWR Tile_X0Y1_FrameStrobe[1] latch
XANTENNA__0554__D Tile_X0Y1_FrameData[16] VPWR VGND sg13cmos5l_antennanp
X_1013_ _1013_/X Tile_X0Y0_E1END[1] Tile_X0Y0_EE4END[1] Tile_X0Y0_E6END[9] _1089_/X
+ _0319_/Q _0318_/Q VPWR VGND sg13cmos5l_mux4_1
XANTENNA__1201__A0 Tile_X0Y1_N2MID[6] VPWR VGND sg13cmos5l_antennanp
X_0728_ Tile_X0Y0_W2BEG[5] _1036_/X VPWR VGND sg13cmos5l_buf_1
X_0659_ _0659_/L_HI VPWR VGND sg13cmos5l_tiehi
XANTENNA__0866__X Tile_X0Y0_FrameData_O[10] VPWR VGND sg13cmos5l_antennanp
XANTENNA__0464__D Tile_X0Y1_FrameData[10] VPWR VGND sg13cmos5l_antennanp
XFILLER_43_68 VPWR VGND sg13cmos5l_decap_8
XFILLER_4_136 VPWR VGND sg13cmos5l_fill_2
XANTENNA__0639__D NPU_OUT_ACT3 VPWR VGND sg13cmos5l_antennanp
XANTENNA__0776__X Tile_X0Y0_WW4BEG[9] VPWR VGND sg13cmos5l_antennanp
XANTENNA__0374__D Tile_X0Y1_FrameData[4] VPWR VGND sg13cmos5l_antennanp
XFILLER_84_86 VPWR VGND sg13cmos5l_fill_2
X_0513_ _0513_/Q Tile_X0Y1_FrameData[25] VGND VPWR Tile_X0Y1_FrameStrobe[5] latch
X_0444_ _0444_/Q Tile_X0Y1_FrameData[30] VGND VPWR Tile_X0Y1_FrameStrobe[3] latch
XANTENNA__0549__D Tile_X0Y1_FrameData[21] VPWR VGND sg13cmos5l_antennanp
X_0375_ _0375_/Q Tile_X0Y1_FrameData[3] VGND VPWR Tile_X0Y1_FrameStrobe[0] latch
XANTENNA__0284__D Tile_X0Y0_FrameData[0] VPWR VGND sg13cmos5l_antennanp
XANTENNA__0635__Q NPU_WEIGHT_SHIFT_EN VPWR VGND sg13cmos5l_antennanp
XANTENNA__0862__A Tile_X0Y0_FrameData[6] VPWR VGND sg13cmos5l_antennanp
XFILLER_81_179 VPWR VGND sg13cmos5l_fill_1
XANTENNA__0459__D Tile_X0Y1_FrameData[15] VPWR VGND sg13cmos5l_antennanp
XFILLER_38_57 VPWR VGND sg13cmos5l_fill_2
XANTENNA__0194__D Tile_X0Y0_FrameData[26] VPWR VGND sg13cmos5l_antennanp
XFILLER_54_56 VPWR VGND sg13cmos5l_fill_2
XFILLER_72_168 VPWR VGND sg13cmos5l_fill_2
XFILLER_72_179 VPWR VGND sg13cmos5l_fill_1
XFILLER_70_11 VPWR VGND sg13cmos5l_fill_2
XFILLER_79_86 VPWR VGND sg13cmos5l_decap_8
XFILLER_79_20 VPWR VGND sg13cmos5l_decap_8
XANTENNA__0369__D Tile_X0Y1_FrameData[9] VPWR VGND sg13cmos5l_antennanp
XFILLER_48_154 VPWR VGND sg13cmos5l_fill_2
X_0160_ _0160_/Q Tile_X0Y0_FrameData[28] VGND VPWR Tile_X0Y1_FrameStrobe[2] latch
X_0091_ NPU_XBAR_SEL1 Tile_X0Y1_UserCLK _0091_/D _0654_/L_HI VPWR VGND sg13cmos5l_dfrbpq_1
XFILLER_63_179 VPWR VGND sg13cmos5l_fill_1
X_0993_ _0993_/X Tile_X0Y1_EE4END[3] Tile_X0Y1_EE4END[11] Tile_X0Y1_E6END[11] _1214_/X
+ _0412_/Q _0411_/Q VPWR VGND sg13cmos5l_mux4_1
XANTENNA__0563__GATE Tile_X0Y1_FrameStrobe[6] VPWR VGND sg13cmos5l_antennanp
XANTENNA__0279__D Tile_X0Y0_FrameData[5] VPWR VGND sg13cmos5l_antennanp
XANTENNA__0578__GATE Tile_X0Y1_FrameStrobe[7] VPWR VGND sg13cmos5l_antennanp
XANTENNA__0857__A Tile_X0Y0_FrameData[1] VPWR VGND sg13cmos5l_antennanp
XFILLER_39_110 VPWR VGND sg13cmos5l_decap_8
X_0427_ _0427_/Q Tile_X0Y1_FrameData[15] VGND VPWR Tile_X0Y1_FrameStrobe[2] latch
XANTENNA__0501__GATE Tile_X0Y1_FrameStrobe[4] VPWR VGND sg13cmos5l_antennanp
X_0358_ _0358_/Q Tile_X0Y1_FrameData[20] VGND VPWR Tile_X0Y1_FrameStrobe[0] latch
X_0289_ _0289_/Q Tile_X0Y0_FrameData[27] VGND VPWR Tile_X0Y1_FrameStrobe[6] latch
XANTENNA__0516__GATE Tile_X0Y1_FrameStrobe[5] VPWR VGND sg13cmos5l_antennanp
XANTENNA__0997__A2 Tile_X0Y1_EE4END[15] VPWR VGND sg13cmos5l_antennanp
XANTENNA__0189__D Tile_X0Y0_FrameData[31] VPWR VGND sg13cmos5l_antennanp
XFILLER_49_56 VPWR VGND sg13cmos5l_fill_1
XANTENNA__0988__A2 Tile_X0Y1_E6END[6] VPWR VGND sg13cmos5l_antennanp
XFILLER_65_88 VPWR VGND sg13cmos5l_decap_4
XANTENNA__0099__D Tile_X0Y0_FrameData[25] VPWR VGND sg13cmos5l_antennanp
XANTENNA__0964__X Tile_X0Y1_WW4BEG[7] VPWR VGND sg13cmos5l_antennanp
XFILLER_51_116 VPWR VGND sg13cmos5l_decap_4
X_1192_ _1192_/X Tile_X0Y1_N1END[1] Tile_X0Y1_E6END[1] _1228_/X _1192_/A3 _0352_/Q
+ _0351_/Q VPWR VGND sg13cmos5l_mux4_1
X_0212_ _0212_/Q Tile_X0Y0_FrameData[8] VGND VPWR Tile_X0Y1_FrameStrobe[3] latch
X_0143_ _0143_/Q Tile_X0Y0_FrameData[13] VGND VPWR Tile_X0Y1_FrameStrobe[1] latch
X_0074_ _0760_/A _1119_/X _1120_/X _0573_/Q VPWR VGND sg13cmos5l_mux2_1
XANTENNA__0562__D Tile_X0Y1_FrameData[8] VPWR VGND sg13cmos5l_antennanp
XFILLER_51_138 VPWR VGND sg13cmos5l_fill_1
XFILLER_72_0 VPWR VGND sg13cmos5l_fill_1
X_0976_ _0976_/X Tile_X0Y0_E2MID[3] Tile_X0Y0_E2END[3] _1095_/X _0976_/A3 _0164_/Q
+ _0163_/Q VPWR VGND sg13cmos5l_mux4_1
XFILLER_105_107 VPWR VGND sg13cmos5l_fill_2
XANTENNA__0440__GATE Tile_X0Y1_FrameStrobe[2] VPWR VGND sg13cmos5l_antennanp
XANTENNA__0874__X Tile_X0Y0_FrameData_O[18] VPWR VGND sg13cmos5l_antennanp
XANTENNA__0455__GATE Tile_X0Y1_FrameStrobe[3] VPWR VGND sg13cmos5l_antennanp
XANTENNA__1092__A1 Tile_X0Y1_N2MID[0] VPWR VGND sg13cmos5l_antennanp
XFILLER_35_69 VPWR VGND sg13cmos5l_fill_2
XANTENNA__0472__D Tile_X0Y1_FrameData[2] VPWR VGND sg13cmos5l_antennanp
XANTENNA__0408__GATE Tile_X0Y1_FrameStrobe[1] VPWR VGND sg13cmos5l_antennanp
XFILLER_76_21 VPWR VGND sg13cmos5l_fill_1
XANTENNA__0647__D NPU_ACT_RDATA3 VPWR VGND sg13cmos5l_antennanp
XANTENNA__0784__X Tile_X0Y0_N2BEGb[1] VPWR VGND sg13cmos5l_antennanp
XFILLER_33_127 VPWR VGND sg13cmos5l_fill_1
XANTENNA__0382__D Tile_X0Y1_FrameData[28] VPWR VGND sg13cmos5l_antennanp
XANTENNA__1083__A1 Tile_X0Y1_N4END[4] VPWR VGND sg13cmos5l_antennanp
X_0830_ Tile_X0Y1_FrameData_O[6] Tile_X0Y1_FrameData[6] VPWR VGND sg13cmos5l_buf_1
XANTENNA__0959__X Tile_X0Y1_WW4BEG[2] VPWR VGND sg13cmos5l_antennanp
XFILLER_44_4 VPWR VGND sg13cmos5l_fill_1
X_0761_ Tile_X0Y0_N4BEG[10] _0761_/A VPWR VGND sg13cmos5l_buf_1
X_0692_ _0692_/L_HI VPWR VGND sg13cmos5l_tiehi
XANTENNA__0557__D Tile_X0Y1_FrameData[13] VPWR VGND sg13cmos5l_antennanp
X_1175_ _1175_/X _0644_/Q _0648_/Q _1206_/X _1198_/X _0466_/Q _0465_/Q VPWR VGND sg13cmos5l_mux4_1
X_0126_ _0126_/Q Tile_X0Y0_FrameData[30] VGND VPWR Tile_X0Y1_FrameStrobe[1] latch
XANTENNA__0292__D Tile_X0Y0_FrameData[24] VPWR VGND sg13cmos5l_antennanp
XANTENNA__0870__A Tile_X0Y0_FrameData[14] VPWR VGND sg13cmos5l_antennanp
X_0959_ Tile_X0Y1_WW4BEG[2] _1165_/X VPWR VGND sg13cmos5l_buf_1
XANTENNA__0869__X Tile_X0Y0_FrameData_O[13] VPWR VGND sg13cmos5l_antennanp
XANTENNA__1129__A2 Tile_X0Y1_E6END[10] VPWR VGND sg13cmos5l_antennanp
XFILLER_108_9 VPWR VGND sg13cmos5l_decap_4
XANTENNA__0394__GATE Tile_X0Y1_FrameStrobe[1] VPWR VGND sg13cmos5l_antennanp
XANTENNA__0467__D Tile_X0Y1_FrameData[7] VPWR VGND sg13cmos5l_antennanp
XFILLER_46_35 VPWR VGND sg13cmos5l_fill_1
XANTENNA__1065__A1 Tile_X0Y0_S4END[2] VPWR VGND sg13cmos5l_antennanp
XANTENNA__0332__GATE Tile_X0Y1_FrameStrobe[7] VPWR VGND sg13cmos5l_antennanp
XANTENNA__0779__X Tile_X0Y0_WW4BEG[12] VPWR VGND sg13cmos5l_antennanp
XFILLER_2_0 VPWR VGND sg13cmos5l_fill_1
XANTENNA__0347__GATE Tile_X0Y1_FrameStrobe[0] VPWR VGND sg13cmos5l_antennanp
XANTENNA__0377__D Tile_X0Y1_FrameData[1] VPWR VGND sg13cmos5l_antennanp
X_0813_ Tile_X0Y0_FrameStrobe_O[10] Tile_X0Y1_FrameStrobe[10] VPWR VGND sg13cmos5l_buf_1
X_0744_ Tile_X0Y0_W6BEG[5] _1068_/X VPWR VGND sg13cmos5l_buf_1
X_0675_ _0675_/L_HI VPWR VGND sg13cmos5l_tiehi
XANTENNA__0287__D Tile_X0Y0_FrameData[29] VPWR VGND sg13cmos5l_antennanp
XANTENNA__0865__A Tile_X0Y0_FrameData[9] VPWR VGND sg13cmos5l_antennanp
X_1227_ _1227_/X Tile_X0Y0_E1END[0] Tile_X0Y0_E6END[8] _1075_/X _1100_/X _0310_/Q
+ _0309_/Q VPWR VGND sg13cmos5l_mux4_1
X_1158_ _1158_/X Tile_X0Y1_EE4END[5] _0647_/Q _1198_/X _1199_/X _0500_/Q _0499_/Q
+ VPWR VGND sg13cmos5l_mux4_1
X_1089_ _1089_/X _1112_/X Tile_X0Y1_N4END[5] Tile_X0Y0_S1END[1] Tile_X0Y0_S4END[1]
+ _0146_/Q _0145_/Q VPWR VGND sg13cmos5l_mux4_1
X_0109_ _0109_/Q Tile_X0Y0_FrameData[15] VGND VPWR Tile_X0Y1_FrameStrobe[0] latch
XFILLER_87_130 VPWR VGND sg13cmos5l_fill_1
XANTENNA__0197__D Tile_X0Y0_FrameData[23] VPWR VGND sg13cmos5l_antennanp
XANTENNA__0271__GATE Tile_X0Y1_FrameStrobe[5] VPWR VGND sg13cmos5l_antennanp
XANTENNA__0286__GATE Tile_X0Y1_FrameStrobe[6] VPWR VGND sg13cmos5l_antennanp
XANTENNA__1210__A1 Tile_X0Y1_N4END[3] VPWR VGND sg13cmos5l_antennanp
X_0460_ _0460_/Q Tile_X0Y1_FrameData[14] VGND VPWR Tile_X0Y1_FrameStrobe[3] latch
X_1012_ _1012_/X _1087_/X _1083_/X _1075_/X _1092_/X _0322_/Q _0321_/Q VPWR VGND sg13cmos5l_mux4_1
X_0391_ _0391_/Q Tile_X0Y1_FrameData[19] VGND VPWR Tile_X0Y1_FrameStrobe[1] latch
XFILLER_93_166 VPWR VGND sg13cmos5l_fill_2
XANTENNA__0224__GATE Tile_X0Y1_FrameStrobe[4] VPWR VGND sg13cmos5l_antennanp
XANTENNA__0239__GATE Tile_X0Y1_FrameStrobe[4] VPWR VGND sg13cmos5l_antennanp
XANTENNA__0972__X Tile_X0Y1_WW4BEG[15] VPWR VGND sg13cmos5l_antennanp
XANTENNA__1029__A1 Tile_X0Y0_S1END[2] VPWR VGND sg13cmos5l_antennanp
XANTENNA__0570__D Tile_X0Y1_FrameData[0] VPWR VGND sg13cmos5l_antennanp
XANTENNA__1201__A1 Tile_X0Y1_N2END[6] VPWR VGND sg13cmos5l_antennanp
X_0727_ Tile_X0Y0_W2BEG[4] _1035_/X VPWR VGND sg13cmos5l_buf_1
X_0658_ _0658_/L_HI VPWR VGND sg13cmos5l_tiehi
X_0589_ _0589_/Q Tile_X0Y1_FrameData[13] VGND VPWR Tile_X0Y1_FrameStrobe[7] latch
XANTENNA__0882__X Tile_X0Y0_FrameData_O[26] VPWR VGND sg13cmos5l_antennanp
XANTENNA__0480__D Tile_X0Y1_FrameData[26] VPWR VGND sg13cmos5l_antennanp
XANTENNA__0629__CLK Tile_X0Y1_UserCLK VPWR VGND sg13cmos5l_antennanp
XFILLER_84_32 VPWR VGND sg13cmos5l_decap_8
XANTENNA__0792__X Tile_X0Y0_N2BEG[1] VPWR VGND sg13cmos5l_antennanp
XFILLER_90_9 VPWR VGND sg13cmos5l_fill_2
XFILLER_90_169 VPWR VGND sg13cmos5l_fill_2
XFILLER_90_125 VPWR VGND sg13cmos5l_decap_8
XFILLER_84_98 VPWR VGND sg13cmos5l_fill_1
XFILLER_84_76 VPWR VGND sg13cmos5l_decap_4
XANTENNA__0390__D Tile_X0Y1_FrameData[20] VPWR VGND sg13cmos5l_antennanp
XANTENNA__0967__X Tile_X0Y1_WW4BEG[10] VPWR VGND sg13cmos5l_antennanp
XANTENNA__1195__A0 Tile_X0Y1_N2MID[0] VPWR VGND sg13cmos5l_antennanp
X_0512_ _0512_/Q Tile_X0Y1_FrameData[26] VGND VPWR Tile_X0Y1_FrameStrobe[5] latch
X_0443_ _0443_/Q Tile_X0Y1_FrameData[31] VGND VPWR Tile_X0Y1_FrameStrobe[3] latch
X_0374_ _0374_/Q Tile_X0Y1_FrameData[4] VGND VPWR Tile_X0Y1_FrameStrobe[0] latch
XANTENNA__0163__GATE Tile_X0Y1_FrameStrobe[2] VPWR VGND sg13cmos5l_antennanp
XANTENNA__0565__D Tile_X0Y1_FrameData[5] VPWR VGND sg13cmos5l_antennanp
XFILLER_81_147 VPWR VGND sg13cmos5l_fill_1
XFILLER_81_114 VPWR VGND sg13cmos5l_decap_8
XANTENNA__0178__GATE Tile_X0Y1_FrameStrobe[2] VPWR VGND sg13cmos5l_antennanp
XANTENNA__0101__GATE Tile_X0Y1_FrameStrobe[0] VPWR VGND sg13cmos5l_antennanp
XANTENNA__0116__GATE Tile_X0Y1_FrameStrobe[0] VPWR VGND sg13cmos5l_antennanp
XANTENNA__0877__X Tile_X0Y0_FrameData_O[21] VPWR VGND sg13cmos5l_antennanp
XANTENNA__0475__D Tile_X0Y1_FrameData[31] VPWR VGND sg13cmos5l_antennanp
XANTENNA__1110__A0 Tile_X0Y1_E2MID[0] VPWR VGND sg13cmos5l_antennanp
XFILLER_70_34 VPWR VGND sg13cmos5l_decap_4
XANTENNA__0787__X Tile_X0Y0_N2BEGb[4] VPWR VGND sg13cmos5l_antennanp
XFILLER_102_0 VPWR VGND sg13cmos5l_fill_2
XFILLER_95_31 VPWR VGND sg13cmos5l_fill_1
XFILLER_79_65 VPWR VGND sg13cmos5l_decap_8
XANTENNA__0385__D Tile_X0Y1_FrameData[25] VPWR VGND sg13cmos5l_antennanp
XFILLER_28_80 VPWR VGND sg13cmos5l_decap_8
XFILLER_28_91 VPWR VGND sg13cmos5l_fill_1
X_0090_ NPU_XBAR_SEL0 Tile_X0Y1_UserCLK _0090_/D _0655_/L_HI VPWR VGND sg13cmos5l_dfrbpq_1
X_0992_ _0992_/X Tile_X0Y1_EE4END[2] Tile_X0Y1_EE4END[10] Tile_X0Y1_E6END[10] _1213_/X
+ _0414_/Q _0413_/Q VPWR VGND sg13cmos5l_mux4_1
X_0426_ _0426_/Q Tile_X0Y1_FrameData[16] VGND VPWR Tile_X0Y1_FrameStrobe[2] latch
X_0357_ _0357_/Q Tile_X0Y1_FrameData[21] VGND VPWR Tile_X0Y1_FrameStrobe[0] latch
XANTENNA__0295__D Tile_X0Y0_FrameData[21] VPWR VGND sg13cmos5l_antennanp
XANTENNA__0873__A Tile_X0Y0_FrameData[17] VPWR VGND sg13cmos5l_antennanp
X_0288_ _0288_/Q Tile_X0Y0_FrameData[28] VGND VPWR Tile_X0Y1_FrameStrobe[6] latch
XANTENNA__1159__A0 Tile_X0Y1_EE4END[9] VPWR VGND sg13cmos5l_antennanp
XFILLER_49_79 VPWR VGND sg13cmos5l_fill_2
XFILLER_105_41 VPWR VGND sg13cmos5l_decap_8
XFILLER_65_56 VPWR VGND sg13cmos5l_fill_1
X_1191_ _1191_/X Tile_X0Y1_N1END[0] Tile_X0Y1_E6END[0] _1227_/X _1191_/A3 _0354_/Q
+ _0353_/Q VPWR VGND sg13cmos5l_mux4_1
X_0211_ _0211_/Q Tile_X0Y0_FrameData[9] VGND VPWR Tile_X0Y1_FrameStrobe[3] latch
X_0142_ _0142_/Q Tile_X0Y0_FrameData[14] VGND VPWR Tile_X0Y1_FrameStrobe[1] latch
X_0073_ _0759_/A _1121_/X _1122_/X _0576_/Q VPWR VGND sg13cmos5l_mux2_1
X_0975_ _0975_/X Tile_X0Y0_E2MID[2] Tile_X0Y0_E2END[2] _1094_/X _0975_/A3 _0166_/Q
+ _0165_/Q VPWR VGND sg13cmos5l_mux4_1
XANTENNA__0868__A Tile_X0Y0_FrameData[12] VPWR VGND sg13cmos5l_antennanp
X_0409_ _0409_/Q Tile_X0Y1_FrameData[1] VGND VPWR Tile_X0Y1_FrameStrobe[1] latch
XANTENNA__0890__X Tile_X0Y1_S1BEG[2] VPWR VGND sg13cmos5l_antennanp
XANTENNA__1092__A2 Tile_X0Y0_S2MID[0] VPWR VGND sg13cmos5l_antennanp
XFILLER_42_117 VPWR VGND sg13cmos5l_fill_1
XFILLER_42_139 VPWR VGND sg13cmos5l_fill_2
XFILLER_51_36 VPWR VGND sg13cmos5l_decap_4
XANTENNA__0562__GATE Tile_X0Y1_FrameStrobe[6] VPWR VGND sg13cmos5l_antennanp
XFILLER_18_125 VPWR VGND sg13cmos5l_decap_4
XFILLER_76_77 VPWR VGND sg13cmos5l_decap_8
XANTENNA__0577__GATE Tile_X0Y1_FrameStrobe[7] VPWR VGND sg13cmos5l_antennanp
XANTENNA__1083__A2 Tile_X0Y0_S1END[0] VPWR VGND sg13cmos5l_antennanp
X_0760_ Tile_X0Y0_N4BEG[9] _0760_/A VPWR VGND sg13cmos5l_buf_1
XANTENNA__0500__GATE Tile_X0Y1_FrameStrobe[4] VPWR VGND sg13cmos5l_antennanp
XANTENNA__0515__GATE Tile_X0Y1_FrameStrobe[5] VPWR VGND sg13cmos5l_antennanp
X_0691_ _0691_/L_HI VPWR VGND sg13cmos5l_tiehi
X_1174_ _1174_/X _0647_/Q _0651_/Q _1207_/X _1199_/X _0468_/Q _0467_/Q VPWR VGND sg13cmos5l_mux4_1
XANTENNA__0573__D Tile_X0Y1_FrameData[29] VPWR VGND sg13cmos5l_antennanp
X_0125_ _0125_/Q Tile_X0Y0_FrameData[31] VGND VPWR Tile_X0Y1_FrameStrobe[1] latch
X_0889_ Tile_X0Y1_S1BEG[1] _1124_/X VPWR VGND sg13cmos5l_buf_1
X_0958_ Tile_X0Y1_WW4BEG[1] _1164_/X VPWR VGND sg13cmos5l_buf_1
XANTENNA__0885__X Tile_X0Y0_FrameData_O[29] VPWR VGND sg13cmos5l_antennanp
XFILLER_99_161 VPWR VGND sg13cmos5l_fill_1
XANTENNA__0483__D Tile_X0Y1_FrameData[23] VPWR VGND sg13cmos5l_antennanp
XFILLER_23_150 VPWR VGND sg13cmos5l_fill_2
XFILLER_30_109 VPWR VGND sg13cmos5l_decap_4
XANTENNA__0795__X Tile_X0Y0_N2BEG[4] VPWR VGND sg13cmos5l_antennanp
XFILLER_87_98 VPWR VGND sg13cmos5l_decap_8
XANTENNA__0393__D Tile_X0Y1_FrameData[17] VPWR VGND sg13cmos5l_antennanp
XFILLER_36_91 VPWR VGND sg13cmos5l_decap_4
X_0812_ Tile_X0Y0_FrameStrobe_O[9] Tile_X0Y1_FrameStrobe[9] VPWR VGND sg13cmos5l_buf_1
X_0743_ Tile_X0Y0_W6BEG[4] _1067_/X VPWR VGND sg13cmos5l_buf_1
XANTENNA__0454__GATE Tile_X0Y1_FrameStrobe[3] VPWR VGND sg13cmos5l_antennanp
XANTENNA__0568__D Tile_X0Y1_FrameData[2] VPWR VGND sg13cmos5l_antennanp
XFILLER_28_0 VPWR VGND sg13cmos5l_fill_1
X_0674_ _0674_/L_HI VPWR VGND sg13cmos5l_tiehi
XFILLER_96_120 VPWR VGND sg13cmos5l_decap_4
XANTENNA__0469__GATE Tile_X0Y1_FrameStrobe[3] VPWR VGND sg13cmos5l_antennanp
X_1226_ _1226_/X Tile_X0Y0_E1END[3] Tile_X0Y0_E2MID[0] Tile_X0Y0_E2END[0] _1099_/X
+ _0288_/Q _0287_/Q VPWR VGND sg13cmos5l_mux4_1
X_1157_ _1157_/X Tile_X0Y1_E2END[3] _0646_/Q _1197_/X _1200_/X _0502_/Q _0501_/Q VPWR
+ VGND sg13cmos5l_mux4_1
X_0108_ _0108_/Q Tile_X0Y0_FrameData[16] VGND VPWR Tile_X0Y1_FrameStrobe[0] latch
XANTENNA__0407__GATE Tile_X0Y1_FrameStrobe[1] VPWR VGND sg13cmos5l_antennanp
XANTENNA__0881__A Tile_X0Y0_FrameData[25] VPWR VGND sg13cmos5l_antennanp
X_1088_ _1088_/X _1111_/X Tile_X0Y1_N4END[4] Tile_X0Y0_S1END[0] Tile_X0Y0_S4END[0]
+ _0148_/Q _0147_/Q VPWR VGND sg13cmos5l_mux4_1
XANTENNA__0478__D Tile_X0Y1_FrameData[28] VPWR VGND sg13cmos5l_antennanp
XFILLER_73_34 VPWR VGND sg13cmos5l_fill_2
XFILLER_73_89 VPWR VGND sg13cmos5l_fill_2
XFILLER_7_113 VPWR VGND sg13cmos5l_decap_8
XANTENNA__0388__D Tile_X0Y1_FrameData[22] VPWR VGND sg13cmos5l_antennanp
X_0390_ _0390_/Q Tile_X0Y1_FrameData[20] VGND VPWR Tile_X0Y1_FrameStrobe[1] latch
XFILLER_98_86 VPWR VGND sg13cmos5l_decap_8
XFILLER_98_75 VPWR VGND sg13cmos5l_decap_4
XFILLER_78_120 VPWR VGND sg13cmos5l_fill_2
X_1011_ _1011_/X Tile_X0Y0_E1END[0] Tile_X0Y0_EE4END[0] Tile_X0Y0_E6END[8] _1088_/X
+ _0322_/Q _0321_/Q VPWR VGND sg13cmos5l_mux4_1
XFILLER_93_145 VPWR VGND sg13cmos5l_fill_2
XFILLER_8_51 VPWR VGND sg13cmos5l_decap_4
XANTENNA__0393__GATE Tile_X0Y1_FrameStrobe[1] VPWR VGND sg13cmos5l_antennanp
X_0726_ Tile_X0Y0_W2BEG[3] _1034_/X VPWR VGND sg13cmos5l_buf_1
XANTENNA__0298__D Tile_X0Y0_FrameData[18] VPWR VGND sg13cmos5l_antennanp
XANTENNA__0876__A Tile_X0Y0_FrameData[20] VPWR VGND sg13cmos5l_antennanp
XFILLER_69_120 VPWR VGND sg13cmos5l_decap_8
X_0657_ _0657_/L_HI VPWR VGND sg13cmos5l_tiehi
X_0588_ _0588_/Q Tile_X0Y1_FrameData[14] VGND VPWR Tile_X0Y1_FrameStrobe[7] latch
XANTENNA__0331__GATE Tile_X0Y1_FrameStrobe[7] VPWR VGND sg13cmos5l_antennanp
X_1209_ _1209_/X Tile_X0Y1_N1END[2] Tile_X0Y1_N4END[2] _1229_/X Tile_X0Y0_S4END[6]
+ _0390_/Q _0389_/Q VPWR VGND sg13cmos5l_mux4_1
XANTENNA__0346__GATE Tile_X0Y1_FrameStrobe[7] VPWR VGND sg13cmos5l_antennanp
XFILLER_108_30 VPWR VGND sg13cmos5l_fill_2
XFILLER_108_52 VPWR VGND sg13cmos5l_fill_2
XFILLER_68_56 VPWR VGND sg13cmos5l_fill_1
XFILLER_33_70 VPWR VGND sg13cmos5l_decap_8
XANTENNA__1195__A1 Tile_X0Y1_N2END[0] VPWR VGND sg13cmos5l_antennanp
X_0511_ _0511_/Q Tile_X0Y1_FrameData[27] VGND VPWR Tile_X0Y1_FrameStrobe[5] latch
X_0442_ _0442_/Q Tile_X0Y1_FrameData[0] VGND VPWR Tile_X0Y1_FrameStrobe[2] latch
X_0373_ _0373_/Q Tile_X0Y1_FrameData[5] VGND VPWR Tile_X0Y1_FrameStrobe[0] latch
XANTENNA__0581__D Tile_X0Y1_FrameData[21] VPWR VGND sg13cmos5l_antennanp
XFILLER_95_0 VPWR VGND sg13cmos5l_fill_2
X_0709_ _1192_/A3 VPWR VGND sg13cmos5l_tielo
XANTENNA__0270__GATE Tile_X0Y1_FrameStrobe[5] VPWR VGND sg13cmos5l_antennanp
XANTENNA__0893__X Tile_X0Y1_S2BEG[1] VPWR VGND sg13cmos5l_antennanp
XFILLER_38_59 VPWR VGND sg13cmos5l_fill_1
XANTENNA__0285__GATE Tile_X0Y1_FrameStrobe[6] VPWR VGND sg13cmos5l_antennanp
XANTENNA__0491__D Tile_X0Y1_FrameData[15] VPWR VGND sg13cmos5l_antennanp
XANTENNA__1110__A1 Tile_X0Y1_E2END[0] VPWR VGND sg13cmos5l_antennanp
XFILLER_54_58 VPWR VGND sg13cmos5l_fill_1
XANTENNA__0223__GATE Tile_X0Y1_FrameStrobe[4] VPWR VGND sg13cmos5l_antennanp
XFILLER_70_46 VPWR VGND sg13cmos5l_fill_1
XFILLER_79_11 VPWR VGND sg13cmos5l_fill_2
XANTENNA__0238__GATE Tile_X0Y1_FrameStrobe[4] VPWR VGND sg13cmos5l_antennanp
XANTENNA__1101__A1 Tile_X0Y0_E6END[1] VPWR VGND sg13cmos5l_antennanp
XFILLER_63_115 VPWR VGND sg13cmos5l_fill_2
XFILLER_95_87 VPWR VGND sg13cmos5l_fill_2
XFILLER_71_170 VPWR VGND sg13cmos5l_fill_1
X_0991_ _0991_/X Tile_X0Y1_EE4END[1] Tile_X0Y1_EE4END[9] Tile_X0Y1_E6END[9] _1212_/X
+ _0416_/Q _0415_/Q VPWR VGND sg13cmos5l_mux4_1
XFILLER_5_74 VPWR VGND sg13cmos5l_fill_2
XANTENNA__0576__D Tile_X0Y1_FrameData[26] VPWR VGND sg13cmos5l_antennanp
XFILLER_39_178 VPWR VGND sg13cmos5l_fill_2
X_0425_ _0425_/Q Tile_X0Y1_FrameData[17] VGND VPWR Tile_X0Y1_FrameStrobe[2] latch
X_0356_ _0356_/Q Tile_X0Y1_FrameData[22] VGND VPWR Tile_X0Y1_FrameStrobe[0] latch
X_0287_ _0287_/Q Tile_X0Y0_FrameData[29] VGND VPWR Tile_X0Y1_FrameStrobe[6] latch
XANTENNA__0619__CLK Tile_X0Y1_UserCLK VPWR VGND sg13cmos5l_antennanp
XFILLER_24_28 VPWR VGND sg13cmos5l_fill_2
XFILLER_54_137 VPWR VGND sg13cmos5l_fill_1
XFILLER_108_128 VPWR VGND sg13cmos5l_fill_1
XFILLER_40_38 VPWR VGND sg13cmos5l_decap_4
XANTENNA__0888__X Tile_X0Y1_S1BEG[0] VPWR VGND sg13cmos5l_antennanp
XANTENNA__0486__D Tile_X0Y1_FrameData[20] VPWR VGND sg13cmos5l_antennanp
XFILLER_45_126 VPWR VGND sg13cmos5l_fill_2
XFILLER_45_137 VPWR VGND sg13cmos5l_fill_1
XFILLER_65_24 VPWR VGND sg13cmos5l_fill_1
XFILLER_81_78 VPWR VGND sg13cmos5l_fill_1
XANTENNA__0162__GATE Tile_X0Y1_FrameStrobe[2] VPWR VGND sg13cmos5l_antennanp
XANTENNA__0798__X Tile_X0Y0_N2BEG[7] VPWR VGND sg13cmos5l_antennanp
XANTENNA__0100__GATE Tile_X0Y1_FrameStrobe[0] VPWR VGND sg13cmos5l_antennanp
XANTENNA__0177__GATE Tile_X0Y1_FrameStrobe[2] VPWR VGND sg13cmos5l_antennanp
XANTENNA__0396__D Tile_X0Y1_FrameData[14] VPWR VGND sg13cmos5l_antennanp
X_1190_ _1190_/X _0647_/Q _1203_/X _1207_/X _1202_/X _0436_/Q _0435_/Q VPWR VGND sg13cmos5l_mux4_1
X_0210_ _0210_/Q Tile_X0Y0_FrameData[10] VGND VPWR Tile_X0Y1_FrameStrobe[3] latch
X_0141_ _0141_/Q Tile_X0Y0_FrameData[15] VGND VPWR Tile_X0Y1_FrameStrobe[1] latch
XANTENNA__0115__GATE Tile_X0Y1_FrameStrobe[0] VPWR VGND sg13cmos5l_antennanp
XFILLER_55_90 VPWR VGND sg13cmos5l_fill_1
X_0072_ _0092_/D _1233_/X _0605_/Q _0608_/Q VPWR VGND sg13cmos5l_mux2_1
X_0974_ _0974_/X Tile_X0Y0_E2MID[1] Tile_X0Y0_E2END[1] _1093_/X _0974_/A3 _0168_/Q
+ _0167_/Q VPWR VGND sg13cmos5l_mux4_1
XANTENNA__1010__A0 Tile_X0Y0_E2MID[0] VPWR VGND sg13cmos5l_antennanp
XFILLER_58_0 VPWR VGND sg13cmos5l_fill_2
XANTENNA__0884__A Tile_X0Y0_FrameData[28] VPWR VGND sg13cmos5l_antennanp
XFILLER_27_115 VPWR VGND sg13cmos5l_fill_2
X_0408_ _0408_/Q Tile_X0Y1_FrameData[2] VGND VPWR Tile_X0Y1_FrameStrobe[1] latch
X_0339_ _0339_/Q Tile_X0Y0_FrameData[9] VGND VPWR Tile_X0Y1_FrameStrobe[7] latch
XANTENNA__1092__A3 Tile_X0Y0_S2END[0] VPWR VGND sg13cmos5l_antennanp
XANTENNA__1001__A0 Tile_X0Y0_E1END[2] VPWR VGND sg13cmos5l_antennanp
XFILLER_76_45 VPWR VGND sg13cmos5l_fill_1
XFILLER_92_11 VPWR VGND sg13cmos5l_fill_1
XANTENNA__1083__A3 Tile_X0Y0_S4END[0] VPWR VGND sg13cmos5l_antennanp
XFILLER_41_81 VPWR VGND sg13cmos5l_fill_1
X_0690_ _0690_/L_HI VPWR VGND sg13cmos5l_tiehi
X_1173_ _1173_/X _0646_/Q _0650_/Q _1208_/X _1200_/X _0470_/Q _0469_/Q VPWR VGND sg13cmos5l_mux4_1
X_0124_ _0124_/Q Tile_X0Y0_FrameData[0] VGND VPWR Tile_X0Y1_FrameStrobe[0] latch
XANTENNA__0879__A Tile_X0Y0_FrameData[23] VPWR VGND sg13cmos5l_antennanp
XANTENNA__1231__A0 Tile_X0Y0_EE4END[0] VPWR VGND sg13cmos5l_antennanp
X_0888_ Tile_X0Y1_S1BEG[0] _1123_/X VPWR VGND sg13cmos5l_buf_1
X_0957_ Tile_X0Y1_WW4BEG[0] _1163_/X VPWR VGND sg13cmos5l_buf_1
XFILLER_102_87 VPWR VGND sg13cmos5l_decap_8
XFILLER_15_118 VPWR VGND sg13cmos5l_fill_1
XANTENNA__1222__A0 Tile_X0Y0_E2MID[4] VPWR VGND sg13cmos5l_antennanp
XANTENNA__1213__A0 Tile_X0Y1_N1END[2] VPWR VGND sg13cmos5l_antennanp
X_0811_ Tile_X0Y0_FrameStrobe_O[8] Tile_X0Y1_FrameStrobe[8] VPWR VGND sg13cmos5l_buf_1
X_0742_ Tile_X0Y0_W6BEG[3] _1066_/X VPWR VGND sg13cmos5l_buf_1
X_0673_ _0673_/L_HI VPWR VGND sg13cmos5l_tiehi
XANTENNA__0584__D Tile_X0Y1_FrameData[18] VPWR VGND sg13cmos5l_antennanp
X_1087_ _1087_/X _1111_/X Tile_X0Y1_N4END[4] Tile_X0Y0_S1END[0] Tile_X0Y0_S4END[0]
+ _0140_/Q _0139_/Q VPWR VGND sg13cmos5l_mux4_1
X_1225_ _1225_/X Tile_X0Y0_E1END[2] Tile_X0Y0_E2MID[1] Tile_X0Y0_E2END[1] _1098_/X
+ _0290_/Q _0289_/Q VPWR VGND sg13cmos5l_mux4_1
X_1156_ _1156_/X Tile_X0Y1_E2MID[4] _0645_/Q _1196_/X _1201_/X _0504_/Q _0503_/Q VPWR
+ VGND sg13cmos5l_mux4_1
X_0107_ _0107_/Q Tile_X0Y0_FrameData[17] VGND VPWR Tile_X0Y1_FrameStrobe[0] latch
XANTENNA__1204__A0 Tile_X0Y1_N1END[1] VPWR VGND sg13cmos5l_antennanp
XANTENNA__0561__GATE Tile_X0Y1_FrameStrobe[6] VPWR VGND sg13cmos5l_antennanp
XANTENNA__0896__X Tile_X0Y1_S2BEG[4] VPWR VGND sg13cmos5l_antennanp
XANTENNA__0576__GATE Tile_X0Y1_FrameStrobe[7] VPWR VGND sg13cmos5l_antennanp
XFILLER_57_36 VPWR VGND sg13cmos5l_fill_1
XFILLER_87_121 VPWR VGND sg13cmos5l_fill_2
XANTENNA__0494__D Tile_X0Y1_FrameData[12] VPWR VGND sg13cmos5l_antennanp
XANTENNA__0514__GATE Tile_X0Y1_FrameStrobe[5] VPWR VGND sg13cmos5l_antennanp
XANTENNA__0529__GATE Tile_X0Y1_FrameStrobe[5] VPWR VGND sg13cmos5l_antennanp
XANTENNA__1210__A3 Tile_X0Y0_S4END[7] VPWR VGND sg13cmos5l_antennanp
XFILLER_98_54 VPWR VGND sg13cmos5l_decap_4
X_1010_ _1010_/X Tile_X0Y0_E2MID[0] Tile_X0Y0_E2END[0] Tile_X0Y0_E6END[0] _1099_/X
+ _0324_/Q _0323_/Q VPWR VGND sg13cmos5l_mux4_1
XANTENNA__0579__D Tile_X0Y1_FrameData[23] VPWR VGND sg13cmos5l_antennanp
XANTENNA__1201__A3 Tile_X0Y0_S2MID[6] VPWR VGND sg13cmos5l_antennanp
XFILLER_69_110 VPWR VGND sg13cmos5l_fill_2
X_0725_ Tile_X0Y0_W2BEG[2] _1033_/X VPWR VGND sg13cmos5l_buf_1
X_0656_ _0656_/L_HI VPWR VGND sg13cmos5l_tiehi
XFILLER_27_17 VPWR VGND sg13cmos5l_decap_8
XFILLER_27_39 VPWR VGND sg13cmos5l_fill_2
X_1208_ _1208_/X Tile_X0Y1_N1END[1] Tile_X0Y1_N4END[1] _1228_/X Tile_X0Y0_S4END[5]
+ _0392_/Q _0391_/Q VPWR VGND sg13cmos5l_mux4_1
X_0587_ _0587_/Q Tile_X0Y1_FrameData[15] VGND VPWR Tile_X0Y1_FrameStrobe[7] latch
XFILLER_84_179 VPWR VGND sg13cmos5l_fill_1
XFILLER_84_157 VPWR VGND sg13cmos5l_fill_2
XFILLER_43_38 VPWR VGND sg13cmos5l_fill_2
X_1139_ _1139_/X Tile_X0Y1_E1END[2] Tile_X0Y1_EE4END[14] Tile_X0Y1_E6END[6] _1205_/X
+ _0536_/Q _0535_/Q VPWR VGND sg13cmos5l_mux4_1
XANTENNA__0489__D Tile_X0Y1_FrameData[17] VPWR VGND sg13cmos5l_antennanp
XFILLER_75_135 VPWR VGND sg13cmos5l_fill_2
XFILLER_75_124 VPWR VGND sg13cmos5l_decap_8
XANTENNA__0453__GATE Tile_X0Y1_FrameStrobe[3] VPWR VGND sg13cmos5l_antennanp
XANTENNA__0399__D Tile_X0Y1_FrameData[11] VPWR VGND sg13cmos5l_antennanp
XANTENNA__0468__GATE Tile_X0Y1_FrameStrobe[3] VPWR VGND sg13cmos5l_antennanp
X_0510_ _0510_/Q Tile_X0Y1_FrameData[28] VGND VPWR Tile_X0Y1_FrameStrobe[5] latch
XANTENNA__0406__GATE Tile_X0Y1_FrameStrobe[1] VPWR VGND sg13cmos5l_antennanp
X_0441_ _0441_/Q Tile_X0Y1_FrameData[1] VGND VPWR Tile_X0Y1_FrameStrobe[2] latch
X_0372_ _0372_/Q Tile_X0Y1_FrameData[6] VGND VPWR Tile_X0Y1_FrameStrobe[0] latch
XANTENNA__0102__D Tile_X0Y0_FrameData[22] VPWR VGND sg13cmos5l_antennanp
XANTENNA__0887__A Tile_X0Y0_FrameData[31] VPWR VGND sg13cmos5l_antennanp
XFILLER_38_27 VPWR VGND sg13cmos5l_decap_4
X_0708_ _1193_/A3 VPWR VGND sg13cmos5l_tielo
X_0639_ _0639_/Q Tile_X0Y1_UserCLK NPU_OUT_ACT3 _0669_/L_HI VPWR VGND sg13cmos5l_dfrbpq_1
XFILLER_57_168 VPWR VGND sg13cmos5l_fill_2
XANTENNA__1110__A2 Tile_X0Y1_E6END[0] VPWR VGND sg13cmos5l_antennanp
XANTENNA__0392__GATE Tile_X0Y1_FrameStrobe[1] VPWR VGND sg13cmos5l_antennanp
XANTENNA__1101__A2 Tile_X0Y0_S1END[1] VPWR VGND sg13cmos5l_antennanp
XFILLER_44_81 VPWR VGND sg13cmos5l_decap_4
X_0990_ _0990_/X Tile_X0Y1_EE4END[0] Tile_X0Y1_EE4END[8] Tile_X0Y1_E6END[8] _1211_/X
+ _0418_/Q _0417_/Q VPWR VGND sg13cmos5l_mux4_1
XANTENNA__0330__GATE Tile_X0Y1_FrameStrobe[7] VPWR VGND sg13cmos5l_antennanp
XANTENNA__0345__GATE Tile_X0Y1_FrameStrobe[7] VPWR VGND sg13cmos5l_antennanp
X_0424_ _0424_/Q Tile_X0Y1_FrameData[18] VGND VPWR Tile_X0Y1_FrameStrobe[2] latch
X_0355_ _0355_/Q Tile_X0Y1_FrameData[23] VGND VPWR Tile_X0Y1_FrameStrobe[0] latch
X_0286_ _0286_/Q Tile_X0Y0_FrameData[30] VGND VPWR Tile_X0Y1_FrameStrobe[6] latch
XANTENNA__0592__D Tile_X0Y1_FrameData[10] VPWR VGND sg13cmos5l_antennanp
XFILLER_40_28 VPWR VGND sg13cmos5l_fill_2
XFILLER_49_37 VPWR VGND sg13cmos5l_fill_2
XANTENNA__1095__A1 Tile_X0Y1_N2MID[3] VPWR VGND sg13cmos5l_antennanp
XFILLER_45_105 VPWR VGND sg13cmos5l_decap_4
XFILLER_60_108 VPWR VGND sg13cmos5l_fill_1
XFILLER_14_73 VPWR VGND sg13cmos5l_decap_8
XFILLER_81_57 VPWR VGND sg13cmos5l_decap_8
XFILLER_81_46 VPWR VGND sg13cmos5l_decap_4
XFILLER_30_50 VPWR VGND sg13cmos5l_decap_4
XFILLER_39_9 VPWR VGND sg13cmos5l_decap_8
X_0140_ _0140_/Q Tile_X0Y0_FrameData[16] VGND VPWR Tile_X0Y1_FrameStrobe[1] latch
X_0071_ _0091_/D _1232_/X _0606_/Q _0608_/Q VPWR VGND sg13cmos5l_mux2_1
XANTENNA__1086__A1 Tile_X0Y1_N4END[5] VPWR VGND sg13cmos5l_antennanp
X_0973_ _0973_/X Tile_X0Y0_E2MID[0] Tile_X0Y0_E2END[0] _1092_/X _0973_/A3 _0170_/Q
+ _0169_/Q VPWR VGND sg13cmos5l_mux4_1
XANTENNA__0284__GATE Tile_X0Y1_FrameStrobe[5] VPWR VGND sg13cmos5l_antennanp
XANTENNA__0587__D Tile_X0Y1_FrameData[15] VPWR VGND sg13cmos5l_antennanp
XANTENNA__1010__A1 Tile_X0Y0_E2END[0] VPWR VGND sg13cmos5l_antennanp
XFILLER_19_29 VPWR VGND sg13cmos5l_decap_8
X_0407_ _0407_/Q Tile_X0Y1_FrameData[3] VGND VPWR Tile_X0Y1_FrameStrobe[1] latch
XANTENNA__0222__GATE Tile_X0Y1_FrameStrobe[4] VPWR VGND sg13cmos5l_antennanp
XANTENNA__0299__GATE Tile_X0Y1_FrameStrobe[6] VPWR VGND sg13cmos5l_antennanp
XANTENNA__1077__A1 Tile_X0Y1_N4END[6] VPWR VGND sg13cmos5l_antennanp
X_0338_ _0338_/Q Tile_X0Y0_FrameData[10] VGND VPWR Tile_X0Y1_FrameStrobe[7] latch
X_0269_ _0269_/Q Tile_X0Y0_FrameData[15] VGND VPWR Tile_X0Y1_FrameStrobe[5] latch
XANTENNA__0237__GATE Tile_X0Y1_FrameStrobe[4] VPWR VGND sg13cmos5l_antennanp
XFILLER_50_152 VPWR VGND sg13cmos5l_fill_1
XANTENNA__0899__X Tile_X0Y1_S2BEG[7] VPWR VGND sg13cmos5l_antennanp
XANTENNA__1001__A1 Tile_X0Y0_E6END[6] VPWR VGND sg13cmos5l_antennanp
XFILLER_104_154 VPWR VGND sg13cmos5l_fill_1
XFILLER_104_165 VPWR VGND sg13cmos5l_fill_2
XANTENNA__0497__D Tile_X0Y1_FrameData[9] VPWR VGND sg13cmos5l_antennanp
XFILLER_18_116 VPWR VGND sg13cmos5l_fill_2
XFILLER_33_108 VPWR VGND sg13cmos5l_fill_1
XFILLER_92_89 VPWR VGND sg13cmos5l_decap_8
XFILLER_92_23 VPWR VGND sg13cmos5l_fill_2
XFILLER_2_10 VPWR VGND sg13cmos5l_fill_1
XANTENNA__0200__D Tile_X0Y0_FrameData[20] VPWR VGND sg13cmos5l_antennanp
XFILLER_110_168 VPWR VGND sg13cmos5l_fill_2
XFILLER_110_179 VPWR VGND sg13cmos5l_fill_1
XFILLER_17_160 VPWR VGND sg13cmos5l_fill_1
X_1172_ _1172_/X _0645_/Q _0649_/Q _1209_/X _1201_/X _0472_/Q _0471_/Q VPWR VGND sg13cmos5l_mux4_1
X_0123_ _0123_/Q Tile_X0Y0_FrameData[1] VGND VPWR Tile_X0Y1_FrameStrobe[0] latch
XFILLER_70_0 VPWR VGND sg13cmos5l_fill_1
X_0956_ Tile_X0Y1_W6BEG[11] _1190_/X VPWR VGND sg13cmos5l_buf_1
XANTENNA__0990__A0 Tile_X0Y1_EE4END[0] VPWR VGND sg13cmos5l_antennanp
XANTENNA__1231__A1 Tile_X0Y0_EE4END[8] VPWR VGND sg13cmos5l_antennanp
X_0887_ Tile_X0Y0_FrameData_O[31] Tile_X0Y0_FrameData[31] VPWR VGND sg13cmos5l_buf_1
XANTENNA__0110__D Tile_X0Y0_FrameData[14] VPWR VGND sg13cmos5l_antennanp
XANTENNA__0161__GATE Tile_X0Y1_FrameStrobe[2] VPWR VGND sg13cmos5l_antennanp
XFILLER_23_152 VPWR VGND sg13cmos5l_fill_1
XANTENNA__0176__GATE Tile_X0Y1_FrameStrobe[2] VPWR VGND sg13cmos5l_antennanp
XANTENNA__1222__A1 Tile_X0Y0_E2END[4] VPWR VGND sg13cmos5l_antennanp
XANTENNA__0114__GATE Tile_X0Y1_FrameStrobe[0] VPWR VGND sg13cmos5l_antennanp
XANTENNA__0981__A0 Tile_X0Y0_E1END[0] VPWR VGND sg13cmos5l_antennanp
XFILLER_11_63 VPWR VGND sg13cmos5l_decap_8
XFILLER_11_96 VPWR VGND sg13cmos5l_fill_1
XFILLER_87_56 VPWR VGND sg13cmos5l_fill_1
XANTENNA__0129__GATE Tile_X0Y1_FrameStrobe[1] VPWR VGND sg13cmos5l_antennanp
X_0810_ Tile_X0Y0_FrameStrobe_O[7] Tile_X0Y1_FrameStrobe[7] VPWR VGND sg13cmos5l_buf_1
XANTENNA__1213__A1 Tile_X0Y1_N4END[2] VPWR VGND sg13cmos5l_antennanp
X_0741_ Tile_X0Y0_W6BEG[2] _1065_/X VPWR VGND sg13cmos5l_buf_1
X_0672_ _0672_/L_HI VPWR VGND sg13cmos5l_tiehi
X_1224_ _1224_/X Tile_X0Y0_E1END[1] Tile_X0Y0_E2MID[2] Tile_X0Y0_E2END[2] _1097_/X
+ _0292_/Q _0291_/Q VPWR VGND sg13cmos5l_mux4_1
X_1086_ _1086_/X _1112_/X Tile_X0Y1_N4END[5] Tile_X0Y0_S1END[1] Tile_X0Y0_S4END[1]
+ _0138_/Q _0137_/Q VPWR VGND sg13cmos5l_mux4_1
X_1155_ _1155_/X Tile_X0Y1_E2MID[1] _0644_/Q _1195_/X _1202_/X _0506_/Q _0505_/Q VPWR
+ VGND sg13cmos5l_mux4_1
X_0106_ _0106_/Q Tile_X0Y0_FrameData[18] VGND VPWR Tile_X0Y1_FrameStrobe[0] latch
XANTENNA__0105__D Tile_X0Y0_FrameData[19] VPWR VGND sg13cmos5l_antennanp
XANTENNA__1204__A1 Tile_X0Y1_N4END[1] VPWR VGND sg13cmos5l_antennanp
XFILLER_20_122 VPWR VGND sg13cmos5l_fill_1
X_0939_ Tile_X0Y1_W2BEGb[2] _1157_/X VPWR VGND sg13cmos5l_buf_1
XFILLER_118_0 VPWR VGND sg13cmos5l_fill_1
XFILLER_98_33 VPWR VGND sg13cmos5l_decap_8
XFILLER_0_0 VPWR VGND sg13cmos5l_fill_2
XFILLER_78_122 VPWR VGND sg13cmos5l_fill_1
XANTENNA__1131__A0 Tile_X0Y1_E1END[0] VPWR VGND sg13cmos5l_antennanp
XANTENNA__1198__A0 Tile_X0Y1_N2MID[3] VPWR VGND sg13cmos5l_antennanp
X_0724_ Tile_X0Y0_W2BEG[1] _1032_/X VPWR VGND sg13cmos5l_buf_1
X_0655_ _0655_/L_HI VPWR VGND sg13cmos5l_tiehi
X_0586_ _0586_/Q Tile_X0Y1_FrameData[16] VGND VPWR Tile_X0Y1_FrameStrobe[7] latch
XANTENNA__0595__D Tile_X0Y1_FrameData[7] VPWR VGND sg13cmos5l_antennanp
X_1207_ _1207_/X Tile_X0Y1_N1END[0] Tile_X0Y1_N4END[0] _1227_/X Tile_X0Y0_S4END[4]
+ _0394_/Q _0393_/Q VPWR VGND sg13cmos5l_mux4_1
XFILLER_43_28 VPWR VGND sg13cmos5l_fill_2
X_1069_ _1069_/X _0642_/Q _1086_/X _1082_/X _1094_/X _0190_/Q _0189_/Q VPWR VGND sg13cmos5l_mux4_1
X_1138_ _1138_/X _1208_/X _1212_/X _1216_/X _1200_/X _0539_/Q _0538_/Q VPWR VGND sg13cmos5l_mux4_1
XFILLER_108_43 VPWR VGND sg13cmos5l_fill_2
XFILLER_108_54 VPWR VGND sg13cmos5l_fill_1
XFILLER_108_76 VPWR VGND sg13cmos5l_decap_4
XANTENNA__1113__A0 Tile_X0Y1_E1END[2] VPWR VGND sg13cmos5l_antennanp
XFILLER_17_40 VPWR VGND sg13cmos5l_decap_8
XFILLER_90_117 VPWR VGND sg13cmos5l_fill_1
XANTENNA__1195__A3 Tile_X0Y0_S2MID[0] VPWR VGND sg13cmos5l_antennanp
X_0440_ _0440_/Q Tile_X0Y1_FrameData[2] VGND VPWR Tile_X0Y1_FrameStrobe[2] latch
XANTENNA__1104__A0 Tile_X0Y1_E2MID[6] VPWR VGND sg13cmos5l_antennanp
X_0371_ _0371_/Q Tile_X0Y1_FrameData[7] VGND VPWR Tile_X0Y1_FrameStrobe[0] latch
XANTENNA__0560__GATE Tile_X0Y1_FrameStrobe[6] VPWR VGND sg13cmos5l_antennanp
XFILLER_95_2 VPWR VGND sg13cmos5l_fill_1
XANTENNA__0575__GATE Tile_X0Y1_FrameStrobe[7] VPWR VGND sg13cmos5l_antennanp
X_0707_ _1194_/A3 VPWR VGND sg13cmos5l_tielo
XANTENNA__0513__GATE Tile_X0Y1_FrameStrobe[5] VPWR VGND sg13cmos5l_antennanp
X_0638_ _0638_/Q Tile_X0Y1_UserCLK NPU_OUT_ACT2 _0670_/L_HI VPWR VGND sg13cmos5l_dfrbpq_1
X_0569_ _0569_/Q Tile_X0Y1_FrameData[1] VGND VPWR Tile_X0Y1_FrameStrobe[6] latch
XANTENNA__0528__GATE Tile_X0Y1_FrameStrobe[5] VPWR VGND sg13cmos5l_antennanp
XFILLER_54_27 VPWR VGND sg13cmos5l_decap_4
XFILLER_70_59 VPWR VGND sg13cmos5l_fill_2
XFILLER_79_79 VPWR VGND sg13cmos5l_decap_8
XANTENNA__0642__CLK Tile_X0Y1_UserCLK VPWR VGND sg13cmos5l_antennanp
XFILLER_63_117 VPWR VGND sg13cmos5l_fill_1
XFILLER_95_78 VPWR VGND sg13cmos5l_fill_2
XFILLER_44_93 VPWR VGND sg13cmos5l_decap_8
XFILLER_60_92 VPWR VGND sg13cmos5l_decap_8
XANTENNA__0203__D Tile_X0Y0_FrameData[17] VPWR VGND sg13cmos5l_antennanp
X_0423_ _0423_/Q Tile_X0Y1_FrameData[19] VGND VPWR Tile_X0Y1_FrameStrobe[2] latch
X_0354_ _0354_/Q Tile_X0Y1_FrameData[24] VGND VPWR Tile_X0Y1_FrameStrobe[0] latch
X_0285_ _0285_/Q Tile_X0Y0_FrameData[31] VGND VPWR Tile_X0Y1_FrameStrobe[6] latch
XANTENNA__0113__D Tile_X0Y0_FrameData[11] VPWR VGND sg13cmos5l_antennanp
XFILLER_116_152 VPWR VGND sg13cmos5l_fill_1
XANTENNA__0452__GATE Tile_X0Y1_FrameStrobe[3] VPWR VGND sg13cmos5l_antennanp
XANTENNA__0467__GATE Tile_X0Y1_FrameStrobe[3] VPWR VGND sg13cmos5l_antennanp
XFILLER_105_66 VPWR VGND sg13cmos5l_fill_2
XANTENNA__1095__A2 Tile_X0Y0_S2MID[3] VPWR VGND sg13cmos5l_antennanp
XANTENNA__0405__GATE Tile_X0Y1_FrameStrobe[1] VPWR VGND sg13cmos5l_antennanp
XFILLER_100_0 VPWR VGND sg13cmos5l_fill_2
XFILLER_51_109 VPWR VGND sg13cmos5l_fill_2
X_0070_ _0090_/D _1231_/X _0607_/Q _0608_/Q VPWR VGND sg13cmos5l_mux2_1
XANTENNA__1086__A2 Tile_X0Y0_S1END[1] VPWR VGND sg13cmos5l_antennanp
XFILLER_71_80 VPWR VGND sg13cmos5l_decap_8
XFILLER_71_91 VPWR VGND sg13cmos5l_decap_8
X_0972_ Tile_X0Y1_WW4BEG[15] _1178_/X VPWR VGND sg13cmos5l_buf_1
XANTENNA__1010__A2 Tile_X0Y0_E6END[0] VPWR VGND sg13cmos5l_antennanp
XFILLER_113_133 VPWR VGND sg13cmos5l_fill_1
XFILLER_27_117 VPWR VGND sg13cmos5l_fill_1
X_0406_ _0406_/Q Tile_X0Y1_FrameData[4] VGND VPWR Tile_X0Y1_FrameStrobe[1] latch
X_0337_ _0337_/Q Tile_X0Y0_FrameData[11] VGND VPWR Tile_X0Y1_FrameStrobe[7] latch
XANTENNA__1077__A2 Tile_X0Y0_S1END[2] VPWR VGND sg13cmos5l_antennanp
XFILLER_27_139 VPWR VGND sg13cmos5l_fill_2
X_0268_ _0268_/Q Tile_X0Y0_FrameData[16] VGND VPWR Tile_X0Y1_FrameStrobe[5] latch
X_0199_ _0199_/Q Tile_X0Y0_FrameData[21] VGND VPWR Tile_X0Y1_FrameStrobe[3] latch
XANTENNA__0108__D Tile_X0Y0_FrameData[16] VPWR VGND sg13cmos5l_antennanp
XANTENNA__0391__GATE Tile_X0Y1_FrameStrobe[1] VPWR VGND sg13cmos5l_antennanp
XFILLER_116_65 VPWR VGND sg13cmos5l_fill_1
XFILLER_76_14 VPWR VGND sg13cmos5l_decap_8
XFILLER_76_36 VPWR VGND sg13cmos5l_fill_2
XANTENNA__0344__GATE Tile_X0Y1_FrameStrobe[7] VPWR VGND sg13cmos5l_antennanp
XFILLER_25_84 VPWR VGND sg13cmos5l_decap_4
XANTENNA__0359__GATE Tile_X0Y1_FrameStrobe[0] VPWR VGND sg13cmos5l_antennanp
XFILLER_41_72 VPWR VGND sg13cmos5l_decap_8
XFILLER_110_158 VPWR VGND sg13cmos5l_fill_1
X_1171_ _1171_/X _0644_/Q _0648_/Q _1210_/X _1202_/X _0474_/Q _0473_/Q VPWR VGND sg13cmos5l_mux4_1
XFILLER_66_91 VPWR VGND sg13cmos5l_fill_2
X_0122_ _0122_/Q Tile_X0Y0_FrameData[2] VGND VPWR Tile_X0Y1_FrameStrobe[0] latch
XANTENNA__1231__A2 Tile_X0Y0_E6END[0] VPWR VGND sg13cmos5l_antennanp
X_0886_ Tile_X0Y0_FrameData_O[30] Tile_X0Y0_FrameData[30] VPWR VGND sg13cmos5l_buf_1
X_0955_ Tile_X0Y1_W6BEG[10] _1189_/X VPWR VGND sg13cmos5l_buf_1
XFILLER_82_90 VPWR VGND sg13cmos5l_decap_8
XANTENNA__0598__D Tile_X0Y1_FrameData[4] VPWR VGND sg13cmos5l_antennanp
XANTENNA__0990__A1 Tile_X0Y1_EE4END[8] VPWR VGND sg13cmos5l_antennanp
XFILLER_99_142 VPWR VGND sg13cmos5l_decap_8
XANTENNA__0981__A1 Tile_X0Y0_E6END[0] VPWR VGND sg13cmos5l_antennanp
XANTENNA__1222__A2 Tile_X0Y0_E6END[11] VPWR VGND sg13cmos5l_antennanp
XANTENNA__0301__D Tile_X0Y0_FrameData[15] VPWR VGND sg13cmos5l_antennanp
XFILLER_87_35 VPWR VGND sg13cmos5l_decap_4
XANTENNA__0283__GATE Tile_X0Y1_FrameStrobe[5] VPWR VGND sg13cmos5l_antennanp
X_0740_ Tile_X0Y0_W6BEG[1] _1064_/X VPWR VGND sg13cmos5l_buf_1
XANTENNA__0221__GATE Tile_X0Y1_FrameStrobe[4] VPWR VGND sg13cmos5l_antennanp
XANTENNA__0298__GATE Tile_X0Y1_FrameStrobe[6] VPWR VGND sg13cmos5l_antennanp
X_0671_ _0671_/L_HI VPWR VGND sg13cmos5l_tiehi
XANTENNA__0211__D Tile_X0Y0_FrameData[9] VPWR VGND sg13cmos5l_antennanp
XANTENNA__0236__GATE Tile_X0Y1_FrameStrobe[4] VPWR VGND sg13cmos5l_antennanp
X_1223_ _1223_/X Tile_X0Y0_E1END[0] Tile_X0Y0_E2MID[3] Tile_X0Y0_E2END[3] _1096_/X
+ _0294_/Q _0293_/Q VPWR VGND sg13cmos5l_mux4_1
X_1154_ _1154_/X _0651_/Q _1195_/X _1202_/X _1193_/X _0508_/Q _0507_/Q VPWR VGND sg13cmos5l_mux4_1
XFILLER_96_145 VPWR VGND sg13cmos5l_fill_2
X_1085_ _1085_/X _1113_/X Tile_X0Y1_N4END[6] Tile_X0Y0_S1END[2] Tile_X0Y0_S4END[2]
+ _0136_/Q _0135_/Q VPWR VGND sg13cmos5l_mux4_1
X_0105_ _0105_/Q Tile_X0Y0_FrameData[19] VGND VPWR Tile_X0Y1_FrameStrobe[0] latch
X_0869_ Tile_X0Y0_FrameData_O[13] Tile_X0Y0_FrameData[13] VPWR VGND sg13cmos5l_buf_1
X_0938_ Tile_X0Y1_W2BEGb[1] _1156_/X VPWR VGND sg13cmos5l_buf_1
XANTENNA__0121__D Tile_X0Y0_FrameData[3] VPWR VGND sg13cmos5l_antennanp
XFILLER_87_145 VPWR VGND sg13cmos5l_decap_8
XFILLER_113_11 VPWR VGND sg13cmos5l_fill_1
XFILLER_113_99 VPWR VGND sg13cmos5l_fill_1
XFILLER_7_127 VPWR VGND sg13cmos5l_decap_4
XFILLER_98_67 VPWR VGND sg13cmos5l_fill_2
XANTENNA__1131__A1 Tile_X0Y1_E2MID[3] VPWR VGND sg13cmos5l_antennanp
XFILLER_47_82 VPWR VGND sg13cmos5l_decap_4
XFILLER_93_137 VPWR VGND sg13cmos5l_fill_1
XFILLER_63_70 VPWR VGND sg13cmos5l_decap_4
XANTENNA__0206__D Tile_X0Y0_FrameData[14] VPWR VGND sg13cmos5l_antennanp
XANTENNA__1198__A1 Tile_X0Y1_N2END[3] VPWR VGND sg13cmos5l_antennanp
X_0723_ Tile_X0Y0_W2BEG[0] _1031_/X VPWR VGND sg13cmos5l_buf_1
XANTENNA__0160__GATE Tile_X0Y1_FrameStrobe[2] VPWR VGND sg13cmos5l_antennanp
XANTENNA__0175__GATE Tile_X0Y1_FrameStrobe[2] VPWR VGND sg13cmos5l_antennanp
XFILLER_26_0 VPWR VGND sg13cmos5l_fill_2
XFILLER_69_112 VPWR VGND sg13cmos5l_fill_1
X_0654_ _0654_/L_HI VPWR VGND sg13cmos5l_tiehi
X_0585_ _0585_/Q Tile_X0Y1_FrameData[17] VGND VPWR Tile_X0Y1_FrameStrobe[7] latch
X_1137_ _1137_/X Tile_X0Y1_E1END[1] Tile_X0Y1_EE4END[13] Tile_X0Y1_E6END[5] _1204_/X
+ _0539_/Q _0538_/Q VPWR VGND sg13cmos5l_mux4_1
X_1206_ _1206_/X Tile_X0Y1_N1END[3] Tile_X0Y1_N4END[3] _1230_/X Tile_X0Y0_S4END[7]
+ _0396_/Q _0395_/Q VPWR VGND sg13cmos5l_mux4_1
XANTENNA__0113__GATE Tile_X0Y1_FrameStrobe[0] VPWR VGND sg13cmos5l_antennanp
XANTENNA__0116__D Tile_X0Y0_FrameData[8] VPWR VGND sg13cmos5l_antennanp
X_1068_ _1068_/X _0641_/Q _1085_/X _1081_/X _1093_/X _0192_/Q _0191_/Q VPWR VGND sg13cmos5l_mux4_1
XANTENNA__0128__GATE Tile_X0Y1_FrameStrobe[1] VPWR VGND sg13cmos5l_antennanp
XANTENNA__1113__A1 Tile_X0Y1_E6END[6] VPWR VGND sg13cmos5l_antennanp
XFILLER_84_69 VPWR VGND sg13cmos5l_decap_8
XFILLER_33_40 VPWR VGND sg13cmos5l_decap_8
XFILLER_33_51 VPWR VGND sg13cmos5l_fill_1
XFILLER_3_141 VPWR VGND sg13cmos5l_fill_1
X_0370_ _0370_/Q Tile_X0Y1_FrameData[8] VGND VPWR Tile_X0Y1_FrameStrobe[0] latch
XANTENNA__1104__A1 Tile_X0Y1_E2END[6] VPWR VGND sg13cmos5l_antennanp
XANTENNA__0801__X Tile_X0Y0_N1BEG[2] VPWR VGND sg13cmos5l_antennanp
XANTENNA__1040__A0 Tile_X0Y0_EE4END[7] VPWR VGND sg13cmos5l_antennanp
X_0706_ _1078_/A3 VPWR VGND sg13cmos5l_tielo
XFILLER_57_104 VPWR VGND sg13cmos5l_fill_2
X_0637_ _0637_/Q Tile_X0Y1_UserCLK NPU_OUT_ACT1 _0668_/L_HI VPWR VGND sg13cmos5l_dfrbpq_1
X_0568_ _0568_/Q Tile_X0Y1_FrameData[2] VGND VPWR Tile_X0Y1_FrameStrobe[6] latch
X_0499_ _0499_/Q Tile_X0Y1_FrameData[7] VGND VPWR Tile_X0Y1_FrameStrobe[4] latch
XFILLER_70_27 VPWR VGND sg13cmos5l_decap_8
XFILLER_70_38 VPWR VGND sg13cmos5l_fill_1
XANTENNA__1031__A0 Tile_X0Y0_EE4END[4] VPWR VGND sg13cmos5l_antennanp
XFILLER_95_13 VPWR VGND sg13cmos5l_fill_2
XFILLER_79_58 VPWR VGND sg13cmos5l_decap_8
XFILLER_28_62 VPWR VGND sg13cmos5l_decap_8
XFILLER_56_170 VPWR VGND sg13cmos5l_fill_1
XFILLER_44_50 VPWR VGND sg13cmos5l_decap_8
X_0422_ _0422_/Q Tile_X0Y1_FrameData[20] VGND VPWR Tile_X0Y1_FrameStrobe[2] latch
X_0353_ _0353_/Q Tile_X0Y1_FrameData[25] VGND VPWR Tile_X0Y1_FrameStrobe[0] latch
X_0284_ _0284_/Q Tile_X0Y0_FrameData[0] VGND VPWR Tile_X0Y1_FrameStrobe[5] latch
XFILLER_93_0 VPWR VGND sg13cmos5l_fill_2
XANTENNA__1013__A0 Tile_X0Y0_E1END[1] VPWR VGND sg13cmos5l_antennanp
XFILLER_49_39 VPWR VGND sg13cmos5l_fill_1
XFILLER_105_34 VPWR VGND sg13cmos5l_decap_8
XANTENNA__1095__A3 Tile_X0Y0_S2END[3] VPWR VGND sg13cmos5l_antennanp
XANTENNA__0304__D Tile_X0Y0_FrameData[12] VPWR VGND sg13cmos5l_antennanp
XANTENNA__1004__A0 Tile_X0Y0_E2MID[6] VPWR VGND sg13cmos5l_antennanp
XANTENNA__0574__GATE Tile_X0Y1_FrameStrobe[7] VPWR VGND sg13cmos5l_antennanp
XANTENNA__0589__GATE Tile_X0Y1_FrameStrobe[7] VPWR VGND sg13cmos5l_antennanp
XANTENNA__1086__A3 Tile_X0Y0_S4END[1] VPWR VGND sg13cmos5l_antennanp
XANTENNA__0512__GATE Tile_X0Y1_FrameStrobe[5] VPWR VGND sg13cmos5l_antennanp
X_0971_ Tile_X0Y1_WW4BEG[14] _1177_/X VPWR VGND sg13cmos5l_buf_1
XANTENNA__0214__D Tile_X0Y0_FrameData[6] VPWR VGND sg13cmos5l_antennanp
XANTENNA__0527__GATE Tile_X0Y1_FrameStrobe[5] VPWR VGND sg13cmos5l_antennanp
X_0405_ _0405_/Q Tile_X0Y1_FrameData[5] VGND VPWR Tile_X0Y1_FrameStrobe[1] latch
X_0336_ _0336_/Q Tile_X0Y0_FrameData[12] VGND VPWR Tile_X0Y1_FrameStrobe[7] latch
X_0267_ _0267_/Q Tile_X0Y0_FrameData[17] VGND VPWR Tile_X0Y1_FrameStrobe[5] latch
XANTENNA__1077__A3 Tile_X0Y0_S4END[2] VPWR VGND sg13cmos5l_antennanp
X_0198_ _0198_/Q Tile_X0Y0_FrameData[22] VGND VPWR Tile_X0Y1_FrameStrobe[3] latch
XANTENNA__0124__D Tile_X0Y0_FrameData[0] VPWR VGND sg13cmos5l_antennanp
XANTENNA__0632__CLK Tile_X0Y1_UserCLK VPWR VGND sg13cmos5l_antennanp
XANTENNA__1234__A0 Tile_X0Y0_E1END[2] VPWR VGND sg13cmos5l_antennanp
XFILLER_116_88 VPWR VGND sg13cmos5l_fill_1
XFILLER_92_25 VPWR VGND sg13cmos5l_fill_1
XANTENNA__1225__A0 Tile_X0Y0_E1END[2] VPWR VGND sg13cmos5l_antennanp
XFILLER_25_41 VPWR VGND sg13cmos5l_decap_8
XFILLER_2_45 VPWR VGND sg13cmos5l_fill_1
XFILLER_66_70 VPWR VGND sg13cmos5l_decap_8
X_1170_ _1170_/X _0647_/Q _0651_/Q _1211_/X _1195_/X _0476_/Q _0475_/Q VPWR VGND sg13cmos5l_mux4_1
X_0121_ _0121_/Q Tile_X0Y0_FrameData[3] VGND VPWR Tile_X0Y1_FrameStrobe[0] latch
XANTENNA__0209__D Tile_X0Y0_FrameData[11] VPWR VGND sg13cmos5l_antennanp
XANTENNA__0451__GATE Tile_X0Y1_FrameStrobe[3] VPWR VGND sg13cmos5l_antennanp
XANTENNA__0466__GATE Tile_X0Y1_FrameStrobe[3] VPWR VGND sg13cmos5l_antennanp
XANTENNA__1216__A0 Tile_X0Y1_N1END[1] VPWR VGND sg13cmos5l_antennanp
X_0885_ Tile_X0Y0_FrameData_O[29] Tile_X0Y0_FrameData[29] VPWR VGND sg13cmos5l_buf_1
X_0954_ Tile_X0Y1_W6BEG[9] _1188_/X VPWR VGND sg13cmos5l_buf_1
XANTENNA__0990__A2 Tile_X0Y1_E6END[8] VPWR VGND sg13cmos5l_antennanp
XFILLER_56_0 VPWR VGND sg13cmos5l_fill_1
XFILLER_99_121 VPWR VGND sg13cmos5l_decap_8
XANTENNA__0404__GATE Tile_X0Y1_FrameStrobe[1] VPWR VGND sg13cmos5l_antennanp
X_0319_ _0319_/Q Tile_X0Y0_FrameData[29] VGND VPWR Tile_X0Y1_FrameStrobe[7] latch
XANTENNA__0119__D Tile_X0Y0_FrameData[5] VPWR VGND sg13cmos5l_antennanp
XANTENNA__0419__GATE Tile_X0Y1_FrameStrobe[2] VPWR VGND sg13cmos5l_antennanp
XANTENNA__1207__A0 Tile_X0Y1_N1END[0] VPWR VGND sg13cmos5l_antennanp
XFILLER_102_79 VPWR VGND sg13cmos5l_fill_1
XFILLER_23_143 VPWR VGND sg13cmos5l_decap_8
XFILLER_11_21 VPWR VGND sg13cmos5l_fill_1
XFILLER_11_43 VPWR VGND sg13cmos5l_decap_4
XANTENNA__1213__A3 Tile_X0Y0_S4END[6] VPWR VGND sg13cmos5l_antennanp
X_0670_ _0670_/L_HI VPWR VGND sg13cmos5l_tiehi
X_1084_ _1084_/X _1114_/X Tile_X0Y1_N4END[7] Tile_X0Y0_S1END[3] Tile_X0Y0_S4END[3]
+ _0134_/Q _0133_/Q VPWR VGND sg13cmos5l_mux4_1
X_1222_ _1222_/X Tile_X0Y0_E2MID[4] Tile_X0Y0_E2END[4] Tile_X0Y0_E6END[11] _1095_/X
+ _0296_/Q _0295_/Q VPWR VGND sg13cmos5l_mux4_1
X_1153_ _1153_/X _0650_/Q _1196_/X _1201_/X _1192_/X _0510_/Q _0509_/Q VPWR VGND sg13cmos5l_mux4_1
X_0104_ _0104_/Q Tile_X0Y0_FrameData[20] VGND VPWR Tile_X0Y1_FrameStrobe[0] latch
XFILLER_96_157 VPWR VGND sg13cmos5l_fill_2
XANTENNA__0390__GATE Tile_X0Y1_FrameStrobe[1] VPWR VGND sg13cmos5l_antennanp
XANTENNA__0804__X Tile_X0Y0_FrameStrobe_O[1] VPWR VGND sg13cmos5l_antennanp
XANTENNA__0402__D Tile_X0Y1_FrameData[8] VPWR VGND sg13cmos5l_antennanp
XANTENNA__1204__A3 Tile_X0Y0_S4END[5] VPWR VGND sg13cmos5l_antennanp
X_0868_ Tile_X0Y0_FrameData_O[12] Tile_X0Y0_FrameData[12] VPWR VGND sg13cmos5l_buf_1
X_0937_ Tile_X0Y1_W2BEGb[0] _1155_/X VPWR VGND sg13cmos5l_buf_1
X_0799_ Tile_X0Y0_N1BEG[0] _0999_/X VPWR VGND sg13cmos5l_buf_1
XANTENNA__0343__GATE Tile_X0Y1_FrameStrobe[7] VPWR VGND sg13cmos5l_antennanp
XFILLER_87_179 VPWR VGND sg13cmos5l_fill_1
XANTENNA__0358__GATE Tile_X0Y1_FrameStrobe[0] VPWR VGND sg13cmos5l_antennanp
XFILLER_11_179 VPWR VGND sg13cmos5l_fill_1
XFILLER_22_53 VPWR VGND sg13cmos5l_fill_1
XANTENNA__0312__D Tile_X0Y0_FrameData[4] VPWR VGND sg13cmos5l_antennanp
XANTENNA__1131__A2 Tile_X0Y1_E2END[3] VPWR VGND sg13cmos5l_antennanp
X_0722_ Tile_X0Y0_W1BEG[3] _1030_/X VPWR VGND sg13cmos5l_buf_1
X_0653_ _0653_/L_HI VPWR VGND sg13cmos5l_tiehi
XFILLER_8_66 VPWR VGND sg13cmos5l_fill_1
XFILLER_8_55 VPWR VGND sg13cmos5l_fill_1
XFILLER_8_44 VPWR VGND sg13cmos5l_decap_8
XANTENNA__0222__D Tile_X0Y0_FrameData[30] VPWR VGND sg13cmos5l_antennanp
X_0584_ _0584_/Q Tile_X0Y1_FrameData[18] VGND VPWR Tile_X0Y1_FrameStrobe[7] latch
XFILLER_84_127 VPWR VGND sg13cmos5l_fill_2
XFILLER_19_0 VPWR VGND sg13cmos5l_decap_4
X_1067_ _1067_/X _0640_/Q _1084_/X _1080_/X _1092_/X _0194_/Q _0193_/Q VPWR VGND sg13cmos5l_mux4_1
X_1136_ _1136_/X _1207_/X _1211_/X _1215_/X _1199_/X _0542_/Q _0541_/Q VPWR VGND sg13cmos5l_mux4_1
X_1205_ _1205_/X Tile_X0Y1_N1END[2] Tile_X0Y1_N4END[2] _1229_/X Tile_X0Y0_S4END[6]
+ _0398_/Q _0397_/Q VPWR VGND sg13cmos5l_mux4_1
XANTENNA__0132__D Tile_X0Y0_FrameData[24] VPWR VGND sg13cmos5l_antennanp
XFILLER_68_27 VPWR VGND sg13cmos5l_fill_2
XANTENNA__0282__GATE Tile_X0Y1_FrameStrobe[5] VPWR VGND sg13cmos5l_antennanp
XANTENNA__0297__GATE Tile_X0Y1_FrameStrobe[6] VPWR VGND sg13cmos5l_antennanp
XANTENNA__0220__GATE Tile_X0Y1_FrameStrobe[3] VPWR VGND sg13cmos5l_antennanp
XANTENNA__0307__D Tile_X0Y0_FrameData[9] VPWR VGND sg13cmos5l_antennanp
XANTENNA__0235__GATE Tile_X0Y1_FrameStrobe[4] VPWR VGND sg13cmos5l_antennanp
XANTENNA__1104__A2 Tile_X0Y1_E6END[6] VPWR VGND sg13cmos5l_antennanp
XANTENNA__0217__D Tile_X0Y0_FrameData[3] VPWR VGND sg13cmos5l_antennanp
X_0705_ _0973_/A3 VPWR VGND sg13cmos5l_tielo
X_0636_ _0636_/Q Tile_X0Y1_UserCLK NPU_OUT_ACT0 _0664_/L_HI VPWR VGND sg13cmos5l_dfrbpq_1
X_0567_ _0567_/Q Tile_X0Y1_FrameData[3] VGND VPWR Tile_X0Y1_FrameStrobe[6] latch
X_0498_ _0498_/Q Tile_X0Y1_FrameData[8] VGND VPWR Tile_X0Y1_FrameStrobe[4] latch
XANTENNA__0127__D Tile_X0Y0_FrameData[29] VPWR VGND sg13cmos5l_antennanp
X_1119_ _1119_/X Tile_X0Y1_E1END[1] Tile_X0Y1_EE4END[1] Tile_X0Y1_E6END[9] _1204_/X
+ _0575_/Q _0574_/Q VPWR VGND sg13cmos5l_mux4_1
XFILLER_80_141 VPWR VGND sg13cmos5l_fill_2
XFILLER_0_178 VPWR VGND sg13cmos5l_fill_2
XFILLER_48_105 VPWR VGND sg13cmos5l_fill_2
XANTENNA__1098__A1 Tile_X0Y1_N2MID[6] VPWR VGND sg13cmos5l_antennanp
XFILLER_28_96 VPWR VGND sg13cmos5l_fill_2
XFILLER_48_138 VPWR VGND sg13cmos5l_fill_1
XFILLER_63_108 VPWR VGND sg13cmos5l_fill_2
XANTENNA__0174__GATE Tile_X0Y1_FrameStrobe[2] VPWR VGND sg13cmos5l_antennanp
XANTENNA__0189__GATE Tile_X0Y1_FrameStrobe[3] VPWR VGND sg13cmos5l_antennanp
XANTENNA__0902__X Tile_X0Y1_S2BEGb[2] VPWR VGND sg13cmos5l_antennanp
XANTENNA__0112__GATE Tile_X0Y1_FrameStrobe[0] VPWR VGND sg13cmos5l_antennanp
XANTENNA__0500__D Tile_X0Y1_FrameData[6] VPWR VGND sg13cmos5l_antennanp
X_0421_ _0421_/Q Tile_X0Y1_FrameData[21] VGND VPWR Tile_X0Y1_FrameStrobe[2] latch
X_0352_ _0352_/Q Tile_X0Y1_FrameData[26] VGND VPWR Tile_X0Y1_FrameStrobe[0] latch
X_0283_ _0283_/Q Tile_X0Y0_FrameData[1] VGND VPWR Tile_X0Y1_FrameStrobe[5] latch
XANTENNA__0127__GATE Tile_X0Y1_FrameStrobe[1] VPWR VGND sg13cmos5l_antennanp
XANTENNA__1089__A1 Tile_X0Y1_N4END[5] VPWR VGND sg13cmos5l_antennanp
XANTENNA__0812__X Tile_X0Y0_FrameStrobe_O[9] VPWR VGND sg13cmos5l_antennanp
XANTENNA__1013__A1 Tile_X0Y0_EE4END[1] VPWR VGND sg13cmos5l_antennanp
XFILLER_116_110 VPWR VGND sg13cmos5l_fill_2
XFILLER_86_0 VPWR VGND sg13cmos5l_fill_1
XANTENNA__0410__D Tile_X0Y1_FrameData[0] VPWR VGND sg13cmos5l_antennanp
X_0619_ NPU_ACT_WDATA1 Tile_X0Y1_UserCLK _0983_/X _0660_/L_HI VPWR VGND sg13cmos5l_dfrbpq_1
XFILLER_105_57 VPWR VGND sg13cmos5l_fill_2
XFILLER_105_68 VPWR VGND sg13cmos5l_fill_1
XFILLER_14_43 VPWR VGND sg13cmos5l_fill_2
XFILLER_14_87 VPWR VGND sg13cmos5l_fill_2
XANTENNA__0091__CLK Tile_X0Y1_UserCLK VPWR VGND sg13cmos5l_antennanp
XANTENNA__0722__X Tile_X0Y0_W1BEG[3] VPWR VGND sg13cmos5l_antennanp
XANTENNA__1004__A1 Tile_X0Y0_E2END[6] VPWR VGND sg13cmos5l_antennanp
XFILLER_100_2 VPWR VGND sg13cmos5l_fill_1
XFILLER_14_98 VPWR VGND sg13cmos5l_fill_1
XANTENNA__0320__D Tile_X0Y0_FrameData[28] VPWR VGND sg13cmos5l_antennanp
XFILLER_55_83 VPWR VGND sg13cmos5l_fill_1
X_0970_ Tile_X0Y1_WW4BEG[13] _1176_/X VPWR VGND sg13cmos5l_buf_1
XANTENNA__0230__D Tile_X0Y0_FrameData[22] VPWR VGND sg13cmos5l_antennanp
X_0404_ _0404_/Q Tile_X0Y1_FrameData[6] VGND VPWR Tile_X0Y1_FrameStrobe[1] latch
XANTENNA__0807__X Tile_X0Y0_FrameStrobe_O[4] VPWR VGND sg13cmos5l_antennanp
XFILLER_27_108 VPWR VGND sg13cmos5l_decap_8
X_0335_ _0335_/Q Tile_X0Y0_FrameData[13] VGND VPWR Tile_X0Y1_FrameStrobe[7] latch
X_0266_ _0266_/Q Tile_X0Y0_FrameData[18] VGND VPWR Tile_X0Y1_FrameStrobe[5] latch
XANTENNA__1234__A1 Tile_X0Y0_E6END[2] VPWR VGND sg13cmos5l_antennanp
X_0197_ _0197_/Q Tile_X0Y0_FrameData[23] VGND VPWR Tile_X0Y1_FrameStrobe[3] latch
XANTENNA__0405__D Tile_X0Y1_FrameData[5] VPWR VGND sg13cmos5l_antennanp
XANTENNA__0993__A0 Tile_X0Y1_EE4END[3] VPWR VGND sg13cmos5l_antennanp
XFILLER_104_113 VPWR VGND sg13cmos5l_fill_2
XANTENNA__0140__D Tile_X0Y0_FrameData[16] VPWR VGND sg13cmos5l_antennanp
XFILLER_26_130 VPWR VGND sg13cmos5l_decap_8
XFILLER_41_122 VPWR VGND sg13cmos5l_fill_2
XANTENNA__0315__D Tile_X0Y0_FrameData[1] VPWR VGND sg13cmos5l_antennanp
XANTENNA__0984__A0 Tile_X0Y1_EE4END[2] VPWR VGND sg13cmos5l_antennanp
XANTENNA__1225__A1 Tile_X0Y0_E2MID[1] VPWR VGND sg13cmos5l_antennanp
XANTENNA__1161__A0 Tile_X0Y1_E2MID[2] VPWR VGND sg13cmos5l_antennanp
X_0120_ _0120_/Q Tile_X0Y0_FrameData[4] VGND VPWR Tile_X0Y1_FrameStrobe[0] latch
XANTENNA__1216__A1 Tile_X0Y1_N4END[1] VPWR VGND sg13cmos5l_antennanp
XANTENNA__0225__D Tile_X0Y0_FrameData[27] VPWR VGND sg13cmos5l_antennanp
XANTENNA__0803__A Tile_X0Y1_FrameStrobe[0] VPWR VGND sg13cmos5l_antennanp
XANTENNA__0975__A0 Tile_X0Y0_E2MID[2] VPWR VGND sg13cmos5l_antennanp
X_0884_ Tile_X0Y0_FrameData_O[28] Tile_X0Y0_FrameData[28] VPWR VGND sg13cmos5l_buf_1
X_0953_ Tile_X0Y1_W6BEG[8] _1187_/X VPWR VGND sg13cmos5l_buf_1
XFILLER_49_0 VPWR VGND sg13cmos5l_fill_2
X_0318_ _0318_/Q Tile_X0Y0_FrameData[30] VGND VPWR Tile_X0Y1_FrameStrobe[7] latch
X_0249_ _0249_/Q Tile_X0Y0_FrameData[3] VGND VPWR Tile_X0Y1_FrameStrobe[4] latch
XANTENNA__0135__D Tile_X0Y0_FrameData[21] VPWR VGND sg13cmos5l_antennanp
XANTENNA__0573__GATE Tile_X0Y1_FrameStrobe[7] VPWR VGND sg13cmos5l_antennanp
XANTENNA__1207__A1 Tile_X0Y1_N4END[0] VPWR VGND sg13cmos5l_antennanp
XANTENNA__0588__GATE Tile_X0Y1_FrameStrobe[7] VPWR VGND sg13cmos5l_antennanp
XFILLER_87_48 VPWR VGND sg13cmos5l_decap_4
XANTENNA__0511__GATE Tile_X0Y1_FrameStrobe[5] VPWR VGND sg13cmos5l_antennanp
XANTENNA__1143__A0 Tile_X0Y1_N1END[0] VPWR VGND sg13cmos5l_antennanp
XANTENNA__0526__GATE Tile_X0Y1_FrameStrobe[5] VPWR VGND sg13cmos5l_antennanp
XANTENNA__0910__X Tile_X0Y1_S4BEG[2] VPWR VGND sg13cmos5l_antennanp
XANTENNA__1134__A0 Tile_X0Y1_E1END[3] VPWR VGND sg13cmos5l_antennanp
X_1221_ _1221_/X Tile_X0Y0_E2MID[5] Tile_X0Y0_E2END[5] Tile_X0Y0_E6END[10] _1094_/X
+ _0298_/Q _0297_/Q VPWR VGND sg13cmos5l_mux4_1
XFILLER_96_147 VPWR VGND sg13cmos5l_fill_1
XANTENNA__0622__CLK Tile_X0Y1_UserCLK VPWR VGND sg13cmos5l_antennanp
X_1083_ _1083_/X _1111_/X Tile_X0Y1_N4END[4] Tile_X0Y0_S1END[0] Tile_X0Y0_S4END[0]
+ _0132_/Q _0131_/Q VPWR VGND sg13cmos5l_mux4_1
X_1152_ _1152_/X _0649_/Q _1197_/X _1200_/X _1191_/X _0512_/Q _0511_/Q VPWR VGND sg13cmos5l_mux4_1
X_0103_ _0103_/Q Tile_X0Y0_FrameData[21] VGND VPWR Tile_X0Y1_FrameStrobe[0] latch
XFILLER_20_158 VPWR VGND sg13cmos5l_decap_4
X_0936_ Tile_X0Y1_W2BEG[7] _1154_/X VPWR VGND sg13cmos5l_buf_1
XANTENNA__0820__X Tile_X0Y0_FrameStrobe_O[17] VPWR VGND sg13cmos5l_antennanp
X_0867_ Tile_X0Y0_FrameData_O[11] Tile_X0Y0_FrameData[11] VPWR VGND sg13cmos5l_buf_1
X_0798_ Tile_X0Y0_N2BEG[7] _1010_/X VPWR VGND sg13cmos5l_buf_1
XANTENNA__1125__A0 Tile_X0Y1_E1END[2] VPWR VGND sg13cmos5l_antennanp
XFILLER_113_57 VPWR VGND sg13cmos5l_fill_2
XANTENNA__0730__X Tile_X0Y0_W2BEG[7] VPWR VGND sg13cmos5l_antennanp
XANTENNA__0450__GATE Tile_X0Y1_FrameStrobe[3] VPWR VGND sg13cmos5l_antennanp
XANTENNA__0645__CLK Tile_X0Y1_UserCLK VPWR VGND sg13cmos5l_antennanp
XFILLER_98_58 VPWR VGND sg13cmos5l_fill_2
XFILLER_98_47 VPWR VGND sg13cmos5l_decap_8
XANTENNA__0465__GATE Tile_X0Y1_FrameStrobe[3] VPWR VGND sg13cmos5l_antennanp
XFILLER_47_51 VPWR VGND sg13cmos5l_decap_4
XFILLER_47_73 VPWR VGND sg13cmos5l_fill_2
XANTENNA__0905__X Tile_X0Y1_S2BEGb[5] VPWR VGND sg13cmos5l_antennanp
XFILLER_63_61 VPWR VGND sg13cmos5l_fill_2
XFILLER_63_94 VPWR VGND sg13cmos5l_fill_1
XANTENNA__0403__GATE Tile_X0Y1_FrameStrobe[1] VPWR VGND sg13cmos5l_antennanp
XANTENNA__0503__D Tile_X0Y1_FrameData[3] VPWR VGND sg13cmos5l_antennanp
XANTENNA__1198__A3 Tile_X0Y0_S2MID[3] VPWR VGND sg13cmos5l_antennanp
X_0721_ Tile_X0Y0_W1BEG[2] _1029_/X VPWR VGND sg13cmos5l_buf_1
X_0652_ _0652_/L_HI VPWR VGND sg13cmos5l_tiehi
X_0583_ _0583_/Q Tile_X0Y1_FrameData[19] VGND VPWR Tile_X0Y1_FrameStrobe[7] latch
XANTENNA__0418__GATE Tile_X0Y1_FrameStrobe[2] VPWR VGND sg13cmos5l_antennanp
XANTENNA__1107__A0 Tile_X0Y1_E2MID[3] VPWR VGND sg13cmos5l_antennanp
XFILLER_26_2 VPWR VGND sg13cmos5l_fill_1
X_1204_ _1204_/X Tile_X0Y1_N1END[1] Tile_X0Y1_N4END[1] _1228_/X Tile_X0Y0_S4END[5]
+ _0400_/Q _0399_/Q VPWR VGND sg13cmos5l_mux4_1
XANTENNA__0815__X Tile_X0Y0_FrameStrobe_O[12] VPWR VGND sg13cmos5l_antennanp
X_1066_ _1066_/X Tile_X0Y1_N4END[7] Tile_X0Y0_S4END[3] _1083_/X _1075_/X _0196_/Q
+ _0195_/Q VPWR VGND sg13cmos5l_mux4_1
X_1135_ _1135_/X Tile_X0Y1_E1END[0] Tile_X0Y1_EE4END[12] Tile_X0Y1_E6END[4] _1203_/X
+ _0542_/Q _0541_/Q VPWR VGND sg13cmos5l_mux4_1
XANTENNA__0413__D Tile_X0Y1_FrameData[29] VPWR VGND sg13cmos5l_antennanp
X_0919_ Tile_X0Y1_S4BEG[11] _0919_/A VPWR VGND sg13cmos5l_buf_1
XFILLER_108_13 VPWR VGND sg13cmos5l_fill_2
XANTENNA__0725__X Tile_X0Y0_W2BEG[2] VPWR VGND sg13cmos5l_antennanp
XANTENNA__0323__D Tile_X0Y0_FrameData[25] VPWR VGND sg13cmos5l_antennanp
XANTENNA__0233__D Tile_X0Y0_FrameData[19] VPWR VGND sg13cmos5l_antennanp
XANTENNA__0342__GATE Tile_X0Y1_FrameStrobe[7] VPWR VGND sg13cmos5l_antennanp
XANTENNA__0357__GATE Tile_X0Y1_FrameStrobe[0] VPWR VGND sg13cmos5l_antennanp
XANTENNA__0811__A Tile_X0Y1_FrameStrobe[8] VPWR VGND sg13cmos5l_antennanp
XFILLER_31_0 VPWR VGND sg13cmos5l_fill_2
X_0704_ _1235_/A3 VPWR VGND sg13cmos5l_tielo
X_0635_ NPU_WEIGHT_SHIFT_EN Tile_X0Y1_UserCLK _1234_/X _0665_/L_HI VPWR VGND sg13cmos5l_dfrbpq_1
X_0566_ _0566_/Q Tile_X0Y1_FrameData[4] VGND VPWR Tile_X0Y1_FrameStrobe[6] latch
XFILLER_57_128 VPWR VGND sg13cmos5l_fill_1
X_0497_ _0497_/Q Tile_X0Y1_FrameData[9] VGND VPWR Tile_X0Y1_FrameStrobe[4] latch
XANTENNA__0408__D Tile_X0Y1_FrameData[2] VPWR VGND sg13cmos5l_antennanp
X_1049_ _1049_/X _0638_/Q _0642_/Q _1076_/X _1097_/X _0230_/Q _0229_/Q VPWR VGND sg13cmos5l_mux4_1
X_1118_ _1118_/X _1209_/X _1213_/X _1217_/X _1197_/X _0572_/Q _0571_/Q VPWR VGND sg13cmos5l_mux4_1
XFILLER_80_164 VPWR VGND sg13cmos5l_fill_2
XANTENNA__0143__D Tile_X0Y0_FrameData[13] VPWR VGND sg13cmos5l_antennanp
XFILLER_79_27 VPWR VGND sg13cmos5l_fill_2
XFILLER_0_102 VPWR VGND sg13cmos5l_fill_1
XFILLER_48_128 VPWR VGND sg13cmos5l_fill_1
XANTENNA__0318__D Tile_X0Y0_FrameData[30] VPWR VGND sg13cmos5l_antennanp
XANTENNA__1098__A2 Tile_X0Y0_S2MID[6] VPWR VGND sg13cmos5l_antennanp
XFILLER_28_53 VPWR VGND sg13cmos5l_fill_2
XFILLER_71_120 VPWR VGND sg13cmos5l_decap_8
XFILLER_100_91 VPWR VGND sg13cmos5l_fill_1
XFILLER_44_85 VPWR VGND sg13cmos5l_fill_1
XFILLER_60_62 VPWR VGND sg13cmos5l_decap_8
XFILLER_60_73 VPWR VGND sg13cmos5l_fill_2
X_0420_ _0420_/Q Tile_X0Y1_FrameData[22] VGND VPWR Tile_X0Y1_FrameStrobe[2] latch
XANTENNA__1089__A2 Tile_X0Y0_S1END[1] VPWR VGND sg13cmos5l_antennanp
XFILLER_39_117 VPWR VGND sg13cmos5l_fill_1
X_0351_ _0351_/Q Tile_X0Y1_FrameData[27] VGND VPWR Tile_X0Y1_FrameStrobe[0] latch
X_0282_ _0282_/Q Tile_X0Y0_FrameData[2] VGND VPWR Tile_X0Y1_FrameStrobe[5] latch
XFILLER_85_70 VPWR VGND sg13cmos5l_decap_4
XANTENNA__0228__D Tile_X0Y0_FrameData[24] VPWR VGND sg13cmos5l_antennanp
XANTENNA__0281__GATE Tile_X0Y1_FrameStrobe[5] VPWR VGND sg13cmos5l_antennanp
XANTENNA__0806__A Tile_X0Y1_FrameStrobe[3] VPWR VGND sg13cmos5l_antennanp
XANTENNA__0296__GATE Tile_X0Y1_FrameStrobe[6] VPWR VGND sg13cmos5l_antennanp
XANTENNA__1013__A2 Tile_X0Y0_E6END[9] VPWR VGND sg13cmos5l_antennanp
XFILLER_79_0 VPWR VGND sg13cmos5l_fill_1
X_0618_ NPU_ACT_WDATA0 Tile_X0Y1_UserCLK _0982_/X _0681_/L_HI VPWR VGND sg13cmos5l_dfrbpq_1
X_0549_ _0549_/Q Tile_X0Y1_FrameData[21] VGND VPWR Tile_X0Y1_FrameStrobe[6] latch
XANTENNA__0138__D Tile_X0Y0_FrameData[18] VPWR VGND sg13cmos5l_antennanp
XANTENNA__0234__GATE Tile_X0Y1_FrameStrobe[4] VPWR VGND sg13cmos5l_antennanp
XFILLER_38_150 VPWR VGND sg13cmos5l_fill_1
XFILLER_45_109 VPWR VGND sg13cmos5l_fill_2
XANTENNA__0249__GATE Tile_X0Y1_FrameStrobe[4] VPWR VGND sg13cmos5l_antennanp
XFILLER_14_22 VPWR VGND sg13cmos5l_decap_8
XFILLER_81_39 VPWR VGND sg13cmos5l_decap_8
XANTENNA__0601__D Tile_X0Y1_FrameData[1] VPWR VGND sg13cmos5l_antennanp
XANTENNA__1004__A2 Tile_X0Y0_E6END[6] VPWR VGND sg13cmos5l_antennanp
XFILLER_30_65 VPWR VGND sg13cmos5l_decap_4
XANTENNA__0913__X Tile_X0Y1_S4BEG[5] VPWR VGND sg13cmos5l_antennanp
XANTENNA__0511__D Tile_X0Y1_FrameData[27] VPWR VGND sg13cmos5l_antennanp
X_0403_ _0403_/Q Tile_X0Y1_FrameData[7] VGND VPWR Tile_X0Y1_FrameStrobe[1] latch
XFILLER_96_80 VPWR VGND sg13cmos5l_decap_4
X_0334_ _0334_/Q Tile_X0Y0_FrameData[14] VGND VPWR Tile_X0Y1_FrameStrobe[7] latch
X_0265_ _0265_/Q Tile_X0Y0_FrameData[19] VGND VPWR Tile_X0Y1_FrameStrobe[5] latch
X_0196_ _0196_/Q Tile_X0Y0_FrameData[24] VGND VPWR Tile_X0Y1_FrameStrobe[3] latch
XFILLER_96_91 VPWR VGND sg13cmos5l_decap_4
XANTENNA__0823__X FAB_USER_CLK VPWR VGND sg13cmos5l_antennanp
XANTENNA__0421__D Tile_X0Y1_FrameData[21] VPWR VGND sg13cmos5l_antennanp
XANTENNA__0993__A1 Tile_X0Y1_EE4END[11] VPWR VGND sg13cmos5l_antennanp
XANTENNA__0173__GATE Tile_X0Y1_FrameStrobe[2] VPWR VGND sg13cmos5l_antennanp
XFILLER_104_158 VPWR VGND sg13cmos5l_fill_1
XANTENNA__0188__GATE Tile_X0Y1_FrameStrobe[2] VPWR VGND sg13cmos5l_antennanp
XFILLER_25_32 VPWR VGND sg13cmos5l_fill_2
XANTENNA__0111__GATE Tile_X0Y1_FrameStrobe[0] VPWR VGND sg13cmos5l_antennanp
XANTENNA__0733__X Tile_X0Y0_W2BEGb[2] VPWR VGND sg13cmos5l_antennanp
XANTENNA__0984__A1 Tile_X0Y1_EE4END[10] VPWR VGND sg13cmos5l_antennanp
XANTENNA__1225__A2 Tile_X0Y0_E2END[1] VPWR VGND sg13cmos5l_antennanp
XFILLER_41_20 VPWR VGND sg13cmos5l_decap_4
XANTENNA__0126__GATE Tile_X0Y1_FrameStrobe[1] VPWR VGND sg13cmos5l_antennanp
XANTENNA__0331__D Tile_X0Y0_FrameData[17] VPWR VGND sg13cmos5l_antennanp
XFILLER_110_106 VPWR VGND sg13cmos5l_fill_2
XFILLER_110_117 VPWR VGND sg13cmos5l_fill_2
XANTENNA__0908__X Tile_X0Y1_S4BEG[0] VPWR VGND sg13cmos5l_antennanp
XFILLER_2_58 VPWR VGND sg13cmos5l_fill_2
XANTENNA__0506__D Tile_X0Y1_FrameData[0] VPWR VGND sg13cmos5l_antennanp
XFILLER_32_178 VPWR VGND sg13cmos5l_fill_2
X_0952_ Tile_X0Y1_W6BEG[7] _1186_/X VPWR VGND sg13cmos5l_buf_1
XFILLER_82_82 VPWR VGND sg13cmos5l_fill_1
XANTENNA__0241__D Tile_X0Y0_FrameData[11] VPWR VGND sg13cmos5l_antennanp
XANTENNA__0975__A1 Tile_X0Y0_E2END[2] VPWR VGND sg13cmos5l_antennanp
X_0883_ Tile_X0Y0_FrameData_O[27] Tile_X0Y0_FrameData[27] VPWR VGND sg13cmos5l_buf_1
XANTENNA__0818__X Tile_X0Y0_FrameStrobe_O[15] VPWR VGND sg13cmos5l_antennanp
X_0317_ _0317_/Q Tile_X0Y0_FrameData[31] VGND VPWR Tile_X0Y1_FrameStrobe[7] latch
XFILLER_99_178 VPWR VGND sg13cmos5l_fill_2
X_0248_ _0248_/Q Tile_X0Y0_FrameData[4] VGND VPWR Tile_X0Y1_FrameStrobe[4] latch
X_0179_ _0179_/Q Tile_X0Y0_FrameData[9] VGND VPWR Tile_X0Y1_FrameStrobe[2] latch
XANTENNA__0416__D Tile_X0Y1_FrameData[26] VPWR VGND sg13cmos5l_antennanp
XANTENNA__0151__D Tile_X0Y0_FrameData[5] VPWR VGND sg13cmos5l_antennanp
XFILLER_11_56 VPWR VGND sg13cmos5l_decap_8
XANTENNA__0728__X Tile_X0Y0_W2BEG[5] VPWR VGND sg13cmos5l_antennanp
XANTENNA__0326__D Tile_X0Y0_FrameData[22] VPWR VGND sg13cmos5l_antennanp
XANTENNA__1134__A1 Tile_X0Y1_E2MID[0] VPWR VGND sg13cmos5l_antennanp
X_1220_ _1220_/X Tile_X0Y0_E2MID[6] Tile_X0Y0_E2END[6] Tile_X0Y0_E6END[9] _1093_/X
+ _0300_/Q _0299_/Q VPWR VGND sg13cmos5l_mux4_1
X_1151_ _1151_/X Tile_X0Y1_EE4END[8] _0648_/Q _1198_/X _1199_/X _0514_/Q _0513_/Q
+ VPWR VGND sg13cmos5l_mux4_1
XFILLER_96_104 VPWR VGND sg13cmos5l_fill_1
X_1082_ _1082_/X _1112_/X Tile_X0Y1_N4END[5] Tile_X0Y0_S1END[1] Tile_X0Y0_S4END[1]
+ _0130_/Q _0129_/Q VPWR VGND sg13cmos5l_mux4_1
X_0102_ _0102_/Q Tile_X0Y0_FrameData[22] VGND VPWR Tile_X0Y1_FrameStrobe[0] latch
XANTENNA__0236__D Tile_X0Y0_FrameData[16] VPWR VGND sg13cmos5l_antennanp
XANTENNA__0814__A Tile_X0Y1_FrameStrobe[11] VPWR VGND sg13cmos5l_antennanp
XFILLER_20_115 VPWR VGND sg13cmos5l_decap_8
X_0866_ Tile_X0Y0_FrameData_O[10] Tile_X0Y0_FrameData[10] VPWR VGND sg13cmos5l_buf_1
X_0935_ Tile_X0Y1_W2BEG[6] _1153_/X VPWR VGND sg13cmos5l_buf_1
XFILLER_9_160 VPWR VGND sg13cmos5l_fill_1
XFILLER_61_0 VPWR VGND sg13cmos5l_fill_2
X_0797_ Tile_X0Y0_N2BEG[6] _1009_/X VPWR VGND sg13cmos5l_buf_1
XANTENNA__1125__A1 Tile_X0Y1_E6END[10] VPWR VGND sg13cmos5l_antennanp
XANTENNA__0146__D Tile_X0Y0_FrameData[10] VPWR VGND sg13cmos5l_antennanp
XANTENNA__0921__X Tile_X0Y1_S4BEG[13] VPWR VGND sg13cmos5l_antennanp
XFILLER_10_170 VPWR VGND sg13cmos5l_fill_1
X_0720_ Tile_X0Y0_W1BEG[1] _1028_/X VPWR VGND sg13cmos5l_buf_1
X_0651_ _0651_/Q Tile_X0Y1_UserCLK NPU_ACT_RDATA7 _0659_/L_HI VPWR VGND sg13cmos5l_dfrbpq_1
X_0582_ _0582_/Q Tile_X0Y1_FrameData[20] VGND VPWR Tile_X0Y1_FrameStrobe[7] latch
XANTENNA__0572__GATE Tile_X0Y1_FrameStrobe[7] VPWR VGND sg13cmos5l_antennanp
XANTENNA__0809__A Tile_X0Y1_FrameStrobe[6] VPWR VGND sg13cmos5l_antennanp
XANTENNA__1107__A1 Tile_X0Y1_E2END[3] VPWR VGND sg13cmos5l_antennanp
X_1134_ _1134_/X Tile_X0Y1_E1END[3] Tile_X0Y1_E2MID[0] Tile_X0Y1_E2END[0] _1202_/X
+ _0544_/Q _0543_/Q VPWR VGND sg13cmos5l_mux4_1
X_1203_ _1203_/X Tile_X0Y1_N1END[0] Tile_X0Y1_N4END[0] _1227_/X Tile_X0Y0_S4END[4]
+ _0402_/Q _0401_/Q VPWR VGND sg13cmos5l_mux4_1
XANTENNA__0587__GATE Tile_X0Y1_FrameStrobe[7] VPWR VGND sg13cmos5l_antennanp
X_1065_ _1065_/X Tile_X0Y1_N4END[6] Tile_X0Y0_S4END[2] _1082_/X _1076_/X _0198_/Q
+ _0197_/Q VPWR VGND sg13cmos5l_mux4_1
XANTENNA__0510__GATE Tile_X0Y1_FrameStrobe[5] VPWR VGND sg13cmos5l_antennanp
XANTENNA__0831__X Tile_X0Y1_FrameData_O[7] VPWR VGND sg13cmos5l_antennanp
XANTENNA__1043__A0 Tile_X0Y0_EE4END[11] VPWR VGND sg13cmos5l_antennanp
X_0918_ Tile_X0Y1_S4BEG[10] _0918_/A VPWR VGND sg13cmos5l_buf_1
X_0849_ Tile_X0Y1_FrameData_O[25] Tile_X0Y1_FrameData[25] VPWR VGND sg13cmos5l_buf_1
XANTENNA__0525__GATE Tile_X0Y1_FrameStrobe[5] VPWR VGND sg13cmos5l_antennanp
XFILLER_108_69 VPWR VGND sg13cmos5l_decap_8
XFILLER_75_118 VPWR VGND sg13cmos5l_fill_2
XFILLER_17_33 VPWR VGND sg13cmos5l_decap_8
XFILLER_84_39 VPWR VGND sg13cmos5l_fill_2
XANTENNA__0604__D Tile_X0Y1_FrameData[26] VPWR VGND sg13cmos5l_antennanp
XANTENNA__0741__X Tile_X0Y0_W6BEG[2] VPWR VGND sg13cmos5l_antennanp
XANTENNA__1034__A0 Tile_X0Y0_EE4END[7] VPWR VGND sg13cmos5l_antennanp
XANTENNA__0612__CLK Tile_X0Y1_UserCLK VPWR VGND sg13cmos5l_antennanp
XFILLER_109_0 VPWR VGND sg13cmos5l_fill_2
XFILLER_12_9 VPWR VGND sg13cmos5l_fill_1
XANTENNA__0916__X Tile_X0Y1_S4BEG[8] VPWR VGND sg13cmos5l_antennanp
XANTENNA__0514__D Tile_X0Y1_FrameData[24] VPWR VGND sg13cmos5l_antennanp
XANTENNA__1025__A0 Tile_X0Y0_E1END[3] VPWR VGND sg13cmos5l_antennanp
X_0703_ _1100_/A3 VPWR VGND sg13cmos5l_tielo
X_0634_ NPU_ACT_ADDR8 Tile_X0Y1_UserCLK _0981_/X _0666_/L_HI VPWR VGND sg13cmos5l_dfrbpq_1
X_0565_ _0565_/Q Tile_X0Y1_FrameData[5] VGND VPWR Tile_X0Y1_FrameStrobe[6] latch
X_0496_ _0496_/Q Tile_X0Y1_FrameData[10] VGND VPWR Tile_X0Y1_FrameStrobe[4] latch
XANTENNA__0826__X Tile_X0Y1_FrameData_O[2] VPWR VGND sg13cmos5l_antennanp
XFILLER_65_140 VPWR VGND sg13cmos5l_fill_1
X_1117_ _1117_/X Tile_X0Y1_E1END[2] Tile_X0Y1_EE4END[2] Tile_X0Y1_E6END[10] _1205_/X
+ _0572_/Q _0571_/Q VPWR VGND sg13cmos5l_mux4_1
XFILLER_80_143 VPWR VGND sg13cmos5l_fill_1
XANTENNA__0424__D Tile_X0Y1_FrameData[18] VPWR VGND sg13cmos5l_antennanp
XANTENNA__0635__CLK Tile_X0Y1_UserCLK VPWR VGND sg13cmos5l_antennanp
X_1048_ _1048_/X _0637_/Q _0641_/Q _1077_/X _1098_/X _0232_/Q _0231_/Q VPWR VGND sg13cmos5l_mux4_1
XANTENNA__0464__GATE Tile_X0Y1_FrameStrobe[3] VPWR VGND sg13cmos5l_antennanp
XANTENNA__0479__GATE Tile_X0Y1_FrameStrobe[4] VPWR VGND sg13cmos5l_antennanp
XFILLER_95_27 VPWR VGND sg13cmos5l_decap_4
XANTENNA__0402__GATE Tile_X0Y1_FrameStrobe[1] VPWR VGND sg13cmos5l_antennanp
XANTENNA__0736__X Tile_X0Y0_W2BEGb[5] VPWR VGND sg13cmos5l_antennanp
XANTENNA__1098__A3 Tile_X0Y0_S2END[6] VPWR VGND sg13cmos5l_antennanp
XFILLER_28_87 VPWR VGND sg13cmos5l_decap_4
XANTENNA__0334__D Tile_X0Y0_FrameData[14] VPWR VGND sg13cmos5l_antennanp
XANTENNA__0417__GATE Tile_X0Y1_FrameStrobe[2] VPWR VGND sg13cmos5l_antennanp
XANTENNA__0912__A Tile_X0Y0_S4END[12] VPWR VGND sg13cmos5l_antennanp
XANTENNA__1007__A0 Tile_X0Y0_E2MID[3] VPWR VGND sg13cmos5l_antennanp
XFILLER_100_70 VPWR VGND sg13cmos5l_fill_1
XFILLER_60_85 VPWR VGND sg13cmos5l_decap_8
XFILLER_5_14 VPWR VGND sg13cmos5l_fill_1
X_0350_ _0350_/Q Tile_X0Y1_FrameData[28] VGND VPWR Tile_X0Y1_FrameStrobe[0] latch
XANTENNA__0509__D Tile_X0Y1_FrameData[29] VPWR VGND sg13cmos5l_antennanp
XANTENNA__1089__A3 Tile_X0Y0_S4END[1] VPWR VGND sg13cmos5l_antennanp
X_0281_ _0281_/Q Tile_X0Y0_FrameData[3] VGND VPWR Tile_X0Y1_FrameStrobe[5] latch
XANTENNA__0244__D Tile_X0Y0_FrameData[8] VPWR VGND sg13cmos5l_antennanp
XANTENNA__0822__A Tile_X0Y1_FrameStrobe[19] VPWR VGND sg13cmos5l_antennanp
XFILLER_116_156 VPWR VGND sg13cmos5l_fill_2
XFILLER_116_178 VPWR VGND sg13cmos5l_fill_2
XFILLER_105_48 VPWR VGND sg13cmos5l_fill_2
X_0617_ NPU_WEIGHT_IN7 Tile_X0Y1_UserCLK _0997_/X _0680_/L_HI VPWR VGND sg13cmos5l_dfrbpq_1
X_0548_ _0548_/Q Tile_X0Y1_FrameData[22] VGND VPWR Tile_X0Y1_FrameStrobe[6] latch
X_0479_ _0479_/Q Tile_X0Y1_FrameData[27] VGND VPWR Tile_X0Y1_FrameStrobe[4] latch
XANTENNA__0419__D Tile_X0Y1_FrameData[23] VPWR VGND sg13cmos5l_antennanp
XANTENNA__0154__D Tile_X0Y0_FrameData[2] VPWR VGND sg13cmos5l_antennanp
XANTENNA__0329__D Tile_X0Y0_FrameData[19] VPWR VGND sg13cmos5l_antennanp
XANTENNA__0341__GATE Tile_X0Y1_FrameStrobe[7] VPWR VGND sg13cmos5l_antennanp
XFILLER_44_110 VPWR VGND sg13cmos5l_fill_2
XANTENNA__0356__GATE Tile_X0Y1_FrameStrobe[0] VPWR VGND sg13cmos5l_antennanp
XANTENNA__1228__A0 Tile_X0Y0_E1END[1] VPWR VGND sg13cmos5l_antennanp
XFILLER_71_73 VPWR VGND sg13cmos5l_decap_8
XANTENNA__0309__GATE Tile_X0Y1_FrameStrobe[6] VPWR VGND sg13cmos5l_antennanp
X_0402_ _0402_/Q Tile_X0Y1_FrameData[8] VGND VPWR Tile_X0Y1_FrameStrobe[1] latch
X_0333_ _0333_/Q Tile_X0Y0_FrameData[15] VGND VPWR Tile_X0Y1_FrameStrobe[7] latch
XANTENNA__0239__D Tile_X0Y0_FrameData[13] VPWR VGND sg13cmos5l_antennanp
XANTENNA__0817__A Tile_X0Y1_FrameStrobe[14] VPWR VGND sg13cmos5l_antennanp
XANTENNA__1219__A0 Tile_X0Y0_E2MID[7] VPWR VGND sg13cmos5l_antennanp
X_0264_ _0264_/Q Tile_X0Y0_FrameData[20] VGND VPWR Tile_X0Y1_FrameStrobe[5] latch
X_0195_ _0195_/Q Tile_X0Y0_FrameData[25] VGND VPWR Tile_X0Y1_FrameStrobe[3] latch
XANTENNA__0993__A2 Tile_X0Y1_E6END[11] VPWR VGND sg13cmos5l_antennanp
XANTENNA__0149__D Tile_X0Y0_FrameData[7] VPWR VGND sg13cmos5l_antennanp
XFILLER_76_29 VPWR VGND sg13cmos5l_decap_8
XFILLER_25_11 VPWR VGND sg13cmos5l_fill_2
XFILLER_25_88 VPWR VGND sg13cmos5l_fill_2
XANTENNA__0984__A2 Tile_X0Y1_E6END[2] VPWR VGND sg13cmos5l_antennanp
XFILLER_41_65 VPWR VGND sg13cmos5l_decap_8
XANTENNA__0280__GATE Tile_X0Y1_FrameStrobe[5] VPWR VGND sg13cmos5l_antennanp
XFILLER_103_170 VPWR VGND sg13cmos5l_fill_1
XANTENNA__0295__GATE Tile_X0Y1_FrameStrobe[6] VPWR VGND sg13cmos5l_antennanp
XFILLER_66_40 VPWR VGND sg13cmos5l_fill_2
XFILLER_66_84 VPWR VGND sg13cmos5l_decap_8
XANTENNA__0924__X Tile_X0Y1_UserCLKo VPWR VGND sg13cmos5l_antennanp
XANTENNA__1216__A3 Tile_X0Y0_S4END[5] VPWR VGND sg13cmos5l_antennanp
X_0882_ Tile_X0Y0_FrameData_O[26] Tile_X0Y0_FrameData[26] VPWR VGND sg13cmos5l_buf_1
X_0951_ Tile_X0Y1_W6BEG[6] _1185_/X VPWR VGND sg13cmos5l_buf_1
XANTENNA__0233__GATE Tile_X0Y1_FrameStrobe[4] VPWR VGND sg13cmos5l_antennanp
XANTENNA__0522__D Tile_X0Y1_FrameData[16] VPWR VGND sg13cmos5l_antennanp
XFILLER_99_135 VPWR VGND sg13cmos5l_decap_8
XANTENNA__0248__GATE Tile_X0Y1_FrameStrobe[4] VPWR VGND sg13cmos5l_antennanp
X_0316_ _0316_/Q Tile_X0Y0_FrameData[0] VGND VPWR Tile_X0Y1_FrameStrobe[6] latch
XANTENNA__0834__X Tile_X0Y1_FrameData_O[10] VPWR VGND sg13cmos5l_antennanp
X_0247_ _0247_/Q Tile_X0Y0_FrameData[5] VGND VPWR Tile_X0Y1_FrameStrobe[4] latch
X_0178_ _0178_/Q Tile_X0Y0_FrameData[10] VGND VPWR Tile_X0Y1_FrameStrobe[2] latch
XANTENNA__0432__D Tile_X0Y1_FrameData[10] VPWR VGND sg13cmos5l_antennanp
XANTENNA__1207__A3 Tile_X0Y0_S4END[4] VPWR VGND sg13cmos5l_antennanp
XFILLER_87_39 VPWR VGND sg13cmos5l_fill_2
XFILLER_87_28 VPWR VGND sg13cmos5l_decap_8
XANTENNA__0607__D Tile_X0Y1_FrameData[29] VPWR VGND sg13cmos5l_antennanp
XANTENNA__0744__X Tile_X0Y0_W6BEG[5] VPWR VGND sg13cmos5l_antennanp
XFILLER_14_179 VPWR VGND sg13cmos5l_fill_1
XANTENNA__0342__D Tile_X0Y0_FrameData[6] VPWR VGND sg13cmos5l_antennanp
XANTENNA__0919__X Tile_X0Y1_S4BEG[11] VPWR VGND sg13cmos5l_antennanp
XANTENNA__1134__A2 Tile_X0Y1_E2END[0] VPWR VGND sg13cmos5l_antennanp
X_1150_ _1150_/X Tile_X0Y1_EE4END[4] _0647_/Q _1198_/X _1199_/X _0516_/Q _0515_/Q
+ VPWR VGND sg13cmos5l_mux4_1
X_0101_ _0101_/Q Tile_X0Y0_FrameData[23] VGND VPWR Tile_X0Y1_FrameStrobe[0] latch
XANTENNA__0517__D Tile_X0Y1_FrameData[21] VPWR VGND sg13cmos5l_antennanp
X_1081_ _1081_/X _1113_/X Tile_X0Y1_N4END[6] Tile_X0Y0_S1END[2] Tile_X0Y0_S4END[2]
+ _0128_/Q _0127_/Q VPWR VGND sg13cmos5l_mux4_1
XFILLER_93_71 VPWR VGND sg13cmos5l_fill_1
XANTENNA__0172__GATE Tile_X0Y1_FrameStrobe[2] VPWR VGND sg13cmos5l_antennanp
XANTENNA__0252__D Tile_X0Y0_FrameData[0] VPWR VGND sg13cmos5l_antennanp
XANTENNA__0830__A Tile_X0Y1_FrameData[6] VPWR VGND sg13cmos5l_antennanp
X_0865_ Tile_X0Y0_FrameData_O[9] Tile_X0Y0_FrameData[9] VPWR VGND sg13cmos5l_buf_1
X_0934_ Tile_X0Y1_W2BEG[5] _1152_/X VPWR VGND sg13cmos5l_buf_1
XANTENNA__0187__GATE Tile_X0Y1_FrameStrobe[2] VPWR VGND sg13cmos5l_antennanp
XANTENNA__0829__X Tile_X0Y1_FrameData_O[5] VPWR VGND sg13cmos5l_antennanp
X_0796_ Tile_X0Y0_N2BEG[5] _1008_/X VPWR VGND sg13cmos5l_buf_1
XFILLER_87_105 VPWR VGND sg13cmos5l_fill_2
XANTENNA__0110__GATE Tile_X0Y1_FrameStrobe[0] VPWR VGND sg13cmos5l_antennanp
XFILLER_3_91 VPWR VGND sg13cmos5l_fill_2
XANTENNA__0125__GATE Tile_X0Y1_FrameStrobe[1] VPWR VGND sg13cmos5l_antennanp
XANTENNA__0427__D Tile_X0Y1_FrameData[15] VPWR VGND sg13cmos5l_antennanp
XFILLER_22_12 VPWR VGND sg13cmos5l_decap_8
XFILLER_22_23 VPWR VGND sg13cmos5l_fill_1
XANTENNA__0162__D Tile_X0Y0_FrameData[26] VPWR VGND sg13cmos5l_antennanp
XANTENNA__0739__X Tile_X0Y0_W6BEG[0] VPWR VGND sg13cmos5l_antennanp
XANTENNA__0337__D Tile_X0Y0_FrameData[11] VPWR VGND sg13cmos5l_antennanp
XANTENNA__0915__A Tile_X0Y0_S4END[15] VPWR VGND sg13cmos5l_antennanp
XFILLER_63_30 VPWR VGND sg13cmos5l_fill_2
XFILLER_63_74 VPWR VGND sg13cmos5l_fill_2
X_0650_ _0650_/Q Tile_X0Y1_UserCLK NPU_ACT_RDATA6 _0658_/L_HI VPWR VGND sg13cmos5l_dfrbpq_1
X_0581_ _0581_/Q Tile_X0Y1_FrameData[21] VGND VPWR Tile_X0Y1_FrameStrobe[7] latch
XFILLER_88_93 VPWR VGND sg13cmos5l_fill_1
XANTENNA__1107__A2 Tile_X0Y1_E6END[3] VPWR VGND sg13cmos5l_antennanp
X_1064_ _1064_/X Tile_X0Y1_N4END[5] Tile_X0Y0_S4END[1] _1081_/X _1077_/X _0200_/Q
+ _0199_/Q VPWR VGND sg13cmos5l_mux4_1
X_1133_ _1133_/X Tile_X0Y1_E1END[2] Tile_X0Y1_E2MID[1] Tile_X0Y1_E2END[1] _1201_/X
+ _0546_/Q _0545_/Q VPWR VGND sg13cmos5l_mux4_1
X_1202_ _1202_/X Tile_X0Y1_N2MID[7] Tile_X0Y1_N2END[7] _1226_/X Tile_X0Y0_S2MID[7]
+ _0356_/Q _0355_/Q VPWR VGND sg13cmos5l_mux4_1
XFILLER_92_130 VPWR VGND sg13cmos5l_fill_2
XANTENNA__0247__D Tile_X0Y0_FrameData[5] VPWR VGND sg13cmos5l_antennanp
XANTENNA__0825__A Tile_X0Y1_FrameData[1] VPWR VGND sg13cmos5l_antennanp
XFILLER_108_26 VPWR VGND sg13cmos5l_decap_4
X_0917_ Tile_X0Y1_S4BEG[9] _0917_/A VPWR VGND sg13cmos5l_buf_1
X_0848_ Tile_X0Y1_FrameData_O[24] Tile_X0Y1_FrameData[24] VPWR VGND sg13cmos5l_buf_1
X_0779_ Tile_X0Y0_WW4BEG[12] _1059_/X VPWR VGND sg13cmos5l_buf_1
XANTENNA__0157__D Tile_X0Y0_FrameData[31] VPWR VGND sg13cmos5l_antennanp
XFILLER_33_33 VPWR VGND sg13cmos5l_decap_8
XFILLER_33_77 VPWR VGND sg13cmos5l_fill_2
XFILLER_114_91 VPWR VGND sg13cmos5l_fill_1
XANTENNA__0932__X Tile_X0Y1_W2BEG[3] VPWR VGND sg13cmos5l_antennanp
XANTENNA__1025__A1 Tile_X0Y0_EE4END[15] VPWR VGND sg13cmos5l_antennanp
X_0702_ _1234_/A3 VPWR VGND sg13cmos5l_tielo
X_0633_ NPU_ACT_ADDR7 Tile_X0Y1_UserCLK _0980_/X _0688_/L_HI VPWR VGND sg13cmos5l_dfrbpq_1
XANTENNA__0530__D Tile_X0Y1_FrameData[8] VPWR VGND sg13cmos5l_antennanp
XFILLER_31_2 VPWR VGND sg13cmos5l_fill_1
X_0564_ _0564_/Q Tile_X0Y1_FrameData[6] VGND VPWR Tile_X0Y1_FrameStrobe[6] latch
X_0495_ _0495_/Q Tile_X0Y1_FrameData[11] VGND VPWR Tile_X0Y1_FrameStrobe[4] latch
XFILLER_17_0 VPWR VGND sg13cmos5l_decap_4
X_1047_ _1047_/X _0636_/Q _0640_/Q _1079_/X _1099_/X _0234_/Q _0233_/Q VPWR VGND sg13cmos5l_mux4_1
X_1116_ _1116_/X _1210_/X _1214_/X _1218_/X _1198_/X _0569_/Q _0568_/Q VPWR VGND sg13cmos5l_mux4_1
XANTENNA__0842__X Tile_X0Y1_FrameData_O[18] VPWR VGND sg13cmos5l_antennanp
XFILLER_110_49 VPWR VGND sg13cmos5l_fill_1
XANTENNA__0440__D Tile_X0Y1_FrameData[2] VPWR VGND sg13cmos5l_antennanp
XFILLER_79_29 VPWR VGND sg13cmos5l_fill_1
XFILLER_56_130 VPWR VGND sg13cmos5l_fill_2
XFILLER_56_163 VPWR VGND sg13cmos5l_fill_1
XANTENNA__0752__X Tile_X0Y0_N4BEG[1] VPWR VGND sg13cmos5l_antennanp
XFILLER_44_43 VPWR VGND sg13cmos5l_decap_8
XFILLER_71_100 VPWR VGND sg13cmos5l_fill_1
XFILLER_71_133 VPWR VGND sg13cmos5l_fill_2
XANTENNA__0571__GATE Tile_X0Y1_FrameStrobe[7] VPWR VGND sg13cmos5l_antennanp
XANTENNA__1007__A1 Tile_X0Y0_E2END[3] VPWR VGND sg13cmos5l_antennanp
XANTENNA__0350__D Tile_X0Y1_FrameData[28] VPWR VGND sg13cmos5l_antennanp
XANTENNA__0586__GATE Tile_X0Y1_FrameStrobe[7] VPWR VGND sg13cmos5l_antennanp
XANTENNA__1191__A0 Tile_X0Y1_N1END[0] VPWR VGND sg13cmos5l_antennanp
X_0280_ _0280_/Q Tile_X0Y0_FrameData[4] VGND VPWR Tile_X0Y1_FrameStrobe[5] latch
XANTENNA__0927__X Tile_X0Y1_W1BEG[2] VPWR VGND sg13cmos5l_antennanp
XFILLER_47_130 VPWR VGND sg13cmos5l_fill_1
XFILLER_47_163 VPWR VGND sg13cmos5l_fill_2
XANTENNA__0524__GATE Tile_X0Y1_FrameStrobe[5] VPWR VGND sg13cmos5l_antennanp
XANTENNA__0525__D Tile_X0Y1_FrameData[13] VPWR VGND sg13cmos5l_antennanp
XANTENNA__0260__D Tile_X0Y0_FrameData[24] VPWR VGND sg13cmos5l_antennanp
XANTENNA__0539__GATE Tile_X0Y1_FrameStrobe[6] VPWR VGND sg13cmos5l_antennanp
XANTENNA__0611__Q NPU_WEIGHT_IN1 VPWR VGND sg13cmos5l_antennanp
X_0616_ NPU_WEIGHT_IN6 Tile_X0Y1_UserCLK _0996_/X _0679_/L_HI VPWR VGND sg13cmos5l_dfrbpq_1
XANTENNA__0837__X Tile_X0Y1_FrameData_O[13] VPWR VGND sg13cmos5l_antennanp
XANTENNA__1182__A0 Tile_X0Y1_N4END[3] VPWR VGND sg13cmos5l_antennanp
XFILLER_105_27 VPWR VGND sg13cmos5l_decap_8
X_0547_ _0547_/Q Tile_X0Y1_FrameData[23] VGND VPWR Tile_X0Y1_FrameStrobe[6] latch
X_0478_ _0478_/Q Tile_X0Y1_FrameData[28] VGND VPWR Tile_X0Y1_FrameStrobe[4] latch
XANTENNA__0435__D Tile_X0Y1_FrameData[7] VPWR VGND sg13cmos5l_antennanp
XANTENNA__0996__A0 Tile_X0Y1_E1END[2] VPWR VGND sg13cmos5l_antennanp
XANTENNA__0170__D Tile_X0Y0_FrameData[18] VPWR VGND sg13cmos5l_antennanp
XANTENNA__0747__X Tile_X0Y0_W6BEG[8] VPWR VGND sg13cmos5l_antennanp
XFILLER_44_100 VPWR VGND sg13cmos5l_fill_2
XFILLER_55_31 VPWR VGND sg13cmos5l_fill_1
XANTENNA__0345__D Tile_X0Y0_FrameData[3] VPWR VGND sg13cmos5l_antennanp
XANTENNA__0987__A0 Tile_X0Y1_EE4END[5] VPWR VGND sg13cmos5l_antennanp
XANTENNA__1228__A1 Tile_X0Y0_E6END[9] VPWR VGND sg13cmos5l_antennanp
XANTENNA__0625__CLK Tile_X0Y1_UserCLK VPWR VGND sg13cmos5l_antennanp
X_0401_ _0401_/Q Tile_X0Y1_FrameData[9] VGND VPWR Tile_X0Y1_FrameStrobe[1] latch
X_0332_ _0332_/Q Tile_X0Y0_FrameData[16] VGND VPWR Tile_X0Y1_FrameStrobe[7] latch
X_0263_ _0263_/Q Tile_X0Y0_FrameData[21] VGND VPWR Tile_X0Y1_FrameStrobe[5] latch
XANTENNA__0255__D Tile_X0Y0_FrameData[29] VPWR VGND sg13cmos5l_antennanp
XANTENNA__0463__GATE Tile_X0Y1_FrameStrobe[3] VPWR VGND sg13cmos5l_antennanp
XANTENNA__1219__A1 Tile_X0Y0_E2END[7] VPWR VGND sg13cmos5l_antennanp
X_0194_ _0194_/Q Tile_X0Y0_FrameData[26] VGND VPWR Tile_X0Y1_FrameStrobe[3] latch
XANTENNA__0478__GATE Tile_X0Y1_FrameStrobe[4] VPWR VGND sg13cmos5l_antennanp
XANTENNA__0833__A Tile_X0Y1_FrameData[9] VPWR VGND sg13cmos5l_antennanp
XANTENNA__0978__A0 Tile_X0Y0_E2MID[5] VPWR VGND sg13cmos5l_antennanp
XFILLER_84_0 VPWR VGND sg13cmos5l_fill_1
XANTENNA__0401__GATE Tile_X0Y1_FrameStrobe[1] VPWR VGND sg13cmos5l_antennanp
XANTENNA__1155__A0 Tile_X0Y1_E2MID[1] VPWR VGND sg13cmos5l_antennanp
XANTENNA__0416__GATE Tile_X0Y1_FrameStrobe[2] VPWR VGND sg13cmos5l_antennanp
XANTENNA__0165__D Tile_X0Y0_FrameData[23] VPWR VGND sg13cmos5l_antennanp
XFILLER_41_158 VPWR VGND sg13cmos5l_fill_1
XANTENNA__0648__CLK Tile_X0Y1_UserCLK VPWR VGND sg13cmos5l_antennanp
XFILLER_41_33 VPWR VGND sg13cmos5l_decap_4
XFILLER_41_99 VPWR VGND sg13cmos5l_fill_2
XANTENNA__1146__A0 Tile_X0Y1_N1END[3] VPWR VGND sg13cmos5l_antennanp
XANTENNA__0940__X Tile_X0Y1_W2BEGb[3] VPWR VGND sg13cmos5l_antennanp
XFILLER_32_158 VPWR VGND sg13cmos5l_fill_1
X_0881_ Tile_X0Y0_FrameData_O[25] Tile_X0Y0_FrameData[25] VPWR VGND sg13cmos5l_buf_1
X_0950_ Tile_X0Y1_W6BEG[5] _1184_/X VPWR VGND sg13cmos5l_buf_1
XANTENNA__1137__A0 Tile_X0Y1_E1END[1] VPWR VGND sg13cmos5l_antennanp
XANTENNA__0828__A Tile_X0Y1_FrameData[4] VPWR VGND sg13cmos5l_antennanp
XFILLER_102_28 VPWR VGND sg13cmos5l_fill_2
X_0315_ _0315_/Q Tile_X0Y0_FrameData[1] VGND VPWR Tile_X0Y1_FrameStrobe[6] latch
X_0246_ _0246_/Q Tile_X0Y0_FrameData[6] VGND VPWR Tile_X0Y1_FrameStrobe[4] latch
XFILLER_23_136 VPWR VGND sg13cmos5l_decap_8
X_0177_ _0177_/Q Tile_X0Y0_FrameData[11] VGND VPWR Tile_X0Y1_FrameStrobe[2] latch
XANTENNA__0340__GATE Tile_X0Y1_FrameStrobe[7] VPWR VGND sg13cmos5l_antennanp
XANTENNA__0850__X Tile_X0Y1_FrameData_O[26] VPWR VGND sg13cmos5l_antennanp
XFILLER_11_47 VPWR VGND sg13cmos5l_fill_2
XANTENNA__0355__GATE Tile_X0Y1_FrameStrobe[0] VPWR VGND sg13cmos5l_antennanp
XANTENNA__1128__A0 Tile_X0Y1_E2MID[6] VPWR VGND sg13cmos5l_antennanp
XANTENNA__0308__GATE Tile_X0Y1_FrameStrobe[6] VPWR VGND sg13cmos5l_antennanp
XANTENNA__0760__X Tile_X0Y0_N4BEG[9] VPWR VGND sg13cmos5l_antennanp
XFILLER_52_87 VPWR VGND sg13cmos5l_fill_2
XANTENNA__1119__A0 Tile_X0Y1_E1END[1] VPWR VGND sg13cmos5l_antennanp
X_1080_ _1080_/X _1114_/X Tile_X0Y1_N4END[7] Tile_X0Y0_S1END[3] Tile_X0Y0_S4END[3]
+ _0126_/Q _0125_/Q VPWR VGND sg13cmos5l_mux4_1
X_0100_ _0100_/Q Tile_X0Y0_FrameData[24] VGND VPWR Tile_X0Y1_FrameStrobe[0] latch
XANTENNA__0935__X Tile_X0Y1_W2BEG[6] VPWR VGND sg13cmos5l_antennanp
XFILLER_93_94 VPWR VGND sg13cmos5l_fill_1
XANTENNA__0533__D Tile_X0Y1_FrameData[5] VPWR VGND sg13cmos5l_antennanp
X_0864_ Tile_X0Y0_FrameData_O[8] Tile_X0Y0_FrameData[8] VPWR VGND sg13cmos5l_buf_1
X_0933_ Tile_X0Y1_W2BEG[4] _1151_/X VPWR VGND sg13cmos5l_buf_1
X_0795_ Tile_X0Y0_N2BEG[4] _1007_/X VPWR VGND sg13cmos5l_buf_1
XFILLER_47_0 VPWR VGND sg13cmos5l_decap_4
XANTENNA__0845__X Tile_X0Y1_FrameData_O[21] VPWR VGND sg13cmos5l_antennanp
XFILLER_113_16 VPWR VGND sg13cmos5l_fill_1
X_0229_ _0229_/Q Tile_X0Y0_FrameData[23] VGND VPWR Tile_X0Y1_FrameStrobe[4] latch
XANTENNA__0443__D Tile_X0Y1_FrameData[31] VPWR VGND sg13cmos5l_antennanp
XFILLER_22_46 VPWR VGND sg13cmos5l_decap_4
XANTENNA__0294__GATE Tile_X0Y1_FrameStrobe[6] VPWR VGND sg13cmos5l_antennanp
XFILLER_98_17 VPWR VGND sg13cmos5l_fill_2
XANTENNA__0232__GATE Tile_X0Y1_FrameStrobe[4] VPWR VGND sg13cmos5l_antennanp
XANTENNA__0755__X Tile_X0Y0_N4BEG[4] VPWR VGND sg13cmos5l_antennanp
XFILLER_8_15 VPWR VGND sg13cmos5l_fill_1
XANTENNA__0247__GATE Tile_X0Y1_FrameStrobe[4] VPWR VGND sg13cmos5l_antennanp
XANTENNA__0353__D Tile_X0Y1_FrameData[25] VPWR VGND sg13cmos5l_antennanp
XFILLER_8_59 VPWR VGND sg13cmos5l_decap_8
X_1201_ _1201_/X Tile_X0Y1_N2MID[6] Tile_X0Y1_N2END[6] _1225_/X Tile_X0Y0_S2MID[6]
+ _0358_/Q _0357_/Q VPWR VGND sg13cmos5l_mux4_1
X_0580_ _0580_/Q Tile_X0Y1_FrameData[22] VGND VPWR Tile_X0Y1_FrameStrobe[7] latch
XANTENNA__0528__D Tile_X0Y1_FrameData[10] VPWR VGND sg13cmos5l_antennanp
X_1063_ _1063_/X Tile_X0Y1_N4END[4] Tile_X0Y0_S4END[0] _1080_/X _1079_/X _0202_/Q
+ _0201_/Q VPWR VGND sg13cmos5l_mux4_1
X_1132_ _1132_/X Tile_X0Y1_E1END[1] Tile_X0Y1_E2MID[2] Tile_X0Y1_E2END[2] _1200_/X
+ _0548_/Q _0547_/Q VPWR VGND sg13cmos5l_mux4_1
XANTENNA__0263__D Tile_X0Y0_FrameData[21] VPWR VGND sg13cmos5l_antennanp
XANTENNA__0614__Q NPU_WEIGHT_IN4 VPWR VGND sg13cmos5l_antennanp
XANTENNA__0841__A Tile_X0Y1_FrameData[17] VPWR VGND sg13cmos5l_antennanp
X_0916_ Tile_X0Y1_S4BEG[8] _0916_/A VPWR VGND sg13cmos5l_buf_1
X_0847_ Tile_X0Y1_FrameData_O[23] Tile_X0Y1_FrameData[23] VPWR VGND sg13cmos5l_buf_1
X_0778_ Tile_X0Y0_WW4BEG[11] _1058_/X VPWR VGND sg13cmos5l_buf_1
XANTENNA__0438__D Tile_X0Y1_FrameData[4] VPWR VGND sg13cmos5l_antennanp
XFILLER_33_12 VPWR VGND sg13cmos5l_decap_8
XANTENNA__0173__D Tile_X0Y0_FrameData[15] VPWR VGND sg13cmos5l_antennanp
XANTENNA__0751__A Tile_X0Y1_N4END[8] VPWR VGND sg13cmos5l_antennanp
XFILLER_3_179 VPWR VGND sg13cmos5l_fill_1
XFILLER_58_20 VPWR VGND sg13cmos5l_fill_2
XANTENNA__0171__GATE Tile_X0Y1_FrameStrobe[2] VPWR VGND sg13cmos5l_antennanp
XANTENNA__0348__D Tile_X0Y1_FrameData[30] VPWR VGND sg13cmos5l_antennanp
XANTENNA__0186__GATE Tile_X0Y1_FrameStrobe[2] VPWR VGND sg13cmos5l_antennanp
XANTENNA__1025__A2 Tile_X0Y0_E6END[7] VPWR VGND sg13cmos5l_antennanp
XFILLER_90_40 VPWR VGND sg13cmos5l_decap_8
X_0701_ _1102_/A3 VPWR VGND sg13cmos5l_tielo
X_0632_ NPU_ACT_ADDR6 Tile_X0Y1_UserCLK _0979_/X _0689_/L_HI VPWR VGND sg13cmos5l_dfrbpq_1
X_0563_ _0563_/Q Tile_X0Y1_FrameData[7] VGND VPWR Tile_X0Y1_FrameStrobe[6] latch
XANTENNA__0124__GATE Tile_X0Y1_FrameStrobe[0] VPWR VGND sg13cmos5l_antennanp
XANTENNA__0139__GATE Tile_X0Y1_FrameStrobe[1] VPWR VGND sg13cmos5l_antennanp
XFILLER_57_109 VPWR VGND sg13cmos5l_fill_2
X_0494_ _0494_/Q Tile_X0Y1_FrameData[12] VGND VPWR Tile_X0Y1_FrameStrobe[4] latch
XANTENNA__0258__D Tile_X0Y0_FrameData[26] VPWR VGND sg13cmos5l_antennanp
XANTENNA__0836__A Tile_X0Y1_FrameData[12] VPWR VGND sg13cmos5l_antennanp
X_1046_ _1046_/X Tile_X0Y0_EE4END[14] _0643_/Q _1092_/X _1099_/X _0236_/Q _0235_/Q
+ VPWR VGND sg13cmos5l_mux4_1
X_1115_ _1115_/X Tile_X0Y1_E1END[3] Tile_X0Y1_EE4END[3] Tile_X0Y1_E6END[11] _1206_/X
+ _0569_/Q _0568_/Q VPWR VGND sg13cmos5l_mux4_1
XFILLER_80_134 VPWR VGND sg13cmos5l_decap_8
XFILLER_9_80 VPWR VGND sg13cmos5l_fill_1
XANTENNA__0168__D Tile_X0Y0_FrameData[20] VPWR VGND sg13cmos5l_antennanp
XFILLER_44_66 VPWR VGND sg13cmos5l_decap_4
XANTENNA__1007__A2 Tile_X0Y0_E6END[3] VPWR VGND sg13cmos5l_antennanp
XFILLER_109_92 VPWR VGND sg13cmos5l_fill_2
XFILLER_69_30 VPWR VGND sg13cmos5l_fill_1
XANTENNA__1191__A1 Tile_X0Y1_E6END[0] VPWR VGND sg13cmos5l_antennanp
XANTENNA__0943__X Tile_X0Y1_W2BEGb[6] VPWR VGND sg13cmos5l_antennanp
XFILLER_62_178 VPWR VGND sg13cmos5l_fill_2
XANTENNA__0541__D Tile_X0Y1_FrameData[29] VPWR VGND sg13cmos5l_antennanp
XANTENNA__1182__A1 Tile_X0Y0_S4END[7] VPWR VGND sg13cmos5l_antennanp
X_0615_ NPU_WEIGHT_IN5 Tile_X0Y1_UserCLK _0995_/X _0656_/L_HI VPWR VGND sg13cmos5l_dfrbpq_1
X_0546_ _0546_/Q Tile_X0Y1_FrameData[24] VGND VPWR Tile_X0Y1_FrameStrobe[6] latch
XFILLER_38_120 VPWR VGND sg13cmos5l_fill_2
XFILLER_53_101 VPWR VGND sg13cmos5l_fill_1
X_0477_ _0477_/Q Tile_X0Y1_FrameData[29] VGND VPWR Tile_X0Y1_FrameStrobe[4] latch
XANTENNA__0853__X Tile_X0Y1_FrameData_O[29] VPWR VGND sg13cmos5l_antennanp
XANTENNA__0996__A1 Tile_X0Y1_EE4END[6] VPWR VGND sg13cmos5l_antennanp
XFILLER_53_178 VPWR VGND sg13cmos5l_fill_2
X_1029_ _1029_/X _1113_/X Tile_X0Y0_S1END[2] _0636_/Q _0641_/Q _0270_/Q _0269_/Q VPWR
+ VGND sg13cmos5l_mux4_1
XANTENNA__0451__D Tile_X0Y1_FrameData[23] VPWR VGND sg13cmos5l_antennanp
XFILLER_39_33 VPWR VGND sg13cmos5l_decap_8
XANTENNA__0763__X Tile_X0Y0_N4BEG[12] VPWR VGND sg13cmos5l_antennanp
XFILLER_44_178 VPWR VGND sg13cmos5l_fill_2
XANTENNA__0987__A1 Tile_X0Y1_EE4END[13] VPWR VGND sg13cmos5l_antennanp
XANTENNA__0361__D Tile_X0Y1_FrameData[17] VPWR VGND sg13cmos5l_antennanp
X_0400_ _0400_/Q Tile_X0Y1_FrameData[10] VGND VPWR Tile_X0Y1_FrameStrobe[1] latch
XANTENNA__0938__X Tile_X0Y1_W2BEGb[1] VPWR VGND sg13cmos5l_antennanp
X_0331_ _0331_/Q Tile_X0Y0_FrameData[17] VGND VPWR Tile_X0Y1_FrameStrobe[7] latch
X_0262_ _0262_/Q Tile_X0Y0_FrameData[22] VGND VPWR Tile_X0Y1_FrameStrobe[5] latch
X_0193_ _0193_/Q Tile_X0Y0_FrameData[27] VGND VPWR Tile_X0Y1_FrameStrobe[3] latch
XANTENNA__0536__D Tile_X0Y1_FrameData[2] VPWR VGND sg13cmos5l_antennanp
XANTENNA__0978__A1 Tile_X0Y0_E2END[5] VPWR VGND sg13cmos5l_antennanp
XANTENNA__1219__A2 Tile_X0Y0_E6END[8] VPWR VGND sg13cmos5l_antennanp
XFILLER_35_134 VPWR VGND sg13cmos5l_fill_1
XFILLER_50_115 VPWR VGND sg13cmos5l_fill_2
XANTENNA__0271__D Tile_X0Y0_FrameData[13] VPWR VGND sg13cmos5l_antennanp
XANTENNA__0622__Q NPU_ACT_WDATA4 VPWR VGND sg13cmos5l_antennanp
XFILLER_77_0 VPWR VGND sg13cmos5l_fill_2
XANTENNA__0848__X Tile_X0Y1_FrameData_O[24] VPWR VGND sg13cmos5l_antennanp
XFILLER_6_81 VPWR VGND sg13cmos5l_decap_8
X_0529_ _0529_/Q Tile_X0Y1_FrameData[9] VGND VPWR Tile_X0Y1_FrameStrobe[5] latch
XANTENNA__0446__D Tile_X0Y1_FrameData[28] VPWR VGND sg13cmos5l_antennanp
XANTENNA__0570__GATE Tile_X0Y1_FrameStrobe[6] VPWR VGND sg13cmos5l_antennanp
XANTENNA__0585__GATE Tile_X0Y1_FrameStrobe[7] VPWR VGND sg13cmos5l_antennanp
XANTENNA__0181__D Tile_X0Y0_FrameData[7] VPWR VGND sg13cmos5l_antennanp
XANTENNA__0523__GATE Tile_X0Y1_FrameStrobe[5] VPWR VGND sg13cmos5l_antennanp
XANTENNA__0538__GATE Tile_X0Y1_FrameStrobe[5] VPWR VGND sg13cmos5l_antennanp
XANTENNA__0758__X Tile_X0Y0_N4BEG[7] VPWR VGND sg13cmos5l_antennanp
XFILLER_2_17 VPWR VGND sg13cmos5l_fill_1
XANTENNA__0356__D Tile_X0Y1_FrameData[22] VPWR VGND sg13cmos5l_antennanp
XFILLER_17_178 VPWR VGND sg13cmos5l_fill_2
XFILLER_82_74 VPWR VGND sg13cmos5l_fill_1
XFILLER_82_30 VPWR VGND sg13cmos5l_fill_1
X_0880_ Tile_X0Y0_FrameData_O[24] Tile_X0Y0_FrameData[24] VPWR VGND sg13cmos5l_buf_1
XANTENNA__1137__A1 Tile_X0Y1_EE4END[13] VPWR VGND sg13cmos5l_antennanp
XANTENNA__0266__D Tile_X0Y0_FrameData[18] VPWR VGND sg13cmos5l_antennanp
XANTENNA__0617__Q NPU_WEIGHT_IN7 VPWR VGND sg13cmos5l_antennanp
X_0314_ _0314_/Q Tile_X0Y0_FrameData[2] VGND VPWR Tile_X0Y1_FrameStrobe[6] latch
X_0245_ _0245_/Q Tile_X0Y0_FrameData[7] VGND VPWR Tile_X0Y1_FrameStrobe[4] latch
X_0176_ _0176_/Q Tile_X0Y0_FrameData[12] VGND VPWR Tile_X0Y1_FrameStrobe[2] latch
XANTENNA__0844__A Tile_X0Y1_FrameData[20] VPWR VGND sg13cmos5l_antennanp
XANTENNA__1128__A1 Tile_X0Y1_E2END[6] VPWR VGND sg13cmos5l_antennanp
XANTENNA__0176__D Tile_X0Y0_FrameData[12] VPWR VGND sg13cmos5l_antennanp
XANTENNA__0754__A Tile_X0Y1_N4END[11] VPWR VGND sg13cmos5l_antennanp
XFILLER_52_22 VPWR VGND sg13cmos5l_decap_8
XANTENNA__0615__CLK Tile_X0Y1_UserCLK VPWR VGND sg13cmos5l_antennanp
XANTENNA__1064__A0 Tile_X0Y1_N4END[5] VPWR VGND sg13cmos5l_antennanp
XANTENNA__0462__GATE Tile_X0Y1_FrameStrobe[3] VPWR VGND sg13cmos5l_antennanp
XANTENNA__1119__A1 Tile_X0Y1_EE4END[1] VPWR VGND sg13cmos5l_antennanp
XFILLER_89_170 VPWR VGND sg13cmos5l_fill_1
XFILLER_7_0 VPWR VGND sg13cmos5l_fill_1
XANTENNA__0477__GATE Tile_X0Y1_FrameStrobe[4] VPWR VGND sg13cmos5l_antennanp
XFILLER_93_62 VPWR VGND sg13cmos5l_decap_8
XANTENNA__0400__GATE Tile_X0Y1_FrameStrobe[1] VPWR VGND sg13cmos5l_antennanp
XANTENNA__0415__GATE Tile_X0Y1_FrameStrobe[2] VPWR VGND sg13cmos5l_antennanp
XANTENNA__0951__X Tile_X0Y1_W6BEG[6] VPWR VGND sg13cmos5l_antennanp
X_0932_ Tile_X0Y1_W2BEG[3] _1150_/X VPWR VGND sg13cmos5l_buf_1
X_0863_ Tile_X0Y0_FrameData_O[7] Tile_X0Y0_FrameData[7] VPWR VGND sg13cmos5l_buf_1
X_0794_ Tile_X0Y0_N2BEG[3] _1006_/X VPWR VGND sg13cmos5l_buf_1
XANTENNA__0839__A Tile_X0Y1_FrameData[15] VPWR VGND sg13cmos5l_antennanp
XFILLER_87_107 VPWR VGND sg13cmos5l_fill_1
XANTENNA__0638__CLK Tile_X0Y1_UserCLK VPWR VGND sg13cmos5l_antennanp
X_0228_ _0228_/Q Tile_X0Y0_FrameData[24] VGND VPWR Tile_X0Y1_FrameStrobe[4] latch
X_0159_ _0159_/Q Tile_X0Y0_FrameData[29] VGND VPWR Tile_X0Y1_FrameStrobe[2] latch
XANTENNA__0861__X Tile_X0Y0_FrameData_O[5] VPWR VGND sg13cmos5l_antennanp
XANTENNA__1046__A0 Tile_X0Y0_EE4END[14] VPWR VGND sg13cmos5l_antennanp
XFILLER_11_118 VPWR VGND sg13cmos5l_fill_1
XFILLER_86_140 VPWR VGND sg13cmos5l_decap_8
XANTENNA__0771__X Tile_X0Y0_WW4BEG[4] VPWR VGND sg13cmos5l_antennanp
XANTENNA__1037__A0 Tile_X0Y0_EE4END[4] VPWR VGND sg13cmos5l_antennanp
X_1200_ _1200_/X Tile_X0Y1_N2MID[5] Tile_X0Y1_N2END[5] _1224_/X Tile_X0Y0_S2MID[5]
+ _0360_/Q _0359_/Q VPWR VGND sg13cmos5l_mux4_1
XANTENNA__0946__X Tile_X0Y1_W6BEG[1] VPWR VGND sg13cmos5l_antennanp
X_1062_ _1062_/X _0639_/Q _0643_/Q _1088_/X _1092_/X _0204_/Q _0203_/Q VPWR VGND sg13cmos5l_mux4_1
X_1131_ _1131_/X Tile_X0Y1_E1END[0] Tile_X0Y1_E2MID[3] Tile_X0Y1_E2END[3] _1199_/X
+ _0550_/Q _0549_/Q VPWR VGND sg13cmos5l_mux4_1
XFILLER_92_132 VPWR VGND sg13cmos5l_fill_1
XFILLER_92_121 VPWR VGND sg13cmos5l_fill_2
XANTENNA__0354__GATE Tile_X0Y1_FrameStrobe[0] VPWR VGND sg13cmos5l_antennanp
XANTENNA__0544__D Tile_X0Y1_FrameData[26] VPWR VGND sg13cmos5l_antennanp
X_0915_ Tile_X0Y1_S4BEG[7] Tile_X0Y0_S4END[15] VPWR VGND sg13cmos5l_buf_1
XANTENNA__0369__GATE Tile_X0Y1_FrameStrobe[0] VPWR VGND sg13cmos5l_antennanp
XANTENNA__0630__Q NPU_ACT_ADDR4 VPWR VGND sg13cmos5l_antennanp
XANTENNA__1200__A0 Tile_X0Y1_N2MID[5] VPWR VGND sg13cmos5l_antennanp
XFILLER_108_39 VPWR VGND sg13cmos5l_decap_4
X_0846_ Tile_X0Y1_FrameData_O[22] Tile_X0Y1_FrameData[22] VPWR VGND sg13cmos5l_buf_1
X_0777_ Tile_X0Y0_WW4BEG[10] _1057_/X VPWR VGND sg13cmos5l_buf_1
XANTENNA__0307__GATE Tile_X0Y1_FrameStrobe[6] VPWR VGND sg13cmos5l_antennanp
XANTENNA__0856__X Tile_X0Y0_FrameData_O[0] VPWR VGND sg13cmos5l_antennanp
XFILLER_17_47 VPWR VGND sg13cmos5l_decap_4
XANTENNA__0454__D Tile_X0Y1_FrameData[20] VPWR VGND sg13cmos5l_antennanp
XANTENNA__1019__A0 Tile_X0Y0_E1END[0] VPWR VGND sg13cmos5l_antennanp
XFILLER_33_79 VPWR VGND sg13cmos5l_fill_1
XANTENNA__0766__X Tile_X0Y0_N4BEG[15] VPWR VGND sg13cmos5l_antennanp
XANTENNA__0364__D Tile_X0Y1_FrameData[14] VPWR VGND sg13cmos5l_antennanp
X_0700_ _1101_/A3 VPWR VGND sg13cmos5l_tielo
XFILLER_95_9 VPWR VGND sg13cmos5l_decap_4
XFILLER_90_52 VPWR VGND sg13cmos5l_decap_8
X_0631_ NPU_ACT_ADDR5 Tile_X0Y1_UserCLK _0978_/X _0686_/L_HI VPWR VGND sg13cmos5l_dfrbpq_1
X_0562_ _0562_/Q Tile_X0Y1_FrameData[8] VGND VPWR Tile_X0Y1_FrameStrobe[6] latch
XANTENNA__0539__D Tile_X0Y1_FrameData[31] VPWR VGND sg13cmos5l_antennanp
X_1114_ _1114_/X Tile_X0Y1_E1END[3] Tile_X0Y1_E6END[7] _1218_/X _1194_/X _0596_/Q
+ _0595_/Q VPWR VGND sg13cmos5l_mux4_1
X_0493_ _0493_/Q Tile_X0Y1_FrameData[13] VGND VPWR Tile_X0Y1_FrameStrobe[4] latch
XANTENNA__0274__D Tile_X0Y0_FrameData[10] VPWR VGND sg13cmos5l_antennanp
XANTENNA__0293__GATE Tile_X0Y1_FrameStrobe[6] VPWR VGND sg13cmos5l_antennanp
XANTENNA__0625__Q NPU_ACT_WDATA7 VPWR VGND sg13cmos5l_antennanp
XANTENNA__0852__A Tile_X0Y1_FrameData[28] VPWR VGND sg13cmos5l_antennanp
X_1045_ _1045_/X Tile_X0Y0_EE4END[13] _0642_/Q _1093_/X _1098_/X _0238_/Q _0237_/Q
+ VPWR VGND sg13cmos5l_mux4_1
XFILLER_80_179 VPWR VGND sg13cmos5l_fill_1
X_0829_ Tile_X0Y1_FrameData_O[5] Tile_X0Y1_FrameData[5] VPWR VGND sg13cmos5l_buf_1
XANTENNA__0231__GATE Tile_X0Y1_FrameStrobe[4] VPWR VGND sg13cmos5l_antennanp
XFILLER_95_19 VPWR VGND sg13cmos5l_fill_1
XANTENNA__0246__GATE Tile_X0Y1_FrameStrobe[4] VPWR VGND sg13cmos5l_antennanp
XANTENNA__0449__D Tile_X0Y1_FrameData[25] VPWR VGND sg13cmos5l_antennanp
XFILLER_71_135 VPWR VGND sg13cmos5l_fill_1
XANTENNA__0184__D Tile_X0Y0_FrameData[4] VPWR VGND sg13cmos5l_antennanp
XFILLER_60_33 VPWR VGND sg13cmos5l_decap_4
XFILLER_60_55 VPWR VGND sg13cmos5l_decap_8
XFILLER_107_0 VPWR VGND sg13cmos5l_fill_2
XFILLER_60_99 VPWR VGND sg13cmos5l_fill_2
XFILLER_69_75 VPWR VGND sg13cmos5l_fill_2
XANTENNA__0359__D Tile_X0Y1_FrameData[19] VPWR VGND sg13cmos5l_antennanp
XFILLER_47_143 VPWR VGND sg13cmos5l_fill_2
XFILLER_85_74 VPWR VGND sg13cmos5l_fill_2
XANTENNA__0094__D Tile_X0Y0_FrameData[30] VPWR VGND sg13cmos5l_antennanp
XFILLER_62_168 VPWR VGND sg13cmos5l_fill_1
XFILLER_116_115 VPWR VGND sg13cmos5l_fill_1
XFILLER_22_0 VPWR VGND sg13cmos5l_fill_2
X_0614_ NPU_WEIGHT_IN4 Tile_X0Y1_UserCLK _0994_/X _0653_/L_HI VPWR VGND sg13cmos5l_dfrbpq_1
X_0545_ _0545_/Q Tile_X0Y1_FrameData[25] VGND VPWR Tile_X0Y1_FrameStrobe[6] latch
X_0476_ _0476_/Q Tile_X0Y1_FrameData[30] VGND VPWR Tile_X0Y1_FrameStrobe[4] latch
XANTENNA__0269__D Tile_X0Y0_FrameData[15] VPWR VGND sg13cmos5l_antennanp
XANTENNA__0847__A Tile_X0Y1_FrameData[23] VPWR VGND sg13cmos5l_antennanp
XFILLER_38_132 VPWR VGND sg13cmos5l_fill_2
XFILLER_53_135 VPWR VGND sg13cmos5l_fill_1
XANTENNA__0996__A2 Tile_X0Y1_EE4END[14] VPWR VGND sg13cmos5l_antennanp
XFILLER_14_15 VPWR VGND sg13cmos5l_decap_8
X_1028_ _1028_/X _1112_/X Tile_X0Y0_S1END[1] _0639_/Q _0642_/Q _0272_/Q _0271_/Q VPWR
+ VGND sg13cmos5l_mux4_1
XANTENNA__0090__Q NPU_XBAR_SEL0 VPWR VGND sg13cmos5l_antennanp
XANTENNA__0170__GATE Tile_X0Y1_FrameStrobe[2] VPWR VGND sg13cmos5l_antennanp
XFILLER_30_36 VPWR VGND sg13cmos5l_decap_8
XFILLER_30_58 VPWR VGND sg13cmos5l_decap_8
XFILLER_30_69 VPWR VGND sg13cmos5l_fill_1
XANTENNA__0179__D Tile_X0Y0_FrameData[9] VPWR VGND sg13cmos5l_antennanp
XANTENNA__0185__GATE Tile_X0Y1_FrameStrobe[2] VPWR VGND sg13cmos5l_antennanp
XANTENNA__0757__A Tile_X0Y1_N4END[14] VPWR VGND sg13cmos5l_antennanp
XFILLER_115_170 VPWR VGND sg13cmos5l_fill_1
XFILLER_29_121 VPWR VGND sg13cmos5l_decap_4
XFILLER_29_143 VPWR VGND sg13cmos5l_fill_2
XFILLER_39_89 VPWR VGND sg13cmos5l_decap_8
XANTENNA__0123__GATE Tile_X0Y1_FrameStrobe[0] VPWR VGND sg13cmos5l_antennanp
XFILLER_44_102 VPWR VGND sg13cmos5l_fill_1
XANTENNA__0138__GATE Tile_X0Y1_FrameStrobe[1] VPWR VGND sg13cmos5l_antennanp
XANTENNA__0642__D NPU_OUT_ACT6 VPWR VGND sg13cmos5l_antennanp
XANTENNA__0987__A2 Tile_X0Y1_E6END[5] VPWR VGND sg13cmos5l_antennanp
XFILLER_71_87 VPWR VGND sg13cmos5l_fill_1
XFILLER_71_98 VPWR VGND sg13cmos5l_fill_2
XFILLER_113_107 VPWR VGND sg13cmos5l_fill_1
XFILLER_20_80 VPWR VGND sg13cmos5l_fill_1
X_0330_ _0330_/Q Tile_X0Y0_FrameData[18] VGND VPWR Tile_X0Y1_FrameStrobe[7] latch
XANTENNA__0954__X Tile_X0Y1_W6BEG[9] VPWR VGND sg13cmos5l_antennanp
X_0261_ _0261_/Q Tile_X0Y0_FrameData[23] VGND VPWR Tile_X0Y1_FrameStrobe[5] latch
X_0192_ _0192_/Q Tile_X0Y0_FrameData[28] VGND VPWR Tile_X0Y1_FrameStrobe[3] latch
XFILLER_96_95 VPWR VGND sg13cmos5l_fill_2
XANTENNA__0552__D Tile_X0Y1_FrameData[18] VPWR VGND sg13cmos5l_antennanp
X_0528_ _0528_/Q Tile_X0Y1_FrameData[10] VGND VPWR Tile_X0Y1_FrameStrobe[5] latch
X_0459_ _0459_/Q Tile_X0Y1_FrameData[15] VGND VPWR Tile_X0Y1_FrameStrobe[3] latch
XANTENNA__0864__X Tile_X0Y0_FrameData_O[8] VPWR VGND sg13cmos5l_antennanp
XFILLER_26_124 VPWR VGND sg13cmos5l_fill_2
XFILLER_26_179 VPWR VGND sg13cmos5l_fill_1
XANTENNA__0462__D Tile_X0Y1_FrameData[12] VPWR VGND sg13cmos5l_antennanp
XANTENNA__1091__A1 Tile_X0Y1_N4END[7] VPWR VGND sg13cmos5l_antennanp
XFILLER_41_13 VPWR VGND sg13cmos5l_decap_8
XFILLER_41_24 VPWR VGND sg13cmos5l_fill_2
XFILLER_41_79 VPWR VGND sg13cmos5l_fill_2
XANTENNA__0637__D NPU_OUT_ACT1 VPWR VGND sg13cmos5l_antennanp
XANTENNA__0774__X Tile_X0Y0_WW4BEG[7] VPWR VGND sg13cmos5l_antennanp
XFILLER_106_94 VPWR VGND sg13cmos5l_decap_4
XANTENNA__1082__A1 Tile_X0Y1_N4END[5] VPWR VGND sg13cmos5l_antennanp
XFILLER_82_97 VPWR VGND sg13cmos5l_fill_2
XFILLER_82_20 VPWR VGND sg13cmos5l_fill_2
XANTENNA__0372__D Tile_X0Y1_FrameData[6] VPWR VGND sg13cmos5l_antennanp
XFILLER_31_90 VPWR VGND sg13cmos5l_fill_2
XANTENNA__0949__X Tile_X0Y1_W6BEG[4] VPWR VGND sg13cmos5l_antennanp
XANTENNA__1137__A2 Tile_X0Y1_E6END[5] VPWR VGND sg13cmos5l_antennanp
X_0313_ _0313_/Q Tile_X0Y0_FrameData[3] VGND VPWR Tile_X0Y1_FrameStrobe[6] latch
XANTENNA__0547__D Tile_X0Y1_FrameData[23] VPWR VGND sg13cmos5l_antennanp
XFILLER_102_19 VPWR VGND sg13cmos5l_fill_2
X_0244_ _0244_/Q Tile_X0Y0_FrameData[8] VGND VPWR Tile_X0Y1_FrameStrobe[4] latch
X_0175_ _0175_/Q Tile_X0Y0_FrameData[13] VGND VPWR Tile_X0Y1_FrameStrobe[2] latch
XANTENNA__0282__D Tile_X0Y0_FrameData[2] VPWR VGND sg13cmos5l_antennanp
XANTENNA__0633__Q NPU_ACT_ADDR7 VPWR VGND sg13cmos5l_antennanp
XANTENNA__0860__A Tile_X0Y0_FrameData[4] VPWR VGND sg13cmos5l_antennanp
XANTENNA__0859__X Tile_X0Y0_FrameData_O[3] VPWR VGND sg13cmos5l_antennanp
XANTENNA__1128__A2 Tile_X0Y1_E6END[9] VPWR VGND sg13cmos5l_antennanp
XANTENNA__0457__D Tile_X0Y1_FrameData[17] VPWR VGND sg13cmos5l_antennanp
XANTENNA__1064__A1 Tile_X0Y0_S4END[1] VPWR VGND sg13cmos5l_antennanp
XANTENNA__0192__D Tile_X0Y0_FrameData[28] VPWR VGND sg13cmos5l_antennanp
XANTENNA__0769__X Tile_X0Y0_WW4BEG[2] VPWR VGND sg13cmos5l_antennanp
XANTENNA__1119__A2 Tile_X0Y1_E6END[9] VPWR VGND sg13cmos5l_antennanp
XFILLER_96_108 VPWR VGND sg13cmos5l_fill_1
XFILLER_77_53 VPWR VGND sg13cmos5l_fill_2
XFILLER_77_31 VPWR VGND sg13cmos5l_decap_8
XANTENNA__0367__D Tile_X0Y1_FrameData[11] VPWR VGND sg13cmos5l_antennanp
XFILLER_93_30 VPWR VGND sg13cmos5l_fill_1
XFILLER_26_90 VPWR VGND sg13cmos5l_fill_2
X_0862_ Tile_X0Y0_FrameData_O[6] Tile_X0Y0_FrameData[6] VPWR VGND sg13cmos5l_buf_1
X_0931_ Tile_X0Y1_W2BEG[2] _1149_/X VPWR VGND sg13cmos5l_buf_1
X_0793_ Tile_X0Y0_N2BEG[2] _1005_/X VPWR VGND sg13cmos5l_buf_1
XANTENNA__0277__D Tile_X0Y0_FrameData[7] VPWR VGND sg13cmos5l_antennanp
XANTENNA__0584__GATE Tile_X0Y1_FrameStrobe[7] VPWR VGND sg13cmos5l_antennanp
XANTENNA__0628__Q NPU_ACT_ADDR2 VPWR VGND sg13cmos5l_antennanp
XFILLER_3_72 VPWR VGND sg13cmos5l_fill_2
XANTENNA__0522__GATE Tile_X0Y1_FrameStrobe[5] VPWR VGND sg13cmos5l_antennanp
XANTENNA__0599__GATE Tile_X0Y1_FrameStrobe[7] VPWR VGND sg13cmos5l_antennanp
XANTENNA__0855__A Tile_X0Y1_FrameData[31] VPWR VGND sg13cmos5l_antennanp
X_0227_ _0227_/Q Tile_X0Y0_FrameData[25] VGND VPWR Tile_X0Y1_FrameStrobe[4] latch
X_0158_ _0158_/Q Tile_X0Y0_FrameData[30] VGND VPWR Tile_X0Y1_FrameStrobe[2] latch
X_0089_ NPU_ACT_WE Tile_X0Y1_UserCLK _0089_/D _0697_/L_HI VPWR VGND sg13cmos5l_dfrbpq_1
XANTENNA__0537__GATE Tile_X0Y1_FrameStrobe[5] VPWR VGND sg13cmos5l_antennanp
XANTENNA__0187__D Tile_X0Y0_FrameData[1] VPWR VGND sg13cmos5l_antennanp
XANTENNA__0650__D NPU_ACT_RDATA6 VPWR VGND sg13cmos5l_antennanp
XANTENNA__0097__D Tile_X0Y0_FrameData[27] VPWR VGND sg13cmos5l_antennanp
X_1130_ _1130_/X Tile_X0Y1_E2MID[4] Tile_X0Y1_E2END[4] Tile_X0Y1_E6END[11] _1198_/X
+ _0552_/Q _0551_/Q VPWR VGND sg13cmos5l_mux4_1
XFILLER_92_100 VPWR VGND sg13cmos5l_fill_1
XFILLER_88_85 VPWR VGND sg13cmos5l_fill_1
XANTENNA__0962__X Tile_X0Y1_WW4BEG[5] VPWR VGND sg13cmos5l_antennanp
XANTENNA__1028__A1 Tile_X0Y0_S1END[1] VPWR VGND sg13cmos5l_antennanp
X_1061_ _1061_/X _0638_/Q _0642_/Q _1089_/X _1093_/X _0206_/Q _0205_/Q VPWR VGND sg13cmos5l_mux4_1
XANTENNA__0560__D Tile_X0Y1_FrameData[10] VPWR VGND sg13cmos5l_antennanp
X_0914_ Tile_X0Y1_S4BEG[6] Tile_X0Y0_S4END[14] VPWR VGND sg13cmos5l_buf_1
X_0845_ Tile_X0Y1_FrameData_O[21] Tile_X0Y1_FrameData[21] VPWR VGND sg13cmos5l_buf_1
XANTENNA__1200__A1 Tile_X0Y1_N2END[5] VPWR VGND sg13cmos5l_antennanp
X_0776_ Tile_X0Y0_WW4BEG[9] _1056_/X VPWR VGND sg13cmos5l_buf_1
XFILLER_17_26 VPWR VGND sg13cmos5l_decap_8
XANTENNA__0093__Q NPU_XBAR_SEL3 VPWR VGND sg13cmos5l_antennanp
XANTENNA__0461__GATE Tile_X0Y1_FrameStrobe[3] VPWR VGND sg13cmos5l_antennanp
XANTENNA__0872__X Tile_X0Y0_FrameData_O[16] VPWR VGND sg13cmos5l_antennanp
XANTENNA__1019__A1 Tile_X0Y0_EE4END[12] VPWR VGND sg13cmos5l_antennanp
XFILLER_33_47 VPWR VGND sg13cmos5l_decap_4
XANTENNA__0470__D Tile_X0Y1_FrameData[4] VPWR VGND sg13cmos5l_antennanp
XANTENNA__0476__GATE Tile_X0Y1_FrameStrobe[4] VPWR VGND sg13cmos5l_antennanp
XANTENNA__0414__GATE Tile_X0Y1_FrameStrobe[2] VPWR VGND sg13cmos5l_antennanp
XFILLER_114_61 VPWR VGND sg13cmos5l_fill_1
XFILLER_59_130 VPWR VGND sg13cmos5l_fill_2
XFILLER_74_111 VPWR VGND sg13cmos5l_decap_4
XANTENNA__0429__GATE Tile_X0Y1_FrameStrobe[2] VPWR VGND sg13cmos5l_antennanp
XANTENNA__0645__D NPU_ACT_RDATA1 VPWR VGND sg13cmos5l_antennanp
XANTENNA__0782__X Tile_X0Y0_WW4BEG[15] VPWR VGND sg13cmos5l_antennanp
XFILLER_74_76 VPWR VGND sg13cmos5l_decap_8
XANTENNA__0380__D Tile_X0Y1_FrameData[30] VPWR VGND sg13cmos5l_antennanp
XFILLER_88_9 VPWR VGND sg13cmos5l_fill_1
XANTENNA__0628__CLK Tile_X0Y1_UserCLK VPWR VGND sg13cmos5l_antennanp
XANTENNA__1194__A0 Tile_X0Y1_N1END[3] VPWR VGND sg13cmos5l_antennanp
X_0630_ NPU_ACT_ADDR4 Tile_X0Y1_UserCLK _0977_/X _0687_/L_HI VPWR VGND sg13cmos5l_dfrbpq_1
X_0561_ _0561_/Q Tile_X0Y1_FrameData[9] VGND VPWR Tile_X0Y1_FrameStrobe[6] latch
X_0492_ _0492_/Q Tile_X0Y1_FrameData[14] VGND VPWR Tile_X0Y1_FrameStrobe[4] latch
XANTENNA__0957__X Tile_X0Y1_WW4BEG[0] VPWR VGND sg13cmos5l_antennanp
X_1044_ _1044_/X Tile_X0Y0_EE4END[12] _0641_/Q _1094_/X _1097_/X _0240_/Q _0239_/Q
+ VPWR VGND sg13cmos5l_mux4_1
X_1113_ _1113_/X Tile_X0Y1_E1END[2] Tile_X0Y1_E6END[6] _1217_/X _1193_/X _0598_/Q
+ _0597_/Q VPWR VGND sg13cmos5l_mux4_1
XFILLER_80_114 VPWR VGND sg13cmos5l_decap_4
XANTENNA__0555__D Tile_X0Y1_FrameData[15] VPWR VGND sg13cmos5l_antennanp
XFILLER_0_95 VPWR VGND sg13cmos5l_fill_1
XANTENNA__0290__D Tile_X0Y0_FrameData[26] VPWR VGND sg13cmos5l_antennanp
X_0828_ Tile_X0Y1_FrameData_O[4] Tile_X0Y1_FrameData[4] VPWR VGND sg13cmos5l_buf_1
X_0759_ Tile_X0Y0_N4BEG[8] _0759_/A VPWR VGND sg13cmos5l_buf_1
XANTENNA__0867__X Tile_X0Y0_FrameData_O[11] VPWR VGND sg13cmos5l_antennanp
XANTENNA__0465__D Tile_X0Y1_FrameData[9] VPWR VGND sg13cmos5l_antennanp
XANTENNA__0999__A0 Tile_X0Y0_E1END[0] VPWR VGND sg13cmos5l_antennanp
XFILLER_44_57 VPWR VGND sg13cmos5l_fill_2
XFILLER_60_78 VPWR VGND sg13cmos5l_decap_8
XFILLER_69_87 VPWR VGND sg13cmos5l_fill_2
XANTENNA__0353__GATE Tile_X0Y1_FrameStrobe[0] VPWR VGND sg13cmos5l_antennanp
XANTENNA__0368__GATE Tile_X0Y1_FrameStrobe[0] VPWR VGND sg13cmos5l_antennanp
XANTENNA__0777__X Tile_X0Y0_WW4BEG[10] VPWR VGND sg13cmos5l_antennanp
XFILLER_47_111 VPWR VGND sg13cmos5l_fill_1
XANTENNA__0375__D Tile_X0Y1_FrameData[3] VPWR VGND sg13cmos5l_antennanp
XANTENNA__0306__GATE Tile_X0Y1_FrameStrobe[6] VPWR VGND sg13cmos5l_antennanp
X_0613_ NPU_WEIGHT_IN3 Tile_X0Y1_UserCLK _0993_/X _0694_/L_HI VPWR VGND sg13cmos5l_dfrbpq_1
X_0544_ _0544_/Q Tile_X0Y1_FrameData[26] VGND VPWR Tile_X0Y1_FrameStrobe[6] latch
X_0475_ _0475_/Q Tile_X0Y1_FrameData[31] VGND VPWR Tile_X0Y1_FrameStrobe[4] latch
XANTENNA__0285__D Tile_X0Y0_FrameData[31] VPWR VGND sg13cmos5l_antennanp
XANTENNA__0863__A Tile_X0Y0_FrameData[7] VPWR VGND sg13cmos5l_antennanp
XFILLER_38_122 VPWR VGND sg13cmos5l_fill_1
X_1027_ _1027_/X _1111_/X Tile_X0Y0_S1END[0] _0638_/Q _0643_/Q _0274_/Q _0273_/Q VPWR
+ VGND sg13cmos5l_mux4_1
XANTENNA__1158__A0 Tile_X0Y1_EE4END[5] VPWR VGND sg13cmos5l_antennanp
XANTENNA__0195__D Tile_X0Y0_FrameData[25] VPWR VGND sg13cmos5l_antennanp
XFILLER_44_158 VPWR VGND sg13cmos5l_fill_2
XFILLER_71_66 VPWR VGND sg13cmos5l_decap_8
XANTENNA__0292__GATE Tile_X0Y1_FrameStrobe[6] VPWR VGND sg13cmos5l_antennanp
XANTENNA__1149__A0 Tile_X0Y1_E2END[2] VPWR VGND sg13cmos5l_antennanp
X_0260_ _0260_/Q Tile_X0Y0_FrameData[24] VGND VPWR Tile_X0Y1_FrameStrobe[5] latch
XFILLER_35_169 VPWR VGND sg13cmos5l_fill_2
X_0191_ _0191_/Q Tile_X0Y0_FrameData[29] VGND VPWR Tile_X0Y1_FrameStrobe[3] latch
XANTENNA__0230__GATE Tile_X0Y1_FrameStrobe[4] VPWR VGND sg13cmos5l_antennanp
XANTENNA__0245__GATE Tile_X0Y1_FrameStrobe[4] VPWR VGND sg13cmos5l_antennanp
XANTENNA__0970__X Tile_X0Y1_WW4BEG[13] VPWR VGND sg13cmos5l_antennanp
XFILLER_77_2 VPWR VGND sg13cmos5l_fill_1
XFILLER_6_72 VPWR VGND sg13cmos5l_fill_2
XANTENNA__0858__A Tile_X0Y0_FrameData[2] VPWR VGND sg13cmos5l_antennanp
X_0527_ _0527_/Q Tile_X0Y1_FrameData[11] VGND VPWR Tile_X0Y1_FrameStrobe[5] latch
X_0458_ _0458_/Q Tile_X0Y1_FrameData[16] VGND VPWR Tile_X0Y1_FrameStrobe[3] latch
X_0389_ _0389_/Q Tile_X0Y1_FrameData[21] VGND VPWR Tile_X0Y1_FrameStrobe[1] latch
XFILLER_25_48 VPWR VGND sg13cmos5l_decap_4
XANTENNA__0880__X Tile_X0Y0_FrameData_O[24] VPWR VGND sg13cmos5l_antennanp
XANTENNA__1091__A2 Tile_X0Y0_S1END[3] VPWR VGND sg13cmos5l_antennanp
XFILLER_66_11 VPWR VGND sg13cmos5l_fill_1
XFILLER_17_158 VPWR VGND sg13cmos5l_fill_2
XFILLER_66_77 VPWR VGND sg13cmos5l_decap_8
XANTENNA__0790__X Tile_X0Y0_N2BEGb[7] VPWR VGND sg13cmos5l_antennanp
XANTENNA__1082__A2 Tile_X0Y0_S1END[1] VPWR VGND sg13cmos5l_antennanp
XFILLER_99_128 VPWR VGND sg13cmos5l_decap_8
XANTENNA__0965__X Tile_X0Y1_WW4BEG[8] VPWR VGND sg13cmos5l_antennanp
X_0312_ _0312_/Q Tile_X0Y0_FrameData[4] VGND VPWR Tile_X0Y1_FrameStrobe[6] latch
X_0243_ _0243_/Q Tile_X0Y0_FrameData[9] VGND VPWR Tile_X0Y1_FrameStrobe[4] latch
XANTENNA__0563__D Tile_X0Y1_FrameData[7] VPWR VGND sg13cmos5l_antennanp
X_0174_ _0174_/Q Tile_X0Y0_FrameData[14] VGND VPWR Tile_X0Y1_FrameStrobe[2] latch
XANTENNA__0184__GATE Tile_X0Y1_FrameStrobe[2] VPWR VGND sg13cmos5l_antennanp
XFILLER_82_0 VPWR VGND sg13cmos5l_fill_2
XANTENNA__0122__GATE Tile_X0Y1_FrameStrobe[0] VPWR VGND sg13cmos5l_antennanp
XANTENNA__0199__GATE Tile_X0Y1_FrameStrobe[3] VPWR VGND sg13cmos5l_antennanp
XFILLER_98_161 VPWR VGND sg13cmos5l_fill_2
XANTENNA__0137__GATE Tile_X0Y1_FrameStrobe[1] VPWR VGND sg13cmos5l_antennanp
XANTENNA__0875__X Tile_X0Y0_FrameData_O[19] VPWR VGND sg13cmos5l_antennanp
XFILLER_100_144 VPWR VGND sg13cmos5l_fill_1
XANTENNA__0473__D Tile_X0Y1_FrameData[1] VPWR VGND sg13cmos5l_antennanp
XANTENNA__0648__D NPU_ACT_RDATA4 VPWR VGND sg13cmos5l_antennanp
XANTENNA__0785__X Tile_X0Y0_N2BEGb[2] VPWR VGND sg13cmos5l_antennanp
XFILLER_77_87 VPWR VGND sg13cmos5l_fill_2
XFILLER_93_86 VPWR VGND sg13cmos5l_fill_1
XANTENNA__0383__D Tile_X0Y1_FrameData[27] VPWR VGND sg13cmos5l_antennanp
XFILLER_13_161 VPWR VGND sg13cmos5l_fill_2
X_0861_ Tile_X0Y0_FrameData_O[5] Tile_X0Y0_FrameData[5] VPWR VGND sg13cmos5l_buf_1
X_0930_ Tile_X0Y1_W2BEG[1] _1148_/X VPWR VGND sg13cmos5l_buf_1
X_0792_ Tile_X0Y0_N2BEG[1] _1004_/X VPWR VGND sg13cmos5l_buf_1
XANTENNA__0558__D Tile_X0Y1_FrameData[12] VPWR VGND sg13cmos5l_antennanp
XFILLER_3_51 VPWR VGND sg13cmos5l_fill_1
X_0226_ _0226_/Q Tile_X0Y0_FrameData[26] VGND VPWR Tile_X0Y1_FrameStrobe[4] latch
XANTENNA__0293__D Tile_X0Y0_FrameData[23] VPWR VGND sg13cmos5l_antennanp
XANTENNA__0871__A Tile_X0Y0_FrameData[15] VPWR VGND sg13cmos5l_antennanp
X_0157_ _0157_/Q Tile_X0Y0_FrameData[31] VGND VPWR Tile_X0Y1_FrameStrobe[2] latch
X_0088_ _0093_/D _0998_/X _0609_/Q VPWR VGND sg13cmos5l_or2_1
XANTENNA__0468__D Tile_X0Y1_FrameData[6] VPWR VGND sg13cmos5l_antennanp
XFILLER_86_164 VPWR VGND sg13cmos5l_fill_2
XFILLER_103_63 VPWR VGND sg13cmos5l_fill_1
XFILLER_10_164 VPWR VGND sg13cmos5l_fill_2
XFILLER_6_102 VPWR VGND sg13cmos5l_decap_8
XFILLER_12_60 VPWR VGND sg13cmos5l_fill_2
XFILLER_6_168 VPWR VGND sg13cmos5l_fill_2
XANTENNA__0378__D Tile_X0Y1_FrameData[0] VPWR VGND sg13cmos5l_antennanp
X_1060_ _1060_/X _0637_/Q _0641_/Q _1090_/X _1094_/X _0208_/Q _0207_/Q VPWR VGND sg13cmos5l_mux4_1
XFILLER_92_178 VPWR VGND sg13cmos5l_fill_2
XFILLER_108_19 VPWR VGND sg13cmos5l_decap_8
X_0913_ Tile_X0Y1_S4BEG[5] Tile_X0Y0_S4END[13] VPWR VGND sg13cmos5l_buf_1
X_0844_ Tile_X0Y1_FrameData_O[20] Tile_X0Y1_FrameData[20] VPWR VGND sg13cmos5l_buf_1
X_0775_ Tile_X0Y0_WW4BEG[8] _1055_/X VPWR VGND sg13cmos5l_buf_1
XANTENNA__0288__D Tile_X0Y0_FrameData[28] VPWR VGND sg13cmos5l_antennanp
XFILLER_45_0 VPWR VGND sg13cmos5l_decap_8
XANTENNA__0866__A Tile_X0Y0_FrameData[10] VPWR VGND sg13cmos5l_antennanp
X_1189_ _1189_/X _0646_/Q _1204_/X _1208_/X _1201_/X _0438_/Q _0437_/Q VPWR VGND sg13cmos5l_mux4_1
X_0209_ _0209_/Q Tile_X0Y0_FrameData[11] VGND VPWR Tile_X0Y1_FrameStrobe[3] latch
XFILLER_83_178 VPWR VGND sg13cmos5l_fill_2
XANTENNA__1019__A2 Tile_X0Y0_E6END[4] VPWR VGND sg13cmos5l_antennanp
XFILLER_3_149 VPWR VGND sg13cmos5l_fill_2
XANTENNA__0198__D Tile_X0Y0_FrameData[22] VPWR VGND sg13cmos5l_antennanp
XFILLER_114_95 VPWR VGND sg13cmos5l_fill_1
XFILLER_74_178 VPWR VGND sg13cmos5l_fill_2
XANTENNA__0583__GATE Tile_X0Y1_FrameStrobe[7] VPWR VGND sg13cmos5l_antennanp
XFILLER_99_30 VPWR VGND sg13cmos5l_fill_2
XANTENNA__0521__GATE Tile_X0Y1_FrameStrobe[5] VPWR VGND sg13cmos5l_antennanp
XANTENNA__0598__GATE Tile_X0Y1_FrameStrobe[7] VPWR VGND sg13cmos5l_antennanp
XANTENNA__1194__A1 Tile_X0Y1_E6END[3] VPWR VGND sg13cmos5l_antennanp
X_0560_ _0560_/Q Tile_X0Y1_FrameData[10] VGND VPWR Tile_X0Y1_FrameStrobe[6] latch
X_0491_ _0491_/Q Tile_X0Y1_FrameData[15] VGND VPWR Tile_X0Y1_FrameStrobe[4] latch
XANTENNA__0536__GATE Tile_X0Y1_FrameStrobe[5] VPWR VGND sg13cmos5l_antennanp
XFILLER_0_63 VPWR VGND sg13cmos5l_fill_2
XFILLER_17_4 VPWR VGND sg13cmos5l_fill_1
XFILLER_65_101 VPWR VGND sg13cmos5l_decap_8
XFILLER_65_178 VPWR VGND sg13cmos5l_fill_2
X_1043_ _1043_/X Tile_X0Y0_EE4END[11] _0640_/Q _1095_/X _1096_/X _0242_/Q _0241_/Q
+ VPWR VGND sg13cmos5l_mux4_1
X_1112_ _1112_/X Tile_X0Y1_E1END[1] Tile_X0Y1_E6END[5] _1216_/X _1192_/X _0600_/Q
+ _0599_/Q VPWR VGND sg13cmos5l_mux4_1
XANTENNA__0571__D Tile_X0Y1_FrameData[31] VPWR VGND sg13cmos5l_antennanp
X_0827_ Tile_X0Y1_FrameData_O[3] Tile_X0Y1_FrameData[3] VPWR VGND sg13cmos5l_buf_1
X_0758_ Tile_X0Y0_N4BEG[7] Tile_X0Y1_N4END[15] VPWR VGND sg13cmos5l_buf_1
X_0689_ _0689_/L_HI VPWR VGND sg13cmos5l_tiehi
XANTENNA__0883__X Tile_X0Y0_FrameData_O[27] VPWR VGND sg13cmos5l_antennanp
XANTENNA__0999__A1 Tile_X0Y0_E6END[4] VPWR VGND sg13cmos5l_antennanp
XFILLER_100_31 VPWR VGND sg13cmos5l_decap_4
XFILLER_44_36 VPWR VGND sg13cmos5l_decap_8
XANTENNA__0481__D Tile_X0Y1_FrameData[25] VPWR VGND sg13cmos5l_antennanp
XFILLER_100_75 VPWR VGND sg13cmos5l_fill_2
XFILLER_107_2 VPWR VGND sg13cmos5l_fill_1
XANTENNA__0793__X Tile_X0Y0_N2BEG[2] VPWR VGND sg13cmos5l_antennanp
XANTENNA__0391__D Tile_X0Y1_FrameData[19] VPWR VGND sg13cmos5l_antennanp
XANTENNA__1100__A1 Tile_X0Y0_E6END[0] VPWR VGND sg13cmos5l_antennanp
XANTENNA__0968__X Tile_X0Y1_WW4BEG[11] VPWR VGND sg13cmos5l_antennanp
X_0612_ NPU_WEIGHT_IN2 Tile_X0Y1_UserCLK _0992_/X _0695_/L_HI VPWR VGND sg13cmos5l_dfrbpq_1
XANTENNA__0460__GATE Tile_X0Y1_FrameStrobe[3] VPWR VGND sg13cmos5l_antennanp
XFILLER_22_2 VPWR VGND sg13cmos5l_fill_1
X_0543_ _0543_/Q Tile_X0Y1_FrameData[27] VGND VPWR Tile_X0Y1_FrameStrobe[6] latch
X_0474_ _0474_/Q Tile_X0Y1_FrameData[0] VGND VPWR Tile_X0Y1_FrameStrobe[3] latch
XANTENNA__0475__GATE Tile_X0Y1_FrameStrobe[4] VPWR VGND sg13cmos5l_antennanp
XANTENNA__0566__D Tile_X0Y1_FrameData[4] VPWR VGND sg13cmos5l_antennanp
XFILLER_38_178 VPWR VGND sg13cmos5l_fill_2
X_1026_ _1026_/X _1084_/X _1080_/X _1079_/X _1099_/X _0277_/Q _0276_/Q VPWR VGND sg13cmos5l_mux4_1
XANTENNA__0413__GATE Tile_X0Y1_FrameStrobe[2] VPWR VGND sg13cmos5l_antennanp
XANTENNA__0428__GATE Tile_X0Y1_FrameStrobe[2] VPWR VGND sg13cmos5l_antennanp
XANTENNA__0878__X Tile_X0Y0_FrameData_O[22] VPWR VGND sg13cmos5l_antennanp
XANTENNA__0476__D Tile_X0Y1_FrameData[30] VPWR VGND sg13cmos5l_antennanp
XFILLER_29_134 VPWR VGND sg13cmos5l_fill_2
XFILLER_55_13 VPWR VGND sg13cmos5l_fill_1
XANTENNA__0618__CLK Tile_X0Y1_UserCLK VPWR VGND sg13cmos5l_antennanp
XFILLER_111_30 VPWR VGND sg13cmos5l_fill_2
XFILLER_112_0 VPWR VGND sg13cmos5l_fill_1
XANTENNA__0788__X Tile_X0Y0_N2BEGb[5] VPWR VGND sg13cmos5l_antennanp
XANTENNA__0386__D Tile_X0Y1_FrameData[24] VPWR VGND sg13cmos5l_antennanp
X_0190_ _0190_/Q Tile_X0Y0_FrameData[30] VGND VPWR Tile_X0Y1_FrameStrobe[3] latch
XFILLER_6_95 VPWR VGND sg13cmos5l_decap_8
X_0526_ _0526_/Q Tile_X0Y1_FrameData[12] VGND VPWR Tile_X0Y1_FrameStrobe[5] latch
XANTENNA__0296__D Tile_X0Y0_FrameData[20] VPWR VGND sg13cmos5l_antennanp
XANTENNA__0874__A Tile_X0Y0_FrameData[18] VPWR VGND sg13cmos5l_antennanp
XFILLER_26_137 VPWR VGND sg13cmos5l_fill_2
X_0457_ _0457_/Q Tile_X0Y1_FrameData[17] VGND VPWR Tile_X0Y1_FrameStrobe[3] latch
X_0388_ _0388_/Q Tile_X0Y1_FrameData[22] VGND VPWR Tile_X0Y1_FrameStrobe[1] latch
XANTENNA__0352__GATE Tile_X0Y1_FrameStrobe[0] VPWR VGND sg13cmos5l_antennanp
XANTENNA__1091__A3 Tile_X0Y0_S4END[3] VPWR VGND sg13cmos5l_antennanp
X_1009_ _1009_/X Tile_X0Y0_E2MID[1] Tile_X0Y0_E2END[1] Tile_X0Y0_E6END[1] _1098_/X
+ _0326_/Q _0325_/Q VPWR VGND sg13cmos5l_mux4_1
XANTENNA__0367__GATE Tile_X0Y1_FrameStrobe[0] VPWR VGND sg13cmos5l_antennanp
XANTENNA__1000__A0 Tile_X0Y0_E1END[1] VPWR VGND sg13cmos5l_antennanp
XFILLER_106_30 VPWR VGND sg13cmos5l_decap_8
XANTENNA__0305__GATE Tile_X0Y1_FrameStrobe[6] VPWR VGND sg13cmos5l_antennanp
XFILLER_82_66 VPWR VGND sg13cmos5l_fill_1
XANTENNA__1082__A3 Tile_X0Y0_S4END[1] VPWR VGND sg13cmos5l_antennanp
XFILLER_15_60 VPWR VGND sg13cmos5l_decap_4
XFILLER_31_92 VPWR VGND sg13cmos5l_fill_1
X_0311_ _0311_/Q Tile_X0Y0_FrameData[5] VGND VPWR Tile_X0Y1_FrameStrobe[6] latch
X_0242_ _0242_/Q Tile_X0Y0_FrameData[10] VGND VPWR Tile_X0Y1_FrameStrobe[4] latch
X_0173_ _0173_/Q Tile_X0Y0_FrameData[15] VGND VPWR Tile_X0Y1_FrameStrobe[2] latch
XFILLER_23_129 VPWR VGND sg13cmos5l_decap_8
XANTENNA__1230__A0 Tile_X0Y0_E1END[3] VPWR VGND sg13cmos5l_antennanp
XFILLER_75_0 VPWR VGND sg13cmos5l_decap_4
XANTENNA__0869__A Tile_X0Y0_FrameData[13] VPWR VGND sg13cmos5l_antennanp
X_0509_ _0509_/Q Tile_X0Y1_FrameData[29] VGND VPWR Tile_X0Y1_FrameStrobe[5] latch
XANTENNA__0291__GATE Tile_X0Y1_FrameStrobe[6] VPWR VGND sg13cmos5l_antennanp
XANTENNA__0891__X Tile_X0Y1_S1BEG[3] VPWR VGND sg13cmos5l_antennanp
XANTENNA__1221__A0 Tile_X0Y0_E2MID[5] VPWR VGND sg13cmos5l_antennanp
XANTENNA__0244__GATE Tile_X0Y1_FrameStrobe[4] VPWR VGND sg13cmos5l_antennanp
XANTENNA__0259__GATE Tile_X0Y1_FrameStrobe[5] VPWR VGND sg13cmos5l_antennanp
XANTENNA__1212__A0 Tile_X0Y1_N1END[1] VPWR VGND sg13cmos5l_antennanp
X_0860_ Tile_X0Y0_FrameData_O[4] Tile_X0Y0_FrameData[4] VPWR VGND sg13cmos5l_buf_1
X_0791_ Tile_X0Y0_N2BEG[0] _1003_/X VPWR VGND sg13cmos5l_buf_1
XFILLER_9_111 VPWR VGND sg13cmos5l_fill_1
XFILLER_47_4 VPWR VGND sg13cmos5l_fill_2
XANTENNA__0574__D Tile_X0Y1_FrameData[28] VPWR VGND sg13cmos5l_antennanp
XFILLER_3_96 VPWR VGND sg13cmos5l_decap_8
X_0225_ _0225_/Q Tile_X0Y0_FrameData[27] VGND VPWR Tile_X0Y1_FrameStrobe[4] latch
X_0156_ _0156_/Q Tile_X0Y0_FrameData[0] VGND VPWR Tile_X0Y1_FrameStrobe[1] latch
XFILLER_95_143 VPWR VGND sg13cmos5l_decap_4
XFILLER_22_39 VPWR VGND sg13cmos5l_decap_8
X_0087_ _0089_/D _0604_/Q _1235_/X VPWR VGND sg13cmos5l_nor2b_1
XANTENNA__1203__A0 Tile_X0Y1_N1END[0] VPWR VGND sg13cmos5l_antennanp
X_0989_ _0989_/X Tile_X0Y1_EE4END[7] Tile_X0Y1_EE4END[15] Tile_X0Y1_E6END[7] _1210_/X
+ _0420_/Q _0419_/Q VPWR VGND sg13cmos5l_mux4_1
XANTENNA__0886__X Tile_X0Y0_FrameData_O[30] VPWR VGND sg13cmos5l_antennanp
XFILLER_47_69 VPWR VGND sg13cmos5l_decap_4
XANTENNA__0484__D Tile_X0Y1_FrameData[22] VPWR VGND sg13cmos5l_antennanp
XANTENNA__0796__X Tile_X0Y0_N2BEG[5] VPWR VGND sg13cmos5l_antennanp
XFILLER_5_0 VPWR VGND sg13cmos5l_fill_2
XFILLER_88_65 VPWR VGND sg13cmos5l_fill_2
XANTENNA__0183__GATE Tile_X0Y1_FrameStrobe[2] VPWR VGND sg13cmos5l_antennanp
XFILLER_26_9 VPWR VGND sg13cmos5l_fill_1
XFILLER_37_91 VPWR VGND sg13cmos5l_decap_4
XANTENNA__0121__GATE Tile_X0Y1_FrameStrobe[0] VPWR VGND sg13cmos5l_antennanp
XANTENNA__0198__GATE Tile_X0Y1_FrameStrobe[3] VPWR VGND sg13cmos5l_antennanp
XANTENNA__0394__D Tile_X0Y1_FrameData[16] VPWR VGND sg13cmos5l_antennanp
X_0912_ Tile_X0Y1_S4BEG[4] Tile_X0Y0_S4END[12] VPWR VGND sg13cmos5l_buf_1
XANTENNA__0136__GATE Tile_X0Y1_FrameStrobe[1] VPWR VGND sg13cmos5l_antennanp
XANTENNA__1200__A3 Tile_X0Y0_S2MID[5] VPWR VGND sg13cmos5l_antennanp
X_0843_ Tile_X0Y1_FrameData_O[19] Tile_X0Y1_FrameData[19] VPWR VGND sg13cmos5l_buf_1
X_0774_ Tile_X0Y0_WW4BEG[7] _1054_/X VPWR VGND sg13cmos5l_buf_1
XANTENNA__0569__D Tile_X0Y1_FrameData[1] VPWR VGND sg13cmos5l_antennanp
XFILLER_38_0 VPWR VGND sg13cmos5l_fill_2
XFILLER_68_110 VPWR VGND sg13cmos5l_fill_2
XFILLER_68_121 VPWR VGND sg13cmos5l_fill_1
XANTENNA__0882__A Tile_X0Y0_FrameData[26] VPWR VGND sg13cmos5l_antennanp
X_1188_ _1188_/X _0645_/Q _1205_/X _1209_/X _1200_/X _0440_/Q _0439_/Q VPWR VGND sg13cmos5l_mux4_1
X_0208_ _0208_/Q Tile_X0Y0_FrameData[12] VGND VPWR Tile_X0Y1_FrameStrobe[3] latch
X_0139_ _0139_/Q Tile_X0Y0_FrameData[17] VGND VPWR Tile_X0Y1_FrameStrobe[1] latch
XANTENNA__0651__CLK Tile_X0Y1_UserCLK VPWR VGND sg13cmos5l_antennanp
XANTENNA__0479__D Tile_X0Y1_FrameData[27] VPWR VGND sg13cmos5l_antennanp
XFILLER_3_128 VPWR VGND sg13cmos5l_fill_1
XFILLER_74_124 VPWR VGND sg13cmos5l_decap_4
XFILLER_90_33 VPWR VGND sg13cmos5l_decap_8
XFILLER_23_60 VPWR VGND sg13cmos5l_fill_2
XFILLER_99_64 VPWR VGND sg13cmos5l_fill_1
XANTENNA__0389__D Tile_X0Y1_FrameData[21] VPWR VGND sg13cmos5l_antennanp
X_0490_ _0490_/Q Tile_X0Y1_FrameData[16] VGND VPWR Tile_X0Y1_FrameStrobe[4] latch
X_1042_ _1042_/X Tile_X0Y0_EE4END[10] _0639_/Q _1095_/X _1096_/X _0244_/Q _0243_/Q
+ VPWR VGND sg13cmos5l_mux4_1
X_1111_ _1111_/X Tile_X0Y1_E1END[0] Tile_X0Y1_E6END[4] _1215_/X _1191_/X _0602_/Q
+ _0601_/Q VPWR VGND sg13cmos5l_mux4_1
XFILLER_80_127 VPWR VGND sg13cmos5l_decap_8
XFILLER_9_73 VPWR VGND sg13cmos5l_decap_8
XANTENNA__0299__D Tile_X0Y0_FrameData[17] VPWR VGND sg13cmos5l_antennanp
XANTENNA__0877__A Tile_X0Y0_FrameData[21] VPWR VGND sg13cmos5l_antennanp
X_0826_ Tile_X0Y1_FrameData_O[2] Tile_X0Y1_FrameData[2] VPWR VGND sg13cmos5l_buf_1
X_0757_ Tile_X0Y0_N4BEG[6] Tile_X0Y1_N4END[14] VPWR VGND sg13cmos5l_buf_1
X_0688_ _0688_/L_HI VPWR VGND sg13cmos5l_tiehi
XFILLER_109_30 VPWR VGND sg13cmos5l_decap_8
XFILLER_60_69 VPWR VGND sg13cmos5l_decap_4
XFILLER_85_33 VPWR VGND sg13cmos5l_fill_1
XANTENNA__1100__A2 Tile_X0Y0_S1END[0] VPWR VGND sg13cmos5l_antennanp
X_0611_ NPU_WEIGHT_IN1 Tile_X0Y1_UserCLK _0991_/X _0696_/L_HI VPWR VGND sg13cmos5l_dfrbpq_1
X_0542_ _0542_/Q Tile_X0Y1_FrameData[28] VGND VPWR Tile_X0Y1_FrameStrobe[6] latch
XFILLER_38_113 VPWR VGND sg13cmos5l_decap_8
X_0473_ _0473_/Q Tile_X0Y1_FrameData[1] VGND VPWR Tile_X0Y1_FrameStrobe[3] latch
XANTENNA__0582__D Tile_X0Y1_FrameData[20] VPWR VGND sg13cmos5l_antennanp
XFILLER_61_160 VPWR VGND sg13cmos5l_fill_1
X_1025_ _1025_/X Tile_X0Y0_E1END[3] Tile_X0Y0_EE4END[15] Tile_X0Y0_E6END[7] _1091_/X
+ _0277_/Q _0276_/Q VPWR VGND sg13cmos5l_mux4_1
X_0809_ Tile_X0Y0_FrameStrobe_O[6] Tile_X0Y1_FrameStrobe[6] VPWR VGND sg13cmos5l_buf_1
XFILLER_39_26 VPWR VGND sg13cmos5l_decap_8
XANTENNA__0582__GATE Tile_X0Y1_FrameStrobe[7] VPWR VGND sg13cmos5l_antennanp
XANTENNA__0894__X Tile_X0Y1_S2BEG[2] VPWR VGND sg13cmos5l_antennanp
XFILLER_29_179 VPWR VGND sg13cmos5l_fill_1
XANTENNA__0492__D Tile_X0Y1_FrameData[14] VPWR VGND sg13cmos5l_antennanp
XANTENNA__0520__GATE Tile_X0Y1_FrameStrobe[5] VPWR VGND sg13cmos5l_antennanp
XANTENNA__0597__GATE Tile_X0Y1_FrameStrobe[7] VPWR VGND sg13cmos5l_antennanp
XANTENNA__1094__A1 Tile_X0Y1_N2MID[2] VPWR VGND sg13cmos5l_antennanp
XANTENNA__0535__GATE Tile_X0Y1_FrameStrobe[5] VPWR VGND sg13cmos5l_antennanp
XFILLER_105_0 VPWR VGND sg13cmos5l_fill_2
XANTENNA__1085__A1 Tile_X0Y1_N4END[6] VPWR VGND sg13cmos5l_antennanp
XFILLER_45_91 VPWR VGND sg13cmos5l_decap_8
XANTENNA_1 Tile_X0Y1_FrameStrobe[11] VPWR VGND sg13cmos5l_antennanp
XFILLER_112_154 VPWR VGND sg13cmos5l_fill_2
X_0525_ _0525_/Q Tile_X0Y1_FrameData[13] VGND VPWR Tile_X0Y1_FrameStrobe[5] latch
X_0456_ _0456_/Q Tile_X0Y1_FrameData[18] VGND VPWR Tile_X0Y1_FrameStrobe[3] latch
XANTENNA__0577__D Tile_X0Y1_FrameData[25] VPWR VGND sg13cmos5l_antennanp
XFILLER_20_0 VPWR VGND sg13cmos5l_fill_2
XFILLER_25_17 VPWR VGND sg13cmos5l_fill_1
X_0387_ _0387_/Q Tile_X0Y1_FrameData[23] VGND VPWR Tile_X0Y1_FrameStrobe[1] latch
XANTENNA__1076__A1 Tile_X0Y1_N4END[5] VPWR VGND sg13cmos5l_antennanp
X_1008_ _1008_/X Tile_X0Y0_E2MID[2] Tile_X0Y0_E2END[2] Tile_X0Y0_E6END[2] _1097_/X
+ _0328_/Q _0327_/Q VPWR VGND sg13cmos5l_mux4_1
XANTENNA__0889__X Tile_X0Y1_S1BEG[1] VPWR VGND sg13cmos5l_antennanp
XANTENNA__0487__D Tile_X0Y1_FrameData[19] VPWR VGND sg13cmos5l_antennanp
XANTENNA__1000__A1 Tile_X0Y0_E6END[5] VPWR VGND sg13cmos5l_antennanp
XFILLER_25_160 VPWR VGND sg13cmos5l_fill_1
XFILLER_82_78 VPWR VGND sg13cmos5l_decap_4
XFILLER_82_12 VPWR VGND sg13cmos5l_decap_4
XANTENNA__0474__GATE Tile_X0Y1_FrameStrobe[3] VPWR VGND sg13cmos5l_antennanp
XANTENNA__0489__GATE Tile_X0Y1_FrameStrobe[4] VPWR VGND sg13cmos5l_antennanp
XANTENNA__0799__X Tile_X0Y0_N1BEG[0] VPWR VGND sg13cmos5l_antennanp
X_0310_ _0310_/Q Tile_X0Y0_FrameData[6] VGND VPWR Tile_X0Y1_FrameStrobe[6] latch
XANTENNA__0397__D Tile_X0Y1_FrameData[13] VPWR VGND sg13cmos5l_antennanp
XANTENNA__0412__GATE Tile_X0Y1_FrameStrobe[2] VPWR VGND sg13cmos5l_antennanp
X_0241_ _0241_/Q Tile_X0Y0_FrameData[11] VGND VPWR Tile_X0Y1_FrameStrobe[4] latch
X_0172_ _0172_/Q Tile_X0Y0_FrameData[16] VGND VPWR Tile_X0Y1_FrameStrobe[2] latch
XANTENNA__0427__GATE Tile_X0Y1_FrameStrobe[2] VPWR VGND sg13cmos5l_antennanp
XANTENNA__1230__A1 Tile_X0Y0_E6END[11] VPWR VGND sg13cmos5l_antennanp
XANTENNA__0100__D Tile_X0Y0_FrameData[24] VPWR VGND sg13cmos5l_antennanp
XANTENNA__0885__A Tile_X0Y0_FrameData[29] VPWR VGND sg13cmos5l_antennanp
X_0508_ _0508_/Q Tile_X0Y1_FrameData[30] VGND VPWR Tile_X0Y1_FrameStrobe[5] latch
X_0439_ _0439_/Q Tile_X0Y1_FrameData[3] VGND VPWR Tile_X0Y1_FrameStrobe[2] latch
XANTENNA__0980__A0 Tile_X0Y0_E2MID[7] VPWR VGND sg13cmos5l_antennanp
XANTENNA__1221__A1 Tile_X0Y0_E2END[5] VPWR VGND sg13cmos5l_antennanp
XFILLER_77_45 VPWR VGND sg13cmos5l_fill_1
XFILLER_93_55 VPWR VGND sg13cmos5l_decap_8
XANTENNA__1212__A1 Tile_X0Y1_N4END[1] VPWR VGND sg13cmos5l_antennanp
XFILLER_42_81 VPWR VGND sg13cmos5l_decap_8
X_0790_ Tile_X0Y0_N2BEGb[7] _1110_/X VPWR VGND sg13cmos5l_buf_1
XANTENNA__0351__GATE Tile_X0Y1_FrameStrobe[0] VPWR VGND sg13cmos5l_antennanp
XFILLER_3_64 VPWR VGND sg13cmos5l_fill_1
XFILLER_3_86 VPWR VGND sg13cmos5l_fill_1
XANTENNA__0366__GATE Tile_X0Y1_FrameStrobe[0] VPWR VGND sg13cmos5l_antennanp
X_0224_ _0224_/Q Tile_X0Y0_FrameData[28] VGND VPWR Tile_X0Y1_FrameStrobe[4] latch
X_0155_ _0155_/Q Tile_X0Y0_FrameData[1] VGND VPWR Tile_X0Y1_FrameStrobe[1] latch
X_0086_ _0917_/A _1021_/X _1022_/X _0281_/Q VPWR VGND sg13cmos5l_mux2_1
XANTENNA__0590__D Tile_X0Y1_FrameData[12] VPWR VGND sg13cmos5l_antennanp
X_0988_ _0988_/X Tile_X0Y1_EE4END[6] Tile_X0Y1_EE4END[14] Tile_X0Y1_E6END[6] _1209_/X
+ _0422_/Q _0421_/Q VPWR VGND sg13cmos5l_mux4_1
XANTENNA__0304__GATE Tile_X0Y1_FrameStrobe[6] VPWR VGND sg13cmos5l_antennanp
XANTENNA__1203__A1 Tile_X0Y1_N4END[0] VPWR VGND sg13cmos5l_antennanp
XANTENNA__0319__GATE Tile_X0Y1_FrameStrobe[7] VPWR VGND sg13cmos5l_antennanp
XFILLER_86_133 VPWR VGND sg13cmos5l_decap_8
XFILLER_103_98 VPWR VGND sg13cmos5l_decap_4
XFILLER_12_62 VPWR VGND sg13cmos5l_fill_1
XFILLER_88_55 VPWR VGND sg13cmos5l_fill_2
XFILLER_77_133 VPWR VGND sg13cmos5l_fill_1
XANTENNA__1130__A0 Tile_X0Y1_E2MID[4] VPWR VGND sg13cmos5l_antennanp
XFILLER_92_147 VPWR VGND sg13cmos5l_fill_1
X_0911_ Tile_X0Y1_S4BEG[3] Tile_X0Y0_S4END[11] VPWR VGND sg13cmos5l_buf_1
X_0842_ Tile_X0Y1_FrameData_O[18] Tile_X0Y1_FrameData[18] VPWR VGND sg13cmos5l_buf_1
XANTENNA__1197__A0 Tile_X0Y1_N2MID[2] VPWR VGND sg13cmos5l_antennanp
X_0773_ Tile_X0Y0_WW4BEG[6] _1053_/X VPWR VGND sg13cmos5l_buf_1
XANTENNA__0290__GATE Tile_X0Y1_FrameStrobe[6] VPWR VGND sg13cmos5l_antennanp
XANTENNA__0585__D Tile_X0Y1_FrameData[17] VPWR VGND sg13cmos5l_antennanp
XANTENNA__1121__A0 Tile_X0Y1_E1END[0] VPWR VGND sg13cmos5l_antennanp
X_1187_ _1187_/X _0644_/Q _1206_/X _1210_/X _1199_/X _0442_/Q _0441_/Q VPWR VGND sg13cmos5l_mux4_1
X_0207_ _0207_/Q Tile_X0Y0_FrameData[13] VGND VPWR Tile_X0Y1_FrameStrobe[3] latch
X_0138_ _0138_/Q Tile_X0Y0_FrameData[18] VGND VPWR Tile_X0Y1_FrameStrobe[1] latch
X_0069_ _0919_/A _1025_/X _1026_/X _0275_/Q VPWR VGND sg13cmos5l_mux2_1
XFILLER_83_158 VPWR VGND sg13cmos5l_fill_1
XANTENNA__0243__GATE Tile_X0Y1_FrameStrobe[4] VPWR VGND sg13cmos5l_antennanp
XANTENNA__0258__GATE Tile_X0Y1_FrameStrobe[5] VPWR VGND sg13cmos5l_antennanp
XANTENNA__0897__X Tile_X0Y1_S2BEG[5] VPWR VGND sg13cmos5l_antennanp
XFILLER_58_14 VPWR VGND sg13cmos5l_fill_2
XANTENNA__0495__D Tile_X0Y1_FrameData[11] VPWR VGND sg13cmos5l_antennanp
XANTENNA__1112__A0 Tile_X0Y1_E1END[1] VPWR VGND sg13cmos5l_antennanp
XFILLER_114_42 VPWR VGND sg13cmos5l_fill_2
XANTENNA__1179__A0 Tile_X0Y1_N4END[0] VPWR VGND sg13cmos5l_antennanp
XFILLER_23_94 VPWR VGND sg13cmos5l_fill_2
XFILLER_48_91 VPWR VGND sg13cmos5l_decap_8
X_1110_ _1110_/X Tile_X0Y1_E2MID[0] Tile_X0Y1_E2END[0] Tile_X0Y1_E6END[0] _1202_/X
+ _0580_/Q _0579_/Q VPWR VGND sg13cmos5l_mux4_1
XANTENNA__1103__A0 Tile_X0Y1_E2MID[7] VPWR VGND sg13cmos5l_antennanp
X_1041_ _1041_/X Tile_X0Y0_EE4END[9] _0638_/Q _1094_/X _1097_/X _0246_/Q _0245_/Q
+ VPWR VGND sg13cmos5l_mux4_1
X_0825_ Tile_X0Y1_FrameData_O[1] Tile_X0Y1_FrameData[1] VPWR VGND sg13cmos5l_buf_1
XFILLER_9_41 VPWR VGND sg13cmos5l_decap_8
XFILLER_50_0 VPWR VGND sg13cmos5l_decap_4
X_0756_ Tile_X0Y0_N4BEG[5] Tile_X0Y1_N4END[13] VPWR VGND sg13cmos5l_buf_1
X_0687_ _0687_/L_HI VPWR VGND sg13cmos5l_tiehi
XFILLER_100_77 VPWR VGND sg13cmos5l_fill_1
XFILLER_60_26 VPWR VGND sg13cmos5l_decap_8
XANTENNA__0182__GATE Tile_X0Y1_FrameStrobe[2] VPWR VGND sg13cmos5l_antennanp
XANTENNA__0197__GATE Tile_X0Y1_FrameStrobe[3] VPWR VGND sg13cmos5l_antennanp
XFILLER_60_48 VPWR VGND sg13cmos5l_decap_8
XANTENNA__0120__GATE Tile_X0Y1_FrameStrobe[0] VPWR VGND sg13cmos5l_antennanp
XFILLER_85_23 VPWR VGND sg13cmos5l_fill_2
XANTENNA__0135__GATE Tile_X0Y1_FrameStrobe[1] VPWR VGND sg13cmos5l_antennanp
X_0610_ NPU_WEIGHT_IN0 Tile_X0Y1_UserCLK _0990_/X _0693_/L_HI VPWR VGND sg13cmos5l_dfrbpq_1
X_0541_ _0541_/Q Tile_X0Y1_FrameData[29] VGND VPWR Tile_X0Y1_FrameStrobe[6] latch
X_0472_ _0472_/Q Tile_X0Y1_FrameData[2] VGND VPWR Tile_X0Y1_FrameStrobe[3] latch
XANTENNA__0641__CLK Tile_X0Y1_UserCLK VPWR VGND sg13cmos5l_antennanp
X_1024_ _1024_/X _1085_/X _1081_/X _1077_/X _1098_/X _0280_/Q _0279_/Q VPWR VGND sg13cmos5l_mux4_1
XFILLER_30_29 VPWR VGND sg13cmos5l_decap_8
X_0808_ Tile_X0Y0_FrameStrobe_O[5] Tile_X0Y1_FrameStrobe[5] VPWR VGND sg13cmos5l_buf_1
XANTENNA__0103__D Tile_X0Y0_FrameData[21] VPWR VGND sg13cmos5l_antennanp
XFILLER_29_125 VPWR VGND sg13cmos5l_fill_2
XFILLER_39_16 VPWR VGND sg13cmos5l_fill_2
X_0739_ Tile_X0Y0_W6BEG[0] _1063_/X VPWR VGND sg13cmos5l_buf_1
XANTENNA__1094__A2 Tile_X0Y0_S2MID[2] VPWR VGND sg13cmos5l_antennanp
XFILLER_20_40 VPWR VGND sg13cmos5l_decap_8
XFILLER_20_73 VPWR VGND sg13cmos5l_decap_8
XFILLER_96_11 VPWR VGND sg13cmos5l_fill_2
XANTENNA__1085__A2 Tile_X0Y0_S1END[2] VPWR VGND sg13cmos5l_antennanp
XANTENNA_2 Tile_X0Y1_FrameStrobe[14] VPWR VGND sg13cmos5l_antennanp
XFILLER_112_111 VPWR VGND sg13cmos5l_fill_2
XFILLER_112_166 VPWR VGND sg13cmos5l_fill_2
X_0524_ _0524_/Q Tile_X0Y1_FrameData[14] VGND VPWR Tile_X0Y1_FrameStrobe[5] latch
X_0455_ _0455_/Q Tile_X0Y1_FrameData[19] VGND VPWR Tile_X0Y1_FrameStrobe[3] latch
XANTENNA__0593__D Tile_X0Y1_FrameData[9] VPWR VGND sg13cmos5l_antennanp
XANTENNA__1076__A2 Tile_X0Y0_S1END[1] VPWR VGND sg13cmos5l_antennanp
XFILLER_26_106 VPWR VGND sg13cmos5l_decap_4
XFILLER_34_161 VPWR VGND sg13cmos5l_fill_1
X_1007_ _1007_/X Tile_X0Y0_E2MID[3] Tile_X0Y0_E2END[3] Tile_X0Y0_E6END[3] _1096_/X
+ _0330_/Q _0329_/Q VPWR VGND sg13cmos5l_mux4_1
X_0386_ _0386_/Q Tile_X0Y1_FrameData[24] VGND VPWR Tile_X0Y1_FrameStrobe[1] latch
XFILLER_103_111 VPWR VGND sg13cmos5l_fill_2
XFILLER_103_122 VPWR VGND sg13cmos5l_fill_1
XFILLER_106_87 VPWR VGND sg13cmos5l_decap_8
XFILLER_106_98 VPWR VGND sg13cmos5l_fill_2
XFILLER_31_83 VPWR VGND sg13cmos5l_decap_8
X_0240_ _0240_/Q Tile_X0Y0_FrameData[12] VGND VPWR Tile_X0Y1_FrameStrobe[4] latch
X_0171_ _0171_/Q Tile_X0Y0_FrameData[17] VGND VPWR Tile_X0Y1_FrameStrobe[2] latch
XANTENNA__0581__GATE Tile_X0Y1_FrameStrobe[7] VPWR VGND sg13cmos5l_antennanp
XANTENNA__0596__GATE Tile_X0Y1_FrameStrobe[7] VPWR VGND sg13cmos5l_antennanp
XANTENNA__0588__D Tile_X0Y1_FrameData[14] VPWR VGND sg13cmos5l_antennanp
XFILLER_100_103 VPWR VGND sg13cmos5l_fill_1
XFILLER_100_169 VPWR VGND sg13cmos5l_fill_2
X_0507_ _0507_/Q Tile_X0Y1_FrameData[31] VGND VPWR Tile_X0Y1_FrameStrobe[5] latch
X_0438_ _0438_/Q Tile_X0Y1_FrameData[4] VGND VPWR Tile_X0Y1_FrameStrobe[2] latch
X_0369_ _0369_/Q Tile_X0Y1_FrameData[9] VGND VPWR Tile_X0Y1_FrameStrobe[0] latch
XANTENNA__0534__GATE Tile_X0Y1_FrameStrobe[5] VPWR VGND sg13cmos5l_antennanp
XANTENNA__0549__GATE Tile_X0Y1_FrameStrobe[6] VPWR VGND sg13cmos5l_antennanp
XANTENNA__1221__A2 Tile_X0Y0_E6END[10] VPWR VGND sg13cmos5l_antennanp
XANTENNA__0498__D Tile_X0Y1_FrameData[8] VPWR VGND sg13cmos5l_antennanp
XANTENNA__0980__A1 Tile_X0Y0_E2END[7] VPWR VGND sg13cmos5l_antennanp
XFILLER_89_142 VPWR VGND sg13cmos5l_fill_2
XFILLER_13_153 VPWR VGND sg13cmos5l_fill_1
XFILLER_26_83 VPWR VGND sg13cmos5l_decap_8
XANTENNA__0201__D Tile_X0Y0_FrameData[19] VPWR VGND sg13cmos5l_antennanp
X_0223_ _0223_/Q Tile_X0Y0_FrameData[29] VGND VPWR Tile_X0Y1_FrameStrobe[4] latch
X_0154_ _0154_/Q Tile_X0Y0_FrameData[2] VGND VPWR Tile_X0Y1_FrameStrobe[1] latch
X_0085_ _0765_/A _1015_/X _1016_/X _0314_/Q VPWR VGND sg13cmos5l_mux2_1
XFILLER_22_19 VPWR VGND sg13cmos5l_decap_4
X_0987_ _0987_/X Tile_X0Y1_EE4END[5] Tile_X0Y1_EE4END[13] Tile_X0Y1_E6END[5] _1208_/X
+ _0424_/Q _0423_/Q VPWR VGND sg13cmos5l_mux4_1
XANTENNA__0111__D Tile_X0Y0_FrameData[13] VPWR VGND sg13cmos5l_antennanp
XANTENNA__0473__GATE Tile_X0Y1_FrameStrobe[3] VPWR VGND sg13cmos5l_antennanp
XFILLER_47_16 VPWR VGND sg13cmos5l_decap_8
XFILLER_86_178 VPWR VGND sg13cmos5l_fill_2
XANTENNA__0488__GATE Tile_X0Y1_FrameStrobe[4] VPWR VGND sg13cmos5l_antennanp
XFILLER_10_101 VPWR VGND sg13cmos5l_fill_2
XANTENNA__0411__GATE Tile_X0Y1_FrameStrobe[2] VPWR VGND sg13cmos5l_antennanp
XFILLER_12_52 VPWR VGND sg13cmos5l_fill_1
XFILLER_88_45 VPWR VGND sg13cmos5l_fill_2
XANTENNA__0426__GATE Tile_X0Y1_FrameStrobe[2] VPWR VGND sg13cmos5l_antennanp
XFILLER_92_115 VPWR VGND sg13cmos5l_fill_2
XFILLER_88_78 VPWR VGND sg13cmos5l_decap_8
XANTENNA__1130__A1 Tile_X0Y1_E2END[4] VPWR VGND sg13cmos5l_antennanp
XFILLER_53_70 VPWR VGND sg13cmos5l_fill_2
XFILLER_53_92 VPWR VGND sg13cmos5l_decap_8
X_0910_ Tile_X0Y1_S4BEG[2] Tile_X0Y0_S4END[10] VPWR VGND sg13cmos5l_buf_1
X_0841_ Tile_X0Y1_FrameData_O[17] Tile_X0Y1_FrameData[17] VPWR VGND sg13cmos5l_buf_1
X_0772_ Tile_X0Y0_WW4BEG[5] _1052_/X VPWR VGND sg13cmos5l_buf_1
XANTENNA__1197__A1 Tile_X0Y1_N2END[2] VPWR VGND sg13cmos5l_antennanp
XFILLER_38_2 VPWR VGND sg13cmos5l_fill_1
XANTENNA__1121__A1 Tile_X0Y1_EE4END[0] VPWR VGND sg13cmos5l_antennanp
XFILLER_68_134 VPWR VGND sg13cmos5l_fill_2
X_1186_ _1186_/X _0651_/Q _1207_/X _1211_/X _1198_/X _0444_/Q _0443_/Q VPWR VGND sg13cmos5l_mux4_1
X_0206_ _0206_/Q Tile_X0Y0_FrameData[14] VGND VPWR Tile_X0Y1_FrameStrobe[3] latch
X_0137_ _0137_/Q Tile_X0Y0_FrameData[19] VGND VPWR Tile_X0Y1_FrameStrobe[1] latch
X_0068_ _0918_/A _1023_/X _1024_/X _0278_/Q VPWR VGND sg13cmos5l_mux2_1
XANTENNA__0106__D Tile_X0Y0_FrameData[18] VPWR VGND sg13cmos5l_antennanp
XFILLER_59_178 VPWR VGND sg13cmos5l_fill_2
XFILLER_74_104 VPWR VGND sg13cmos5l_decap_8
XANTENNA__1112__A1 Tile_X0Y1_E6END[5] VPWR VGND sg13cmos5l_antennanp
XFILLER_74_115 VPWR VGND sg13cmos5l_fill_2
XANTENNA__0350__GATE Tile_X0Y1_FrameStrobe[0] VPWR VGND sg13cmos5l_antennanp
XANTENNA__0365__GATE Tile_X0Y1_FrameStrobe[0] VPWR VGND sg13cmos5l_antennanp
XANTENNA__1179__A1 Tile_X0Y0_S4END[4] VPWR VGND sg13cmos5l_antennanp
XFILLER_2_163 VPWR VGND sg13cmos5l_fill_2
XFILLER_31_9 VPWR VGND sg13cmos5l_decap_4
XANTENNA__1103__A1 Tile_X0Y1_E2END[7] VPWR VGND sg13cmos5l_antennanp
X_1040_ _1040_/X Tile_X0Y0_EE4END[7] _0637_/Q _1093_/X _1098_/X _0248_/Q _0247_/Q
+ VPWR VGND sg13cmos5l_mux4_1
XANTENNA__0303__GATE Tile_X0Y1_FrameStrobe[6] VPWR VGND sg13cmos5l_antennanp
XFILLER_80_118 VPWR VGND sg13cmos5l_fill_2
XANTENNA__0318__GATE Tile_X0Y1_FrameStrobe[7] VPWR VGND sg13cmos5l_antennanp
X_0824_ Tile_X0Y1_FrameData_O[0] Tile_X0Y1_FrameData[0] VPWR VGND sg13cmos5l_buf_1
X_0755_ Tile_X0Y0_N4BEG[4] Tile_X0Y1_N4END[12] VPWR VGND sg13cmos5l_buf_1
XFILLER_9_64 VPWR VGND sg13cmos5l_fill_2
XANTENNA__0596__D Tile_X0Y1_FrameData[6] VPWR VGND sg13cmos5l_antennanp
XFILLER_43_0 VPWR VGND sg13cmos5l_decap_4
X_0686_ _0686_/L_HI VPWR VGND sg13cmos5l_tiehi
X_1169_ _1169_/X _0646_/Q _0650_/Q _1212_/X _1196_/X _0478_/Q _0477_/Q VPWR VGND sg13cmos5l_mux4_1
XANTENNA__1021__A0 Tile_X0Y0_E1END[1] VPWR VGND sg13cmos5l_antennanp
X_0540_ _0540_/Q Tile_X0Y1_FrameData[30] VGND VPWR Tile_X0Y1_FrameStrobe[6] latch
X_0471_ _0471_/Q Tile_X0Y1_FrameData[3] VGND VPWR Tile_X0Y1_FrameStrobe[3] latch
XANTENNA__0242__GATE Tile_X0Y1_FrameStrobe[4] VPWR VGND sg13cmos5l_antennanp
X_1023_ _1023_/X Tile_X0Y0_E1END[2] Tile_X0Y0_EE4END[14] Tile_X0Y0_E6END[6] _1090_/X
+ _0280_/Q _0279_/Q VPWR VGND sg13cmos5l_mux4_1
XANTENNA__0257__GATE Tile_X0Y1_FrameStrobe[5] VPWR VGND sg13cmos5l_antennanp
XFILLER_107_109 VPWR VGND sg13cmos5l_fill_2
X_0807_ Tile_X0Y0_FrameStrobe_O[4] Tile_X0Y1_FrameStrobe[4] VPWR VGND sg13cmos5l_buf_1
X_0738_ Tile_X0Y0_W2BEGb[7] _1046_/X VPWR VGND sg13cmos5l_buf_1
X_0669_ _0669_/L_HI VPWR VGND sg13cmos5l_tiehi
XANTENNA__1094__A3 Tile_X0Y0_S2END[2] VPWR VGND sg13cmos5l_antennanp
XFILLER_52_140 VPWR VGND sg13cmos5l_fill_1
XFILLER_71_15 VPWR VGND sg13cmos5l_decap_4
XANTENNA__1003__A0 Tile_X0Y0_E2MID[7] VPWR VGND sg13cmos5l_antennanp
XFILLER_105_2 VPWR VGND sg13cmos5l_fill_1
XANTENNA__1085__A3 Tile_X0Y0_S4END[2] VPWR VGND sg13cmos5l_antennanp
XFILLER_45_82 VPWR VGND sg13cmos5l_fill_2
XANTENNA_3 Tile_X0Y1_FrameStrobe[18] VPWR VGND sg13cmos5l_antennanp
XANTENNA__0204__D Tile_X0Y0_FrameData[16] VPWR VGND sg13cmos5l_antennanp
XANTENNA__0181__GATE Tile_X0Y1_FrameStrobe[2] VPWR VGND sg13cmos5l_antennanp
XFILLER_20_2 VPWR VGND sg13cmos5l_fill_1
X_0523_ _0523_/Q Tile_X0Y1_FrameData[15] VGND VPWR Tile_X0Y1_FrameStrobe[5] latch
X_0454_ _0454_/Q Tile_X0Y1_FrameData[20] VGND VPWR Tile_X0Y1_FrameStrobe[3] latch
X_0385_ _0385_/Q Tile_X0Y1_FrameData[25] VGND VPWR Tile_X0Y1_FrameStrobe[1] latch
XANTENNA__0196__GATE Tile_X0Y1_FrameStrobe[3] VPWR VGND sg13cmos5l_antennanp
XANTENNA__1076__A3 Tile_X0Y0_S4END[1] VPWR VGND sg13cmos5l_antennanp
XFILLER_19_170 VPWR VGND sg13cmos5l_fill_1
X_1006_ _1006_/X Tile_X0Y0_E2MID[4] Tile_X0Y0_E2END[4] Tile_X0Y0_E6END[4] _1095_/X
+ _0332_/Q _0331_/Q VPWR VGND sg13cmos5l_mux4_1
XANTENNA__1233__A0 Tile_X0Y0_EE4END[2] VPWR VGND sg13cmos5l_antennanp
XANTENNA__0114__D Tile_X0Y0_FrameData[10] VPWR VGND sg13cmos5l_antennanp
XANTENNA__0134__GATE Tile_X0Y1_FrameStrobe[1] VPWR VGND sg13cmos5l_antennanp
XFILLER_106_22 VPWR VGND sg13cmos5l_fill_1
XANTENNA__0149__GATE Tile_X0Y1_FrameStrobe[1] VPWR VGND sg13cmos5l_antennanp
XFILLER_17_129 VPWR VGND sg13cmos5l_fill_1
XANTENNA__0631__CLK Tile_X0Y1_UserCLK VPWR VGND sg13cmos5l_antennanp
XANTENNA__1224__A0 Tile_X0Y0_E1END[1] VPWR VGND sg13cmos5l_antennanp
XFILLER_110_0 VPWR VGND sg13cmos5l_decap_4
X_0170_ _0170_/Q Tile_X0Y0_FrameData[18] VGND VPWR Tile_X0Y1_FrameStrobe[2] latch
XANTENNA__1215__A0 Tile_X0Y1_N1END[0] VPWR VGND sg13cmos5l_antennanp
X_0506_ _0506_/Q Tile_X0Y1_FrameData[0] VGND VPWR Tile_X0Y1_FrameStrobe[4] latch
XFILLER_100_115 VPWR VGND sg13cmos5l_fill_1
X_0437_ _0437_/Q Tile_X0Y1_FrameData[5] VGND VPWR Tile_X0Y1_FrameStrobe[2] latch
X_0368_ _0368_/Q Tile_X0Y1_FrameData[10] VGND VPWR Tile_X0Y1_FrameStrobe[0] latch
XANTENNA__0109__D Tile_X0Y0_FrameData[15] VPWR VGND sg13cmos5l_antennanp
X_0299_ _0299_/Q Tile_X0Y0_FrameData[17] VGND VPWR Tile_X0Y1_FrameStrobe[6] latch
XANTENNA__1206__A0 Tile_X0Y1_N1END[3] VPWR VGND sg13cmos5l_antennanp
XFILLER_89_132 VPWR VGND sg13cmos5l_decap_4
XFILLER_93_79 VPWR VGND sg13cmos5l_decap_4
XANTENNA__1212__A3 Tile_X0Y0_S4END[5] VPWR VGND sg13cmos5l_antennanp
XFILLER_3_33 VPWR VGND sg13cmos5l_fill_1
X_0222_ _0222_/Q Tile_X0Y0_FrameData[30] VGND VPWR Tile_X0Y1_FrameStrobe[4] latch
X_0153_ _0153_/Q Tile_X0Y0_FrameData[3] VGND VPWR Tile_X0Y1_FrameStrobe[1] latch
XFILLER_95_179 VPWR VGND sg13cmos5l_fill_1
XANTENNA__0609__GATE Tile_X0Y1_FrameStrobe[8] VPWR VGND sg13cmos5l_antennanp
X_0084_ _0766_/A _1017_/X _1018_/X _0311_/Q VPWR VGND sg13cmos5l_mux2_1
XANTENNA__1203__A3 Tile_X0Y0_S4END[4] VPWR VGND sg13cmos5l_antennanp
XFILLER_73_0 VPWR VGND sg13cmos5l_fill_2
X_0986_ _0986_/X Tile_X0Y1_EE4END[4] Tile_X0Y1_EE4END[12] Tile_X0Y1_E6END[4] _1207_/X
+ _0426_/Q _0425_/Q VPWR VGND sg13cmos5l_mux4_1
XANTENNA__0599__D Tile_X0Y1_FrameData[3] VPWR VGND sg13cmos5l_antennanp
XFILLER_63_38 VPWR VGND sg13cmos5l_fill_2
XFILLER_10_157 VPWR VGND sg13cmos5l_fill_2
XANTENNA__0302__D Tile_X0Y0_FrameData[14] VPWR VGND sg13cmos5l_antennanp
XFILLER_88_57 VPWR VGND sg13cmos5l_fill_1
XANTENNA__0580__GATE Tile_X0Y1_FrameStrobe[7] VPWR VGND sg13cmos5l_antennanp
XFILLER_77_179 VPWR VGND sg13cmos5l_fill_1
XANTENNA__0595__GATE Tile_X0Y1_FrameStrobe[7] VPWR VGND sg13cmos5l_antennanp
XANTENNA__1130__A2 Tile_X0Y1_E6END[11] VPWR VGND sg13cmos5l_antennanp
X_0840_ Tile_X0Y1_FrameData_O[16] Tile_X0Y1_FrameData[16] VPWR VGND sg13cmos5l_buf_1
X_0771_ Tile_X0Y0_WW4BEG[4] _1051_/X VPWR VGND sg13cmos5l_buf_1
XANTENNA__0212__D Tile_X0Y0_FrameData[8] VPWR VGND sg13cmos5l_antennanp
XANTENNA__0533__GATE Tile_X0Y1_FrameStrobe[5] VPWR VGND sg13cmos5l_antennanp
XANTENNA__0548__GATE Tile_X0Y1_FrameStrobe[6] VPWR VGND sg13cmos5l_antennanp
XANTENNA__1121__A2 Tile_X0Y1_E6END[8] VPWR VGND sg13cmos5l_antennanp
X_1185_ _1185_/X _0650_/Q _1208_/X _1212_/X _1197_/X _0446_/Q _0445_/Q VPWR VGND sg13cmos5l_mux4_1
X_0205_ _0205_/Q Tile_X0Y0_FrameData[15] VGND VPWR Tile_X0Y1_FrameStrobe[3] latch
X_0136_ _0136_/Q Tile_X0Y0_FrameData[20] VGND VPWR Tile_X0Y1_FrameStrobe[1] latch
XFILLER_33_19 VPWR VGND sg13cmos5l_decap_8
XANTENNA__0122__D Tile_X0Y0_FrameData[2] VPWR VGND sg13cmos5l_antennanp
XFILLER_3_109 VPWR VGND sg13cmos5l_fill_1
X_0969_ Tile_X0Y1_WW4BEG[12] _1175_/X VPWR VGND sg13cmos5l_buf_1
XFILLER_114_22 VPWR VGND sg13cmos5l_decap_8
XFILLER_114_33 VPWR VGND sg13cmos5l_fill_2
XFILLER_58_16 VPWR VGND sg13cmos5l_fill_1
XFILLER_23_96 VPWR VGND sg13cmos5l_fill_1
XFILLER_90_47 VPWR VGND sg13cmos5l_fill_1
XANTENNA__1103__A2 Tile_X0Y1_E6END[7] VPWR VGND sg13cmos5l_antennanp
XFILLER_65_127 VPWR VGND sg13cmos5l_decap_4
XFILLER_65_138 VPWR VGND sg13cmos5l_fill_2
XANTENNA__0207__D Tile_X0Y0_FrameData[13] VPWR VGND sg13cmos5l_antennanp
XANTENNA__0472__GATE Tile_X0Y1_FrameStrobe[3] VPWR VGND sg13cmos5l_antennanp
X_0823_ FAB_USER_CLK Tile_X0Y1_UserCLK VPWR VGND sg13cmos5l_buf_1
X_0754_ Tile_X0Y0_N4BEG[3] Tile_X0Y1_N4END[11] VPWR VGND sg13cmos5l_buf_1
X_0685_ _0685_/L_HI VPWR VGND sg13cmos5l_tiehi
XANTENNA__0487__GATE Tile_X0Y1_FrameStrobe[4] VPWR VGND sg13cmos5l_antennanp
XANTENNA__0410__GATE Tile_X0Y1_FrameStrobe[1] VPWR VGND sg13cmos5l_antennanp
XFILLER_71_108 VPWR VGND sg13cmos5l_fill_2
X_1099_ _1099_/X _1110_/X Tile_X0Y1_N2MID[7] Tile_X0Y0_S2MID[7] Tile_X0Y0_S2END[7]
+ _0102_/Q _0101_/Q VPWR VGND sg13cmos5l_mux4_1
X_1168_ _1168_/X _0645_/Q _0649_/Q _1213_/X _1197_/X _0480_/Q _0479_/Q VPWR VGND sg13cmos5l_mux4_1
X_0119_ _0119_/Q Tile_X0Y0_FrameData[5] VGND VPWR Tile_X0Y1_FrameStrobe[0] latch
XANTENNA__0117__D Tile_X0Y0_FrameData[7] VPWR VGND sg13cmos5l_antennanp
XANTENNA__0425__GATE Tile_X0Y1_FrameStrobe[2] VPWR VGND sg13cmos5l_antennanp
XANTENNA__1030__A1 Tile_X0Y0_S1END[3] VPWR VGND sg13cmos5l_antennanp
XANTENNA__1097__A1 Tile_X0Y1_N2MID[5] VPWR VGND sg13cmos5l_antennanp
XFILLER_18_30 VPWR VGND sg13cmos5l_fill_2
XFILLER_85_25 VPWR VGND sg13cmos5l_fill_1
XANTENNA__1021__A1 Tile_X0Y0_EE4END[13] VPWR VGND sg13cmos5l_antennanp
XFILLER_38_127 VPWR VGND sg13cmos5l_fill_1
X_0470_ _0470_/Q Tile_X0Y1_FrameData[4] VGND VPWR Tile_X0Y1_FrameStrobe[3] latch
XANTENNA__1088__A1 Tile_X0Y1_N4END[4] VPWR VGND sg13cmos5l_antennanp
X_1022_ _1022_/X _1086_/X _1082_/X _1076_/X _1097_/X _0283_/Q _0282_/Q VPWR VGND sg13cmos5l_mux4_1
XANTENNA__0802__X Tile_X0Y0_N1BEG[3] VPWR VGND sg13cmos5l_antennanp
XFILLER_39_18 VPWR VGND sg13cmos5l_fill_1
X_0806_ Tile_X0Y0_FrameStrobe_O[3] Tile_X0Y1_FrameStrobe[3] VPWR VGND sg13cmos5l_buf_1
X_0737_ Tile_X0Y0_W2BEGb[6] _1045_/X VPWR VGND sg13cmos5l_buf_1
X_0668_ _0668_/L_HI VPWR VGND sg13cmos5l_tiehi
XANTENNA__0400__D Tile_X0Y1_FrameData[10] VPWR VGND sg13cmos5l_antennanp
XANTENNA__1079__A1 Tile_X0Y1_N4END[7] VPWR VGND sg13cmos5l_antennanp
X_0599_ _0599_/Q Tile_X0Y1_FrameData[3] VGND VPWR Tile_X0Y1_FrameStrobe[7] latch
XANTENNA__0364__GATE Tile_X0Y1_FrameStrobe[0] VPWR VGND sg13cmos5l_antennanp
XFILLER_71_27 VPWR VGND sg13cmos5l_decap_4
XANTENNA__0379__GATE Tile_X0Y1_FrameStrobe[1] VPWR VGND sg13cmos5l_antennanp
XANTENNA__1003__A1 Tile_X0Y0_E2END[7] VPWR VGND sg13cmos5l_antennanp
XANTENNA__0302__GATE Tile_X0Y1_FrameStrobe[6] VPWR VGND sg13cmos5l_antennanp
XANTENNA__0310__D Tile_X0Y0_FrameData[6] VPWR VGND sg13cmos5l_antennanp
XFILLER_29_40 VPWR VGND sg13cmos5l_fill_2
XANTENNA__0317__GATE Tile_X0Y1_FrameStrobe[7] VPWR VGND sg13cmos5l_antennanp
XANTENNA__0090__CLK Tile_X0Y1_UserCLK VPWR VGND sg13cmos5l_antennanp
XFILLER_6_88 VPWR VGND sg13cmos5l_decap_8
X_0522_ _0522_/Q Tile_X0Y1_FrameData[16] VGND VPWR Tile_X0Y1_FrameStrobe[5] latch
XANTENNA__0220__D Tile_X0Y0_FrameData[0] VPWR VGND sg13cmos5l_antennanp
X_0453_ _0453_/Q Tile_X0Y1_FrameData[21] VGND VPWR Tile_X0Y1_FrameStrobe[3] latch
X_0384_ _0384_/Q Tile_X0Y1_FrameData[26] VGND VPWR Tile_X0Y1_FrameStrobe[1] latch
X_1005_ _1005_/X Tile_X0Y0_E2MID[5] Tile_X0Y0_E2END[5] Tile_X0Y0_E6END[5] _1094_/X
+ _0334_/Q _0333_/Q VPWR VGND sg13cmos5l_mux4_1
XANTENNA__0992__A0 Tile_X0Y1_EE4END[2] VPWR VGND sg13cmos5l_antennanp
XANTENNA__1233__A1 Tile_X0Y0_EE4END[10] VPWR VGND sg13cmos5l_antennanp
XANTENNA__0130__D Tile_X0Y0_FrameData[26] VPWR VGND sg13cmos5l_antennanp
XFILLER_103_102 VPWR VGND sg13cmos5l_fill_2
XFILLER_103_113 VPWR VGND sg13cmos5l_fill_1
XFILLER_82_26 VPWR VGND sg13cmos5l_decap_4
XANTENNA__1224__A1 Tile_X0Y0_E2MID[2] VPWR VGND sg13cmos5l_antennanp
XFILLER_82_59 VPWR VGND sg13cmos5l_decap_8
XANTENNA__0241__GATE Tile_X0Y1_FrameStrobe[4] VPWR VGND sg13cmos5l_antennanp
XANTENNA__0305__D Tile_X0Y0_FrameData[11] VPWR VGND sg13cmos5l_antennanp
XANTENNA__0983__A0 Tile_X0Y1_EE4END[1] VPWR VGND sg13cmos5l_antennanp
XFILLER_103_0 VPWR VGND sg13cmos5l_fill_2
XANTENNA__0256__GATE Tile_X0Y1_FrameStrobe[5] VPWR VGND sg13cmos5l_antennanp
XFILLER_56_93 VPWR VGND sg13cmos5l_fill_1
XANTENNA__0209__GATE Tile_X0Y1_FrameStrobe[3] VPWR VGND sg13cmos5l_antennanp
XANTENNA__0215__D Tile_X0Y0_FrameData[5] VPWR VGND sg13cmos5l_antennanp
XANTENNA__0974__A0 Tile_X0Y0_E2MID[1] VPWR VGND sg13cmos5l_antennanp
XANTENNA__1215__A1 Tile_X0Y1_N4END[0] VPWR VGND sg13cmos5l_antennanp
XFILLER_75_4 VPWR VGND sg13cmos5l_fill_2
X_0505_ _0505_/Q Tile_X0Y1_FrameData[1] VGND VPWR Tile_X0Y1_FrameStrobe[4] latch
X_0436_ _0436_/Q Tile_X0Y1_FrameData[6] VGND VPWR Tile_X0Y1_FrameStrobe[2] latch
.ends
