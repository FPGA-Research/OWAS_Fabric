* NGSPICE file created from AXIL_S_IO_W.ext - technology: ihp-sg13cmos5l

* Black-box entry subcircuit for sg13cmos5l_antennanp abstract view
.subckt sg13cmos5l_antennanp A VDD VSS
.ends

* Black-box entry subcircuit for sg13cmos5l_decap_8 abstract view
.subckt sg13cmos5l_decap_8 VDD VSS
.ends

* Black-box entry subcircuit for latch abstract view
.subckt latch Q D VSS VDD GATE
.ends

* Black-box entry subcircuit for sg13cmos5l_mux4_1 abstract view
.subckt sg13cmos5l_mux4_1 X A0 A1 A2 A3 S0 S1 VDD VSS
.ends

* Black-box entry subcircuit for sg13cmos5l_buf_1 abstract view
.subckt sg13cmos5l_buf_1 X A VDD VSS
.ends

* Black-box entry subcircuit for sg13cmos5l_fill_1 abstract view
.subckt sg13cmos5l_fill_1 VDD VSS
.ends

* Black-box entry subcircuit for sg13cmos5l_fill_2 abstract view
.subckt sg13cmos5l_fill_2 VDD VSS
.ends

* Black-box entry subcircuit for sg13cmos5l_decap_4 abstract view
.subckt sg13cmos5l_decap_4 VDD VSS
.ends

* Black-box entry subcircuit for sg13cmos5l_mux2_1 abstract view
.subckt sg13cmos5l_mux2_1 X A0 A1 S VDD VSS
.ends

* Black-box entry subcircuit for sg13cmos5l_tielo abstract view
.subckt sg13cmos5l_tielo L_LO VDD VSS
.ends

.subckt AXIL_S_IO_W AXIL_S_SOC_ARADDR0 AXIL_S_SOC_ARADDR1 AXIL_S_SOC_ARADDR2 AXIL_S_SOC_ARADDR3
+ AXIL_S_SOC_ARADDR4 AXIL_S_SOC_ARADDR5 AXIL_S_SOC_ARADDR6 AXIL_S_SOC_ARADDR7 AXIL_S_SOC_ARADDR8
+ AXIL_S_SOC_ARADDR9 AXIL_S_SOC_ARPROT0 AXIL_S_SOC_ARPROT1 AXIL_S_SOC_ARPROT2 AXIL_S_SOC_ARREADY
+ AXIL_S_SOC_ARVALID AXIL_S_SOC_AWADDR0 AXIL_S_SOC_AWADDR1 AXIL_S_SOC_AWADDR2 AXIL_S_SOC_AWADDR3
+ AXIL_S_SOC_AWADDR4 AXIL_S_SOC_AWADDR5 AXIL_S_SOC_AWADDR6 AXIL_S_SOC_AWADDR7 AXIL_S_SOC_AWADDR8
+ AXIL_S_SOC_AWADDR9 AXIL_S_SOC_AWPROT0 AXIL_S_SOC_AWPROT1 AXIL_S_SOC_AWPROT2 AXIL_S_SOC_AWREADY
+ AXIL_S_SOC_AWVALID AXIL_S_SOC_BREADY AXIL_S_SOC_BRESP0 AXIL_S_SOC_BRESP1 AXIL_S_SOC_BVALID
+ AXIL_S_SOC_RDATA0 AXIL_S_SOC_RDATA1 AXIL_S_SOC_RDATA10 AXIL_S_SOC_RDATA11 AXIL_S_SOC_RDATA12
+ AXIL_S_SOC_RDATA13 AXIL_S_SOC_RDATA14 AXIL_S_SOC_RDATA15 AXIL_S_SOC_RDATA16 AXIL_S_SOC_RDATA17
+ AXIL_S_SOC_RDATA18 AXIL_S_SOC_RDATA19 AXIL_S_SOC_RDATA2 AXIL_S_SOC_RDATA20 AXIL_S_SOC_RDATA21
+ AXIL_S_SOC_RDATA22 AXIL_S_SOC_RDATA23 AXIL_S_SOC_RDATA24 AXIL_S_SOC_RDATA25 AXIL_S_SOC_RDATA26
+ AXIL_S_SOC_RDATA27 AXIL_S_SOC_RDATA28 AXIL_S_SOC_RDATA29 AXIL_S_SOC_RDATA3 AXIL_S_SOC_RDATA30
+ AXIL_S_SOC_RDATA31 AXIL_S_SOC_RDATA4 AXIL_S_SOC_RDATA5 AXIL_S_SOC_RDATA6 AXIL_S_SOC_RDATA7
+ AXIL_S_SOC_RDATA8 AXIL_S_SOC_RDATA9 AXIL_S_SOC_RREADY AXIL_S_SOC_RRESP0 AXIL_S_SOC_RRESP1
+ AXIL_S_SOC_RVALID AXIL_S_SOC_WDATA0 AXIL_S_SOC_WDATA1 AXIL_S_SOC_WDATA10 AXIL_S_SOC_WDATA11
+ AXIL_S_SOC_WDATA12 AXIL_S_SOC_WDATA13 AXIL_S_SOC_WDATA14 AXIL_S_SOC_WDATA15 AXIL_S_SOC_WDATA16
+ AXIL_S_SOC_WDATA17 AXIL_S_SOC_WDATA18 AXIL_S_SOC_WDATA19 AXIL_S_SOC_WDATA2 AXIL_S_SOC_WDATA20
+ AXIL_S_SOC_WDATA21 AXIL_S_SOC_WDATA22 AXIL_S_SOC_WDATA23 AXIL_S_SOC_WDATA24 AXIL_S_SOC_WDATA25
+ AXIL_S_SOC_WDATA26 AXIL_S_SOC_WDATA27 AXIL_S_SOC_WDATA28 AXIL_S_SOC_WDATA29 AXIL_S_SOC_WDATA3
+ AXIL_S_SOC_WDATA30 AXIL_S_SOC_WDATA31 AXIL_S_SOC_WDATA4 AXIL_S_SOC_WDATA5 AXIL_S_SOC_WDATA6
+ AXIL_S_SOC_WDATA7 AXIL_S_SOC_WDATA8 AXIL_S_SOC_WDATA9 AXIL_S_SOC_WREADY AXIL_S_SOC_WSTRB0
+ AXIL_S_SOC_WSTRB1 AXIL_S_SOC_WSTRB2 AXIL_S_SOC_WSTRB3 AXIL_S_SOC_WVALID Tile_X0Y0_E1BEG[0]
+ Tile_X0Y0_E1BEG[1] Tile_X0Y0_E1BEG[2] Tile_X0Y0_E1BEG[3] Tile_X0Y0_E2BEG[0] Tile_X0Y0_E2BEG[1]
+ Tile_X0Y0_E2BEG[2] Tile_X0Y0_E2BEG[3] Tile_X0Y0_E2BEG[4] Tile_X0Y0_E2BEG[5] Tile_X0Y0_E2BEG[6]
+ Tile_X0Y0_E2BEG[7] Tile_X0Y0_E2BEGb[0] Tile_X0Y0_E2BEGb[1] Tile_X0Y0_E2BEGb[2] Tile_X0Y0_E2BEGb[3]
+ Tile_X0Y0_E2BEGb[4] Tile_X0Y0_E2BEGb[5] Tile_X0Y0_E2BEGb[6] Tile_X0Y0_E2BEGb[7]
+ Tile_X0Y0_E6BEG[0] Tile_X0Y0_E6BEG[10] Tile_X0Y0_E6BEG[11] Tile_X0Y0_E6BEG[1] Tile_X0Y0_E6BEG[2]
+ Tile_X0Y0_E6BEG[3] Tile_X0Y0_E6BEG[4] Tile_X0Y0_E6BEG[5] Tile_X0Y0_E6BEG[6] Tile_X0Y0_E6BEG[7]
+ Tile_X0Y0_E6BEG[8] Tile_X0Y0_E6BEG[9] Tile_X0Y0_EE4BEG[0] Tile_X0Y0_EE4BEG[10] Tile_X0Y0_EE4BEG[11]
+ Tile_X0Y0_EE4BEG[12] Tile_X0Y0_EE4BEG[13] Tile_X0Y0_EE4BEG[14] Tile_X0Y0_EE4BEG[15]
+ Tile_X0Y0_EE4BEG[1] Tile_X0Y0_EE4BEG[2] Tile_X0Y0_EE4BEG[3] Tile_X0Y0_EE4BEG[4]
+ Tile_X0Y0_EE4BEG[5] Tile_X0Y0_EE4BEG[6] Tile_X0Y0_EE4BEG[7] Tile_X0Y0_EE4BEG[8]
+ Tile_X0Y0_EE4BEG[9] Tile_X0Y0_FrameData[0] Tile_X0Y0_FrameData[10] Tile_X0Y0_FrameData[11]
+ Tile_X0Y0_FrameData[12] Tile_X0Y0_FrameData[13] Tile_X0Y0_FrameData[14] Tile_X0Y0_FrameData[15]
+ Tile_X0Y0_FrameData[16] Tile_X0Y0_FrameData[17] Tile_X0Y0_FrameData[18] Tile_X0Y0_FrameData[19]
+ Tile_X0Y0_FrameData[1] Tile_X0Y0_FrameData[20] Tile_X0Y0_FrameData[21] Tile_X0Y0_FrameData[22]
+ Tile_X0Y0_FrameData[23] Tile_X0Y0_FrameData[24] Tile_X0Y0_FrameData[25] Tile_X0Y0_FrameData[26]
+ Tile_X0Y0_FrameData[27] Tile_X0Y0_FrameData[28] Tile_X0Y0_FrameData[29] Tile_X0Y0_FrameData[2]
+ Tile_X0Y0_FrameData[30] Tile_X0Y0_FrameData[31] Tile_X0Y0_FrameData[3] Tile_X0Y0_FrameData[4]
+ Tile_X0Y0_FrameData[5] Tile_X0Y0_FrameData[6] Tile_X0Y0_FrameData[7] Tile_X0Y0_FrameData[8]
+ Tile_X0Y0_FrameData[9] Tile_X0Y0_FrameData_O[0] Tile_X0Y0_FrameData_O[10] Tile_X0Y0_FrameData_O[11]
+ Tile_X0Y0_FrameData_O[12] Tile_X0Y0_FrameData_O[13] Tile_X0Y0_FrameData_O[14] Tile_X0Y0_FrameData_O[15]
+ Tile_X0Y0_FrameData_O[16] Tile_X0Y0_FrameData_O[17] Tile_X0Y0_FrameData_O[18] Tile_X0Y0_FrameData_O[19]
+ Tile_X0Y0_FrameData_O[1] Tile_X0Y0_FrameData_O[20] Tile_X0Y0_FrameData_O[21] Tile_X0Y0_FrameData_O[22]
+ Tile_X0Y0_FrameData_O[23] Tile_X0Y0_FrameData_O[24] Tile_X0Y0_FrameData_O[25] Tile_X0Y0_FrameData_O[26]
+ Tile_X0Y0_FrameData_O[27] Tile_X0Y0_FrameData_O[28] Tile_X0Y0_FrameData_O[29] Tile_X0Y0_FrameData_O[2]
+ Tile_X0Y0_FrameData_O[30] Tile_X0Y0_FrameData_O[31] Tile_X0Y0_FrameData_O[3] Tile_X0Y0_FrameData_O[4]
+ Tile_X0Y0_FrameData_O[5] Tile_X0Y0_FrameData_O[6] Tile_X0Y0_FrameData_O[7] Tile_X0Y0_FrameData_O[8]
+ Tile_X0Y0_FrameData_O[9] Tile_X0Y0_FrameStrobe_O[0] Tile_X0Y0_FrameStrobe_O[10]
+ Tile_X0Y0_FrameStrobe_O[11] Tile_X0Y0_FrameStrobe_O[12] Tile_X0Y0_FrameStrobe_O[13]
+ Tile_X0Y0_FrameStrobe_O[14] Tile_X0Y0_FrameStrobe_O[15] Tile_X0Y0_FrameStrobe_O[16]
+ Tile_X0Y0_FrameStrobe_O[17] Tile_X0Y0_FrameStrobe_O[18] Tile_X0Y0_FrameStrobe_O[19]
+ Tile_X0Y0_FrameStrobe_O[1] Tile_X0Y0_FrameStrobe_O[2] Tile_X0Y0_FrameStrobe_O[3]
+ Tile_X0Y0_FrameStrobe_O[4] Tile_X0Y0_FrameStrobe_O[5] Tile_X0Y0_FrameStrobe_O[6]
+ Tile_X0Y0_FrameStrobe_O[7] Tile_X0Y0_FrameStrobe_O[8] Tile_X0Y0_FrameStrobe_O[9]
+ Tile_X0Y0_N1BEG[0] Tile_X0Y0_N1BEG[1] Tile_X0Y0_N1BEG[2] Tile_X0Y0_N1BEG[3] Tile_X0Y0_N2BEG[0]
+ Tile_X0Y0_N2BEG[1] Tile_X0Y0_N2BEG[2] Tile_X0Y0_N2BEG[3] Tile_X0Y0_N2BEG[4] Tile_X0Y0_N2BEG[5]
+ Tile_X0Y0_N2BEG[6] Tile_X0Y0_N2BEG[7] Tile_X0Y0_N2BEGb[0] Tile_X0Y0_N2BEGb[1] Tile_X0Y0_N2BEGb[2]
+ Tile_X0Y0_N2BEGb[3] Tile_X0Y0_N2BEGb[4] Tile_X0Y0_N2BEGb[5] Tile_X0Y0_N2BEGb[6]
+ Tile_X0Y0_N2BEGb[7] Tile_X0Y0_N4BEG[0] Tile_X0Y0_N4BEG[10] Tile_X0Y0_N4BEG[11] Tile_X0Y0_N4BEG[12]
+ Tile_X0Y0_N4BEG[13] Tile_X0Y0_N4BEG[14] Tile_X0Y0_N4BEG[15] Tile_X0Y0_N4BEG[1] Tile_X0Y0_N4BEG[2]
+ Tile_X0Y0_N4BEG[3] Tile_X0Y0_N4BEG[4] Tile_X0Y0_N4BEG[5] Tile_X0Y0_N4BEG[6] Tile_X0Y0_N4BEG[7]
+ Tile_X0Y0_N4BEG[8] Tile_X0Y0_N4BEG[9] Tile_X0Y0_S1END[0] Tile_X0Y0_S1END[1] Tile_X0Y0_S1END[2]
+ Tile_X0Y0_S1END[3] Tile_X0Y0_S2END[0] Tile_X0Y0_S2END[1] Tile_X0Y0_S2END[2] Tile_X0Y0_S2END[3]
+ Tile_X0Y0_S2END[4] Tile_X0Y0_S2END[5] Tile_X0Y0_S2END[6] Tile_X0Y0_S2END[7] Tile_X0Y0_S2MID[0]
+ Tile_X0Y0_S2MID[1] Tile_X0Y0_S2MID[2] Tile_X0Y0_S2MID[3] Tile_X0Y0_S2MID[4] Tile_X0Y0_S2MID[5]
+ Tile_X0Y0_S2MID[6] Tile_X0Y0_S2MID[7] Tile_X0Y0_S4END[0] Tile_X0Y0_S4END[10] Tile_X0Y0_S4END[11]
+ Tile_X0Y0_S4END[12] Tile_X0Y0_S4END[13] Tile_X0Y0_S4END[14] Tile_X0Y0_S4END[15]
+ Tile_X0Y0_S4END[1] Tile_X0Y0_S4END[2] Tile_X0Y0_S4END[3] Tile_X0Y0_S4END[4] Tile_X0Y0_S4END[5]
+ Tile_X0Y0_S4END[6] Tile_X0Y0_S4END[7] Tile_X0Y0_S4END[8] Tile_X0Y0_S4END[9] Tile_X0Y0_UserCLK
+ Tile_X0Y0_UserCLKo Tile_X0Y0_W1END[0] Tile_X0Y0_W1END[1] Tile_X0Y0_W1END[2] Tile_X0Y0_W1END[3]
+ Tile_X0Y0_W2END[0] Tile_X0Y0_W2END[1] Tile_X0Y0_W2END[2] Tile_X0Y0_W2END[3] Tile_X0Y0_W2END[4]
+ Tile_X0Y0_W2END[5] Tile_X0Y0_W2END[6] Tile_X0Y0_W2END[7] Tile_X0Y0_W2MID[0] Tile_X0Y0_W2MID[1]
+ Tile_X0Y0_W2MID[2] Tile_X0Y0_W2MID[3] Tile_X0Y0_W2MID[4] Tile_X0Y0_W2MID[5] Tile_X0Y0_W2MID[6]
+ Tile_X0Y0_W2MID[7] Tile_X0Y0_W6END[0] Tile_X0Y0_W6END[10] Tile_X0Y0_W6END[11] Tile_X0Y0_W6END[1]
+ Tile_X0Y0_W6END[2] Tile_X0Y0_W6END[3] Tile_X0Y0_W6END[4] Tile_X0Y0_W6END[5] Tile_X0Y0_W6END[6]
+ Tile_X0Y0_W6END[7] Tile_X0Y0_W6END[8] Tile_X0Y0_W6END[9] Tile_X0Y0_WW4END[0] Tile_X0Y0_WW4END[10]
+ Tile_X0Y0_WW4END[11] Tile_X0Y0_WW4END[12] Tile_X0Y0_WW4END[13] Tile_X0Y0_WW4END[14]
+ Tile_X0Y0_WW4END[15] Tile_X0Y0_WW4END[1] Tile_X0Y0_WW4END[2] Tile_X0Y0_WW4END[3]
+ Tile_X0Y0_WW4END[4] Tile_X0Y0_WW4END[5] Tile_X0Y0_WW4END[6] Tile_X0Y0_WW4END[7]
+ Tile_X0Y0_WW4END[8] Tile_X0Y0_WW4END[9] Tile_X0Y1_E1BEG[0] Tile_X0Y1_E1BEG[1] Tile_X0Y1_E1BEG[2]
+ Tile_X0Y1_E1BEG[3] Tile_X0Y1_E2BEG[0] Tile_X0Y1_E2BEG[1] Tile_X0Y1_E2BEG[2] Tile_X0Y1_E2BEG[3]
+ Tile_X0Y1_E2BEG[4] Tile_X0Y1_E2BEG[5] Tile_X0Y1_E2BEG[6] Tile_X0Y1_E2BEG[7] Tile_X0Y1_E2BEGb[0]
+ Tile_X0Y1_E2BEGb[1] Tile_X0Y1_E2BEGb[2] Tile_X0Y1_E2BEGb[3] Tile_X0Y1_E2BEGb[4]
+ Tile_X0Y1_E2BEGb[5] Tile_X0Y1_E2BEGb[6] Tile_X0Y1_E2BEGb[7] Tile_X0Y1_E6BEG[0] Tile_X0Y1_E6BEG[10]
+ Tile_X0Y1_E6BEG[11] Tile_X0Y1_E6BEG[1] Tile_X0Y1_E6BEG[2] Tile_X0Y1_E6BEG[3] Tile_X0Y1_E6BEG[4]
+ Tile_X0Y1_E6BEG[5] Tile_X0Y1_E6BEG[6] Tile_X0Y1_E6BEG[7] Tile_X0Y1_E6BEG[8] Tile_X0Y1_E6BEG[9]
+ Tile_X0Y1_EE4BEG[0] Tile_X0Y1_EE4BEG[10] Tile_X0Y1_EE4BEG[11] Tile_X0Y1_EE4BEG[12]
+ Tile_X0Y1_EE4BEG[13] Tile_X0Y1_EE4BEG[14] Tile_X0Y1_EE4BEG[15] Tile_X0Y1_EE4BEG[1]
+ Tile_X0Y1_EE4BEG[2] Tile_X0Y1_EE4BEG[3] Tile_X0Y1_EE4BEG[4] Tile_X0Y1_EE4BEG[5]
+ Tile_X0Y1_EE4BEG[6] Tile_X0Y1_EE4BEG[7] Tile_X0Y1_EE4BEG[8] Tile_X0Y1_EE4BEG[9]
+ Tile_X0Y1_FrameData[0] Tile_X0Y1_FrameData[10] Tile_X0Y1_FrameData[11] Tile_X0Y1_FrameData[12]
+ Tile_X0Y1_FrameData[13] Tile_X0Y1_FrameData[14] Tile_X0Y1_FrameData[15] Tile_X0Y1_FrameData[16]
+ Tile_X0Y1_FrameData[17] Tile_X0Y1_FrameData[18] Tile_X0Y1_FrameData[19] Tile_X0Y1_FrameData[1]
+ Tile_X0Y1_FrameData[20] Tile_X0Y1_FrameData[21] Tile_X0Y1_FrameData[22] Tile_X0Y1_FrameData[23]
+ Tile_X0Y1_FrameData[24] Tile_X0Y1_FrameData[25] Tile_X0Y1_FrameData[26] Tile_X0Y1_FrameData[27]
+ Tile_X0Y1_FrameData[28] Tile_X0Y1_FrameData[29] Tile_X0Y1_FrameData[2] Tile_X0Y1_FrameData[30]
+ Tile_X0Y1_FrameData[31] Tile_X0Y1_FrameData[3] Tile_X0Y1_FrameData[4] Tile_X0Y1_FrameData[5]
+ Tile_X0Y1_FrameData[6] Tile_X0Y1_FrameData[7] Tile_X0Y1_FrameData[8] Tile_X0Y1_FrameData[9]
+ Tile_X0Y1_FrameData_O[0] Tile_X0Y1_FrameData_O[10] Tile_X0Y1_FrameData_O[11] Tile_X0Y1_FrameData_O[12]
+ Tile_X0Y1_FrameData_O[13] Tile_X0Y1_FrameData_O[14] Tile_X0Y1_FrameData_O[15] Tile_X0Y1_FrameData_O[16]
+ Tile_X0Y1_FrameData_O[17] Tile_X0Y1_FrameData_O[18] Tile_X0Y1_FrameData_O[19] Tile_X0Y1_FrameData_O[1]
+ Tile_X0Y1_FrameData_O[20] Tile_X0Y1_FrameData_O[21] Tile_X0Y1_FrameData_O[22] Tile_X0Y1_FrameData_O[23]
+ Tile_X0Y1_FrameData_O[24] Tile_X0Y1_FrameData_O[25] Tile_X0Y1_FrameData_O[26] Tile_X0Y1_FrameData_O[27]
+ Tile_X0Y1_FrameData_O[28] Tile_X0Y1_FrameData_O[29] Tile_X0Y1_FrameData_O[2] Tile_X0Y1_FrameData_O[30]
+ Tile_X0Y1_FrameData_O[31] Tile_X0Y1_FrameData_O[3] Tile_X0Y1_FrameData_O[4] Tile_X0Y1_FrameData_O[5]
+ Tile_X0Y1_FrameData_O[6] Tile_X0Y1_FrameData_O[7] Tile_X0Y1_FrameData_O[8] Tile_X0Y1_FrameData_O[9]
+ Tile_X0Y1_UserCLK Tile_X0Y1_UserCLKo Tile_X0Y1_W1END[0] Tile_X0Y1_W1END[1] Tile_X0Y1_W1END[2]
+ Tile_X0Y1_W1END[3] Tile_X0Y1_W2END[0] Tile_X0Y1_W2END[1] Tile_X0Y1_W2END[2] Tile_X0Y1_W2END[3]
+ Tile_X0Y1_W2END[4] Tile_X0Y1_W2END[5] Tile_X0Y1_W2END[6] Tile_X0Y1_W2END[7] Tile_X0Y1_W2MID[0]
+ Tile_X0Y1_W2MID[1] Tile_X0Y1_W2MID[2] Tile_X0Y1_W2MID[3] Tile_X0Y1_W2MID[4] Tile_X0Y1_W2MID[5]
+ Tile_X0Y1_W2MID[6] Tile_X0Y1_W2MID[7] Tile_X0Y1_W6END[0] Tile_X0Y1_W6END[10] Tile_X0Y1_W6END[11]
+ Tile_X0Y1_W6END[1] Tile_X0Y1_W6END[2] Tile_X0Y1_W6END[3] Tile_X0Y1_W6END[4] Tile_X0Y1_W6END[5]
+ Tile_X0Y1_W6END[6] Tile_X0Y1_W6END[7] Tile_X0Y1_W6END[8] Tile_X0Y1_W6END[9] Tile_X0Y1_WW4END[0]
+ Tile_X0Y1_WW4END[10] Tile_X0Y1_WW4END[11] Tile_X0Y1_WW4END[12] Tile_X0Y1_WW4END[13]
+ Tile_X0Y1_WW4END[14] Tile_X0Y1_WW4END[15] Tile_X0Y1_WW4END[1] Tile_X0Y1_WW4END[2]
+ Tile_X0Y1_WW4END[3] Tile_X0Y1_WW4END[4] Tile_X0Y1_WW4END[5] Tile_X0Y1_WW4END[6]
+ Tile_X0Y1_WW4END[7] Tile_X0Y1_WW4END[8] Tile_X0Y1_WW4END[9] Tile_X0Y2_E1BEG[0] Tile_X0Y2_E1BEG[1]
+ Tile_X0Y2_E1BEG[2] Tile_X0Y2_E1BEG[3] Tile_X0Y2_E2BEG[0] Tile_X0Y2_E2BEG[1] Tile_X0Y2_E2BEG[2]
+ Tile_X0Y2_E2BEG[3] Tile_X0Y2_E2BEG[4] Tile_X0Y2_E2BEG[5] Tile_X0Y2_E2BEG[6] Tile_X0Y2_E2BEG[7]
+ Tile_X0Y2_E2BEGb[0] Tile_X0Y2_E2BEGb[1] Tile_X0Y2_E2BEGb[2] Tile_X0Y2_E2BEGb[3]
+ Tile_X0Y2_E2BEGb[4] Tile_X0Y2_E2BEGb[5] Tile_X0Y2_E2BEGb[6] Tile_X0Y2_E2BEGb[7]
+ Tile_X0Y2_E6BEG[0] Tile_X0Y2_E6BEG[10] Tile_X0Y2_E6BEG[11] Tile_X0Y2_E6BEG[1] Tile_X0Y2_E6BEG[2]
+ Tile_X0Y2_E6BEG[3] Tile_X0Y2_E6BEG[4] Tile_X0Y2_E6BEG[5] Tile_X0Y2_E6BEG[6] Tile_X0Y2_E6BEG[7]
+ Tile_X0Y2_E6BEG[8] Tile_X0Y2_E6BEG[9] Tile_X0Y2_EE4BEG[0] Tile_X0Y2_EE4BEG[10] Tile_X0Y2_EE4BEG[11]
+ Tile_X0Y2_EE4BEG[12] Tile_X0Y2_EE4BEG[13] Tile_X0Y2_EE4BEG[14] Tile_X0Y2_EE4BEG[15]
+ Tile_X0Y2_EE4BEG[1] Tile_X0Y2_EE4BEG[2] Tile_X0Y2_EE4BEG[3] Tile_X0Y2_EE4BEG[4]
+ Tile_X0Y2_EE4BEG[5] Tile_X0Y2_EE4BEG[6] Tile_X0Y2_EE4BEG[7] Tile_X0Y2_EE4BEG[8]
+ Tile_X0Y2_EE4BEG[9] Tile_X0Y2_FrameData[0] Tile_X0Y2_FrameData[10] Tile_X0Y2_FrameData[11]
+ Tile_X0Y2_FrameData[12] Tile_X0Y2_FrameData[13] Tile_X0Y2_FrameData[14] Tile_X0Y2_FrameData[15]
+ Tile_X0Y2_FrameData[16] Tile_X0Y2_FrameData[17] Tile_X0Y2_FrameData[18] Tile_X0Y2_FrameData[19]
+ Tile_X0Y2_FrameData[1] Tile_X0Y2_FrameData[20] Tile_X0Y2_FrameData[21] Tile_X0Y2_FrameData[22]
+ Tile_X0Y2_FrameData[23] Tile_X0Y2_FrameData[24] Tile_X0Y2_FrameData[25] Tile_X0Y2_FrameData[26]
+ Tile_X0Y2_FrameData[27] Tile_X0Y2_FrameData[28] Tile_X0Y2_FrameData[29] Tile_X0Y2_FrameData[2]
+ Tile_X0Y2_FrameData[30] Tile_X0Y2_FrameData[31] Tile_X0Y2_FrameData[3] Tile_X0Y2_FrameData[4]
+ Tile_X0Y2_FrameData[5] Tile_X0Y2_FrameData[6] Tile_X0Y2_FrameData[7] Tile_X0Y2_FrameData[8]
+ Tile_X0Y2_FrameData[9] Tile_X0Y2_FrameData_O[0] Tile_X0Y2_FrameData_O[10] Tile_X0Y2_FrameData_O[11]
+ Tile_X0Y2_FrameData_O[12] Tile_X0Y2_FrameData_O[13] Tile_X0Y2_FrameData_O[14] Tile_X0Y2_FrameData_O[15]
+ Tile_X0Y2_FrameData_O[16] Tile_X0Y2_FrameData_O[17] Tile_X0Y2_FrameData_O[18] Tile_X0Y2_FrameData_O[19]
+ Tile_X0Y2_FrameData_O[1] Tile_X0Y2_FrameData_O[20] Tile_X0Y2_FrameData_O[21] Tile_X0Y2_FrameData_O[22]
+ Tile_X0Y2_FrameData_O[23] Tile_X0Y2_FrameData_O[24] Tile_X0Y2_FrameData_O[25] Tile_X0Y2_FrameData_O[26]
+ Tile_X0Y2_FrameData_O[27] Tile_X0Y2_FrameData_O[28] Tile_X0Y2_FrameData_O[29] Tile_X0Y2_FrameData_O[2]
+ Tile_X0Y2_FrameData_O[30] Tile_X0Y2_FrameData_O[31] Tile_X0Y2_FrameData_O[3] Tile_X0Y2_FrameData_O[4]
+ Tile_X0Y2_FrameData_O[5] Tile_X0Y2_FrameData_O[6] Tile_X0Y2_FrameData_O[7] Tile_X0Y2_FrameData_O[8]
+ Tile_X0Y2_FrameData_O[9] Tile_X0Y2_UserCLK Tile_X0Y2_UserCLKo Tile_X0Y2_W1END[0]
+ Tile_X0Y2_W1END[1] Tile_X0Y2_W1END[2] Tile_X0Y2_W1END[3] Tile_X0Y2_W2END[0] Tile_X0Y2_W2END[1]
+ Tile_X0Y2_W2END[2] Tile_X0Y2_W2END[3] Tile_X0Y2_W2END[4] Tile_X0Y2_W2END[5] Tile_X0Y2_W2END[6]
+ Tile_X0Y2_W2END[7] Tile_X0Y2_W2MID[0] Tile_X0Y2_W2MID[1] Tile_X0Y2_W2MID[2] Tile_X0Y2_W2MID[3]
+ Tile_X0Y2_W2MID[4] Tile_X0Y2_W2MID[5] Tile_X0Y2_W2MID[6] Tile_X0Y2_W2MID[7] Tile_X0Y2_W6END[0]
+ Tile_X0Y2_W6END[10] Tile_X0Y2_W6END[11] Tile_X0Y2_W6END[1] Tile_X0Y2_W6END[2] Tile_X0Y2_W6END[3]
+ Tile_X0Y2_W6END[4] Tile_X0Y2_W6END[5] Tile_X0Y2_W6END[6] Tile_X0Y2_W6END[7] Tile_X0Y2_W6END[8]
+ Tile_X0Y2_W6END[9] Tile_X0Y2_WW4END[0] Tile_X0Y2_WW4END[10] Tile_X0Y2_WW4END[11]
+ Tile_X0Y2_WW4END[12] Tile_X0Y2_WW4END[13] Tile_X0Y2_WW4END[14] Tile_X0Y2_WW4END[15]
+ Tile_X0Y2_WW4END[1] Tile_X0Y2_WW4END[2] Tile_X0Y2_WW4END[3] Tile_X0Y2_WW4END[4]
+ Tile_X0Y2_WW4END[5] Tile_X0Y2_WW4END[6] Tile_X0Y2_WW4END[7] Tile_X0Y2_WW4END[8]
+ Tile_X0Y2_WW4END[9] Tile_X0Y3_E1BEG[0] Tile_X0Y3_E1BEG[1] Tile_X0Y3_E1BEG[2] Tile_X0Y3_E1BEG[3]
+ Tile_X0Y3_E2BEG[0] Tile_X0Y3_E2BEG[1] Tile_X0Y3_E2BEG[2] Tile_X0Y3_E2BEG[3] Tile_X0Y3_E2BEG[4]
+ Tile_X0Y3_E2BEG[5] Tile_X0Y3_E2BEG[6] Tile_X0Y3_E2BEG[7] Tile_X0Y3_E2BEGb[0] Tile_X0Y3_E2BEGb[1]
+ Tile_X0Y3_E2BEGb[2] Tile_X0Y3_E2BEGb[3] Tile_X0Y3_E2BEGb[4] Tile_X0Y3_E2BEGb[5]
+ Tile_X0Y3_E2BEGb[6] Tile_X0Y3_E2BEGb[7] Tile_X0Y3_E6BEG[0] Tile_X0Y3_E6BEG[10] Tile_X0Y3_E6BEG[11]
+ Tile_X0Y3_E6BEG[1] Tile_X0Y3_E6BEG[2] Tile_X0Y3_E6BEG[3] Tile_X0Y3_E6BEG[4] Tile_X0Y3_E6BEG[5]
+ Tile_X0Y3_E6BEG[6] Tile_X0Y3_E6BEG[7] Tile_X0Y3_E6BEG[8] Tile_X0Y3_E6BEG[9] Tile_X0Y3_EE4BEG[0]
+ Tile_X0Y3_EE4BEG[10] Tile_X0Y3_EE4BEG[11] Tile_X0Y3_EE4BEG[12] Tile_X0Y3_EE4BEG[13]
+ Tile_X0Y3_EE4BEG[14] Tile_X0Y3_EE4BEG[15] Tile_X0Y3_EE4BEG[1] Tile_X0Y3_EE4BEG[2]
+ Tile_X0Y3_EE4BEG[3] Tile_X0Y3_EE4BEG[4] Tile_X0Y3_EE4BEG[5] Tile_X0Y3_EE4BEG[6]
+ Tile_X0Y3_EE4BEG[7] Tile_X0Y3_EE4BEG[8] Tile_X0Y3_EE4BEG[9] Tile_X0Y3_FrameData[0]
+ Tile_X0Y3_FrameData[10] Tile_X0Y3_FrameData[11] Tile_X0Y3_FrameData[12] Tile_X0Y3_FrameData[13]
+ Tile_X0Y3_FrameData[14] Tile_X0Y3_FrameData[15] Tile_X0Y3_FrameData[16] Tile_X0Y3_FrameData[17]
+ Tile_X0Y3_FrameData[18] Tile_X0Y3_FrameData[19] Tile_X0Y3_FrameData[1] Tile_X0Y3_FrameData[20]
+ Tile_X0Y3_FrameData[21] Tile_X0Y3_FrameData[22] Tile_X0Y3_FrameData[23] Tile_X0Y3_FrameData[24]
+ Tile_X0Y3_FrameData[25] Tile_X0Y3_FrameData[26] Tile_X0Y3_FrameData[27] Tile_X0Y3_FrameData[28]
+ Tile_X0Y3_FrameData[29] Tile_X0Y3_FrameData[2] Tile_X0Y3_FrameData[30] Tile_X0Y3_FrameData[31]
+ Tile_X0Y3_FrameData[3] Tile_X0Y3_FrameData[4] Tile_X0Y3_FrameData[5] Tile_X0Y3_FrameData[6]
+ Tile_X0Y3_FrameData[7] Tile_X0Y3_FrameData[8] Tile_X0Y3_FrameData[9] Tile_X0Y3_FrameData_O[0]
+ Tile_X0Y3_FrameData_O[10] Tile_X0Y3_FrameData_O[11] Tile_X0Y3_FrameData_O[12] Tile_X0Y3_FrameData_O[13]
+ Tile_X0Y3_FrameData_O[14] Tile_X0Y3_FrameData_O[15] Tile_X0Y3_FrameData_O[16] Tile_X0Y3_FrameData_O[17]
+ Tile_X0Y3_FrameData_O[18] Tile_X0Y3_FrameData_O[19] Tile_X0Y3_FrameData_O[1] Tile_X0Y3_FrameData_O[20]
+ Tile_X0Y3_FrameData_O[21] Tile_X0Y3_FrameData_O[22] Tile_X0Y3_FrameData_O[23] Tile_X0Y3_FrameData_O[24]
+ Tile_X0Y3_FrameData_O[25] Tile_X0Y3_FrameData_O[26] Tile_X0Y3_FrameData_O[27] Tile_X0Y3_FrameData_O[28]
+ Tile_X0Y3_FrameData_O[29] Tile_X0Y3_FrameData_O[2] Tile_X0Y3_FrameData_O[30] Tile_X0Y3_FrameData_O[31]
+ Tile_X0Y3_FrameData_O[3] Tile_X0Y3_FrameData_O[4] Tile_X0Y3_FrameData_O[5] Tile_X0Y3_FrameData_O[6]
+ Tile_X0Y3_FrameData_O[7] Tile_X0Y3_FrameData_O[8] Tile_X0Y3_FrameData_O[9] Tile_X0Y3_UserCLK
+ Tile_X0Y3_UserCLKo Tile_X0Y3_W1END[0] Tile_X0Y3_W1END[1] Tile_X0Y3_W1END[2] Tile_X0Y3_W1END[3]
+ Tile_X0Y3_W2END[0] Tile_X0Y3_W2END[1] Tile_X0Y3_W2END[2] Tile_X0Y3_W2END[3] Tile_X0Y3_W2END[4]
+ Tile_X0Y3_W2END[5] Tile_X0Y3_W2END[6] Tile_X0Y3_W2END[7] Tile_X0Y3_W2MID[0] Tile_X0Y3_W2MID[1]
+ Tile_X0Y3_W2MID[2] Tile_X0Y3_W2MID[3] Tile_X0Y3_W2MID[4] Tile_X0Y3_W2MID[5] Tile_X0Y3_W2MID[6]
+ Tile_X0Y3_W2MID[7] Tile_X0Y3_W6END[0] Tile_X0Y3_W6END[10] Tile_X0Y3_W6END[11] Tile_X0Y3_W6END[1]
+ Tile_X0Y3_W6END[2] Tile_X0Y3_W6END[3] Tile_X0Y3_W6END[4] Tile_X0Y3_W6END[5] Tile_X0Y3_W6END[6]
+ Tile_X0Y3_W6END[7] Tile_X0Y3_W6END[8] Tile_X0Y3_W6END[9] Tile_X0Y3_WW4END[0] Tile_X0Y3_WW4END[10]
+ Tile_X0Y3_WW4END[11] Tile_X0Y3_WW4END[12] Tile_X0Y3_WW4END[13] Tile_X0Y3_WW4END[14]
+ Tile_X0Y3_WW4END[15] Tile_X0Y3_WW4END[1] Tile_X0Y3_WW4END[2] Tile_X0Y3_WW4END[3]
+ Tile_X0Y3_WW4END[4] Tile_X0Y3_WW4END[5] Tile_X0Y3_WW4END[6] Tile_X0Y3_WW4END[7]
+ Tile_X0Y3_WW4END[8] Tile_X0Y3_WW4END[9] Tile_X0Y4_E1BEG[0] Tile_X0Y4_E1BEG[1] Tile_X0Y4_E1BEG[2]
+ Tile_X0Y4_E1BEG[3] Tile_X0Y4_E2BEG[0] Tile_X0Y4_E2BEG[1] Tile_X0Y4_E2BEG[2] Tile_X0Y4_E2BEG[3]
+ Tile_X0Y4_E2BEG[4] Tile_X0Y4_E2BEG[5] Tile_X0Y4_E2BEG[6] Tile_X0Y4_E2BEG[7] Tile_X0Y4_E2BEGb[0]
+ Tile_X0Y4_E2BEGb[1] Tile_X0Y4_E2BEGb[2] Tile_X0Y4_E2BEGb[3] Tile_X0Y4_E2BEGb[4]
+ Tile_X0Y4_E2BEGb[5] Tile_X0Y4_E2BEGb[6] Tile_X0Y4_E2BEGb[7] Tile_X0Y4_E6BEG[0] Tile_X0Y4_E6BEG[10]
+ Tile_X0Y4_E6BEG[11] Tile_X0Y4_E6BEG[1] Tile_X0Y4_E6BEG[2] Tile_X0Y4_E6BEG[3] Tile_X0Y4_E6BEG[4]
+ Tile_X0Y4_E6BEG[5] Tile_X0Y4_E6BEG[6] Tile_X0Y4_E6BEG[7] Tile_X0Y4_E6BEG[8] Tile_X0Y4_E6BEG[9]
+ Tile_X0Y4_EE4BEG[0] Tile_X0Y4_EE4BEG[10] Tile_X0Y4_EE4BEG[11] Tile_X0Y4_EE4BEG[12]
+ Tile_X0Y4_EE4BEG[13] Tile_X0Y4_EE4BEG[14] Tile_X0Y4_EE4BEG[15] Tile_X0Y4_EE4BEG[1]
+ Tile_X0Y4_EE4BEG[2] Tile_X0Y4_EE4BEG[3] Tile_X0Y4_EE4BEG[4] Tile_X0Y4_EE4BEG[5]
+ Tile_X0Y4_EE4BEG[6] Tile_X0Y4_EE4BEG[7] Tile_X0Y4_EE4BEG[8] Tile_X0Y4_EE4BEG[9]
+ Tile_X0Y4_FrameData[0] Tile_X0Y4_FrameData[10] Tile_X0Y4_FrameData[11] Tile_X0Y4_FrameData[12]
+ Tile_X0Y4_FrameData[13] Tile_X0Y4_FrameData[14] Tile_X0Y4_FrameData[15] Tile_X0Y4_FrameData[16]
+ Tile_X0Y4_FrameData[17] Tile_X0Y4_FrameData[18] Tile_X0Y4_FrameData[19] Tile_X0Y4_FrameData[1]
+ Tile_X0Y4_FrameData[20] Tile_X0Y4_FrameData[21] Tile_X0Y4_FrameData[22] Tile_X0Y4_FrameData[23]
+ Tile_X0Y4_FrameData[24] Tile_X0Y4_FrameData[25] Tile_X0Y4_FrameData[26] Tile_X0Y4_FrameData[27]
+ Tile_X0Y4_FrameData[28] Tile_X0Y4_FrameData[29] Tile_X0Y4_FrameData[2] Tile_X0Y4_FrameData[30]
+ Tile_X0Y4_FrameData[31] Tile_X0Y4_FrameData[3] Tile_X0Y4_FrameData[4] Tile_X0Y4_FrameData[5]
+ Tile_X0Y4_FrameData[6] Tile_X0Y4_FrameData[7] Tile_X0Y4_FrameData[8] Tile_X0Y4_FrameData[9]
+ Tile_X0Y4_FrameData_O[0] Tile_X0Y4_FrameData_O[10] Tile_X0Y4_FrameData_O[11] Tile_X0Y4_FrameData_O[12]
+ Tile_X0Y4_FrameData_O[13] Tile_X0Y4_FrameData_O[14] Tile_X0Y4_FrameData_O[15] Tile_X0Y4_FrameData_O[16]
+ Tile_X0Y4_FrameData_O[17] Tile_X0Y4_FrameData_O[18] Tile_X0Y4_FrameData_O[19] Tile_X0Y4_FrameData_O[1]
+ Tile_X0Y4_FrameData_O[20] Tile_X0Y4_FrameData_O[21] Tile_X0Y4_FrameData_O[22] Tile_X0Y4_FrameData_O[23]
+ Tile_X0Y4_FrameData_O[24] Tile_X0Y4_FrameData_O[25] Tile_X0Y4_FrameData_O[26] Tile_X0Y4_FrameData_O[27]
+ Tile_X0Y4_FrameData_O[28] Tile_X0Y4_FrameData_O[29] Tile_X0Y4_FrameData_O[2] Tile_X0Y4_FrameData_O[30]
+ Tile_X0Y4_FrameData_O[31] Tile_X0Y4_FrameData_O[3] Tile_X0Y4_FrameData_O[4] Tile_X0Y4_FrameData_O[5]
+ Tile_X0Y4_FrameData_O[6] Tile_X0Y4_FrameData_O[7] Tile_X0Y4_FrameData_O[8] Tile_X0Y4_FrameData_O[9]
+ Tile_X0Y4_UserCLK Tile_X0Y4_UserCLKo Tile_X0Y4_W1END[0] Tile_X0Y4_W1END[1] Tile_X0Y4_W1END[2]
+ Tile_X0Y4_W1END[3] Tile_X0Y4_W2END[0] Tile_X0Y4_W2END[1] Tile_X0Y4_W2END[2] Tile_X0Y4_W2END[3]
+ Tile_X0Y4_W2END[4] Tile_X0Y4_W2END[5] Tile_X0Y4_W2END[6] Tile_X0Y4_W2END[7] Tile_X0Y4_W2MID[0]
+ Tile_X0Y4_W2MID[1] Tile_X0Y4_W2MID[2] Tile_X0Y4_W2MID[3] Tile_X0Y4_W2MID[4] Tile_X0Y4_W2MID[5]
+ Tile_X0Y4_W2MID[6] Tile_X0Y4_W2MID[7] Tile_X0Y4_W6END[0] Tile_X0Y4_W6END[10] Tile_X0Y4_W6END[11]
+ Tile_X0Y4_W6END[1] Tile_X0Y4_W6END[2] Tile_X0Y4_W6END[3] Tile_X0Y4_W6END[4] Tile_X0Y4_W6END[5]
+ Tile_X0Y4_W6END[6] Tile_X0Y4_W6END[7] Tile_X0Y4_W6END[8] Tile_X0Y4_W6END[9] Tile_X0Y4_WW4END[0]
+ Tile_X0Y4_WW4END[10] Tile_X0Y4_WW4END[11] Tile_X0Y4_WW4END[12] Tile_X0Y4_WW4END[13]
+ Tile_X0Y4_WW4END[14] Tile_X0Y4_WW4END[15] Tile_X0Y4_WW4END[1] Tile_X0Y4_WW4END[2]
+ Tile_X0Y4_WW4END[3] Tile_X0Y4_WW4END[4] Tile_X0Y4_WW4END[5] Tile_X0Y4_WW4END[6]
+ Tile_X0Y4_WW4END[7] Tile_X0Y4_WW4END[8] Tile_X0Y4_WW4END[9] Tile_X0Y5_E1BEG[0] Tile_X0Y5_E1BEG[1]
+ Tile_X0Y5_E1BEG[2] Tile_X0Y5_E1BEG[3] Tile_X0Y5_E2BEG[0] Tile_X0Y5_E2BEG[1] Tile_X0Y5_E2BEG[2]
+ Tile_X0Y5_E2BEG[3] Tile_X0Y5_E2BEG[4] Tile_X0Y5_E2BEG[5] Tile_X0Y5_E2BEG[6] Tile_X0Y5_E2BEG[7]
+ Tile_X0Y5_E2BEGb[0] Tile_X0Y5_E2BEGb[1] Tile_X0Y5_E2BEGb[2] Tile_X0Y5_E2BEGb[3]
+ Tile_X0Y5_E2BEGb[4] Tile_X0Y5_E2BEGb[5] Tile_X0Y5_E2BEGb[6] Tile_X0Y5_E2BEGb[7]
+ Tile_X0Y5_E6BEG[0] Tile_X0Y5_E6BEG[10] Tile_X0Y5_E6BEG[11] Tile_X0Y5_E6BEG[1] Tile_X0Y5_E6BEG[2]
+ Tile_X0Y5_E6BEG[3] Tile_X0Y5_E6BEG[4] Tile_X0Y5_E6BEG[5] Tile_X0Y5_E6BEG[6] Tile_X0Y5_E6BEG[7]
+ Tile_X0Y5_E6BEG[8] Tile_X0Y5_E6BEG[9] Tile_X0Y5_EE4BEG[0] Tile_X0Y5_EE4BEG[10] Tile_X0Y5_EE4BEG[11]
+ Tile_X0Y5_EE4BEG[12] Tile_X0Y5_EE4BEG[13] Tile_X0Y5_EE4BEG[14] Tile_X0Y5_EE4BEG[15]
+ Tile_X0Y5_EE4BEG[1] Tile_X0Y5_EE4BEG[2] Tile_X0Y5_EE4BEG[3] Tile_X0Y5_EE4BEG[4]
+ Tile_X0Y5_EE4BEG[5] Tile_X0Y5_EE4BEG[6] Tile_X0Y5_EE4BEG[7] Tile_X0Y5_EE4BEG[8]
+ Tile_X0Y5_EE4BEG[9] Tile_X0Y5_FrameData[0] Tile_X0Y5_FrameData[10] Tile_X0Y5_FrameData[11]
+ Tile_X0Y5_FrameData[12] Tile_X0Y5_FrameData[13] Tile_X0Y5_FrameData[14] Tile_X0Y5_FrameData[15]
+ Tile_X0Y5_FrameData[16] Tile_X0Y5_FrameData[17] Tile_X0Y5_FrameData[18] Tile_X0Y5_FrameData[19]
+ Tile_X0Y5_FrameData[1] Tile_X0Y5_FrameData[20] Tile_X0Y5_FrameData[21] Tile_X0Y5_FrameData[22]
+ Tile_X0Y5_FrameData[23] Tile_X0Y5_FrameData[24] Tile_X0Y5_FrameData[25] Tile_X0Y5_FrameData[26]
+ Tile_X0Y5_FrameData[27] Tile_X0Y5_FrameData[28] Tile_X0Y5_FrameData[29] Tile_X0Y5_FrameData[2]
+ Tile_X0Y5_FrameData[30] Tile_X0Y5_FrameData[31] Tile_X0Y5_FrameData[3] Tile_X0Y5_FrameData[4]
+ Tile_X0Y5_FrameData[5] Tile_X0Y5_FrameData[6] Tile_X0Y5_FrameData[7] Tile_X0Y5_FrameData[8]
+ Tile_X0Y5_FrameData[9] Tile_X0Y5_FrameData_O[0] Tile_X0Y5_FrameData_O[10] Tile_X0Y5_FrameData_O[11]
+ Tile_X0Y5_FrameData_O[12] Tile_X0Y5_FrameData_O[13] Tile_X0Y5_FrameData_O[14] Tile_X0Y5_FrameData_O[15]
+ Tile_X0Y5_FrameData_O[16] Tile_X0Y5_FrameData_O[17] Tile_X0Y5_FrameData_O[18] Tile_X0Y5_FrameData_O[19]
+ Tile_X0Y5_FrameData_O[1] Tile_X0Y5_FrameData_O[20] Tile_X0Y5_FrameData_O[21] Tile_X0Y5_FrameData_O[22]
+ Tile_X0Y5_FrameData_O[23] Tile_X0Y5_FrameData_O[24] Tile_X0Y5_FrameData_O[25] Tile_X0Y5_FrameData_O[26]
+ Tile_X0Y5_FrameData_O[27] Tile_X0Y5_FrameData_O[28] Tile_X0Y5_FrameData_O[29] Tile_X0Y5_FrameData_O[2]
+ Tile_X0Y5_FrameData_O[30] Tile_X0Y5_FrameData_O[31] Tile_X0Y5_FrameData_O[3] Tile_X0Y5_FrameData_O[4]
+ Tile_X0Y5_FrameData_O[5] Tile_X0Y5_FrameData_O[6] Tile_X0Y5_FrameData_O[7] Tile_X0Y5_FrameData_O[8]
+ Tile_X0Y5_FrameData_O[9] Tile_X0Y5_FrameStrobe[0] Tile_X0Y5_FrameStrobe[10] Tile_X0Y5_FrameStrobe[11]
+ Tile_X0Y5_FrameStrobe[12] Tile_X0Y5_FrameStrobe[13] Tile_X0Y5_FrameStrobe[14] Tile_X0Y5_FrameStrobe[15]
+ Tile_X0Y5_FrameStrobe[16] Tile_X0Y5_FrameStrobe[17] Tile_X0Y5_FrameStrobe[18] Tile_X0Y5_FrameStrobe[19]
+ Tile_X0Y5_FrameStrobe[1] Tile_X0Y5_FrameStrobe[2] Tile_X0Y5_FrameStrobe[3] Tile_X0Y5_FrameStrobe[4]
+ Tile_X0Y5_FrameStrobe[5] Tile_X0Y5_FrameStrobe[6] Tile_X0Y5_FrameStrobe[7] Tile_X0Y5_FrameStrobe[8]
+ Tile_X0Y5_FrameStrobe[9] Tile_X0Y5_N1END[0] Tile_X0Y5_N1END[1] Tile_X0Y5_N1END[2]
+ Tile_X0Y5_N1END[3] Tile_X0Y5_N2END[0] Tile_X0Y5_N2END[1] Tile_X0Y5_N2END[2] Tile_X0Y5_N2END[3]
+ Tile_X0Y5_N2END[4] Tile_X0Y5_N2END[5] Tile_X0Y5_N2END[6] Tile_X0Y5_N2END[7] Tile_X0Y5_N2MID[0]
+ Tile_X0Y5_N2MID[1] Tile_X0Y5_N2MID[2] Tile_X0Y5_N2MID[3] Tile_X0Y5_N2MID[4] Tile_X0Y5_N2MID[5]
+ Tile_X0Y5_N2MID[6] Tile_X0Y5_N2MID[7] Tile_X0Y5_N4END[0] Tile_X0Y5_N4END[10] Tile_X0Y5_N4END[11]
+ Tile_X0Y5_N4END[12] Tile_X0Y5_N4END[13] Tile_X0Y5_N4END[14] Tile_X0Y5_N4END[15]
+ Tile_X0Y5_N4END[1] Tile_X0Y5_N4END[2] Tile_X0Y5_N4END[3] Tile_X0Y5_N4END[4] Tile_X0Y5_N4END[5]
+ Tile_X0Y5_N4END[6] Tile_X0Y5_N4END[7] Tile_X0Y5_N4END[8] Tile_X0Y5_N4END[9] Tile_X0Y5_S1BEG[0]
+ Tile_X0Y5_S1BEG[1] Tile_X0Y5_S1BEG[2] Tile_X0Y5_S1BEG[3] Tile_X0Y5_S2BEG[0] Tile_X0Y5_S2BEG[1]
+ Tile_X0Y5_S2BEG[2] Tile_X0Y5_S2BEG[3] Tile_X0Y5_S2BEG[4] Tile_X0Y5_S2BEG[5] Tile_X0Y5_S2BEG[6]
+ Tile_X0Y5_S2BEG[7] Tile_X0Y5_S2BEGb[0] Tile_X0Y5_S2BEGb[1] Tile_X0Y5_S2BEGb[2] Tile_X0Y5_S2BEGb[3]
+ Tile_X0Y5_S2BEGb[4] Tile_X0Y5_S2BEGb[5] Tile_X0Y5_S2BEGb[6] Tile_X0Y5_S2BEGb[7]
+ Tile_X0Y5_S4BEG[0] Tile_X0Y5_S4BEG[10] Tile_X0Y5_S4BEG[11] Tile_X0Y5_S4BEG[12] Tile_X0Y5_S4BEG[13]
+ Tile_X0Y5_S4BEG[14] Tile_X0Y5_S4BEG[15] Tile_X0Y5_S4BEG[1] Tile_X0Y5_S4BEG[2] Tile_X0Y5_S4BEG[3]
+ Tile_X0Y5_S4BEG[4] Tile_X0Y5_S4BEG[5] Tile_X0Y5_S4BEG[6] Tile_X0Y5_S4BEG[7] Tile_X0Y5_S4BEG[8]
+ Tile_X0Y5_S4BEG[9] Tile_X0Y5_UserCLK Tile_X0Y5_UserCLKo Tile_X0Y5_W1END[0] Tile_X0Y5_W1END[1]
+ Tile_X0Y5_W1END[2] Tile_X0Y5_W1END[3] Tile_X0Y5_W2END[0] Tile_X0Y5_W2END[1] Tile_X0Y5_W2END[2]
+ Tile_X0Y5_W2END[3] Tile_X0Y5_W2END[4] Tile_X0Y5_W2END[5] Tile_X0Y5_W2END[6] Tile_X0Y5_W2END[7]
+ Tile_X0Y5_W2MID[0] Tile_X0Y5_W2MID[1] Tile_X0Y5_W2MID[2] Tile_X0Y5_W2MID[3] Tile_X0Y5_W2MID[4]
+ Tile_X0Y5_W2MID[5] Tile_X0Y5_W2MID[6] Tile_X0Y5_W2MID[7] Tile_X0Y5_W6END[0] Tile_X0Y5_W6END[10]
+ Tile_X0Y5_W6END[11] Tile_X0Y5_W6END[1] Tile_X0Y5_W6END[2] Tile_X0Y5_W6END[3] Tile_X0Y5_W6END[4]
+ Tile_X0Y5_W6END[5] Tile_X0Y5_W6END[6] Tile_X0Y5_W6END[7] Tile_X0Y5_W6END[8] Tile_X0Y5_W6END[9]
+ Tile_X0Y5_WW4END[0] Tile_X0Y5_WW4END[10] Tile_X0Y5_WW4END[11] Tile_X0Y5_WW4END[12]
+ Tile_X0Y5_WW4END[13] Tile_X0Y5_WW4END[14] Tile_X0Y5_WW4END[15] Tile_X0Y5_WW4END[1]
+ Tile_X0Y5_WW4END[2] Tile_X0Y5_WW4END[3] Tile_X0Y5_WW4END[4] Tile_X0Y5_WW4END[5]
+ Tile_X0Y5_WW4END[6] Tile_X0Y5_WW4END[7] Tile_X0Y5_WW4END[8] Tile_X0Y5_WW4END[9]
+ VGND VPWR
XANTENNA__0885__D Tile_X0Y3_FrameData[1] VPWR VGND sg13cmos5l_antennanp
XFILLER_100_127 VPWR VGND sg13cmos5l_decap_8
XANTENNA__1911__X Tile_X0Y1_FrameData_O[24] VPWR VGND sg13cmos5l_antennanp
X_0367_ _0367_/Q Tile_X0Y1_FrameData[7] VGND VPWR Tile_X0Y5_FrameStrobe[1] latch
XFILLER_223_98 VPWR VGND sg13cmos5l_decap_8
X_2106_ AXIL_S_SOC_RDATA0 Tile_X0Y3_W2MID[0] Tile_X0Y3_W2END[0] Tile_X0Y3_W6END[0]
+ _2589_/X _0862_/Q _0861_/Q VPWR VGND sg13cmos5l_mux4_1
X_0298_ _0298_/Q Tile_X0Y0_FrameData[28] VGND VPWR Tile_X0Y5_FrameStrobe[7] latch
X_2037_ Tile_X0Y5_FrameData_O[22] Tile_X0Y5_FrameData[22] VPWR VGND sg13cmos5l_buf_1
XFILLER_299_47 VPWR VGND sg13cmos5l_decap_8
XANTENNA__2246__A3 Tile_X0Y0_S2END[5] VPWR VGND sg13cmos5l_antennanp
XANTENNA__2651__A0 Tile_X0Y5_N4END[6] VPWR VGND sg13cmos5l_antennanp
XFILLER_299_69 VPWR VGND sg13cmos5l_fill_1
XANTENNA__2403__A0 AXIL_S_SOC_AWADDR2 VPWR VGND sg13cmos5l_antennanp
XANTENNA__0125__D Tile_X0Y0_FrameData[9] VPWR VGND sg13cmos5l_antennanp
XFILLER_108_216 VPWR VGND sg13cmos5l_fill_2
XFILLER_184_17 VPWR VGND sg13cmos5l_fill_2
XFILLER_306_9 VPWR VGND sg13cmos5l_decap_8
XANTENNA__2706__A1 Tile_X0Y5_N4END[4] VPWR VGND sg13cmos5l_antennanp
XFILLER_184_39 VPWR VGND sg13cmos5l_fill_1
XFILLER_117_33 VPWR VGND sg13cmos5l_fill_1
XFILLER_190_185 VPWR VGND sg13cmos5l_decap_8
XFILLER_324_179 VPWR VGND sg13cmos5l_decap_4
XFILLER_264_83 VPWR VGND sg13cmos5l_fill_2
XFILLER_89_133 VPWR VGND sg13cmos5l_fill_2
XANTENNA__0795__D Tile_X0Y3_FrameData[27] VPWR VGND sg13cmos5l_antennanp
XFILLER_292_204 VPWR VGND sg13cmos5l_fill_1
XANTENNA__1821__X Tile_X0Y4_EE4BEG[4] VPWR VGND sg13cmos5l_antennanp
XFILLER_133_65 VPWR VGND sg13cmos5l_decap_8
XFILLER_245_142 VPWR VGND sg13cmos5l_fill_2
XANTENNA__2237__A3 Tile_X0Y0_S4END[1] VPWR VGND sg13cmos5l_antennanp
XFILLER_26_74 VPWR VGND sg13cmos5l_decap_4
XFILLER_359_17 VPWR VGND sg13cmos5l_fill_1
XANTENNA__2642__A0 AXIL_S_SOC_WSTRB3 VPWR VGND sg13cmos5l_antennanp
XFILLER_13_177 VPWR VGND sg13cmos5l_fill_2
XFILLER_158_40 VPWR VGND sg13cmos5l_decap_8
XFILLER_220_0 VPWR VGND sg13cmos5l_fill_2
XFILLER_318_0 VPWR VGND sg13cmos5l_fill_1
XANTENNA__0180__GATE Tile_X0Y5_FrameStrobe[3] VPWR VGND sg13cmos5l_antennanp
XFILLER_181_163 VPWR VGND sg13cmos5l_decap_8
XANTENNA__0195__GATE Tile_X0Y5_FrameStrobe[3] VPWR VGND sg13cmos5l_antennanp
XANTENNA__2099__X Tile_X0Y3_E2BEGb[3] VPWR VGND sg13cmos5l_antennanp
XFILLER_95_103 VPWR VGND sg13cmos5l_decap_8
X_1270_ _1270_/Q Tile_X0Y5_FrameData[26] VGND VPWR Tile_X0Y5_FrameStrobe[0] latch
XANTENNA__1731__X Tile_X0Y0_E2BEG[3] VPWR VGND sg13cmos5l_antennanp
X_0221_ _0221_/Q Tile_X0Y0_FrameData[9] VGND VPWR Tile_X0Y5_FrameStrobe[4] latch
XFILLER_67_81 VPWR VGND sg13cmos5l_decap_8
XANTENNA__2476__A3 Tile_X0Y0_S4END[10] VPWR VGND sg13cmos5l_antennanp
X_0152_ _0152_/Q Tile_X0Y0_FrameData[14] VGND VPWR Tile_X0Y5_FrameStrobe[2] latch
XFILLER_251_112 VPWR VGND sg13cmos5l_decap_4
XFILLER_251_145 VPWR VGND sg13cmos5l_decap_4
X_0083_ _0083_/Q Tile_X0Y0_FrameData[19] VGND VPWR Tile_X0Y5_FrameStrobe[0] latch
XANTENNA__0133__GATE Tile_X0Y5_FrameStrobe[1] VPWR VGND sg13cmos5l_antennanp
XANTENNA__2633__A0 Tile_X0Y4_WW4END[4] VPWR VGND sg13cmos5l_antennanp
XANTENNA__0763__GATE Tile_X0Y5_FrameStrobe[6] VPWR VGND sg13cmos5l_antennanp
XFILLER_149_149 VPWR VGND sg13cmos5l_fill_2
XANTENNA__0148__GATE Tile_X0Y5_FrameStrobe[2] VPWR VGND sg13cmos5l_antennanp
XFILLER_285_16 VPWR VGND sg13cmos5l_decap_8
X_0985_ _0985_/Q Tile_X0Y3_FrameData[29] VGND VPWR Tile_X0Y5_FrameStrobe[6] latch
XFILLER_349_94 VPWR VGND sg13cmos5l_decap_8
XANTENNA__0778__GATE Tile_X0Y5_FrameStrobe[7] VPWR VGND sg13cmos5l_antennanp
XANTENNA__2400__A3 AXIL_S_SOC_AWADDR4 VPWR VGND sg13cmos5l_antennanp
XFILLER_218_21 VPWR VGND sg13cmos5l_decap_8
X_2724_ _2724_/X Tile_X0Y5_N1END[3] _2796_/X AXIL_S_SOC_ARPROT1 AXIL_S_SOC_RREADY
+ _1454_/Q _1453_/Q VPWR VGND sg13cmos5l_mux4_1
X_2655_ _2655_/X AXIL_S_SOC_WSTRB0 _2704_/X _2693_/X _2710_/X _1144_/Q _1143_/Q VPWR
+ VGND sg13cmos5l_mux4_1
XANTENNA__1906__X Tile_X0Y1_FrameData_O[19] VPWR VGND sg13cmos5l_antennanp
X_1606_ Tile_X0Y0_N4BEG[2] _1606_/A VPWR VGND sg13cmos5l_buf_1
XANTENNA__0701__GATE Tile_X0Y5_FrameStrobe[4] VPWR VGND sg13cmos5l_antennanp
XANTENNA__2164__A2 AXIL_S_SOC_WDATA17 VPWR VGND sg13cmos5l_antennanp
X_2586_ _2586_/X _2568_/X Tile_X0Y5_N4END[9] _2567_/X Tile_X0Y0_S4END[13] _0844_/Q
+ _0843_/Q VPWR VGND sg13cmos5l_mux4_1
XFILLER_234_20 VPWR VGND sg13cmos5l_fill_1
XFILLER_234_42 VPWR VGND sg13cmos5l_decap_8
X_1537_ Tile_X0Y3_E6BEG[11] _2552_/X VPWR VGND sg13cmos5l_buf_1
XFILLER_274_204 VPWR VGND sg13cmos5l_decap_8
X_1468_ _1468_/Q Tile_X0Y5_FrameData[20] VGND VPWR Tile_X0Y5_FrameStrobe[6] latch
XANTENNA__1641__X Tile_X0Y0_FrameStrobe_O[1] VPWR VGND sg13cmos5l_antennanp
X_1399_ _1399_/Q Tile_X0Y5_FrameData[25] VGND VPWR Tile_X0Y5_FrameStrobe[4] latch
X_0419_ _0419_/Q Tile_X0Y1_FrameData[19] VGND VPWR Tile_X0Y5_FrameStrobe[3] latch
XANTENNA__0716__GATE Tile_X0Y5_FrameStrobe[5] VPWR VGND sg13cmos5l_antennanp
XANTENNA__2467__A3 Tile_X0Y0_S4END[10] VPWR VGND sg13cmos5l_antennanp
XFILLER_27_214 VPWR VGND sg13cmos5l_fill_1
XFILLER_227_164 VPWR VGND sg13cmos5l_decap_8
XFILLER_250_30 VPWR VGND sg13cmos5l_decap_4
XFILLER_250_41 VPWR VGND sg13cmos5l_decap_4
XFILLER_242_134 VPWR VGND sg13cmos5l_fill_1
XFILLER_242_145 VPWR VGND sg13cmos5l_decap_8
XANTENNA__2624__A0 AXIL_S_SOC_WSTRB1 VPWR VGND sg13cmos5l_antennanp
XFILLER_242_189 VPWR VGND sg13cmos5l_decap_8
XFILLER_144_7 VPWR VGND sg13cmos5l_decap_8
XFILLER_259_72 VPWR VGND sg13cmos5l_decap_8
XFILLER_344_208 VPWR VGND sg13cmos5l_fill_1
XFILLER_311_7 VPWR VGND sg13cmos5l_fill_1
XFILLER_163_152 VPWR VGND sg13cmos5l_decap_4
XANTENNA__1816__X Tile_X0Y4_E6BEG[11] VPWR VGND sg13cmos5l_antennanp
XFILLER_312_105 VPWR VGND sg13cmos5l_decap_8
XANTENNA__2155__A2 Tile_X0Y0_WW4END[5] VPWR VGND sg13cmos5l_antennanp
XFILLER_88_47 VPWR VGND sg13cmos5l_fill_1
XFILLER_361_29 VPWR VGND sg13cmos5l_fill_2
XANTENNA__1414__D Tile_X0Y5_FrameData[10] VPWR VGND sg13cmos5l_antennanp
XFILLER_77_158 VPWR VGND sg13cmos5l_decap_8
XFILLER_320_193 VPWR VGND sg13cmos5l_decap_8
XANTENNA__1551__X Tile_X0Y3_EE4BEG[13] VPWR VGND sg13cmos5l_antennanp
XFILLER_170_0 VPWR VGND sg13cmos5l_fill_2
XFILLER_268_0 VPWR VGND sg13cmos5l_decap_8
XFILLER_37_84 VPWR VGND sg13cmos5l_decap_8
XFILLER_160_96 VPWR VGND sg13cmos5l_decap_8
XFILLER_310_33 VPWR VGND sg13cmos5l_decap_8
XFILLER_310_77 VPWR VGND sg13cmos5l_decap_8
XANTENNA__1493__GATE Tile_X0Y5_FrameStrobe[7] VPWR VGND sg13cmos5l_antennanp
XFILLER_169_72 VPWR VGND sg13cmos5l_decap_8
X_0770_ _0770_/Q Tile_X0Y2_FrameData[4] VGND VPWR Tile_X0Y5_FrameStrobe[6] latch
XANTENNA__2394__A2 Tile_X0Y3_W6END[1] VPWR VGND sg13cmos5l_antennanp
XFILLER_154_141 VPWR VGND sg13cmos5l_fill_1
XFILLER_319_97 VPWR VGND sg13cmos5l_decap_8
XFILLER_319_75 VPWR VGND sg13cmos5l_decap_8
XANTENNA__1726__X Tile_X0Y0_E2BEGb[6] VPWR VGND sg13cmos5l_antennanp
X_2440_ _2440_/X AXIL_S_SOC_AWADDR7 _2479_/X _2472_/X _2484_/X _0668_/Q _0667_/Q VPWR
+ VGND sg13cmos5l_mux4_1
XFILLER_303_116 VPWR VGND sg13cmos5l_fill_1
XANTENNA__2146__A2 Tile_X0Y0_W6END[6] VPWR VGND sg13cmos5l_antennanp
XFILLER_303_127 VPWR VGND sg13cmos5l_fill_2
XANTENNA__1431__GATE Tile_X0Y5_FrameStrobe[5] VPWR VGND sg13cmos5l_antennanp
X_2371_ _2371_/X _2342_/X _0063_/X _2341_/X Tile_X0Y0_S4END[4] _0358_/Q _0357_/Q VPWR
+ VGND sg13cmos5l_mux4_1
XFILLER_335_63 VPWR VGND sg13cmos5l_decap_8
X_1322_ _1322_/Q Tile_X0Y5_FrameData[6] VGND VPWR Tile_X0Y5_FrameStrobe[1] latch
XANTENNA__1324__D Tile_X0Y5_FrameData[4] VPWR VGND sg13cmos5l_antennanp
X_1253_ _1253_/Q Tile_X0Y4_FrameData[1] VGND VPWR Tile_X0Y5_FrameStrobe[6] latch
XANTENNA__1902__A Tile_X0Y1_FrameData[15] VPWR VGND sg13cmos5l_antennanp
XANTENNA__2449__A3 Tile_X0Y2_W6END[6] VPWR VGND sg13cmos5l_antennanp
X_0204_ _0204_/Q Tile_X0Y0_FrameData[26] VGND VPWR Tile_X0Y5_FrameStrobe[4] latch
XFILLER_83_139 VPWR VGND sg13cmos5l_decap_8
XFILLER_351_73 VPWR VGND sg13cmos5l_decap_8
XANTENNA__1446__GATE Tile_X0Y5_FrameStrobe[5] VPWR VGND sg13cmos5l_antennanp
XFILLER_224_101 VPWR VGND sg13cmos5l_decap_8
X_1184_ _1184_/Q Tile_X0Y4_FrameData[6] VGND VPWR Tile_X0Y5_FrameStrobe[4] latch
XANTENNA__0072__GATE Tile_X0Y5_FrameStrobe[0] VPWR VGND sg13cmos5l_antennanp
X_0135_ _0135_/Q Tile_X0Y0_FrameData[31] VGND VPWR Tile_X0Y5_FrameStrobe[2] latch
XANTENNA__2606__A0 Tile_X0Y5_W2MID[3] VPWR VGND sg13cmos5l_antennanp
X_0066_ _0066_/X _2223_/X _2224_/X _1235_/Q VPWR VGND sg13cmos5l_mux2_1
XFILLER_296_37 VPWR VGND sg13cmos5l_fill_2
XANTENNA__0087__GATE Tile_X0Y5_FrameStrobe[0] VPWR VGND sg13cmos5l_antennanp
X_0968_ _0968_/Q Tile_X0Y3_FrameData[14] VGND VPWR Tile_X0Y5_FrameStrobe[5] latch
XANTENNA__2385__A2 Tile_X0Y0_W6END[10] VPWR VGND sg13cmos5l_antennanp
X_2707_ _2707_/X _2674_/X Tile_X0Y5_N4END[4] _2673_/X _0039_/X _1086_/Q _1085_/Q VPWR
+ VGND sg13cmos5l_mux4_1
XANTENNA__0403__D Tile_X0Y1_FrameData[3] VPWR VGND sg13cmos5l_antennanp
XANTENNA__0640__GATE Tile_X0Y5_FrameStrobe[2] VPWR VGND sg13cmos5l_antennanp
XANTENNA__1636__X Tile_X0Y0_N1BEG[0] VPWR VGND sg13cmos5l_antennanp
X_0899_ _0899_/Q Tile_X0Y3_FrameData[19] VGND VPWR Tile_X0Y5_FrameStrobe[3] latch
XANTENNA__2137__A2 Tile_X0Y0_W6END[7] VPWR VGND sg13cmos5l_antennanp
XFILLER_145_196 VPWR VGND sg13cmos5l_decap_8
XFILLER_245_52 VPWR VGND sg13cmos5l_decap_4
X_2638_ _2638_/X AXIL_S_SOC_WSTRB3 AXIL_S_SOC_BREADY _2689_/X _2710_/X _1178_/Q _1177_/Q
+ VPWR VGND sg13cmos5l_mux4_1
XFILLER_160_177 VPWR VGND sg13cmos5l_decap_8
X_2569_ _2569_/X Tile_X0Y2_W1END[2] Tile_X0Y2_W6END[10] _2467_/X _2455_/X _0654_/Q
+ _0653_/Q VPWR VGND sg13cmos5l_mux4_1
XFILLER_59_125 VPWR VGND sg13cmos5l_decap_8
XANTENNA__0655__GATE Tile_X0Y5_FrameStrobe[3] VPWR VGND sg13cmos5l_antennanp
XANTENNA__1234__D Tile_X0Y4_FrameData[20] VPWR VGND sg13cmos5l_antennanp
XFILLER_215_134 VPWR VGND sg13cmos5l_fill_1
XFILLER_261_7 VPWR VGND sg13cmos5l_decap_8
XFILLER_130_33 VPWR VGND sg13cmos5l_decap_8
XFILLER_254_6 VPWR VGND sg13cmos5l_decap_4
XFILLER_30_209 VPWR VGND sg13cmos5l_fill_2
XFILLER_130_99 VPWR VGND sg13cmos5l_decap_4
XFILLER_90_48 VPWR VGND sg13cmos5l_decap_8
XFILLER_23_64 VPWR VGND sg13cmos5l_decap_8
XFILLER_139_64 VPWR VGND sg13cmos5l_decap_8
XANTENNA__0313__D Tile_X0Y1_FrameData[29] VPWR VGND sg13cmos5l_antennanp
XANTENNA__0608__GATE Tile_X0Y5_FrameStrobe[1] VPWR VGND sg13cmos5l_antennanp
XANTENNA__1409__D Tile_X0Y5_FrameData[15] VPWR VGND sg13cmos5l_antennanp
XANTENNA__1546__X Tile_X0Y3_EE4BEG[8] VPWR VGND sg13cmos5l_antennanp
XANTENNA__2128__A2 Tile_X0Y1_W6END[6] VPWR VGND sg13cmos5l_antennanp
XFILLER_297_104 VPWR VGND sg13cmos5l_decap_4
XFILLER_151_188 VPWR VGND sg13cmos5l_decap_8
XFILLER_305_22 VPWR VGND sg13cmos5l_fill_1
XANTENNA__1144__D Tile_X0Y4_FrameData[14] VPWR VGND sg13cmos5l_antennanp
XFILLER_171_62 VPWR VGND sg13cmos5l_fill_1
XFILLER_65_117 VPWR VGND sg13cmos5l_decap_8
XFILLER_65_106 VPWR VGND sg13cmos5l_decap_4
XFILLER_48_72 VPWR VGND sg13cmos5l_fill_1
XFILLER_305_88 VPWR VGND sg13cmos5l_fill_1
XANTENNA__0983__D Tile_X0Y3_FrameData[31] VPWR VGND sg13cmos5l_antennanp
XANTENNA__2836__A0 Tile_X0Y4_W1END[3] VPWR VGND sg13cmos5l_antennanp
XFILLER_171_84 VPWR VGND sg13cmos5l_decap_8
XFILLER_80_109 VPWR VGND sg13cmos5l_decap_8
XFILLER_159_200 VPWR VGND sg13cmos5l_decap_8
X_1940_ Tile_X0Y1_E6BEG[5] _2330_/X VPWR VGND sg13cmos5l_buf_1
X_1871_ Tile_X0Y2_E2BEGb[5] _2414_/X VPWR VGND sg13cmos5l_buf_1
X_0822_ _0822_/Q Tile_X0Y3_FrameData[0] VGND VPWR Tile_X0Y5_FrameStrobe[0] latch
XFILLER_9_99 VPWR VGND sg13cmos5l_fill_1
XFILLER_80_70 VPWR VGND sg13cmos5l_decap_8
XANTENNA__0223__D Tile_X0Y0_FrameData[7] VPWR VGND sg13cmos5l_antennanp
XANTENNA__1319__D Tile_X0Y5_FrameData[9] VPWR VGND sg13cmos5l_antennanp
X_0753_ _0753_/Q Tile_X0Y2_FrameData[21] VGND VPWR Tile_X0Y5_FrameStrobe[6] latch
XFILLER_346_40 VPWR VGND sg13cmos5l_decap_8
XANTENNA__1370__GATE Tile_X0Y5_FrameStrobe[3] VPWR VGND sg13cmos5l_antennanp
XANTENNA__2119__A2 Tile_X0Y2_W6END[5] VPWR VGND sg13cmos5l_antennanp
XFILLER_142_111 VPWR VGND sg13cmos5l_decap_8
X_0684_ _0684_/Q Tile_X0Y2_FrameData[26] VGND VPWR Tile_X0Y5_FrameStrobe[4] latch
X_2423_ _2423_/X AXIL_S_SOC_AWADDR6 AXIL_S_SOC_AWPROT0 _2470_/X _2482_/X _0702_/Q
+ _0701_/Q VPWR VGND sg13cmos5l_mux4_1
X_2354_ _2354_/X _2346_/X _0030_/X _2345_/X Tile_X0Y0_S4END[6] _0346_/Q _0345_/Q VPWR
+ VGND sg13cmos5l_mux4_1
X_1305_ _1305_/Q Tile_X0Y5_FrameData[23] VGND VPWR Tile_X0Y5_FrameStrobe[1] latch
XFILLER_29_0 VPWR VGND sg13cmos5l_fill_2
XANTENNA__1054__D Tile_X0Y4_FrameData[8] VPWR VGND sg13cmos5l_antennanp
XANTENNA__1385__GATE Tile_X0Y5_FrameStrobe[3] VPWR VGND sg13cmos5l_antennanp
XFILLER_215_99 VPWR VGND sg13cmos5l_decap_8
X_2285_ _2285_/X Tile_X0Y3_W1END[1] Tile_X0Y3_WW4END[1] Tile_X0Y3_WW4END[5] Tile_X0Y3_W6END[9]
+ _1003_/Q _1002_/Q VPWR VGND sg13cmos5l_mux4_1
XANTENNA__2827__A0 Tile_X0Y5_N2MID[2] VPWR VGND sg13cmos5l_antennanp
X_1236_ _1236_/Q Tile_X0Y4_FrameData[18] VGND VPWR Tile_X0Y5_FrameStrobe[6] latch
XANTENNA__0893__D Tile_X0Y3_FrameData[25] VPWR VGND sg13cmos5l_antennanp
XFILLER_231_43 VPWR VGND sg13cmos5l_decap_8
X_1167_ _1167_/Q Tile_X0Y4_FrameData[23] VGND VPWR Tile_X0Y5_FrameStrobe[4] latch
XFILLER_212_104 VPWR VGND sg13cmos5l_fill_1
X_0118_ _0118_/Q Tile_X0Y0_FrameData[16] VGND VPWR Tile_X0Y5_FrameStrobe[1] latch
XFILLER_212_126 VPWR VGND sg13cmos5l_decap_8
XFILLER_212_137 VPWR VGND sg13cmos5l_fill_1
X_1098_ _1098_/Q Tile_X0Y4_FrameData[28] VGND VPWR Tile_X0Y5_FrameStrobe[2] latch
XFILLER_358_119 VPWR VGND sg13cmos5l_fill_2
XFILLER_100_14 VPWR VGND sg13cmos5l_fill_2
XFILLER_212_159 VPWR VGND sg13cmos5l_fill_2
X_0049_ _0049_/X _2219_/X _2220_/X _1238_/Q VPWR VGND sg13cmos5l_mux2_1
XFILLER_100_69 VPWR VGND sg13cmos5l_decap_8
XANTENNA__1323__GATE Tile_X0Y5_FrameStrobe[1] VPWR VGND sg13cmos5l_antennanp
XFILLER_220_181 VPWR VGND sg13cmos5l_fill_2
XANTENNA__0133__D Tile_X0Y0_FrameData[1] VPWR VGND sg13cmos5l_antennanp
XANTENNA__1229__D Tile_X0Y4_FrameData[25] VPWR VGND sg13cmos5l_antennanp
XFILLER_133_100 VPWR VGND sg13cmos5l_decap_8
XFILLER_180_206 VPWR VGND sg13cmos5l_fill_2
XANTENNA__1338__GATE Tile_X0Y5_FrameStrobe[2] VPWR VGND sg13cmos5l_antennanp
XFILLER_118_196 VPWR VGND sg13cmos5l_fill_2
XANTENNA__0594__GATE Tile_X0Y5_FrameStrobe[1] VPWR VGND sg13cmos5l_antennanp
XFILLER_125_22 VPWR VGND sg13cmos5l_fill_2
XFILLER_294_107 VPWR VGND sg13cmos5l_decap_8
XANTENNA__2818__A0 Tile_X0Y5_N1END[2] VPWR VGND sg13cmos5l_antennanp
XFILLER_141_21 VPWR VGND sg13cmos5l_decap_8
XANTENNA__2294__A1 AXIL_S_SOC_WDATA9 VPWR VGND sg13cmos5l_antennanp
XFILLER_18_64 VPWR VGND sg13cmos5l_decap_8
XFILLER_141_76 VPWR VGND sg13cmos5l_decap_4
XANTENNA__0308__D Tile_X0Y0_FrameData[18] VPWR VGND sg13cmos5l_antennanp
XFILLER_70_142 VPWR VGND sg13cmos5l_decap_8
XFILLER_349_108 VPWR VGND sg13cmos5l_decap_8
XANTENNA__0532__GATE Tile_X0Y5_FrameStrobe[6] VPWR VGND sg13cmos5l_antennanp
XANTENNA__2597__A2 Tile_X0Y2_W6END[8] VPWR VGND sg13cmos5l_antennanp
XFILLER_357_152 VPWR VGND sg13cmos5l_decap_8
XFILLER_357_141 VPWR VGND sg13cmos5l_decap_4
XANTENNA__0547__GATE Tile_X0Y5_FrameStrobe[7] VPWR VGND sg13cmos5l_antennanp
XFILLER_357_196 VPWR VGND sg13cmos5l_decap_8
XANTENNA__1139__D Tile_X0Y4_FrameData[19] VPWR VGND sg13cmos5l_antennanp
XANTENNA__0978__D Tile_X0Y3_FrameData[4] VPWR VGND sg13cmos5l_antennanp
XFILLER_59_93 VPWR VGND sg13cmos5l_fill_1
XFILLER_93_201 VPWR VGND sg13cmos5l_fill_2
XANTENNA__2809__A0 Tile_X0Y5_N1END[1] VPWR VGND sg13cmos5l_antennanp
X_2070_ Tile_X0Y5_S4BEG[3] _2070_/A VPWR VGND sg13cmos5l_buf_1
XFILLER_93_223 VPWR VGND sg13cmos5l_fill_1
XANTENNA__2285__A1 Tile_X0Y3_WW4END[1] VPWR VGND sg13cmos5l_antennanp
X_1021_ _1021_/Q Tile_X0Y3_FrameData[25] VGND VPWR Tile_X0Y5_FrameStrobe[7] latch
XFILLER_75_70 VPWR VGND sg13cmos5l_decap_8
XANTENNA__0218__D Tile_X0Y0_FrameData[12] VPWR VGND sg13cmos5l_antennanp
XFILLER_201_24 VPWR VGND sg13cmos5l_decap_4
X_1923_ Tile_X0Y1_EE4BEG[4] _2313_/X VPWR VGND sg13cmos5l_buf_1
XFILLER_348_130 VPWR VGND sg13cmos5l_decap_8
XFILLER_202_192 VPWR VGND sg13cmos5l_decap_8
X_1854_ Tile_X0Y4_FrameData_O[21] Tile_X0Y4_FrameData[21] VPWR VGND sg13cmos5l_buf_1
XFILLER_357_61 VPWR VGND sg13cmos5l_decap_8
XANTENNA__1049__D Tile_X0Y4_FrameData[13] VPWR VGND sg13cmos5l_antennanp
X_1785_ Tile_X0Y4_E1BEG[0] _2613_/X VPWR VGND sg13cmos5l_buf_1
X_0805_ _0805_/Q Tile_X0Y3_FrameData[17] VGND VPWR Tile_X0Y5_FrameStrobe[0] latch
XFILLER_115_100 VPWR VGND sg13cmos5l_decap_8
XFILLER_293_49 VPWR VGND sg13cmos5l_decap_8
X_0736_ _0736_/Q Tile_X0Y2_FrameData[6] VGND VPWR Tile_X0Y5_FrameStrobe[5] latch
XANTENNA__0888__D Tile_X0Y3_FrameData[30] VPWR VGND sg13cmos5l_antennanp
XANTENNA__1914__X Tile_X0Y1_FrameData_O[27] VPWR VGND sg13cmos5l_antennanp
XFILLER_130_103 VPWR VGND sg13cmos5l_fill_1
XFILLER_276_118 VPWR VGND sg13cmos5l_decap_8
X_2406_ _2406_/X AXIL_S_SOC_AWADDR5 AXIL_S_SOC_AWVALID _2483_/X _2486_/X _0736_/Q
+ _0735_/Q VPWR VGND sg13cmos5l_mux4_1
X_0667_ _0667_/Q Tile_X0Y2_FrameData[11] VGND VPWR Tile_X0Y5_FrameStrobe[3] latch
X_0598_ _0598_/Q Tile_X0Y2_FrameData[16] VGND VPWR Tile_X0Y5_FrameStrobe[1] latch
X_2337_ _2337_/X _2342_/X _2341_/X Tile_X0Y1_W6END[0] _2337_/A3 _0318_/Q _0317_/Q
+ VPWR VGND sg13cmos5l_mux4_1
XFILLER_84_201 VPWR VGND sg13cmos5l_decap_8
XFILLER_242_42 VPWR VGND sg13cmos5l_fill_1
X_2268_ _2268_/X _2368_/X _2366_/X _2354_/X _2353_/X _0520_/Q _0519_/Q VPWR VGND sg13cmos5l_mux4_1
X_1219_ _1219_/Q Tile_X0Y4_FrameData[3] VGND VPWR Tile_X0Y5_FrameStrobe[5] latch
XANTENNA__2815__A3 Tile_X0Y1_W6END[7] VPWR VGND sg13cmos5l_antennanp
X_2199_ _2199_/X _0064_/X Tile_X0Y0_S4END[2] _2226_/X _2225_/X _0198_/Q _0197_/Q VPWR
+ VGND sg13cmos5l_mux4_1
XANTENNA__0128__D Tile_X0Y0_FrameData[6] VPWR VGND sg13cmos5l_antennanp
XFILLER_197_125 VPWR VGND sg13cmos5l_decap_8
XFILLER_197_136 VPWR VGND sg13cmos5l_decap_8
XFILLER_52_186 VPWR VGND sg13cmos5l_fill_1
XFILLER_52_175 VPWR VGND sg13cmos5l_decap_8
XANTENNA__1262__GATE Tile_X0Y5_FrameStrobe[7] VPWR VGND sg13cmos5l_antennanp
XFILLER_339_141 VPWR VGND sg13cmos5l_decap_4
XFILLER_138_214 VPWR VGND sg13cmos5l_fill_1
XFILLER_354_122 VPWR VGND sg13cmos5l_decap_8
XANTENNA__1277__GATE Tile_X0Y5_FrameStrobe[0] VPWR VGND sg13cmos5l_antennanp
XANTENNA__2200__A1 Tile_X0Y0_S4END[3] VPWR VGND sg13cmos5l_antennanp
XFILLER_106_122 VPWR VGND sg13cmos5l_decap_8
XFILLER_106_133 VPWR VGND sg13cmos5l_fill_2
XFILLER_20_43 VPWR VGND sg13cmos5l_fill_1
XFILLER_354_199 VPWR VGND sg13cmos5l_decap_8
XANTENNA__0798__D Tile_X0Y3_FrameData[24] VPWR VGND sg13cmos5l_antennanp
XFILLER_20_54 VPWR VGND sg13cmos5l_decap_8
XANTENNA__1200__GATE Tile_X0Y5_FrameStrobe[5] VPWR VGND sg13cmos5l_antennanp
XANTENNA__1824__X Tile_X0Y4_EE4BEG[7] VPWR VGND sg13cmos5l_antennanp
XFILLER_353_19 VPWR VGND sg13cmos5l_decap_8
XFILLER_121_147 VPWR VGND sg13cmos5l_decap_8
XANTENNA__2503__A2 Tile_X0Y1_W2END[0] VPWR VGND sg13cmos5l_antennanp
XFILLER_29_41 VPWR VGND sg13cmos5l_fill_2
XFILLER_29_63 VPWR VGND sg13cmos5l_fill_2
XANTENNA__1215__GATE Tile_X0Y5_FrameStrobe[5] VPWR VGND sg13cmos5l_antennanp
XANTENNA__2267__A1 Tile_X0Y1_WW4END[2] VPWR VGND sg13cmos5l_antennanp
XANTENNA__1422__D Tile_X0Y5_FrameData[2] VPWR VGND sg13cmos5l_antennanp
XFILLER_290_165 VPWR VGND sg13cmos5l_decap_8
XFILLER_302_56 VPWR VGND sg13cmos5l_fill_2
XANTENNA__0471__GATE Tile_X0Y5_FrameStrobe[5] VPWR VGND sg13cmos5l_antennanp
XFILLER_45_51 VPWR VGND sg13cmos5l_fill_2
XFILLER_348_0 VPWR VGND sg13cmos5l_decap_4
XFILLER_43_197 VPWR VGND sg13cmos5l_fill_1
XFILLER_196_180 VPWR VGND sg13cmos5l_decap_8
XANTENNA__0486__GATE Tile_X0Y5_FrameStrobe[5] VPWR VGND sg13cmos5l_antennanp
XFILLER_6_34 VPWR VGND sg13cmos5l_fill_2
X_1570_ Tile_X0Y3_FrameData_O[16] Tile_X0Y3_FrameData[16] VPWR VGND sg13cmos5l_buf_1
X_0521_ _0521_/Q Tile_X0Y1_FrameData[13] VGND VPWR Tile_X0Y5_FrameStrobe[6] latch
XFILLER_360_169 VPWR VGND sg13cmos5l_fill_1
XANTENNA__0501__D Tile_X0Y1_FrameData[1] VPWR VGND sg13cmos5l_antennanp
XANTENNA__1734__X Tile_X0Y0_E2BEG[6] VPWR VGND sg13cmos5l_antennanp
XFILLER_301_214 VPWR VGND sg13cmos5l_fill_1
XFILLER_258_118 VPWR VGND sg13cmos5l_decap_8
X_0452_ _0452_/Q Tile_X0Y1_FrameData[18] VGND VPWR Tile_X0Y5_FrameStrobe[4] latch
XANTENNA__0424__GATE Tile_X0Y5_FrameStrobe[3] VPWR VGND sg13cmos5l_antennanp
X_0383_ _0383_/Q Tile_X0Y1_FrameData[23] VGND VPWR Tile_X0Y5_FrameStrobe[2] latch
XFILLER_343_63 VPWR VGND sg13cmos5l_decap_8
XFILLER_343_52 VPWR VGND sg13cmos5l_fill_1
XFILLER_120_180 VPWR VGND sg13cmos5l_decap_4
X_2122_ AXIL_S_SOC_RDATA16 Tile_X0Y1_W2MID[0] Tile_X0Y1_W2END[0] Tile_X0Y1_W6END[0]
+ _2373_/X _0382_/Q _0381_/Q VPWR VGND sg13cmos5l_mux4_1
XFILLER_66_223 VPWR VGND sg13cmos5l_fill_1
XFILLER_66_212 VPWR VGND sg13cmos5l_fill_1
XFILLER_212_23 VPWR VGND sg13cmos5l_decap_8
XANTENNA__1332__D Tile_X0Y5_FrameData[28] VPWR VGND sg13cmos5l_antennanp
XANTENNA__1910__A Tile_X0Y1_FrameData[23] VPWR VGND sg13cmos5l_antennanp
XANTENNA__2258__A1 Tile_X0Y1_W2END[3] VPWR VGND sg13cmos5l_antennanp
X_2053_ Tile_X0Y5_S2BEG[2] _2775_/X VPWR VGND sg13cmos5l_buf_1
XANTENNA__0439__GATE Tile_X0Y5_FrameStrobe[4] VPWR VGND sg13cmos5l_antennanp
XFILLER_179_103 VPWR VGND sg13cmos5l_decap_8
X_1004_ _1004_/Q Tile_X0Y3_FrameData[10] VGND VPWR Tile_X0Y5_FrameStrobe[6] latch
XFILLER_34_142 VPWR VGND sg13cmos5l_decap_4
XFILLER_288_27 VPWR VGND sg13cmos5l_decap_8
XFILLER_96_0 VPWR VGND sg13cmos5l_fill_1
XANTENNA__1909__X Tile_X0Y1_FrameData_O[22] VPWR VGND sg13cmos5l_antennanp
XFILLER_336_100 VPWR VGND sg13cmos5l_decap_8
XANTENNA__2430__A1 AXIL_S_SOC_AWVALID VPWR VGND sg13cmos5l_antennanp
X_1906_ Tile_X0Y1_FrameData_O[19] Tile_X0Y1_FrameData[19] VPWR VGND sg13cmos5l_buf_1
X_1837_ Tile_X0Y4_FrameData_O[4] Tile_X0Y4_FrameData[4] VPWR VGND sg13cmos5l_buf_1
XANTENNA__2194__A0 AXIL_S_SOC_WDATA17 VPWR VGND sg13cmos5l_antennanp
XFILLER_289_210 VPWR VGND sg13cmos5l_fill_2
X_1768_ Tile_X0Y2_FrameData_O[28] Tile_X0Y2_FrameData[28] VPWR VGND sg13cmos5l_buf_1
XFILLER_351_158 VPWR VGND sg13cmos5l_fill_1
XANTENNA__0411__D Tile_X0Y1_FrameData[27] VPWR VGND sg13cmos5l_antennanp
XANTENNA__1644__X Tile_X0Y0_FrameStrobe_O[4] VPWR VGND sg13cmos5l_antennanp
XFILLER_237_97 VPWR VGND sg13cmos5l_decap_8
X_1699_ Tile_X0Y0_EE4BEG[7] _2188_/X VPWR VGND sg13cmos5l_buf_1
X_0719_ _0719_/Q Tile_X0Y2_FrameData[23] VGND VPWR Tile_X0Y5_FrameStrobe[5] latch
XFILLER_249_118 VPWR VGND sg13cmos5l_decap_8
XANTENNA__2497__A1 Tile_X0Y1_W2MID[3] VPWR VGND sg13cmos5l_antennanp
XFILLER_66_39 VPWR VGND sg13cmos5l_decap_8
XFILLER_17_109 VPWR VGND sg13cmos5l_decap_8
XANTENNA__1242__D Tile_X0Y4_FrameData[12] VPWR VGND sg13cmos5l_antennanp
XANTENNA__2249__A1 Tile_X0Y2_W2END[7] VPWR VGND sg13cmos5l_antennanp
XFILLER_213_210 VPWR VGND sg13cmos5l_fill_2
XFILLER_341_7 VPWR VGND sg13cmos5l_decap_8
XFILLER_15_54 VPWR VGND sg13cmos5l_fill_2
XFILLER_198_49 VPWR VGND sg13cmos5l_decap_8
XANTENNA__1819__X Tile_X0Y4_EE4BEG[2] VPWR VGND sg13cmos5l_antennanp
XANTENNA__2421__A1 AXIL_S_SOC_AWADDR8 VPWR VGND sg13cmos5l_antennanp
XFILLER_40_189 VPWR VGND sg13cmos5l_decap_8
XFILLER_193_150 VPWR VGND sg13cmos5l_decap_4
XFILLER_193_161 VPWR VGND sg13cmos5l_decap_8
XFILLER_327_188 VPWR VGND sg13cmos5l_fill_2
XANTENNA__2185__A0 AXIL_S_SOC_WDATA20 VPWR VGND sg13cmos5l_antennanp
XANTENNA__2724__A2 AXIL_S_SOC_ARPROT1 VPWR VGND sg13cmos5l_antennanp
XFILLER_294_81 VPWR VGND sg13cmos5l_decap_4
XANTENNA__0321__D Tile_X0Y1_FrameData[21] VPWR VGND sg13cmos5l_antennanp
XANTENNA__1417__D Tile_X0Y5_FrameData[7] VPWR VGND sg13cmos5l_antennanp
XANTENNA__1554__X Tile_X0Y3_FrameData_O[0] VPWR VGND sg13cmos5l_antennanp
XANTENNA__1154__GATE Tile_X0Y5_FrameStrobe[3] VPWR VGND sg13cmos5l_antennanp
XANTENNA__1152__D Tile_X0Y4_FrameData[6] VPWR VGND sg13cmos5l_antennanp
XFILLER_204_210 VPWR VGND sg13cmos5l_decap_8
XANTENNA__0991__D Tile_X0Y3_FrameData[23] VPWR VGND sg13cmos5l_antennanp
XANTENNA__1169__GATE Tile_X0Y5_FrameStrobe[4] VPWR VGND sg13cmos5l_antennanp
XFILLER_204_221 VPWR VGND sg13cmos5l_fill_2
XANTENNA__1729__X Tile_X0Y0_E2BEG[1] VPWR VGND sg13cmos5l_antennanp
XANTENNA__2412__A1 AXIL_S_SOC_AWPROT1 VPWR VGND sg13cmos5l_antennanp
XFILLER_188_82 VPWR VGND sg13cmos5l_decap_8
X_2740_ _2740_/X AXIL_S_SOC_ARPROT0 AXIL_S_SOC_ARPROT2 _2825_/X _2797_/X _1422_/Q
+ _1421_/Q VPWR VGND sg13cmos5l_mux4_1
XFILLER_31_178 VPWR VGND sg13cmos5l_decap_4
X_2671_ _2671_/X _2678_/X _2677_/X Tile_X0Y4_W6END[2] _2671_/A3 _1034_/Q _1033_/Q
+ VPWR VGND sg13cmos5l_mux4_1
XFILLER_184_194 VPWR VGND sg13cmos5l_fill_1
X_1622_ Tile_X0Y0_N2BEGb[2] _2254_/X VPWR VGND sg13cmos5l_buf_1
XANTENNA__1107__GATE Tile_X0Y5_FrameStrobe[2] VPWR VGND sg13cmos5l_antennanp
XANTENNA__2176__A0 AXIL_S_SOC_WDATA19 VPWR VGND sg13cmos5l_antennanp
XANTENNA__0231__D Tile_X0Y0_FrameData[31] VPWR VGND sg13cmos5l_antennanp
XANTENNA__1327__D Tile_X0Y5_FrameData[1] VPWR VGND sg13cmos5l_antennanp
XANTENNA__1905__A Tile_X0Y1_FrameData[18] VPWR VGND sg13cmos5l_antennanp
XANTENNA__2715__A2 Tile_X0Y3_W6END[10] VPWR VGND sg13cmos5l_antennanp
XFILLER_207_45 VPWR VGND sg13cmos5l_decap_8
X_1553_ Tile_X0Y3_EE4BEG[15] _2540_/X VPWR VGND sg13cmos5l_buf_1
XANTENNA__0363__GATE Tile_X0Y5_FrameStrobe[1] VPWR VGND sg13cmos5l_antennanp
X_1484_ _1484_/Q Tile_X0Y5_FrameData[4] VGND VPWR Tile_X0Y5_FrameStrobe[6] latch
X_0504_ _0504_/Q Tile_X0Y1_FrameData[30] VGND VPWR Tile_X0Y5_FrameStrobe[6] latch
XFILLER_98_156 VPWR VGND sg13cmos5l_decap_8
XFILLER_354_84 VPWR VGND sg13cmos5l_decap_4
XANTENNA__0993__GATE Tile_X0Y5_FrameStrobe[6] VPWR VGND sg13cmos5l_antennanp
XANTENNA__2479__A1 Tile_X0Y5_N4END[12] VPWR VGND sg13cmos5l_antennanp
XFILLER_100_106 VPWR VGND sg13cmos5l_decap_8
X_0435_ _0435_/Q Tile_X0Y1_FrameData[3] VGND VPWR Tile_X0Y5_FrameStrobe[3] latch
XFILLER_98_189 VPWR VGND sg13cmos5l_decap_8
XFILLER_98_167 VPWR VGND sg13cmos5l_fill_1
XFILLER_97_90 VPWR VGND sg13cmos5l_decap_8
XFILLER_39_223 VPWR VGND sg13cmos5l_fill_1
X_0366_ _0366_/Q Tile_X0Y1_FrameData[8] VGND VPWR Tile_X0Y5_FrameStrobe[1] latch
XANTENNA__0378__GATE Tile_X0Y5_FrameStrobe[2] VPWR VGND sg13cmos5l_antennanp
XANTENNA__1062__D Tile_X0Y4_FrameData[0] VPWR VGND sg13cmos5l_antennanp
XANTENNA__1640__A Tile_X0Y5_FrameStrobe[0] VPWR VGND sg13cmos5l_antennanp
XFILLER_223_77 VPWR VGND sg13cmos5l_decap_8
X_2105_ AXIL_S_SOC_ARREADY Tile_X0Y5_W2MID[0] Tile_X0Y5_W2END[0] Tile_X0Y5_W6END[0]
+ _2825_/X _1328_/Q _1327_/Q VPWR VGND sg13cmos5l_mux4_1
X_0297_ _0297_/Q Tile_X0Y0_FrameData[29] VGND VPWR Tile_X0Y5_FrameStrobe[7] latch
XANTENNA__2100__A0 Tile_X0Y4_W2MID[0] VPWR VGND sg13cmos5l_antennanp
XFILLER_199_209 VPWR VGND sg13cmos5l_decap_4
X_2036_ Tile_X0Y5_FrameData_O[21] Tile_X0Y5_FrameData[21] VPWR VGND sg13cmos5l_buf_1
XANTENNA__0301__GATE Tile_X0Y5_FrameStrobe[7] VPWR VGND sg13cmos5l_antennanp
XANTENNA__0931__GATE Tile_X0Y5_FrameStrobe[4] VPWR VGND sg13cmos5l_antennanp
XANTENNA__1639__X Tile_X0Y0_N1BEG[3] VPWR VGND sg13cmos5l_antennanp
XFILLER_356_217 VPWR VGND sg13cmos5l_fill_1
XANTENNA__0406__D Tile_X0Y1_FrameData[0] VPWR VGND sg13cmos5l_antennanp
XANTENNA__2403__A1 AXIL_S_SOC_AWPROT0 VPWR VGND sg13cmos5l_antennanp
XFILLER_167_139 VPWR VGND sg13cmos5l_decap_8
XANTENNA__0316__GATE Tile_X0Y5_FrameStrobe[0] VPWR VGND sg13cmos5l_antennanp
XFILLER_248_52 VPWR VGND sg13cmos5l_decap_4
XANTENNA__0946__GATE Tile_X0Y5_FrameStrobe[4] VPWR VGND sg13cmos5l_antennanp
XANTENNA__2167__A0 AXIL_S_SOC_WDATA18 VPWR VGND sg13cmos5l_antennanp
XFILLER_190_142 VPWR VGND sg13cmos5l_decap_8
XFILLER_201_9 VPWR VGND sg13cmos5l_fill_1
XANTENNA__0141__D Tile_X0Y0_FrameData[25] VPWR VGND sg13cmos5l_antennanp
XANTENNA__1237__D Tile_X0Y4_FrameData[17] VPWR VGND sg13cmos5l_antennanp
XFILLER_117_45 VPWR VGND sg13cmos5l_fill_2
XFILLER_89_178 VPWR VGND sg13cmos5l_decap_4
XFILLER_89_156 VPWR VGND sg13cmos5l_fill_1
XFILLER_77_49 VPWR VGND sg13cmos5l_decap_8
XFILLER_93_15 VPWR VGND sg13cmos5l_decap_8
XFILLER_93_26 VPWR VGND sg13cmos5l_fill_2
XFILLER_260_146 VPWR VGND sg13cmos5l_fill_1
XANTENNA__2642__A1 AXIL_S_SOC_BREADY VPWR VGND sg13cmos5l_antennanp
XFILLER_26_86 VPWR VGND sg13cmos5l_decap_8
XANTENNA__1549__X Tile_X0Y3_EE4BEG[11] VPWR VGND sg13cmos5l_antennanp
XFILLER_158_128 VPWR VGND sg13cmos5l_decap_8
XFILLER_289_92 VPWR VGND sg13cmos5l_fill_2
XANTENNA__0316__D Tile_X0Y1_FrameData[26] VPWR VGND sg13cmos5l_antennanp
XFILLER_173_109 VPWR VGND sg13cmos5l_decap_8
XFILLER_158_96 VPWR VGND sg13cmos5l_decap_8
XFILLER_166_183 VPWR VGND sg13cmos5l_fill_2
XFILLER_213_0 VPWR VGND sg13cmos5l_fill_1
XANTENNA__1147__D Tile_X0Y4_FrameData[11] VPWR VGND sg13cmos5l_antennanp
XFILLER_308_66 VPWR VGND sg13cmos5l_fill_1
XANTENNA__0986__D Tile_X0Y3_FrameData[28] VPWR VGND sg13cmos5l_antennanp
XANTENNA__1093__GATE Tile_X0Y5_FrameStrobe[1] VPWR VGND sg13cmos5l_antennanp
XFILLER_174_95 VPWR VGND sg13cmos5l_decap_4
XANTENNA__2330__A0 AXIL_S_SOC_WDATA5 VPWR VGND sg13cmos5l_antennanp
X_0220_ _0220_/Q Tile_X0Y0_FrameData[10] VGND VPWR Tile_X0Y5_FrameStrobe[4] latch
X_0151_ _0151_/Q Tile_X0Y0_FrameData[15] VGND VPWR Tile_X0Y5_FrameStrobe[2] latch
XFILLER_236_187 VPWR VGND sg13cmos5l_decap_8
XFILLER_340_31 VPWR VGND sg13cmos5l_fill_2
X_0082_ _0082_/Q Tile_X0Y0_FrameData[20] VGND VPWR Tile_X0Y5_FrameStrobe[0] latch
XFILLER_340_97 VPWR VGND sg13cmos5l_decap_4
XFILLER_340_64 VPWR VGND sg13cmos5l_fill_1
XANTENNA__2633__A1 AXIL_S_SOC_WSTRB0 VPWR VGND sg13cmos5l_antennanp
XANTENNA__1031__GATE Tile_X0Y5_FrameStrobe[0] VPWR VGND sg13cmos5l_antennanp
XFILLER_338_217 VPWR VGND sg13cmos5l_fill_1
XANTENNA__0226__D Tile_X0Y0_FrameData[4] VPWR VGND sg13cmos5l_antennanp
XFILLER_349_73 VPWR VGND sg13cmos5l_decap_8
X_2723_ _2723_/X Tile_X0Y5_N1END[2] _2795_/X Tile_X0Y5_WW4END[5] AXIL_S_SOC_ARPROT0
+ _1456_/Q _1455_/Q VPWR VGND sg13cmos5l_mux4_1
X_0984_ _0984_/Q Tile_X0Y3_FrameData[30] VGND VPWR Tile_X0Y5_FrameStrobe[6] latch
XFILLER_353_209 VPWR VGND sg13cmos5l_fill_1
XANTENNA__1046__GATE Tile_X0Y5_FrameStrobe[0] VPWR VGND sg13cmos5l_antennanp
XFILLER_157_183 VPWR VGND sg13cmos5l_fill_2
XFILLER_306_114 VPWR VGND sg13cmos5l_fill_2
XANTENNA__2149__A0 Tile_X0Y0_W2MID[3] VPWR VGND sg13cmos5l_antennanp
X_2654_ _2654_/X AXIL_S_SOC_BREADY _2701_/X _2689_/X _2709_/X _1146_/Q _1145_/Q VPWR
+ VGND sg13cmos5l_mux4_1
XANTENNA__1057__D Tile_X0Y4_FrameData[5] VPWR VGND sg13cmos5l_antennanp
X_1605_ Tile_X0Y0_N4BEG[1] _1605_/A VPWR VGND sg13cmos5l_buf_1
X_2585_ _2585_/X _2568_/X Tile_X0Y5_N4END[9] _2567_/X Tile_X0Y0_S4END[13] _0836_/Q
+ _0835_/Q VPWR VGND sg13cmos5l_mux4_1
XFILLER_321_117 VPWR VGND sg13cmos5l_fill_2
XFILLER_321_106 VPWR VGND sg13cmos5l_decap_8
XANTENNA__2164__A3 AXIL_S_SOC_WDATA20 VPWR VGND sg13cmos5l_antennanp
X_1536_ Tile_X0Y3_E6BEG[10] _2551_/X VPWR VGND sg13cmos5l_buf_1
XANTENNA__0896__D Tile_X0Y3_FrameData[22] VPWR VGND sg13cmos5l_antennanp
XANTENNA__1922__X Tile_X0Y1_EE4BEG[3] VPWR VGND sg13cmos5l_antennanp
X_1467_ _1467_/Q Tile_X0Y5_FrameData[21] VGND VPWR Tile_X0Y5_FrameStrobe[6] latch
XANTENNA__2321__A0 AXIL_S_SOC_WDATA0 VPWR VGND sg13cmos5l_antennanp
XFILLER_234_87 VPWR VGND sg13cmos5l_fill_2
X_1398_ _1398_/Q Tile_X0Y5_FrameData[26] VGND VPWR Tile_X0Y5_FrameStrobe[4] latch
X_0418_ _0418_/Q Tile_X0Y1_FrameData[20] VGND VPWR Tile_X0Y5_FrameStrobe[3] latch
XFILLER_86_148 VPWR VGND sg13cmos5l_decap_8
XFILLER_227_132 VPWR VGND sg13cmos5l_decap_4
XFILLER_227_143 VPWR VGND sg13cmos5l_decap_8
X_0349_ _0349_/Q Tile_X0Y1_FrameData[25] VGND VPWR Tile_X0Y5_FrameStrobe[1] latch
XFILLER_94_170 VPWR VGND sg13cmos5l_decap_8
XFILLER_242_113 VPWR VGND sg13cmos5l_decap_8
XANTENNA__0240__GATE Tile_X0Y5_FrameStrobe[5] VPWR VGND sg13cmos5l_antennanp
XFILLER_103_69 VPWR VGND sg13cmos5l_decap_8
XANTENNA__0870__GATE Tile_X0Y5_FrameStrobe[2] VPWR VGND sg13cmos5l_antennanp
XANTENNA__2624__A1 AXIL_S_SOC_WSTRB3 VPWR VGND sg13cmos5l_antennanp
XFILLER_242_168 VPWR VGND sg13cmos5l_decap_8
X_2019_ Tile_X0Y5_FrameData_O[4] Tile_X0Y5_FrameData[4] VPWR VGND sg13cmos5l_buf_1
XANTENNA__0136__D Tile_X0Y0_FrameData[30] VPWR VGND sg13cmos5l_antennanp
XFILLER_195_223 VPWR VGND sg13cmos5l_fill_1
XFILLER_259_51 VPWR VGND sg13cmos5l_decap_8
XANTENNA__0255__GATE Tile_X0Y5_FrameStrobe[5] VPWR VGND sg13cmos5l_antennanp
XANTENNA__2388__A0 Tile_X0Y3_W2MID[4] VPWR VGND sg13cmos5l_antennanp
XFILLER_137_7 VPWR VGND sg13cmos5l_decap_8
XANTENNA__0885__GATE Tile_X0Y5_FrameStrobe[2] VPWR VGND sg13cmos5l_antennanp
XFILLER_12_22 VPWR VGND sg13cmos5l_fill_2
XFILLER_275_83 VPWR VGND sg13cmos5l_fill_2
XANTENNA__2155__A3 Tile_X0Y0_W6END[9] VPWR VGND sg13cmos5l_antennanp
XFILLER_144_21 VPWR VGND sg13cmos5l_decap_8
XANTENNA__1832__X Tile_X0Y4_EE4BEG[15] VPWR VGND sg13cmos5l_antennanp
XFILLER_291_71 VPWR VGND sg13cmos5l_decap_8
XFILLER_361_19 VPWR VGND sg13cmos5l_fill_1
XANTENNA__0823__GATE Tile_X0Y5_FrameStrobe[1] VPWR VGND sg13cmos5l_antennanp
XANTENNA__2312__A0 AXIL_S_SOC_WDATA3 VPWR VGND sg13cmos5l_antennanp
XFILLER_218_110 VPWR VGND sg13cmos5l_decap_8
XFILLER_291_93 VPWR VGND sg13cmos5l_decap_8
XFILLER_92_118 VPWR VGND sg13cmos5l_decap_8
XFILLER_218_176 VPWR VGND sg13cmos5l_decap_8
XFILLER_218_187 VPWR VGND sg13cmos5l_fill_1
XANTENNA__0208__GATE Tile_X0Y5_FrameStrobe[4] VPWR VGND sg13cmos5l_antennanp
XFILLER_163_0 VPWR VGND sg13cmos5l_fill_2
XFILLER_233_135 VPWR VGND sg13cmos5l_decap_8
XANTENNA__0838__GATE Tile_X0Y5_FrameStrobe[1] VPWR VGND sg13cmos5l_antennanp
XANTENNA__1430__D Tile_X0Y5_FrameData[26] VPWR VGND sg13cmos5l_antennanp
XFILLER_53_40 VPWR VGND sg13cmos5l_decap_4
XFILLER_310_67 VPWR VGND sg13cmos5l_fill_2
XFILLER_330_0 VPWR VGND sg13cmos5l_fill_2
XFILLER_139_183 VPWR VGND sg13cmos5l_decap_8
XFILLER_185_50 VPWR VGND sg13cmos5l_decap_8
XFILLER_154_164 VPWR VGND sg13cmos5l_decap_8
XFILLER_154_175 VPWR VGND sg13cmos5l_fill_1
XFILLER_5_152 VPWR VGND sg13cmos5l_fill_1
XFILLER_335_42 VPWR VGND sg13cmos5l_decap_8
XANTENNA__2551__A0 AXIL_S_SOC_ARADDR2 VPWR VGND sg13cmos5l_antennanp
X_2370_ _2370_/X _2344_/X _0031_/X _2343_/X Tile_X0Y0_S4END[5] _0364_/Q _0363_/Q VPWR
+ VGND sg13cmos5l_mux4_1
XANTENNA__1742__X Tile_X0Y2_FrameData_O[2] VPWR VGND sg13cmos5l_antennanp
XFILLER_110_201 VPWR VGND sg13cmos5l_fill_1
X_1321_ _1321_/Q Tile_X0Y5_FrameData[7] VGND VPWR Tile_X0Y5_FrameStrobe[1] latch
XANTENNA__2303__A0 AXIL_S_SOC_WDATA2 VPWR VGND sg13cmos5l_antennanp
XFILLER_209_110 VPWR VGND sg13cmos5l_fill_1
X_1252_ _1252_/Q Tile_X0Y4_FrameData[2] VGND VPWR Tile_X0Y5_FrameStrobe[6] latch
XFILLER_204_35 VPWR VGND sg13cmos5l_decap_8
XFILLER_209_132 VPWR VGND sg13cmos5l_fill_2
X_0203_ _0203_/Q Tile_X0Y0_FrameData[27] VGND VPWR Tile_X0Y5_FrameStrobe[4] latch
XFILLER_83_118 VPWR VGND sg13cmos5l_decap_8
XFILLER_351_52 VPWR VGND sg13cmos5l_decap_8
XFILLER_351_41 VPWR VGND sg13cmos5l_fill_1
X_1183_ _1183_/Q Tile_X0Y4_FrameData[7] VGND VPWR Tile_X0Y5_FrameStrobe[4] latch
XFILLER_209_198 VPWR VGND sg13cmos5l_decap_8
X_0134_ _0134_/Q Tile_X0Y0_FrameData[0] VGND VPWR Tile_X0Y5_FrameStrobe[1] latch
XANTENNA__1340__D Tile_X0Y5_FrameData[20] VPWR VGND sg13cmos5l_antennanp
XANTENNA__2606__A1 Tile_X0Y5_W2END[3] VPWR VGND sg13cmos5l_antennanp
XFILLER_220_23 VPWR VGND sg13cmos5l_fill_2
X_0065_ _0065_/X _2231_/X _2232_/X _1229_/Q VPWR VGND sg13cmos5l_mux2_1
XFILLER_91_195 VPWR VGND sg13cmos5l_decap_4
XFILLER_220_67 VPWR VGND sg13cmos5l_decap_8
XFILLER_137_109 VPWR VGND sg13cmos5l_decap_8
XFILLER_229_21 VPWR VGND sg13cmos5l_fill_2
XFILLER_326_209 VPWR VGND sg13cmos5l_fill_2
XFILLER_296_49 VPWR VGND sg13cmos5l_decap_8
XANTENNA__1917__X Tile_X0Y1_FrameData_O[30] VPWR VGND sg13cmos5l_antennanp
XFILLER_229_43 VPWR VGND sg13cmos5l_decap_8
X_0967_ _0967_/Q Tile_X0Y3_FrameData[15] VGND VPWR Tile_X0Y5_FrameStrobe[5] latch
XFILLER_145_142 VPWR VGND sg13cmos5l_decap_8
X_2706_ _2706_/X _2674_/X Tile_X0Y5_N4END[4] _2673_/X _0039_/X _1078_/Q _1077_/Q VPWR
+ VGND sg13cmos5l_mux4_1
XANTENNA__2790__A0 Tile_X0Y5_N1END[1] VPWR VGND sg13cmos5l_antennanp
XFILLER_145_153 VPWR VGND sg13cmos5l_fill_1
XFILLER_145_175 VPWR VGND sg13cmos5l_decap_8
X_2637_ _2637_/X AXIL_S_SOC_WSTRB2 AXIL_S_SOC_WVALID _2685_/X _2711_/X _1180_/Q _1179_/Q
+ VPWR VGND sg13cmos5l_mux4_1
X_0898_ _0898_/Q Tile_X0Y3_FrameData[20] VGND VPWR Tile_X0Y5_FrameStrobe[3] latch
XANTENNA__2542__A0 Tile_X0Y5_N4END[9] VPWR VGND sg13cmos5l_antennanp
X_2568_ _2568_/X Tile_X0Y4_W1END[1] Tile_X0Y4_W6END[5] _2692_/X _2670_/X _1262_/Q
+ _1261_/Q VPWR VGND sg13cmos5l_mux4_1
XFILLER_299_190 VPWR VGND sg13cmos5l_decap_8
XANTENNA__1652__X Tile_X0Y0_FrameStrobe_O[12] VPWR VGND sg13cmos5l_antennanp
XFILLER_101_223 VPWR VGND sg13cmos5l_fill_1
X_1519_ _2455_/A3 VPWR VGND sg13cmos5l_tielo
X_2499_ _2499_/X Tile_X0Y1_W1END[1] Tile_X0Y1_W2MID[2] Tile_X0Y1_W2END[2] _2378_/X
+ _0400_/Q _0399_/Q VPWR VGND sg13cmos5l_mux4_1
XFILLER_59_104 VPWR VGND sg13cmos5l_decap_8
XFILLER_114_46 VPWR VGND sg13cmos5l_fill_1
XFILLER_261_41 VPWR VGND sg13cmos5l_decap_8
XFILLER_130_12 VPWR VGND sg13cmos5l_decap_8
XFILLER_215_113 VPWR VGND sg13cmos5l_decap_8
XANTENNA__1250__D Tile_X0Y4_FrameData[4] VPWR VGND sg13cmos5l_antennanp
XFILLER_215_168 VPWR VGND sg13cmos5l_decap_8
XFILLER_230_127 VPWR VGND sg13cmos5l_decap_8
XFILLER_90_27 VPWR VGND sg13cmos5l_decap_8
XANTENNA__0194__GATE Tile_X0Y5_FrameStrobe[3] VPWR VGND sg13cmos5l_antennanp
XFILLER_130_89 VPWR VGND sg13cmos5l_fill_2
XFILLER_183_204 VPWR VGND sg13cmos5l_decap_4
XFILLER_23_54 VPWR VGND sg13cmos5l_decap_8
XFILLER_139_43 VPWR VGND sg13cmos5l_decap_8
XANTENNA__1827__X Tile_X0Y4_EE4BEG[10] VPWR VGND sg13cmos5l_antennanp
XANTENNA__2376__A3 Tile_X0Y0_S2MID[3] VPWR VGND sg13cmos5l_antennanp
XANTENNA__2781__A0 Tile_X0Y5_W1END[0] VPWR VGND sg13cmos5l_antennanp
XFILLER_136_153 VPWR VGND sg13cmos5l_decap_8
XFILLER_99_69 VPWR VGND sg13cmos5l_decap_8
XFILLER_136_197 VPWR VGND sg13cmos5l_decap_8
XFILLER_155_20 VPWR VGND sg13cmos5l_fill_2
XANTENNA__0132__GATE Tile_X0Y5_FrameStrobe[1] VPWR VGND sg13cmos5l_antennanp
XANTENNA__2533__A0 AXIL_S_SOC_ARADDR4 VPWR VGND sg13cmos5l_antennanp
XANTENNA__0762__GATE Tile_X0Y5_FrameStrobe[6] VPWR VGND sg13cmos5l_antennanp
XANTENNA__1425__D Tile_X0Y5_FrameData[31] VPWR VGND sg13cmos5l_antennanp
XANTENNA__1562__X Tile_X0Y3_FrameData_O[8] VPWR VGND sg13cmos5l_antennanp
XFILLER_155_97 VPWR VGND sg13cmos5l_decap_8
XFILLER_305_34 VPWR VGND sg13cmos5l_decap_8
XFILLER_305_12 VPWR VGND sg13cmos5l_fill_1
XANTENNA__0147__GATE Tile_X0Y5_FrameStrobe[2] VPWR VGND sg13cmos5l_antennanp
XANTENNA__2836__A1 Tile_X0Y4_W2MID[0] VPWR VGND sg13cmos5l_antennanp
XFILLER_321_11 VPWR VGND sg13cmos5l_fill_1
XANTENNA__0777__GATE Tile_X0Y5_FrameStrobe[7] VPWR VGND sg13cmos5l_antennanp
XFILLER_321_55 VPWR VGND sg13cmos5l_fill_1
XANTENNA__1160__D Tile_X0Y4_FrameData[30] VPWR VGND sg13cmos5l_antennanp
XFILLER_73_195 VPWR VGND sg13cmos5l_decap_8
XFILLER_321_77 VPWR VGND sg13cmos5l_fill_1
XFILLER_221_138 VPWR VGND sg13cmos5l_decap_8
XFILLER_9_12 VPWR VGND sg13cmos5l_fill_1
XANTENNA__0700__GATE Tile_X0Y5_FrameStrobe[4] VPWR VGND sg13cmos5l_antennanp
XFILLER_159_223 VPWR VGND sg13cmos5l_fill_1
X_1870_ Tile_X0Y2_E2BEGb[4] _2413_/X VPWR VGND sg13cmos5l_buf_1
X_0821_ _0821_/Q Tile_X0Y3_FrameData[1] VGND VPWR Tile_X0Y5_FrameStrobe[0] latch
XANTENNA__0504__D Tile_X0Y1_FrameData[30] VPWR VGND sg13cmos5l_antennanp
XANTENNA__0715__GATE Tile_X0Y5_FrameStrobe[5] VPWR VGND sg13cmos5l_antennanp
XANTENNA__1737__X Tile_X0Y0_E1BEG[1] VPWR VGND sg13cmos5l_antennanp
XANTENNA__2367__A3 Tile_X0Y0_S4END[7] VPWR VGND sg13cmos5l_antennanp
X_0752_ _0752_/Q Tile_X0Y2_FrameData[22] VGND VPWR Tile_X0Y5_FrameStrobe[6] latch
XANTENNA__2772__A0 Tile_X0Y5_W1END[3] VPWR VGND sg13cmos5l_antennanp
XFILLER_142_134 VPWR VGND sg13cmos5l_decap_8
X_0683_ _0683_/Q Tile_X0Y2_FrameData[27] VGND VPWR Tile_X0Y5_FrameStrobe[4] latch
XANTENNA__2524__A0 AXIL_S_SOC_ARADDR5 VPWR VGND sg13cmos5l_antennanp
XFILLER_282_29 VPWR VGND sg13cmos5l_decap_4
XFILLER_288_138 VPWR VGND sg13cmos5l_fill_1
X_2422_ _2422_/X AXIL_S_SOC_AWADDR5 AXIL_S_SOC_AWADDR9 _2468_/X _2483_/X _0704_/Q
+ _0703_/Q VPWR VGND sg13cmos5l_mux4_1
XFILLER_346_96 VPWR VGND sg13cmos5l_decap_8
XANTENNA__1335__D Tile_X0Y5_FrameData[25] VPWR VGND sg13cmos5l_antennanp
X_2353_ _2353_/X _2346_/X _0030_/X _2345_/X Tile_X0Y0_S4END[6] _0338_/Q _0337_/Q VPWR
+ VGND sg13cmos5l_mux4_1
XFILLER_96_210 VPWR VGND sg13cmos5l_decap_4
XANTENNA__1913__A Tile_X0Y1_FrameData[26] VPWR VGND sg13cmos5l_antennanp
X_1304_ _1304_/Q Tile_X0Y5_FrameData[24] VGND VPWR Tile_X0Y5_FrameStrobe[1] latch
XFILLER_362_73 VPWR VGND sg13cmos5l_decap_8
XFILLER_215_78 VPWR VGND sg13cmos5l_decap_8
X_2284_ _2284_/X _2584_/X _2582_/X _2576_/X _2575_/X _1000_/Q _0999_/Q VPWR VGND sg13cmos5l_mux4_1
XFILLER_56_129 VPWR VGND sg13cmos5l_decap_8
XFILLER_362_95 VPWR VGND sg13cmos5l_decap_8
XFILLER_296_193 VPWR VGND sg13cmos5l_decap_8
XANTENNA__2827__A1 Tile_X0Y5_N2END[2] VPWR VGND sg13cmos5l_antennanp
X_1235_ _1235_/Q Tile_X0Y4_FrameData[19] VGND VPWR Tile_X0Y5_FrameStrobe[6] latch
X_1166_ _1166_/Q Tile_X0Y4_FrameData[24] VGND VPWR Tile_X0Y5_FrameStrobe[4] latch
XANTENNA__1070__D Tile_X0Y4_FrameData[24] VPWR VGND sg13cmos5l_antennanp
X_0117_ _0117_/Q Tile_X0Y0_FrameData[17] VGND VPWR Tile_X0Y5_FrameStrobe[1] latch
XFILLER_231_99 VPWR VGND sg13cmos5l_decap_8
X_1097_ _1097_/Q Tile_X0Y4_FrameData[29] VGND VPWR Tile_X0Y5_FrameStrobe[2] latch
X_0048_ _2072_/A _2555_/X _2556_/X _0869_/Q VPWR VGND sg13cmos5l_mux2_1
XFILLER_100_48 VPWR VGND sg13cmos5l_decap_8
XFILLER_220_160 VPWR VGND sg13cmos5l_decap_8
XANTENNA__0414__D Tile_X0Y1_FrameData[24] VPWR VGND sg13cmos5l_antennanp
XANTENNA__1647__X Tile_X0Y0_FrameStrobe_O[7] VPWR VGND sg13cmos5l_antennanp
XANTENNA__2358__A3 Tile_X0Y0_S4END[5] VPWR VGND sg13cmos5l_antennanp
X_1999_ Tile_X0Y5_EE4BEG[0] _2741_/X VPWR VGND sg13cmos5l_buf_1
XANTENNA__2763__A0 AXIL_S_SOC_ARPROT1 VPWR VGND sg13cmos5l_antennanp
XFILLER_256_52 VPWR VGND sg13cmos5l_fill_1
XFILLER_118_186 VPWR VGND sg13cmos5l_fill_2
XFILLER_256_74 VPWR VGND sg13cmos5l_decap_8
XFILLER_279_105 VPWR VGND sg13cmos5l_fill_2
XANTENNA__2515__A0 AXIL_S_SOC_ARADDR4 VPWR VGND sg13cmos5l_antennanp
XFILLER_133_156 VPWR VGND sg13cmos5l_decap_8
XFILLER_192_29 VPWR VGND sg13cmos5l_decap_8
XANTENNA__1245__D Tile_X0Y4_FrameData[9] VPWR VGND sg13cmos5l_antennanp
XFILLER_125_12 VPWR VGND sg13cmos5l_fill_1
XANTENNA__1492__GATE Tile_X0Y5_FrameStrobe[7] VPWR VGND sg13cmos5l_antennanp
XFILLER_272_73 VPWR VGND sg13cmos5l_decap_8
XFILLER_287_182 VPWR VGND sg13cmos5l_fill_1
XFILLER_197_6 VPWR VGND sg13cmos5l_decap_8
XANTENNA__2818__A1 Tile_X0Y5_N4END[2] VPWR VGND sg13cmos5l_antennanp
XFILLER_18_32 VPWR VGND sg13cmos5l_fill_1
XFILLER_18_54 VPWR VGND sg13cmos5l_fill_2
XFILLER_203_127 VPWR VGND sg13cmos5l_fill_2
XANTENNA__1430__GATE Tile_X0Y5_FrameStrobe[5] VPWR VGND sg13cmos5l_antennanp
XFILLER_140_2 VPWR VGND sg13cmos5l_fill_1
XFILLER_357_120 VPWR VGND sg13cmos5l_decap_8
XFILLER_34_75 VPWR VGND sg13cmos5l_fill_1
XANTENNA__0324__D Tile_X0Y1_FrameData[18] VPWR VGND sg13cmos5l_antennanp
XANTENNA__1557__X Tile_X0Y3_FrameData_O[3] VPWR VGND sg13cmos5l_antennanp
XANTENNA__2349__A3 Tile_X0Y0_S4END[7] VPWR VGND sg13cmos5l_antennanp
XFILLER_126_0 VPWR VGND sg13cmos5l_fill_2
XANTENNA__1445__GATE Tile_X0Y5_FrameStrobe[5] VPWR VGND sg13cmos5l_antennanp
XANTENNA__2754__A0 AXIL_S_SOC_ARPROT1 VPWR VGND sg13cmos5l_antennanp
XFILLER_109_197 VPWR VGND sg13cmos5l_fill_2
XFILLER_166_74 VPWR VGND sg13cmos5l_fill_2
XANTENNA__1155__D Tile_X0Y4_FrameData[3] VPWR VGND sg13cmos5l_antennanp
XANTENNA__0086__GATE Tile_X0Y5_FrameStrobe[0] VPWR VGND sg13cmos5l_antennanp
XANTENNA__0994__D Tile_X0Y3_FrameData[20] VPWR VGND sg13cmos5l_antennanp
XFILLER_182_73 VPWR VGND sg13cmos5l_decap_8
XFILLER_293_130 VPWR VGND sg13cmos5l_decap_8
XANTENNA__2809__A1 Tile_X0Y5_N4END[1] VPWR VGND sg13cmos5l_antennanp
XFILLER_293_174 VPWR VGND sg13cmos5l_decap_8
XFILLER_38_129 VPWR VGND sg13cmos5l_fill_1
XANTENNA__2285__A2 Tile_X0Y3_WW4END[5] VPWR VGND sg13cmos5l_antennanp
X_1020_ _1020_/Q Tile_X0Y3_FrameData[26] VGND VPWR Tile_X0Y5_FrameStrobe[7] latch
XFILLER_75_82 VPWR VGND sg13cmos5l_decap_8
XFILLER_46_173 VPWR VGND sg13cmos5l_fill_1
XFILLER_46_162 VPWR VGND sg13cmos5l_decap_4
XANTENNA__2588__A3 Tile_X0Y0_S4END[12] VPWR VGND sg13cmos5l_antennanp
XFILLER_277_18 VPWR VGND sg13cmos5l_fill_2
X_1922_ Tile_X0Y1_EE4BEG[3] _2312_/X VPWR VGND sg13cmos5l_buf_1
XFILLER_91_92 VPWR VGND sg13cmos5l_decap_8
XFILLER_202_171 VPWR VGND sg13cmos5l_decap_8
X_1853_ Tile_X0Y4_FrameData_O[20] Tile_X0Y4_FrameData[20] VPWR VGND sg13cmos5l_buf_1
XANTENNA__0234__D Tile_X0Y0_FrameData[28] VPWR VGND sg13cmos5l_antennanp
XANTENNA__0654__GATE Tile_X0Y5_FrameStrobe[3] VPWR VGND sg13cmos5l_antennanp
XANTENNA__1908__A Tile_X0Y1_FrameData[21] VPWR VGND sg13cmos5l_antennanp
X_0804_ _0804_/Q Tile_X0Y3_FrameData[18] VGND VPWR Tile_X0Y5_FrameStrobe[0] latch
XFILLER_357_51 VPWR VGND sg13cmos5l_fill_1
XANTENNA__2745__A0 AXIL_S_SOC_ARVALID VPWR VGND sg13cmos5l_antennanp
XFILLER_293_17 VPWR VGND sg13cmos5l_fill_1
X_1784_ Tile_X0Y2_E2BEG[7] _2408_/X VPWR VGND sg13cmos5l_buf_1
XFILLER_293_28 VPWR VGND sg13cmos5l_decap_4
X_0735_ _0735_/Q Tile_X0Y2_FrameData[7] VGND VPWR Tile_X0Y5_FrameStrobe[5] latch
XANTENNA__0669__GATE Tile_X0Y5_FrameStrobe[3] VPWR VGND sg13cmos5l_antennanp
X_0666_ _0666_/Q Tile_X0Y2_FrameData[12] VGND VPWR Tile_X0Y5_FrameStrobe[3] latch
XANTENNA__1065__D Tile_X0Y4_FrameData[29] VPWR VGND sg13cmos5l_antennanp
XFILLER_226_55 VPWR VGND sg13cmos5l_fill_2
X_2405_ _2405_/X AXIL_S_SOC_AWADDR4 AXIL_S_SOC_AWPROT2 _2484_/X _2485_/X _0738_/Q
+ _0737_/Q VPWR VGND sg13cmos5l_mux4_1
XANTENNA__1643__A Tile_X0Y5_FrameStrobe[3] VPWR VGND sg13cmos5l_antennanp
X_0597_ _0597_/Q Tile_X0Y2_FrameData[17] VGND VPWR Tile_X0Y5_FrameStrobe[1] latch
X_2336_ _2336_/X AXIL_S_SOC_WDATA3 _2372_/X _2371_/X _2380_/X _0420_/Q _0419_/Q VPWR
+ VGND sg13cmos5l_mux4_1
XANTENNA__1930__X Tile_X0Y1_EE4BEG[11] VPWR VGND sg13cmos5l_antennanp
XFILLER_242_54 VPWR VGND sg13cmos5l_decap_8
X_2267_ _2267_/X Tile_X0Y1_W1END[2] Tile_X0Y1_WW4END[2] Tile_X0Y1_WW4END[6] Tile_X0Y1_W6END[10]
+ _0520_/Q _0519_/Q VPWR VGND sg13cmos5l_mux4_1
X_1218_ _1218_/Q Tile_X0Y4_FrameData[4] VGND VPWR Tile_X0Y5_FrameStrobe[5] latch
XFILLER_37_151 VPWR VGND sg13cmos5l_fill_2
XANTENNA__0409__D Tile_X0Y1_FrameData[29] VPWR VGND sg13cmos5l_antennanp
X_2198_ _2198_/X _0066_/X Tile_X0Y0_S4END[1] _2222_/X _2221_/X _0200_/Q _0199_/Q VPWR
+ VGND sg13cmos5l_mux4_1
XANTENNA__0607__GATE Tile_X0Y5_FrameStrobe[1] VPWR VGND sg13cmos5l_antennanp
X_1149_ _1149_/Q Tile_X0Y4_FrameData[9] VGND VPWR Tile_X0Y5_FrameStrobe[3] latch
XFILLER_37_195 VPWR VGND sg13cmos5l_decap_8
XFILLER_52_154 VPWR VGND sg13cmos5l_decap_8
XANTENNA__2579__A3 Tile_X0Y0_S4END[12] VPWR VGND sg13cmos5l_antennanp
XANTENNA__0144__D Tile_X0Y0_FrameData[22] VPWR VGND sg13cmos5l_antennanp
XANTENNA__2736__A0 AXIL_S_SOC_ARPROT1 VPWR VGND sg13cmos5l_antennanp
XFILLER_354_178 VPWR VGND sg13cmos5l_decap_8
XFILLER_106_101 VPWR VGND sg13cmos5l_decap_8
XFILLER_20_33 VPWR VGND sg13cmos5l_fill_1
XFILLER_136_88 VPWR VGND sg13cmos5l_decap_8
XANTENNA__2001__X Tile_X0Y5_EE4BEG[2] VPWR VGND sg13cmos5l_antennanp
XFILLER_152_32 VPWR VGND sg13cmos5l_fill_1
XFILLER_75_213 VPWR VGND sg13cmos5l_fill_2
XANTENNA__1840__X Tile_X0Y4_FrameData_O[7] VPWR VGND sg13cmos5l_antennanp
XFILLER_290_133 VPWR VGND sg13cmos5l_decap_8
XFILLER_29_97 VPWR VGND sg13cmos5l_fill_1
XANTENNA__0319__D Tile_X0Y1_FrameData[23] VPWR VGND sg13cmos5l_antennanp
XANTENNA__2267__A2 Tile_X0Y1_WW4END[6] VPWR VGND sg13cmos5l_antennanp
XFILLER_290_155 VPWR VGND sg13cmos5l_fill_2
XFILLER_302_35 VPWR VGND sg13cmos5l_fill_2
XFILLER_43_143 VPWR VGND sg13cmos5l_decap_8
XFILLER_43_154 VPWR VGND sg13cmos5l_fill_1
XFILLER_243_0 VPWR VGND sg13cmos5l_fill_2
XANTENNA__1384__GATE Tile_X0Y5_FrameStrobe[3] VPWR VGND sg13cmos5l_antennanp
XANTENNA__2727__A0 AXIL_S_SOC_ARPROT0 VPWR VGND sg13cmos5l_antennanp
XANTENNA__0989__D Tile_X0Y3_FrameData[25] VPWR VGND sg13cmos5l_antennanp
X_0520_ _0520_/Q Tile_X0Y1_FrameData[14] VGND VPWR Tile_X0Y5_FrameStrobe[6] latch
XFILLER_327_76 VPWR VGND sg13cmos5l_fill_2
XFILLER_327_65 VPWR VGND sg13cmos5l_decap_8
XANTENNA__1399__GATE Tile_X0Y5_FrameStrobe[4] VPWR VGND sg13cmos5l_antennanp
XFILLER_112_159 VPWR VGND sg13cmos5l_decap_8
X_0451_ _0451_/Q Tile_X0Y1_FrameData[19] VGND VPWR Tile_X0Y5_FrameStrobe[4] latch
X_0382_ _0382_/Q Tile_X0Y1_FrameData[24] VGND VPWR Tile_X0Y5_FrameStrobe[2] latch
XANTENNA__1322__GATE Tile_X0Y5_FrameStrobe[1] VPWR VGND sg13cmos5l_antennanp
X_2121_ AXIL_S_SOC_RDATA15 Tile_X0Y2_W2MID[7] Tile_X0Y2_W2END[7] Tile_X0Y2_W6END[7]
+ _2488_/X _0608_/Q _0607_/Q VPWR VGND sg13cmos5l_mux4_1
XFILLER_86_92 VPWR VGND sg13cmos5l_decap_8
XANTENNA__1750__X Tile_X0Y2_FrameData_O[10] VPWR VGND sg13cmos5l_antennanp
X_2052_ Tile_X0Y5_S2BEG[1] _2774_/X VPWR VGND sg13cmos5l_buf_1
XANTENNA__0229__D Tile_X0Y0_FrameData[1] VPWR VGND sg13cmos5l_antennanp
XANTENNA__2258__A2 Tile_X0Y1_W6END[3] VPWR VGND sg13cmos5l_antennanp
XFILLER_281_144 VPWR VGND sg13cmos5l_decap_8
XFILLER_281_155 VPWR VGND sg13cmos5l_fill_1
XFILLER_281_166 VPWR VGND sg13cmos5l_decap_4
X_1003_ _1003_/Q Tile_X0Y3_FrameData[11] VGND VPWR Tile_X0Y5_FrameStrobe[6] latch
XFILLER_19_184 VPWR VGND sg13cmos5l_fill_1
XFILLER_281_177 VPWR VGND sg13cmos5l_decap_8
XANTENNA__1337__GATE Tile_X0Y5_FrameStrobe[2] VPWR VGND sg13cmos5l_antennanp
XANTENNA__0593__GATE Tile_X0Y5_FrameStrobe[1] VPWR VGND sg13cmos5l_antennanp
XFILLER_89_0 VPWR VGND sg13cmos5l_decap_4
X_1905_ Tile_X0Y1_FrameData_O[18] Tile_X0Y1_FrameData[18] VPWR VGND sg13cmos5l_buf_1
XANTENNA__2718__A0 Tile_X0Y3_W1END[1] VPWR VGND sg13cmos5l_antennanp
XFILLER_237_10 VPWR VGND sg13cmos5l_fill_1
X_1836_ Tile_X0Y4_FrameData_O[3] Tile_X0Y4_FrameData[3] VPWR VGND sg13cmos5l_buf_1
XANTENNA__0899__D Tile_X0Y3_FrameData[19] VPWR VGND sg13cmos5l_antennanp
X_1767_ Tile_X0Y2_FrameData_O[27] Tile_X0Y2_FrameData[27] VPWR VGND sg13cmos5l_buf_1
XFILLER_336_189 VPWR VGND sg13cmos5l_fill_2
XANTENNA__1925__X Tile_X0Y1_EE4BEG[6] VPWR VGND sg13cmos5l_antennanp
XANTENNA__2194__A1 AXIL_S_SOC_WDATA29 VPWR VGND sg13cmos5l_antennanp
XFILLER_237_76 VPWR VGND sg13cmos5l_decap_8
X_0718_ _0718_/Q Tile_X0Y2_FrameData[24] VGND VPWR Tile_X0Y5_FrameStrobe[5] latch
X_1698_ Tile_X0Y0_EE4BEG[6] _2187_/X VPWR VGND sg13cmos5l_buf_1
XANTENNA__0531__GATE Tile_X0Y5_FrameStrobe[6] VPWR VGND sg13cmos5l_antennanp
XFILLER_103_126 VPWR VGND sg13cmos5l_decap_8
XFILLER_103_137 VPWR VGND sg13cmos5l_fill_2
X_0649_ _0649_/Q Tile_X0Y2_FrameData[29] VGND VPWR Tile_X0Y5_FrameStrobe[3] latch
XANTENNA__2497__A2 Tile_X0Y1_W2END[3] VPWR VGND sg13cmos5l_antennanp
XFILLER_106_47 VPWR VGND sg13cmos5l_fill_1
X_2319_ _2319_/X AXIL_S_SOC_WDATA6 AXIL_S_SOC_WDATA10 _2369_/X _2378_/X _0454_/Q _0453_/Q
+ VPWR VGND sg13cmos5l_mux4_1
XANTENNA__1660__X Tile_X0Y0_FrameData_O[0] VPWR VGND sg13cmos5l_antennanp
XFILLER_111_192 VPWR VGND sg13cmos5l_fill_2
XANTENNA__0139__D Tile_X0Y0_FrameData[27] VPWR VGND sg13cmos5l_antennanp
XANTENNA__0546__GATE Tile_X0Y5_FrameStrobe[7] VPWR VGND sg13cmos5l_antennanp
XANTENNA__2249__A2 Tile_X0Y2_W6END[7] VPWR VGND sg13cmos5l_antennanp
XFILLER_272_144 VPWR VGND sg13cmos5l_fill_2
XFILLER_272_188 VPWR VGND sg13cmos5l_decap_8
XFILLER_198_28 VPWR VGND sg13cmos5l_decap_8
XFILLER_359_204 VPWR VGND sg13cmos5l_decap_8
XFILLER_40_113 VPWR VGND sg13cmos5l_fill_2
XFILLER_334_7 VPWR VGND sg13cmos5l_decap_8
XFILLER_126_207 VPWR VGND sg13cmos5l_fill_2
XFILLER_31_43 VPWR VGND sg13cmos5l_fill_2
XFILLER_147_21 VPWR VGND sg13cmos5l_fill_2
XFILLER_31_65 VPWR VGND sg13cmos5l_decap_4
XANTENNA__0602__D Tile_X0Y2_FrameData[12] VPWR VGND sg13cmos5l_antennanp
XANTENNA__1835__X Tile_X0Y4_FrameData_O[2] VPWR VGND sg13cmos5l_antennanp
XANTENNA__2185__A1 AXIL_S_SOC_WDATA24 VPWR VGND sg13cmos5l_antennanp
XFILLER_147_76 VPWR VGND sg13cmos5l_decap_8
XANTENNA__2724__A3 AXIL_S_SOC_RREADY VPWR VGND sg13cmos5l_antennanp
XFILLER_294_93 VPWR VGND sg13cmos5l_decap_8
XFILLER_163_31 VPWR VGND sg13cmos5l_decap_4
XFILLER_350_192 VPWR VGND sg13cmos5l_fill_1
XFILLER_295_203 VPWR VGND sg13cmos5l_fill_1
XANTENNA__1433__D Tile_X0Y5_FrameData[23] VPWR VGND sg13cmos5l_antennanp
XFILLER_193_0 VPWR VGND sg13cmos5l_decap_4
XFILLER_248_141 VPWR VGND sg13cmos5l_decap_4
XFILLER_313_23 VPWR VGND sg13cmos5l_decap_8
XANTENNA__1570__X Tile_X0Y3_FrameData_O[16] VPWR VGND sg13cmos5l_antennanp
XFILLER_102_192 VPWR VGND sg13cmos5l_decap_8
XFILLER_313_34 VPWR VGND sg13cmos5l_fill_1
XFILLER_56_51 VPWR VGND sg13cmos5l_decap_4
XFILLER_360_0 VPWR VGND sg13cmos5l_fill_2
XFILLER_313_89 VPWR VGND sg13cmos5l_decap_4
XFILLER_16_110 VPWR VGND sg13cmos5l_fill_1
XFILLER_176_118 VPWR VGND sg13cmos5l_decap_8
XFILLER_188_61 VPWR VGND sg13cmos5l_fill_1
XFILLER_72_94 VPWR VGND sg13cmos5l_decap_8
XFILLER_184_151 VPWR VGND sg13cmos5l_decap_8
X_2670_ _2670_/X _2676_/X _2675_/X Tile_X0Y4_W6END[1] _2670_/A3 _1036_/Q _1035_/Q
+ VPWR VGND sg13cmos5l_mux4_1
XFILLER_338_64 VPWR VGND sg13cmos5l_fill_2
X_1621_ Tile_X0Y0_N2BEGb[1] _2252_/X VPWR VGND sg13cmos5l_buf_1
XANTENNA__0512__D Tile_X0Y1_FrameData[22] VPWR VGND sg13cmos5l_antennanp
XANTENNA__1745__X Tile_X0Y2_FrameData_O[5] VPWR VGND sg13cmos5l_antennanp
XANTENNA__2176__A1 AXIL_S_SOC_WDATA27 VPWR VGND sg13cmos5l_antennanp
XFILLER_207_13 VPWR VGND sg13cmos5l_fill_2
X_1552_ Tile_X0Y3_EE4BEG[14] _2539_/X VPWR VGND sg13cmos5l_buf_1
XFILLER_354_30 VPWR VGND sg13cmos5l_fill_2
X_1483_ _1483_/Q Tile_X0Y5_FrameData[5] VGND VPWR Tile_X0Y5_FrameStrobe[6] latch
X_0503_ _0503_/Q Tile_X0Y1_FrameData[31] VGND VPWR Tile_X0Y5_FrameStrobe[6] latch
XFILLER_98_135 VPWR VGND sg13cmos5l_decap_8
XFILLER_341_170 VPWR VGND sg13cmos5l_fill_1
XANTENNA__1261__GATE Tile_X0Y5_FrameStrobe[7] VPWR VGND sg13cmos5l_antennanp
XFILLER_290_29 VPWR VGND sg13cmos5l_decap_4
X_0434_ _0434_/Q Tile_X0Y1_FrameData[4] VGND VPWR Tile_X0Y5_FrameStrobe[3] latch
XFILLER_223_12 VPWR VGND sg13cmos5l_fill_2
XANTENNA__1343__D Tile_X0Y5_FrameData[17] VPWR VGND sg13cmos5l_antennanp
XFILLER_223_56 VPWR VGND sg13cmos5l_decap_8
XFILLER_239_185 VPWR VGND sg13cmos5l_fill_2
X_2104_ AXIL_S_SOC_BVALID Tile_X0Y4_W2MID[4] Tile_X0Y4_W2END[4] Tile_X0Y4_W6END[4]
+ _2712_/X _1088_/Q _1087_/Q VPWR VGND sg13cmos5l_mux4_1
X_0365_ _0365_/Q Tile_X0Y1_FrameData[9] VGND VPWR Tile_X0Y5_FrameStrobe[1] latch
XFILLER_254_133 VPWR VGND sg13cmos5l_decap_4
X_0296_ _0296_/Q Tile_X0Y0_FrameData[30] VGND VPWR Tile_X0Y5_FrameStrobe[7] latch
XANTENNA__1276__GATE Tile_X0Y5_FrameStrobe[0] VPWR VGND sg13cmos5l_antennanp
X_2035_ Tile_X0Y5_FrameData_O[20] Tile_X0Y5_FrameData[20] VPWR VGND sg13cmos5l_buf_1
XANTENNA__2100__A1 Tile_X0Y4_W2END[0] VPWR VGND sg13cmos5l_antennanp
XFILLER_22_102 VPWR VGND sg13cmos5l_fill_2
XFILLER_309_112 VPWR VGND sg13cmos5l_decap_8
XFILLER_248_31 VPWR VGND sg13cmos5l_decap_8
XANTENNA__1214__GATE Tile_X0Y5_FrameStrobe[5] VPWR VGND sg13cmos5l_antennanp
XFILLER_175_184 VPWR VGND sg13cmos5l_decap_8
XFILLER_190_121 VPWR VGND sg13cmos5l_decap_8
XFILLER_248_86 VPWR VGND sg13cmos5l_fill_1
XFILLER_309_178 VPWR VGND sg13cmos5l_fill_2
XANTENNA__0422__D Tile_X0Y1_FrameData[16] VPWR VGND sg13cmos5l_antennanp
XANTENNA__1655__X Tile_X0Y0_FrameStrobe_O[15] VPWR VGND sg13cmos5l_antennanp
XANTENNA__2167__A1 AXIL_S_SOC_WDATA26 VPWR VGND sg13cmos5l_antennanp
XFILLER_184_19 VPWR VGND sg13cmos5l_fill_1
X_1819_ Tile_X0Y4_EE4BEG[2] _2635_/X VPWR VGND sg13cmos5l_buf_1
X_2799_ _2799_/X Tile_X0Y5_N2MID[5] Tile_X0Y5_N2END[5] _2834_/X _2718_/X _1278_/Q
+ _1277_/Q VPWR VGND sg13cmos5l_mux4_1
XANTENNA__0470__GATE Tile_X0Y5_FrameStrobe[4] VPWR VGND sg13cmos5l_antennanp
XFILLER_117_57 VPWR VGND sg13cmos5l_decap_8
XFILLER_89_124 VPWR VGND sg13cmos5l_fill_2
XFILLER_332_181 VPWR VGND sg13cmos5l_fill_1
XANTENNA__1229__GATE Tile_X0Y5_FrameStrobe[6] VPWR VGND sg13cmos5l_antennanp
XANTENNA__0485__GATE Tile_X0Y5_FrameStrobe[5] VPWR VGND sg13cmos5l_antennanp
XANTENNA__1253__D Tile_X0Y4_FrameData[1] VPWR VGND sg13cmos5l_antennanp
XFILLER_277_6 VPWR VGND sg13cmos5l_decap_8
XFILLER_245_177 VPWR VGND sg13cmos5l_decap_4
XFILLER_93_49 VPWR VGND sg13cmos5l_decap_8
XFILLER_198_221 VPWR VGND sg13cmos5l_fill_2
XFILLER_260_125 VPWR VGND sg13cmos5l_decap_8
XFILLER_13_102 VPWR VGND sg13cmos5l_decap_4
XFILLER_26_98 VPWR VGND sg13cmos5l_decap_8
XANTENNA__0423__GATE Tile_X0Y5_FrameStrobe[3] VPWR VGND sg13cmos5l_antennanp
XFILLER_220_2 VPWR VGND sg13cmos5l_fill_1
XFILLER_158_75 VPWR VGND sg13cmos5l_decap_8
XFILLER_315_104 VPWR VGND sg13cmos5l_fill_2
XANTENNA__0332__D Tile_X0Y1_FrameData[10] VPWR VGND sg13cmos5l_antennanp
XANTENNA__1428__D Tile_X0Y5_FrameData[28] VPWR VGND sg13cmos5l_antennanp
XANTENNA__1565__X Tile_X0Y3_FrameData_O[11] VPWR VGND sg13cmos5l_antennanp
XFILLER_181_121 VPWR VGND sg13cmos5l_decap_4
XFILLER_181_154 VPWR VGND sg13cmos5l_decap_4
XFILLER_206_0 VPWR VGND sg13cmos5l_decap_4
XANTENNA__0438__GATE Tile_X0Y5_FrameStrobe[3] VPWR VGND sg13cmos5l_antennanp
XFILLER_181_198 VPWR VGND sg13cmos5l_decap_4
XFILLER_268_203 VPWR VGND sg13cmos5l_decap_8
XFILLER_268_214 VPWR VGND sg13cmos5l_fill_1
XFILLER_107_90 VPWR VGND sg13cmos5l_decap_8
XANTENNA__1163__D Tile_X0Y4_FrameData[27] VPWR VGND sg13cmos5l_antennanp
XANTENNA__1741__A Tile_X0Y2_FrameData[1] VPWR VGND sg13cmos5l_antennanp
XFILLER_236_144 VPWR VGND sg13cmos5l_decap_4
X_0150_ _0150_/Q Tile_X0Y0_FrameData[16] VGND VPWR Tile_X0Y5_FrameStrobe[2] latch
XFILLER_236_166 VPWR VGND sg13cmos5l_decap_8
X_0081_ _0081_/Q Tile_X0Y0_FrameData[21] VGND VPWR Tile_X0Y5_FrameStrobe[0] latch
XFILLER_340_43 VPWR VGND sg13cmos5l_decap_8
XANTENNA__0507__D Tile_X0Y1_FrameData[27] VPWR VGND sg13cmos5l_antennanp
XFILLER_189_221 VPWR VGND sg13cmos5l_fill_2
XFILLER_349_30 VPWR VGND sg13cmos5l_decap_8
X_0983_ _0983_/Q Tile_X0Y3_FrameData[31] VGND VPWR Tile_X0Y5_FrameStrobe[6] latch
XFILLER_349_52 VPWR VGND sg13cmos5l_decap_8
XFILLER_349_41 VPWR VGND sg13cmos5l_fill_1
X_2722_ _2722_/X Tile_X0Y5_N1END[1] _2794_/X AXIL_S_SOC_ARPROT1 AXIL_S_SOC_ARVALID
+ _1458_/Q _1457_/Q VPWR VGND sg13cmos5l_mux4_1
XFILLER_285_29 VPWR VGND sg13cmos5l_decap_4
XANTENNA__0242__D Tile_X0Y0_FrameData[20] VPWR VGND sg13cmos5l_antennanp
XANTENNA__1338__D Tile_X0Y5_FrameData[22] VPWR VGND sg13cmos5l_antennanp
XANTENNA__1916__A Tile_X0Y1_FrameData[29] VPWR VGND sg13cmos5l_antennanp
XANTENNA__2149__A1 Tile_X0Y0_W2END[3] VPWR VGND sg13cmos5l_antennanp
X_2653_ _2653_/X AXIL_S_SOC_WVALID _2700_/X _2685_/X _2708_/X _1148_/Q _1147_/Q VPWR
+ VGND sg13cmos5l_mux4_1
XFILLER_306_137 VPWR VGND sg13cmos5l_decap_8
XFILLER_172_187 VPWR VGND sg13cmos5l_decap_8
X_1604_ Tile_X0Y0_N4BEG[0] _1604_/A VPWR VGND sg13cmos5l_buf_1
X_2584_ _2584_/X _2570_/X Tile_X0Y5_N4END[10] _2569_/X Tile_X0Y0_S4END[14] _0842_/Q
+ _0841_/Q VPWR VGND sg13cmos5l_mux4_1
X_1535_ Tile_X0Y3_E6BEG[9] _2550_/X VPWR VGND sg13cmos5l_buf_1
XFILLER_234_11 VPWR VGND sg13cmos5l_fill_2
XFILLER_234_66 VPWR VGND sg13cmos5l_decap_8
X_1466_ _1466_/Q Tile_X0Y5_FrameData[22] VGND VPWR Tile_X0Y5_FrameStrobe[6] latch
XFILLER_86_127 VPWR VGND sg13cmos5l_decap_8
XANTENNA__1073__D Tile_X0Y4_FrameData[21] VPWR VGND sg13cmos5l_antennanp
XANTENNA__1651__A Tile_X0Y5_FrameStrobe[11] VPWR VGND sg13cmos5l_antennanp
XANTENNA__2321__A1 AXIL_S_SOC_WDATA12 VPWR VGND sg13cmos5l_antennanp
XFILLER_227_111 VPWR VGND sg13cmos5l_decap_8
X_1397_ _1397_/Q Tile_X0Y5_FrameData[27] VGND VPWR Tile_X0Y5_FrameStrobe[4] latch
X_0417_ _0417_/Q Tile_X0Y1_FrameData[21] VGND VPWR Tile_X0Y5_FrameStrobe[3] latch
XFILLER_79_190 VPWR VGND sg13cmos5l_fill_2
X_0348_ _0348_/Q Tile_X0Y1_FrameData[26] VGND VPWR Tile_X0Y5_FrameStrobe[1] latch
XFILLER_103_48 VPWR VGND sg13cmos5l_decap_8
XFILLER_227_199 VPWR VGND sg13cmos5l_fill_2
X_2018_ Tile_X0Y5_FrameData_O[3] Tile_X0Y5_FrameData[3] VPWR VGND sg13cmos5l_buf_1
X_0279_ _0279_/Q Tile_X0Y0_FrameData[15] VGND VPWR Tile_X0Y5_FrameStrobe[6] latch
XANTENNA__0417__D Tile_X0Y1_FrameData[21] VPWR VGND sg13cmos5l_antennanp
XFILLER_10_116 VPWR VGND sg13cmos5l_decap_4
XANTENNA__2388__A1 Tile_X0Y3_W2END[4] VPWR VGND sg13cmos5l_antennanp
XFILLER_10_127 VPWR VGND sg13cmos5l_fill_1
XFILLER_148_151 VPWR VGND sg13cmos5l_decap_8
XANTENNA__1153__GATE Tile_X0Y5_FrameStrobe[3] VPWR VGND sg13cmos5l_antennanp
XFILLER_148_184 VPWR VGND sg13cmos5l_decap_8
XANTENNA__0152__D Tile_X0Y0_FrameData[14] VPWR VGND sg13cmos5l_antennanp
XANTENNA__1248__D Tile_X0Y4_FrameData[6] VPWR VGND sg13cmos5l_antennanp
XFILLER_12_78 VPWR VGND sg13cmos5l_fill_1
XFILLER_163_132 VPWR VGND sg13cmos5l_decap_8
XFILLER_163_143 VPWR VGND sg13cmos5l_fill_2
XFILLER_275_51 VPWR VGND sg13cmos5l_decap_8
XFILLER_128_56 VPWR VGND sg13cmos5l_decap_8
XANTENNA__1168__GATE Tile_X0Y5_FrameStrobe[4] VPWR VGND sg13cmos5l_antennanp
XFILLER_77_138 VPWR VGND sg13cmos5l_decap_8
XFILLER_320_151 VPWR VGND sg13cmos5l_fill_1
XANTENNA__1561__A Tile_X0Y3_FrameData[7] VPWR VGND sg13cmos5l_antennanp
XFILLER_144_77 VPWR VGND sg13cmos5l_fill_1
XFILLER_144_99 VPWR VGND sg13cmos5l_fill_2
XFILLER_77_149 VPWR VGND sg13cmos5l_fill_2
XFILLER_320_184 VPWR VGND sg13cmos5l_fill_2
XANTENNA__2312__A1 AXIL_S_SOC_WDATA15 VPWR VGND sg13cmos5l_antennanp
XFILLER_160_32 VPWR VGND sg13cmos5l_decap_8
XFILLER_37_53 VPWR VGND sg13cmos5l_fill_2
XFILLER_160_54 VPWR VGND sg13cmos5l_decap_8
XFILLER_33_208 VPWR VGND sg13cmos5l_decap_8
XFILLER_310_13 VPWR VGND sg13cmos5l_fill_2
XANTENNA__1106__GATE Tile_X0Y5_FrameStrobe[2] VPWR VGND sg13cmos5l_antennanp
XANTENNA__2615__A2 AXIL_S_SOC_WSTRB0 VPWR VGND sg13cmos5l_antennanp
XFILLER_310_46 VPWR VGND sg13cmos5l_decap_8
XANTENNA__0327__D Tile_X0Y1_FrameData[15] VPWR VGND sg13cmos5l_antennanp
XFILLER_53_52 VPWR VGND sg13cmos5l_fill_2
XFILLER_53_30 VPWR VGND sg13cmos5l_fill_1
XANTENNA__0362__GATE Tile_X0Y5_FrameStrobe[1] VPWR VGND sg13cmos5l_antennanp
XANTENNA__0992__GATE Tile_X0Y5_FrameStrobe[6] VPWR VGND sg13cmos5l_antennanp
XFILLER_323_0 VPWR VGND sg13cmos5l_fill_2
XFILLER_319_44 VPWR VGND sg13cmos5l_decap_8
XANTENNA__0377__GATE Tile_X0Y5_FrameStrobe[2] VPWR VGND sg13cmos5l_antennanp
XANTENNA__1158__D Tile_X0Y4_FrameData[0] VPWR VGND sg13cmos5l_antennanp
XFILLER_154_132 VPWR VGND sg13cmos5l_decap_8
XANTENNA__0997__D Tile_X0Y3_FrameData[17] VPWR VGND sg13cmos5l_antennanp
XFILLER_335_21 VPWR VGND sg13cmos5l_decap_8
XFILLER_303_129 VPWR VGND sg13cmos5l_fill_1
XANTENNA__0300__GATE Tile_X0Y5_FrameStrobe[7] VPWR VGND sg13cmos5l_antennanp
X_1320_ _1320_/Q Tile_X0Y5_FrameData[8] VGND VPWR Tile_X0Y5_FrameStrobe[1] latch
XANTENNA__0930__GATE Tile_X0Y5_FrameStrobe[4] VPWR VGND sg13cmos5l_antennanp
XFILLER_311_162 VPWR VGND sg13cmos5l_decap_4
X_1251_ _1251_/Q Tile_X0Y4_FrameData[3] VGND VPWR Tile_X0Y5_FrameStrobe[6] latch
XFILLER_351_20 VPWR VGND sg13cmos5l_decap_8
XANTENNA__2303__A1 AXIL_S_SOC_WDATA10 VPWR VGND sg13cmos5l_antennanp
X_1182_ _1182_/Q Tile_X0Y4_FrameData[8] VGND VPWR Tile_X0Y5_FrameStrobe[4] latch
X_0202_ _0202_/Q Tile_X0Y0_FrameData[28] VGND VPWR Tile_X0Y5_FrameStrobe[4] latch
XANTENNA__0315__GATE Tile_X0Y5_FrameStrobe[0] VPWR VGND sg13cmos5l_antennanp
XFILLER_271_209 VPWR VGND sg13cmos5l_fill_2
X_0133_ _0133_/Q Tile_X0Y0_FrameData[1] VGND VPWR Tile_X0Y5_FrameStrobe[1] latch
XFILLER_351_97 VPWR VGND sg13cmos5l_decap_4
XANTENNA__0945__GATE Tile_X0Y5_FrameStrobe[4] VPWR VGND sg13cmos5l_antennanp
XFILLER_91_152 VPWR VGND sg13cmos5l_decap_8
XANTENNA__2606__A2 Tile_X0Y5_W6END[3] VPWR VGND sg13cmos5l_antennanp
XFILLER_220_46 VPWR VGND sg13cmos5l_decap_8
X_0064_ _0064_/X _2227_/X _2228_/X _1232_/Q VPWR VGND sg13cmos5l_mux2_1
XANTENNA__0237__D Tile_X0Y0_FrameData[25] VPWR VGND sg13cmos5l_antennanp
XFILLER_177_202 VPWR VGND sg13cmos5l_fill_1
XFILLER_229_11 VPWR VGND sg13cmos5l_fill_1
X_0966_ _0966_/Q Tile_X0Y3_FrameData[16] VGND VPWR Tile_X0Y5_FrameStrobe[5] latch
XANTENNA__1068__D Tile_X0Y4_FrameData[26] VPWR VGND sg13cmos5l_antennanp
XFILLER_145_121 VPWR VGND sg13cmos5l_decap_8
X_2705_ _2705_/X _2676_/X Tile_X0Y5_N4END[5] _2675_/X _0071_/X _1084_/Q _1083_/Q VPWR
+ VGND sg13cmos5l_mux4_1
XANTENNA__1646__A Tile_X0Y5_FrameStrobe[6] VPWR VGND sg13cmos5l_antennanp
X_2636_ _2636_/X Tile_X0Y4_WW4END[7] AXIL_S_SOC_WSTRB3 _2696_/X _2712_/X _1182_/Q
+ _1181_/Q VPWR VGND sg13cmos5l_mux4_1
X_0897_ _0897_/Q Tile_X0Y3_FrameData[21] VGND VPWR Tile_X0Y5_FrameStrobe[3] latch
XFILLER_160_135 VPWR VGND sg13cmos5l_decap_8
XFILLER_245_10 VPWR VGND sg13cmos5l_decap_8
XFILLER_245_21 VPWR VGND sg13cmos5l_decap_8
XANTENNA__0700__D Tile_X0Y2_FrameData[10] VPWR VGND sg13cmos5l_antennanp
XANTENNA__1933__X Tile_X0Y1_EE4BEG[14] VPWR VGND sg13cmos5l_antennanp
XANTENNA__2542__A1 Tile_X0Y0_S4END[13] VPWR VGND sg13cmos5l_antennanp
XFILLER_245_76 VPWR VGND sg13cmos5l_fill_2
X_2567_ _2567_/X Tile_X0Y2_W1END[1] Tile_X0Y2_W6END[9] _2469_/X _2454_/X _0656_/Q
+ _0655_/Q VPWR VGND sg13cmos5l_mux4_1
X_1518_ _2456_/A3 VPWR VGND sg13cmos5l_tielo
X_2498_ _2498_/X Tile_X0Y4_W2MID[3] Tile_X0Y4_W2END[3] Tile_X0Y4_W6END[3] _2712_/X
+ _1248_/Q _1247_/Q VPWR VGND sg13cmos5l_mux4_1
XFILLER_261_20 VPWR VGND sg13cmos5l_decap_8
X_1449_ _1449_/Q Tile_X0Y5_FrameData[7] VGND VPWR Tile_X0Y5_FrameStrobe[5] latch
XFILLER_67_182 VPWR VGND sg13cmos5l_fill_1
XFILLER_82_141 VPWR VGND sg13cmos5l_fill_2
XFILLER_82_185 VPWR VGND sg13cmos5l_decap_8
XANTENNA__0147__D Tile_X0Y0_FrameData[19] VPWR VGND sg13cmos5l_antennanp
XFILLER_130_68 VPWR VGND sg13cmos5l_decap_8
XANTENNA__1092__GATE Tile_X0Y5_FrameStrobe[1] VPWR VGND sg13cmos5l_antennanp
XFILLER_136_132 VPWR VGND sg13cmos5l_decap_8
XFILLER_286_94 VPWR VGND sg13cmos5l_fill_1
XANTENNA__1556__A Tile_X0Y3_FrameData[2] VPWR VGND sg13cmos5l_antennanp
XANTENNA__2004__X Tile_X0Y5_EE4BEG[5] VPWR VGND sg13cmos5l_antennanp
XANTENNA__2781__A1 Tile_X0Y5_WW4END[10] VPWR VGND sg13cmos5l_antennanp
XFILLER_136_176 VPWR VGND sg13cmos5l_decap_8
XFILLER_99_48 VPWR VGND sg13cmos5l_decap_8
XANTENNA__0610__D Tile_X0Y2_FrameData[4] VPWR VGND sg13cmos5l_antennanp
XANTENNA__1843__X Tile_X0Y4_FrameData_O[10] VPWR VGND sg13cmos5l_antennanp
XANTENNA__2533__A1 AXIL_S_SOC_ARADDR8 VPWR VGND sg13cmos5l_antennanp
XFILLER_155_43 VPWR VGND sg13cmos5l_decap_8
XANTENNA__1030__GATE Tile_X0Y5_FrameStrobe[7] VPWR VGND sg13cmos5l_antennanp
XANTENNA__2297__A0 AXIL_S_SOC_WDATA4 VPWR VGND sg13cmos5l_antennanp
XFILLER_171_42 VPWR VGND sg13cmos5l_fill_2
XFILLER_171_53 VPWR VGND sg13cmos5l_decap_8
XANTENNA__2836__A2 Tile_X0Y4_W2END[0] VPWR VGND sg13cmos5l_antennanp
XFILLER_273_0 VPWR VGND sg13cmos5l_fill_2
XANTENNA__1045__GATE Tile_X0Y5_FrameStrobe[0] VPWR VGND sg13cmos5l_antennanp
XANTENNA__1441__D Tile_X0Y5_FrameData[15] VPWR VGND sg13cmos5l_antennanp
XFILLER_321_34 VPWR VGND sg13cmos5l_decap_8
XFILLER_73_174 VPWR VGND sg13cmos5l_decap_8
XFILLER_221_117 VPWR VGND sg13cmos5l_decap_8
XFILLER_214_180 VPWR VGND sg13cmos5l_decap_4
XFILLER_9_68 VPWR VGND sg13cmos5l_fill_1
X_0820_ _0820_/Q Tile_X0Y3_FrameData[2] VGND VPWR Tile_X0Y5_FrameStrobe[0] latch
X_0751_ _0751_/Q Tile_X0Y2_FrameData[23] VGND VPWR Tile_X0Y5_FrameStrobe[6] latch
XANTENNA__2772__A1 Tile_X0Y5_W6END[11] VPWR VGND sg13cmos5l_antennanp
X_0682_ _0682_/Q Tile_X0Y2_FrameData[28] VGND VPWR Tile_X0Y5_FrameStrobe[4] latch
XFILLER_346_75 VPWR VGND sg13cmos5l_decap_8
XANTENNA__0520__D Tile_X0Y1_FrameData[14] VPWR VGND sg13cmos5l_antennanp
XANTENNA__1753__X Tile_X0Y2_FrameData_O[13] VPWR VGND sg13cmos5l_antennanp
XANTENNA__2524__A1 AXIL_S_SOC_ARADDR7 VPWR VGND sg13cmos5l_antennanp
X_2421_ _2421_/X AXIL_S_SOC_AWADDR4 AXIL_S_SOC_AWADDR8 _2466_/X _2484_/X _0706_/Q
+ _0705_/Q VPWR VGND sg13cmos5l_mux4_1
X_2352_ _2352_/X _2824_/X _2823_/X _2814_/X _2813_/X _1472_/Q _1471_/Q VPWR VGND sg13cmos5l_mux4_1
XFILLER_362_30 VPWR VGND sg13cmos5l_fill_1
XFILLER_215_57 VPWR VGND sg13cmos5l_decap_8
XFILLER_229_206 VPWR VGND sg13cmos5l_fill_1
XFILLER_229_217 VPWR VGND sg13cmos5l_fill_1
X_1303_ _1303_/Q Tile_X0Y5_FrameData[25] VGND VPWR Tile_X0Y5_FrameStrobe[1] latch
X_2283_ _2283_/X Tile_X0Y3_W1END[2] Tile_X0Y3_WW4END[2] Tile_X0Y3_WW4END[6] Tile_X0Y3_W6END[10]
+ _1000_/Q _0999_/Q VPWR VGND sg13cmos5l_mux4_1
XFILLER_362_52 VPWR VGND sg13cmos5l_decap_4
XANTENNA__0254__GATE Tile_X0Y5_FrameStrobe[5] VPWR VGND sg13cmos5l_antennanp
X_1234_ _1234_/Q Tile_X0Y4_FrameData[20] VGND VPWR Tile_X0Y5_FrameStrobe[6] latch
XFILLER_56_108 VPWR VGND sg13cmos5l_decap_8
XANTENNA__0884__GATE Tile_X0Y5_FrameStrobe[2] VPWR VGND sg13cmos5l_antennanp
XANTENNA__1351__D Tile_X0Y5_FrameData[9] VPWR VGND sg13cmos5l_antennanp
X_1165_ _1165_/Q Tile_X0Y4_FrameData[25] VGND VPWR Tile_X0Y5_FrameStrobe[4] latch
XFILLER_64_141 VPWR VGND sg13cmos5l_decap_8
XFILLER_231_78 VPWR VGND sg13cmos5l_decap_8
X_1096_ _1096_/Q Tile_X0Y4_FrameData[30] VGND VPWR Tile_X0Y5_FrameStrobe[2] latch
X_0116_ _0116_/Q Tile_X0Y0_FrameData[18] VGND VPWR Tile_X0Y5_FrameStrobe[1] latch
XANTENNA__0269__GATE Tile_X0Y5_FrameStrobe[6] VPWR VGND sg13cmos5l_antennanp
X_0047_ _2068_/A _2447_/X _2448_/X _0629_/Q VPWR VGND sg13cmos5l_mux2_1
XANTENNA__0899__GATE Tile_X0Y5_FrameStrobe[3] VPWR VGND sg13cmos5l_antennanp
XANTENNA__1928__X Tile_X0Y1_EE4BEG[9] VPWR VGND sg13cmos5l_antennanp
XANTENNA__2460__A0 Tile_X0Y3_W1END[1] VPWR VGND sg13cmos5l_antennanp
XFILLER_20_222 VPWR VGND sg13cmos5l_fill_2
XANTENNA__0822__GATE Tile_X0Y5_FrameStrobe[0] VPWR VGND sg13cmos5l_antennanp
XFILLER_118_121 VPWR VGND sg13cmos5l_decap_8
X_1998_ Tile_X0Y5_E6BEG[11] _2768_/X VPWR VGND sg13cmos5l_buf_1
XFILLER_118_165 VPWR VGND sg13cmos5l_decap_8
X_0949_ _0949_/Q Tile_X0Y3_FrameData[1] VGND VPWR Tile_X0Y5_FrameStrobe[4] latch
XANTENNA__0207__GATE Tile_X0Y5_FrameStrobe[4] VPWR VGND sg13cmos5l_antennanp
XFILLER_69_29 VPWR VGND sg13cmos5l_decap_8
XANTENNA__0430__D Tile_X0Y1_FrameData[8] VPWR VGND sg13cmos5l_antennanp
XANTENNA__0837__GATE Tile_X0Y5_FrameStrobe[1] VPWR VGND sg13cmos5l_antennanp
XANTENNA__1663__X Tile_X0Y0_FrameData_O[3] VPWR VGND sg13cmos5l_antennanp
XFILLER_133_135 VPWR VGND sg13cmos5l_decap_8
X_2619_ _2619_/X AXIL_S_SOC_WSTRB2 AXIL_S_SOC_WVALID _2710_/X _2683_/X _1216_/Q _1215_/Q
+ VPWR VGND sg13cmos5l_mux4_1
XANTENNA__2515__A1 AXIL_S_SOC_ARADDR6 VPWR VGND sg13cmos5l_antennanp
XFILLER_133_179 VPWR VGND sg13cmos5l_decap_8
XFILLER_272_52 VPWR VGND sg13cmos5l_decap_8
XANTENNA__2279__A0 Tile_X0Y2_W1END[0] VPWR VGND sg13cmos5l_antennanp
XFILLER_125_79 VPWR VGND sg13cmos5l_fill_1
XANTENNA__1261__D Tile_X0Y4_FrameData[25] VPWR VGND sg13cmos5l_antennanp
XFILLER_141_56 VPWR VGND sg13cmos5l_decap_4
XFILLER_70_111 VPWR VGND sg13cmos5l_decap_8
XFILLER_34_54 VPWR VGND sg13cmos5l_decap_8
XANTENNA__1838__X Tile_X0Y4_FrameData_O[5] VPWR VGND sg13cmos5l_antennanp
XANTENNA__2451__A0 Tile_X0Y2_W1END[3] VPWR VGND sg13cmos5l_antennanp
XANTENNA__0605__D Tile_X0Y2_FrameData[9] VPWR VGND sg13cmos5l_antennanp
XFILLER_211_172 VPWR VGND sg13cmos5l_decap_8
XANTENNA__2203__A0 AXIL_S_SOC_WDATA22 VPWR VGND sg13cmos5l_antennanp
XFILLER_50_31 VPWR VGND sg13cmos5l_fill_2
XANTENNA__2754__A1 AXIL_S_SOC_ARVALID VPWR VGND sg13cmos5l_antennanp
XFILLER_109_165 VPWR VGND sg13cmos5l_decap_8
XFILLER_166_53 VPWR VGND sg13cmos5l_decap_8
XANTENNA__1436__D Tile_X0Y5_FrameData[20] VPWR VGND sg13cmos5l_antennanp
XANTENNA__1573__X Tile_X0Y3_FrameData_O[19] VPWR VGND sg13cmos5l_antennanp
XFILLER_316_34 VPWR VGND sg13cmos5l_fill_2
XFILLER_316_23 VPWR VGND sg13cmos5l_decap_8
XANTENNA__0340__D Tile_X0Y1_FrameData[2] VPWR VGND sg13cmos5l_antennanp
XFILLER_1_0 VPWR VGND sg13cmos5l_fill_1
XFILLER_78_200 VPWR VGND sg13cmos5l_decap_8
XFILLER_316_89 VPWR VGND sg13cmos5l_decap_8
XFILLER_93_203 VPWR VGND sg13cmos5l_fill_1
XFILLER_38_119 VPWR VGND sg13cmos5l_fill_1
XFILLER_332_11 VPWR VGND sg13cmos5l_fill_2
XFILLER_332_44 VPWR VGND sg13cmos5l_decap_8
XANTENNA__1171__D Tile_X0Y4_FrameData[19] VPWR VGND sg13cmos5l_antennanp
XFILLER_332_88 VPWR VGND sg13cmos5l_decap_4
XANTENNA__2285__A3 Tile_X0Y3_W6END[9] VPWR VGND sg13cmos5l_antennanp
XANTENNA__2690__A0 Tile_X0Y0_W1END[1] VPWR VGND sg13cmos5l_antennanp
XFILLER_201_59 VPWR VGND sg13cmos5l_decap_8
XANTENNA__2442__A0 AXIL_S_SOC_AWADDR1 VPWR VGND sg13cmos5l_antennanp
XFILLER_202_150 VPWR VGND sg13cmos5l_decap_8
X_1921_ Tile_X0Y1_EE4BEG[2] _2311_/X VPWR VGND sg13cmos5l_buf_1
XANTENNA__0515__D Tile_X0Y1_FrameData[19] VPWR VGND sg13cmos5l_antennanp
XANTENNA__1748__X Tile_X0Y2_FrameData_O[8] VPWR VGND sg13cmos5l_antennanp
X_1852_ Tile_X0Y4_FrameData_O[19] Tile_X0Y4_FrameData[19] VPWR VGND sg13cmos5l_buf_1
X_0803_ _0803_/Q Tile_X0Y3_FrameData[19] VGND VPWR Tile_X0Y5_FrameStrobe[0] latch
XANTENNA__2745__A1 AXIL_S_SOC_RREADY VPWR VGND sg13cmos5l_antennanp
XFILLER_162_208 VPWR VGND sg13cmos5l_decap_8
X_1783_ Tile_X0Y2_E2BEG[6] _2407_/X VPWR VGND sg13cmos5l_buf_1
X_0734_ _0734_/Q Tile_X0Y2_FrameData[8] VGND VPWR Tile_X0Y5_FrameStrobe[5] latch
XANTENNA__1346__D Tile_X0Y5_FrameData[14] VPWR VGND sg13cmos5l_antennanp
XFILLER_226_23 VPWR VGND sg13cmos5l_decap_8
X_0665_ _0665_/Q Tile_X0Y2_FrameData[13] VGND VPWR Tile_X0Y5_FrameStrobe[3] latch
XANTENNA__0250__D Tile_X0Y0_FrameData[12] VPWR VGND sg13cmos5l_antennanp
XFILLER_115_168 VPWR VGND sg13cmos5l_decap_8
X_2404_ _2404_/X AXIL_S_SOC_AWADDR3 AXIL_S_SOC_AWPROT1 _2484_/X _2485_/X _0740_/Q
+ _0739_/Q VPWR VGND sg13cmos5l_mux4_1
XANTENNA__0193__GATE Tile_X0Y5_FrameStrobe[3] VPWR VGND sg13cmos5l_antennanp
X_0596_ _0596_/Q Tile_X0Y2_FrameData[18] VGND VPWR Tile_X0Y5_FrameStrobe[1] latch
XFILLER_69_222 VPWR VGND sg13cmos5l_fill_2
XFILLER_34_0 VPWR VGND sg13cmos5l_fill_1
XFILLER_242_22 VPWR VGND sg13cmos5l_fill_1
X_2335_ _2335_/X AXIL_S_SOC_WDATA2 _2370_/X _2369_/X _2379_/X _0422_/Q _0421_/Q VPWR
+ VGND sg13cmos5l_mux4_1
X_2266_ _2266_/X _2367_/X _2365_/X _2350_/X _2349_/X _0517_/Q _0516_/Q VPWR VGND sg13cmos5l_mux4_1
XFILLER_29_119 VPWR VGND sg13cmos5l_decap_4
XANTENNA__1081__D Tile_X0Y4_FrameData[13] VPWR VGND sg13cmos5l_antennanp
X_2197_ _2197_/X _0049_/X Tile_X0Y0_S4END[0] _2218_/X _2217_/X _0202_/Q _0201_/Q VPWR
+ VGND sg13cmos5l_mux4_1
X_1217_ _1217_/Q Tile_X0Y4_FrameData[5] VGND VPWR Tile_X0Y5_FrameStrobe[5] latch
XFILLER_242_99 VPWR VGND sg13cmos5l_decap_8
XFILLER_37_174 VPWR VGND sg13cmos5l_decap_8
XFILLER_111_26 VPWR VGND sg13cmos5l_fill_1
XFILLER_111_37 VPWR VGND sg13cmos5l_decap_8
X_1148_ _1148_/Q Tile_X0Y4_FrameData[10] VGND VPWR Tile_X0Y5_FrameStrobe[3] latch
XFILLER_52_133 VPWR VGND sg13cmos5l_decap_8
XFILLER_111_48 VPWR VGND sg13cmos5l_fill_1
X_1079_ _1079_/Q Tile_X0Y4_FrameData[15] VGND VPWR Tile_X0Y5_FrameStrobe[1] latch
XANTENNA__0131__GATE Tile_X0Y5_FrameStrobe[1] VPWR VGND sg13cmos5l_antennanp
XANTENNA__2433__A0 Tile_X0Y5_N4END[12] VPWR VGND sg13cmos5l_antennanp
XANTENNA__0425__D Tile_X0Y1_FrameData[13] VPWR VGND sg13cmos5l_antennanp
XANTENNA__0761__GATE Tile_X0Y5_FrameStrobe[6] VPWR VGND sg13cmos5l_antennanp
XANTENNA__1658__X Tile_X0Y0_FrameStrobe_O[18] VPWR VGND sg13cmos5l_antennanp
XFILLER_224_9 VPWR VGND sg13cmos5l_fill_2
XANTENNA__2736__A1 AXIL_S_SOC_ARVALID VPWR VGND sg13cmos5l_antennanp
XFILLER_354_157 VPWR VGND sg13cmos5l_decap_8
XANTENNA__0146__GATE Tile_X0Y5_FrameStrobe[2] VPWR VGND sg13cmos5l_antennanp
XANTENNA__0776__GATE Tile_X0Y5_FrameStrobe[7] VPWR VGND sg13cmos5l_antennanp
XANTENNA__1256__D Tile_X0Y4_FrameData[30] VPWR VGND sg13cmos5l_antennanp
XFILLER_106_146 VPWR VGND sg13cmos5l_fill_2
XANTENNA__0160__D Tile_X0Y0_FrameData[6] VPWR VGND sg13cmos5l_antennanp
XANTENNA__1834__A Tile_X0Y4_FrameData[1] VPWR VGND sg13cmos5l_antennanp
XFILLER_20_89 VPWR VGND sg13cmos5l_decap_8
XFILLER_283_51 VPWR VGND sg13cmos5l_decap_4
XFILLER_96_16 VPWR VGND sg13cmos5l_decap_4
XFILLER_114_190 VPWR VGND sg13cmos5l_decap_8
XFILLER_96_49 VPWR VGND sg13cmos5l_decap_8
XFILLER_152_11 VPWR VGND sg13cmos5l_decap_8
XFILLER_152_55 VPWR VGND sg13cmos5l_decap_8
XFILLER_275_153 VPWR VGND sg13cmos5l_fill_2
XFILLER_275_197 VPWR VGND sg13cmos5l_decap_8
XFILLER_290_112 VPWR VGND sg13cmos5l_decap_8
XANTENNA__0714__GATE Tile_X0Y5_FrameStrobe[5] VPWR VGND sg13cmos5l_antennanp
XANTENNA__2267__A3 Tile_X0Y1_W6END[10] VPWR VGND sg13cmos5l_antennanp
XFILLER_45_64 VPWR VGND sg13cmos5l_fill_2
XFILLER_45_53 VPWR VGND sg13cmos5l_fill_1
XFILLER_43_122 VPWR VGND sg13cmos5l_decap_8
XFILLER_302_69 VPWR VGND sg13cmos5l_decap_4
XANTENNA__2424__A0 AXIL_S_SOC_AWADDR7 VPWR VGND sg13cmos5l_antennanp
XANTENNA__0335__D Tile_X0Y1_FrameData[7] VPWR VGND sg13cmos5l_antennanp
XANTENNA__0729__GATE Tile_X0Y5_FrameStrobe[5] VPWR VGND sg13cmos5l_antennanp
XANTENNA__1568__X Tile_X0Y3_FrameData_O[14] VPWR VGND sg13cmos5l_antennanp
XFILLER_236_0 VPWR VGND sg13cmos5l_fill_1
XFILLER_345_135 VPWR VGND sg13cmos5l_decap_8
XANTENNA__2727__A1 AXIL_S_SOC_ARPROT2 VPWR VGND sg13cmos5l_antennanp
XFILLER_177_74 VPWR VGND sg13cmos5l_fill_1
XFILLER_360_116 VPWR VGND sg13cmos5l_fill_2
XANTENNA__1166__D Tile_X0Y4_FrameData[24] VPWR VGND sg13cmos5l_antennanp
XFILLER_360_149 VPWR VGND sg13cmos5l_fill_1
XANTENNA__1744__A Tile_X0Y2_FrameData[4] VPWR VGND sg13cmos5l_antennanp
XFILLER_193_73 VPWR VGND sg13cmos5l_decap_4
X_0450_ _0450_/Q Tile_X0Y1_FrameData[20] VGND VPWR Tile_X0Y5_FrameStrobe[4] latch
XFILLER_112_127 VPWR VGND sg13cmos5l_decap_8
XFILLER_266_131 VPWR VGND sg13cmos5l_decap_8
X_0381_ _0381_/Q Tile_X0Y1_FrameData[25] VGND VPWR Tile_X0Y5_FrameStrobe[2] latch
X_2120_ AXIL_S_SOC_RDATA14 Tile_X0Y2_W2MID[6] Tile_X0Y2_W2END[6] Tile_X0Y2_W6END[6]
+ _2487_/X _0610_/Q _0609_/Q VPWR VGND sg13cmos5l_mux4_1
XFILLER_86_71 VPWR VGND sg13cmos5l_decap_8
XFILLER_343_98 VPWR VGND sg13cmos5l_decap_8
XFILLER_266_197 VPWR VGND sg13cmos5l_fill_2
X_2051_ Tile_X0Y5_S2BEG[0] _2773_/X VPWR VGND sg13cmos5l_buf_1
X_1002_ _1002_/Q Tile_X0Y3_FrameData[12] VGND VPWR Tile_X0Y5_FrameStrobe[6] latch
XANTENNA__2663__A0 Tile_X0Y4_W1END[1] VPWR VGND sg13cmos5l_antennanp
XFILLER_222_201 VPWR VGND sg13cmos5l_fill_1
XANTENNA__2415__A0 AXIL_S_SOC_AWADDR0 VPWR VGND sg13cmos5l_antennanp
XANTENNA__0245__D Tile_X0Y0_FrameData[17] VPWR VGND sg13cmos5l_antennanp
XFILLER_187_160 VPWR VGND sg13cmos5l_decap_8
XFILLER_194_119 VPWR VGND sg13cmos5l_decap_8
X_1904_ Tile_X0Y1_FrameData_O[17] Tile_X0Y1_FrameData[17] VPWR VGND sg13cmos5l_buf_1
XANTENNA__1491__GATE Tile_X0Y5_FrameStrobe[7] VPWR VGND sg13cmos5l_antennanp
X_1835_ Tile_X0Y4_FrameData_O[2] Tile_X0Y4_FrameData[2] VPWR VGND sg13cmos5l_buf_1
XFILLER_336_168 VPWR VGND sg13cmos5l_decap_8
XANTENNA__2718__A1 Tile_X0Y3_W2MID[2] VPWR VGND sg13cmos5l_antennanp
X_1766_ Tile_X0Y2_FrameData_O[26] Tile_X0Y2_FrameData[26] VPWR VGND sg13cmos5l_buf_1
XFILLER_351_127 VPWR VGND sg13cmos5l_decap_8
XANTENNA__1076__D Tile_X0Y4_FrameData[18] VPWR VGND sg13cmos5l_antennanp
XFILLER_237_66 VPWR VGND sg13cmos5l_fill_1
XFILLER_289_223 VPWR VGND sg13cmos5l_fill_1
X_0717_ _0717_/Q Tile_X0Y2_FrameData[25] VGND VPWR Tile_X0Y5_FrameStrobe[5] latch
XANTENNA__1654__A Tile_X0Y5_FrameStrobe[14] VPWR VGND sg13cmos5l_antennanp
XANTENNA__2102__X AXIL_S_SOC_BRESP0 VPWR VGND sg13cmos5l_antennanp
X_1697_ Tile_X0Y0_EE4BEG[5] _2186_/X VPWR VGND sg13cmos5l_buf_1
XFILLER_253_32 VPWR VGND sg13cmos5l_decap_4
X_0648_ _0648_/Q Tile_X0Y2_FrameData[30] VGND VPWR Tile_X0Y5_FrameStrobe[3] latch
XANTENNA__1941__X Tile_X0Y1_E6BEG[6] VPWR VGND sg13cmos5l_antennanp
XFILLER_106_59 VPWR VGND sg13cmos5l_decap_8
XFILLER_253_43 VPWR VGND sg13cmos5l_fill_1
XFILLER_257_120 VPWR VGND sg13cmos5l_fill_1
X_0579_ _0579_/Q Tile_X0Y2_FrameData[3] VGND VPWR Tile_X0Y5_FrameStrobe[0] latch
XFILLER_111_171 VPWR VGND sg13cmos5l_decap_8
XFILLER_257_142 VPWR VGND sg13cmos5l_decap_8
XFILLER_257_153 VPWR VGND sg13cmos5l_fill_1
X_2318_ _2318_/X AXIL_S_SOC_WDATA5 AXIL_S_SOC_WDATA9 _2366_/X _2379_/X _0456_/Q _0455_/Q
+ VPWR VGND sg13cmos5l_mux4_1
XFILLER_122_36 VPWR VGND sg13cmos5l_decap_8
X_2249_ _2249_/X Tile_X0Y2_W2MID[7] Tile_X0Y2_W2END[7] Tile_X0Y2_W6END[7] _2481_/X
+ _0782_/Q _0781_/Q VPWR VGND sg13cmos5l_mux4_1
XANTENNA__1444__GATE Tile_X0Y5_FrameStrobe[5] VPWR VGND sg13cmos5l_antennanp
XANTENNA__2654__A0 AXIL_S_SOC_BREADY VPWR VGND sg13cmos5l_antennanp
XFILLER_122_69 VPWR VGND sg13cmos5l_decap_4
XFILLER_82_29 VPWR VGND sg13cmos5l_decap_8
XFILLER_82_18 VPWR VGND sg13cmos5l_fill_1
XFILLER_198_18 VPWR VGND sg13cmos5l_decap_8
XFILLER_25_144 VPWR VGND sg13cmos5l_decap_8
XFILLER_359_216 VPWR VGND sg13cmos5l_fill_2
XANTENNA__2406__A0 AXIL_S_SOC_AWADDR5 VPWR VGND sg13cmos5l_antennanp
XANTENNA__0155__D Tile_X0Y0_FrameData[11] VPWR VGND sg13cmos5l_antennanp
XFILLER_278_51 VPWR VGND sg13cmos5l_decap_4
XANTENNA__1459__GATE Tile_X0Y5_FrameStrobe[6] VPWR VGND sg13cmos5l_antennanp
XFILLER_178_182 VPWR VGND sg13cmos5l_decap_8
XFILLER_327_7 VPWR VGND sg13cmos5l_decap_8
XANTENNA__0085__GATE Tile_X0Y5_FrameStrobe[0] VPWR VGND sg13cmos5l_antennanp
XANTENNA__2709__A1 Tile_X0Y5_N2MID[1] VPWR VGND sg13cmos5l_antennanp
XFILLER_193_196 VPWR VGND sg13cmos5l_fill_2
XFILLER_342_127 VPWR VGND sg13cmos5l_fill_1
XANTENNA__1564__A Tile_X0Y3_FrameData[10] VPWR VGND sg13cmos5l_antennanp
XANTENNA__2012__X Tile_X0Y5_EE4BEG[13] VPWR VGND sg13cmos5l_antennanp
XFILLER_147_99 VPWR VGND sg13cmos5l_decap_8
XFILLER_350_160 VPWR VGND sg13cmos5l_fill_1
XFILLER_295_215 VPWR VGND sg13cmos5l_fill_2
XANTENNA__1851__X Tile_X0Y4_FrameData_O[18] VPWR VGND sg13cmos5l_antennanp
XFILLER_163_43 VPWR VGND sg13cmos5l_decap_8
XFILLER_102_171 VPWR VGND sg13cmos5l_decap_8
XANTENNA__0653__GATE Tile_X0Y5_FrameStrobe[3] VPWR VGND sg13cmos5l_antennanp
XFILLER_263_112 VPWR VGND sg13cmos5l_decap_8
XFILLER_313_68 VPWR VGND sg13cmos5l_decap_8
XANTENNA__2645__A0 Tile_X0Y4_WW4END[8] VPWR VGND sg13cmos5l_antennanp
XFILLER_204_223 VPWR VGND sg13cmos5l_fill_1
XFILLER_353_0 VPWR VGND sg13cmos5l_fill_1
XANTENNA__0668__GATE Tile_X0Y5_FrameStrobe[3] VPWR VGND sg13cmos5l_antennanp
XFILLER_31_103 VPWR VGND sg13cmos5l_decap_4
XFILLER_72_73 VPWR VGND sg13cmos5l_decap_8
XFILLER_31_136 VPWR VGND sg13cmos5l_decap_8
XFILLER_184_130 VPWR VGND sg13cmos5l_decap_8
XFILLER_338_43 VPWR VGND sg13cmos5l_decap_8
XFILLER_184_185 VPWR VGND sg13cmos5l_decap_8
X_1620_ Tile_X0Y0_N2BEGb[0] _2250_/X VPWR VGND sg13cmos5l_buf_1
XANTENNA__0606__GATE Tile_X0Y5_FrameStrobe[1] VPWR VGND sg13cmos5l_antennanp
X_1551_ Tile_X0Y3_EE4BEG[13] _2538_/X VPWR VGND sg13cmos5l_buf_1
XFILLER_140_222 VPWR VGND sg13cmos5l_fill_2
X_1482_ _1482_/Q Tile_X0Y5_FrameData[6] VGND VPWR Tile_X0Y5_FrameStrobe[6] latch
X_0502_ _0502_/Q Tile_X0Y1_FrameData[0] VGND VPWR Tile_X0Y5_FrameStrobe[5] latch
XFILLER_98_114 VPWR VGND sg13cmos5l_decap_8
XFILLER_354_64 VPWR VGND sg13cmos5l_decap_8
X_0433_ _0433_/Q Tile_X0Y1_FrameData[5] VGND VPWR Tile_X0Y5_FrameStrobe[3] latch
XANTENNA__1761__X Tile_X0Y2_FrameData_O[21] VPWR VGND sg13cmos5l_antennanp
XANTENNA__2479__A3 Tile_X0Y0_S4END[8] VPWR VGND sg13cmos5l_antennanp
XFILLER_254_112 VPWR VGND sg13cmos5l_decap_8
X_2103_ AXIL_S_SOC_BRESP1 Tile_X0Y4_W2MID[3] Tile_X0Y4_W2END[3] Tile_X0Y4_W6END[3]
+ _2711_/X _1090_/Q _1089_/Q VPWR VGND sg13cmos5l_mux4_1
X_0364_ _0364_/Q Tile_X0Y1_FrameData[10] VGND VPWR Tile_X0Y5_FrameStrobe[1] latch
XFILLER_254_145 VPWR VGND sg13cmos5l_decap_8
X_0295_ _0295_/Q Tile_X0Y0_FrameData[31] VGND VPWR Tile_X0Y5_FrameStrobe[7] latch
XANTENNA__2636__A0 Tile_X0Y4_WW4END[7] VPWR VGND sg13cmos5l_antennanp
X_2034_ Tile_X0Y5_FrameData_O[19] Tile_X0Y5_FrameData[19] VPWR VGND sg13cmos5l_buf_1
XFILLER_299_28 VPWR VGND sg13cmos5l_decap_8
XANTENNA__2100__A2 Tile_X0Y4_W6END[0] VPWR VGND sg13cmos5l_antennanp
XANTENNA__1649__A Tile_X0Y5_FrameStrobe[9] VPWR VGND sg13cmos5l_antennanp
XFILLER_167_108 VPWR VGND sg13cmos5l_fill_2
XFILLER_356_208 VPWR VGND sg13cmos5l_fill_1
XFILLER_175_130 VPWR VGND sg13cmos5l_decap_4
XFILLER_309_157 VPWR VGND sg13cmos5l_decap_8
XANTENNA__0703__D Tile_X0Y2_FrameData[7] VPWR VGND sg13cmos5l_antennanp
XANTENNA__1936__X Tile_X0Y1_E6BEG[1] VPWR VGND sg13cmos5l_antennanp
XFILLER_108_208 VPWR VGND sg13cmos5l_fill_1
XFILLER_175_163 VPWR VGND sg13cmos5l_decap_8
X_1818_ Tile_X0Y4_EE4BEG[1] _2634_/X VPWR VGND sg13cmos5l_buf_1
X_2798_ _2798_/X Tile_X0Y5_N2MID[6] Tile_X0Y5_N2END[6] _2835_/X _2719_/X _1276_/Q
+ _1275_/Q VPWR VGND sg13cmos5l_mux4_1
XFILLER_117_25 VPWR VGND sg13cmos5l_fill_2
X_1749_ Tile_X0Y2_FrameData_O[9] Tile_X0Y2_FrameData[9] VPWR VGND sg13cmos5l_buf_1
XFILLER_131_211 VPWR VGND sg13cmos5l_fill_1
XFILLER_131_222 VPWR VGND sg13cmos5l_fill_2
XFILLER_264_53 VPWR VGND sg13cmos5l_decap_8
XANTENNA__1671__X Tile_X0Y0_FrameData_O[11] VPWR VGND sg13cmos5l_antennanp
XFILLER_133_35 VPWR VGND sg13cmos5l_decap_8
XFILLER_280_52 VPWR VGND sg13cmos5l_fill_2
XANTENNA__1383__GATE Tile_X0Y5_FrameStrobe[3] VPWR VGND sg13cmos5l_antennanp
XANTENNA__2627__A0 AXIL_S_SOC_WSTRB2 VPWR VGND sg13cmos5l_antennanp
XFILLER_260_104 VPWR VGND sg13cmos5l_decap_8
XFILLER_26_11 VPWR VGND sg13cmos5l_fill_2
XFILLER_198_211 VPWR VGND sg13cmos5l_decap_8
XFILLER_289_72 VPWR VGND sg13cmos5l_decap_4
XANTENNA__1398__GATE Tile_X0Y5_FrameStrobe[4] VPWR VGND sg13cmos5l_antennanp
XANTENNA__1559__A Tile_X0Y3_FrameData[5] VPWR VGND sg13cmos5l_antennanp
XFILLER_289_94 VPWR VGND sg13cmos5l_fill_1
XANTENNA__2007__X Tile_X0Y5_EE4BEG[8] VPWR VGND sg13cmos5l_antennanp
XFILLER_158_54 VPWR VGND sg13cmos5l_decap_8
XFILLER_166_130 VPWR VGND sg13cmos5l_decap_8
XFILLER_42_65 VPWR VGND sg13cmos5l_fill_1
XFILLER_42_54 VPWR VGND sg13cmos5l_fill_1
XANTENNA__0613__D Tile_X0Y2_FrameData[1] VPWR VGND sg13cmos5l_antennanp
XANTENNA__1321__GATE Tile_X0Y5_FrameStrobe[1] VPWR VGND sg13cmos5l_antennanp
XANTENNA__1846__X Tile_X0Y4_FrameData_O[13] VPWR VGND sg13cmos5l_antennanp
XFILLER_166_185 VPWR VGND sg13cmos5l_fill_1
XFILLER_181_100 VPWR VGND sg13cmos5l_decap_8
XFILLER_181_133 VPWR VGND sg13cmos5l_decap_8
XFILLER_181_177 VPWR VGND sg13cmos5l_decap_8
XFILLER_308_79 VPWR VGND sg13cmos5l_decap_8
XANTENNA__1336__GATE Tile_X0Y5_FrameStrobe[2] VPWR VGND sg13cmos5l_antennanp
XFILLER_122_200 VPWR VGND sg13cmos5l_decap_8
XFILLER_122_211 VPWR VGND sg13cmos5l_fill_1
XFILLER_330_119 VPWR VGND sg13cmos5l_decap_4
XANTENNA__1444__D Tile_X0Y5_FrameData[12] VPWR VGND sg13cmos5l_antennanp
XANTENNA__0592__GATE Tile_X0Y5_FrameStrobe[1] VPWR VGND sg13cmos5l_antennanp
XANTENNA__1581__X Tile_X0Y3_FrameData_O[27] VPWR VGND sg13cmos5l_antennanp
XFILLER_95_139 VPWR VGND sg13cmos5l_decap_8
XFILLER_95_117 VPWR VGND sg13cmos5l_decap_8
XFILLER_324_78 VPWR VGND sg13cmos5l_decap_8
XFILLER_190_63 VPWR VGND sg13cmos5l_decap_8
XFILLER_190_85 VPWR VGND sg13cmos5l_decap_4
XFILLER_236_123 VPWR VGND sg13cmos5l_decap_8
XFILLER_67_95 VPWR VGND sg13cmos5l_decap_8
XANTENNA__2618__A0 AXIL_S_SOC_WSTRB1 VPWR VGND sg13cmos5l_antennanp
XFILLER_190_96 VPWR VGND sg13cmos5l_decap_4
X_0080_ _0080_/Q Tile_X0Y0_FrameData[22] VGND VPWR Tile_X0Y5_FrameStrobe[0] latch
XFILLER_83_72 VPWR VGND sg13cmos5l_decap_8
XFILLER_149_119 VPWR VGND sg13cmos5l_decap_8
XANTENNA__0530__GATE Tile_X0Y5_FrameStrobe[6] VPWR VGND sg13cmos5l_antennanp
X_0982_ _0982_/Q Tile_X0Y3_FrameData[0] VGND VPWR Tile_X0Y5_FrameStrobe[5] latch
XANTENNA__2397__A2 AXIL_S_SOC_AWADDR2 VPWR VGND sg13cmos5l_antennanp
X_2721_ _2721_/X Tile_X0Y5_N1END[0] _2793_/X Tile_X0Y5_WW4END[4] AXIL_S_SOC_ARPROT2
+ _1460_/Q _1459_/Q VPWR VGND sg13cmos5l_mux4_1
XANTENNA__0523__D Tile_X0Y1_FrameData[11] VPWR VGND sg13cmos5l_antennanp
XANTENNA__1756__X Tile_X0Y2_FrameData_O[16] VPWR VGND sg13cmos5l_antennanp
XFILLER_157_185 VPWR VGND sg13cmos5l_fill_1
XANTENNA__2149__A2 Tile_X0Y0_W6END[3] VPWR VGND sg13cmos5l_antennanp
XFILLER_172_133 VPWR VGND sg13cmos5l_decap_4
XFILLER_218_35 VPWR VGND sg13cmos5l_fill_1
X_2652_ _2652_/X Tile_X0Y5_N4END[7] _0025_/X _2697_/X _2696_/X _1150_/Q _1149_/Q VPWR
+ VGND sg13cmos5l_mux4_1
XFILLER_306_149 VPWR VGND sg13cmos5l_fill_2
XANTENNA__0545__GATE Tile_X0Y5_FrameStrobe[7] VPWR VGND sg13cmos5l_antennanp
XFILLER_172_166 VPWR VGND sg13cmos5l_decap_8
X_1603_ Tile_X0Y0_UserCLKo Tile_X0Y0_UserCLK VPWR VGND sg13cmos5l_buf_1
X_2583_ _2583_/X _2572_/X Tile_X0Y5_N4END[11] _2571_/X Tile_X0Y0_S4END[15] _0840_/Q
+ _0839_/Q VPWR VGND sg13cmos5l_mux4_1
X_1534_ Tile_X0Y3_E6BEG[8] _2549_/X VPWR VGND sg13cmos5l_buf_1
XANTENNA__1354__D Tile_X0Y5_FrameData[6] VPWR VGND sg13cmos5l_antennanp
XFILLER_234_56 VPWR VGND sg13cmos5l_decap_8
X_1465_ _1465_/Q Tile_X0Y5_FrameData[23] VGND VPWR Tile_X0Y5_FrameStrobe[6] latch
XFILLER_86_106 VPWR VGND sg13cmos5l_decap_8
X_1396_ _1396_/Q Tile_X0Y5_FrameData[28] VGND VPWR Tile_X0Y5_FrameStrobe[4] latch
X_0416_ _0416_/Q Tile_X0Y1_FrameData[22] VGND VPWR Tile_X0Y5_FrameStrobe[3] latch
X_0347_ _0347_/Q Tile_X0Y1_FrameData[27] VGND VPWR Tile_X0Y5_FrameStrobe[1] latch
XANTENNA__2609__A0 Tile_X0Y2_W1END[2] VPWR VGND sg13cmos5l_antennanp
XFILLER_103_27 VPWR VGND sg13cmos5l_decap_8
XFILLER_227_178 VPWR VGND sg13cmos5l_decap_8
X_2017_ Tile_X0Y5_FrameData_O[2] Tile_X0Y5_FrameData[2] VPWR VGND sg13cmos5l_buf_1
X_0278_ _0278_/Q Tile_X0Y0_FrameData[16] VGND VPWR Tile_X0Y5_FrameStrobe[6] latch
XFILLER_250_99 VPWR VGND sg13cmos5l_fill_2
XFILLER_259_20 VPWR VGND sg13cmos5l_decap_8
XFILLER_195_214 VPWR VGND sg13cmos5l_fill_1
XANTENNA__2388__A2 Tile_X0Y3_W6END[4] VPWR VGND sg13cmos5l_antennanp
XFILLER_259_86 VPWR VGND sg13cmos5l_decap_8
XANTENNA__0433__D Tile_X0Y1_FrameData[5] VPWR VGND sg13cmos5l_antennanp
XANTENNA__1666__X Tile_X0Y0_FrameData_O[6] VPWR VGND sg13cmos5l_antennanp
XFILLER_12_35 VPWR VGND sg13cmos5l_fill_1
XFILLER_128_35 VPWR VGND sg13cmos5l_decap_8
XFILLER_163_111 VPWR VGND sg13cmos5l_decap_8
XFILLER_128_79 VPWR VGND sg13cmos5l_decap_8
XFILLER_163_177 VPWR VGND sg13cmos5l_decap_8
XFILLER_275_85 VPWR VGND sg13cmos5l_fill_1
XFILLER_163_188 VPWR VGND sg13cmos5l_fill_1
XFILLER_312_119 VPWR VGND sg13cmos5l_decap_4
XANTENNA__1264__D Tile_X0Y4_FrameData[22] VPWR VGND sg13cmos5l_antennanp
XANTENNA__1842__A Tile_X0Y4_FrameData[9] VPWR VGND sg13cmos5l_antennanp
XFILLER_144_56 VPWR VGND sg13cmos5l_decap_8
XFILLER_77_117 VPWR VGND sg13cmos5l_decap_8
XFILLER_85_183 VPWR VGND sg13cmos5l_decap_8
XFILLER_37_43 VPWR VGND sg13cmos5l_fill_1
XANTENNA__0608__D Tile_X0Y2_FrameData[6] VPWR VGND sg13cmos5l_antennanp
XANTENNA__2615__A3 AXIL_S_SOC_BREADY VPWR VGND sg13cmos5l_antennanp
XFILLER_186_203 VPWR VGND sg13cmos5l_decap_8
XFILLER_310_69 VPWR VGND sg13cmos5l_fill_1
XFILLER_149_0 VPWR VGND sg13cmos5l_fill_2
XFILLER_241_181 VPWR VGND sg13cmos5l_fill_2
XFILLER_53_64 VPWR VGND sg13cmos5l_decap_8
XFILLER_330_2 VPWR VGND sg13cmos5l_fill_1
XANTENNA__1260__GATE Tile_X0Y5_FrameStrobe[7] VPWR VGND sg13cmos5l_antennanp
XFILLER_169_86 VPWR VGND sg13cmos5l_fill_2
XANTENNA__0343__D Tile_X0Y1_FrameData[31] VPWR VGND sg13cmos5l_antennanp
XANTENNA__1439__D Tile_X0Y5_FrameData[17] VPWR VGND sg13cmos5l_antennanp
XANTENNA__1576__X Tile_X0Y3_FrameData_O[22] VPWR VGND sg13cmos5l_antennanp
XFILLER_316_0 VPWR VGND sg13cmos5l_fill_1
XFILLER_154_111 VPWR VGND sg13cmos5l_decap_8
XFILLER_319_89 VPWR VGND sg13cmos5l_fill_1
XANTENNA__1275__GATE Tile_X0Y5_FrameStrobe[0] VPWR VGND sg13cmos5l_antennanp
XFILLER_335_77 VPWR VGND sg13cmos5l_decap_8
XANTENNA__1174__D Tile_X0Y4_FrameData[16] VPWR VGND sg13cmos5l_antennanp
XANTENNA__1752__A Tile_X0Y2_FrameData[12] VPWR VGND sg13cmos5l_antennanp
XFILLER_110_214 VPWR VGND sg13cmos5l_fill_1
XFILLER_78_72 VPWR VGND sg13cmos5l_decap_8
XFILLER_68_128 VPWR VGND sg13cmos5l_fill_1
X_1250_ _1250_/Q Tile_X0Y4_FrameData[4] VGND VPWR Tile_X0Y5_FrameStrobe[6] latch
X_1181_ _1181_/Q Tile_X0Y4_FrameData[9] VGND VPWR Tile_X0Y5_FrameStrobe[4] latch
X_0201_ _0201_/Q Tile_X0Y0_FrameData[29] VGND VPWR Tile_X0Y5_FrameStrobe[4] latch
XFILLER_76_150 VPWR VGND sg13cmos5l_decap_8
X_0132_ _0132_/Q Tile_X0Y0_FrameData[2] VGND VPWR Tile_X0Y5_FrameStrobe[1] latch
XFILLER_91_120 VPWR VGND sg13cmos5l_decap_4
XFILLER_351_87 VPWR VGND sg13cmos5l_decap_8
XANTENNA__0518__D Tile_X0Y1_FrameData[16] VPWR VGND sg13cmos5l_antennanp
XANTENNA__1213__GATE Tile_X0Y5_FrameStrobe[5] VPWR VGND sg13cmos5l_antennanp
XFILLER_224_115 VPWR VGND sg13cmos5l_decap_8
XFILLER_94_93 VPWR VGND sg13cmos5l_decap_8
X_0063_ _0063_/X _2351_/X _2352_/X _1470_/Q VPWR VGND sg13cmos5l_mux2_1
XFILLER_232_170 VPWR VGND sg13cmos5l_decap_8
XANTENNA__1228__GATE Tile_X0Y5_FrameStrobe[6] VPWR VGND sg13cmos5l_antennanp
XFILLER_296_29 VPWR VGND sg13cmos5l_fill_2
XANTENNA__0253__D Tile_X0Y0_FrameData[9] VPWR VGND sg13cmos5l_antennanp
XANTENNA__1349__D Tile_X0Y5_FrameData[11] VPWR VGND sg13cmos5l_antennanp
XFILLER_145_100 VPWR VGND sg13cmos5l_decap_8
XFILLER_192_206 VPWR VGND sg13cmos5l_decap_8
X_0965_ _0965_/Q Tile_X0Y3_FrameData[17] VGND VPWR Tile_X0Y5_FrameStrobe[5] latch
XANTENNA__0484__GATE Tile_X0Y5_FrameStrobe[5] VPWR VGND sg13cmos5l_antennanp
X_2704_ _2704_/X _2676_/X Tile_X0Y5_N4END[5] _2675_/X _0071_/X _1076_/Q _1075_/Q VPWR
+ VGND sg13cmos5l_mux4_1
X_0896_ _0896_/Q Tile_X0Y3_FrameData[22] VGND VPWR Tile_X0Y5_FrameStrobe[3] latch
XANTENNA__2790__A2 Tile_X0Y5_W6END[1] VPWR VGND sg13cmos5l_antennanp
X_2635_ _2635_/X Tile_X0Y4_WW4END[6] AXIL_S_SOC_WSTRB2 _2692_/X _2683_/X _1184_/Q
+ _1183_/Q VPWR VGND sg13cmos5l_mux4_1
XFILLER_160_103 VPWR VGND sg13cmos5l_decap_8
XANTENNA__0499__GATE Tile_X0Y5_FrameStrobe[5] VPWR VGND sg13cmos5l_antennanp
X_2566_ _2566_/X Tile_X0Y4_W1END[0] Tile_X0Y4_W6END[4] _2696_/X _2669_/X _1264_/Q
+ _1263_/Q VPWR VGND sg13cmos5l_mux4_1
XANTENNA__1084__D Tile_X0Y4_FrameData[10] VPWR VGND sg13cmos5l_antennanp
XANTENNA__1662__A Tile_X0Y0_FrameData[2] VPWR VGND sg13cmos5l_antennanp
X_1517_ _2209_/A3 VPWR VGND sg13cmos5l_tielo
X_2497_ _2497_/X Tile_X0Y1_W1END[0] Tile_X0Y1_W2MID[3] Tile_X0Y1_W2END[3] _2377_/X
+ _0402_/Q _0401_/Q VPWR VGND sg13cmos5l_mux4_1
XANTENNA__2110__X AXIL_S_SOC_RDATA4 VPWR VGND sg13cmos5l_antennanp
XFILLER_247_207 VPWR VGND sg13cmos5l_fill_1
X_1448_ _1448_/Q Tile_X0Y5_FrameData[8] VGND VPWR Tile_X0Y5_FrameStrobe[5] latch
XFILLER_59_139 VPWR VGND sg13cmos5l_decap_8
XANTENNA__0422__GATE Tile_X0Y5_FrameStrobe[3] VPWR VGND sg13cmos5l_antennanp
X_1379_ _1379_/Q Tile_X0Y5_FrameData[13] VGND VPWR Tile_X0Y5_FrameStrobe[3] latch
XFILLER_67_194 VPWR VGND sg13cmos5l_decap_8
XANTENNA__0428__D Tile_X0Y1_FrameData[10] VPWR VGND sg13cmos5l_antennanp
XFILLER_82_164 VPWR VGND sg13cmos5l_decap_8
XANTENNA__0437__GATE Tile_X0Y5_FrameStrobe[3] VPWR VGND sg13cmos5l_antennanp
XFILLER_130_47 VPWR VGND sg13cmos5l_decap_8
XFILLER_142_7 VPWR VGND sg13cmos5l_decap_8
XFILLER_139_12 VPWR VGND sg13cmos5l_decap_8
XANTENNA__0163__D Tile_X0Y0_FrameData[3] VPWR VGND sg13cmos5l_antennanp
XANTENNA__1259__D Tile_X0Y4_FrameData[27] VPWR VGND sg13cmos5l_antennanp
XANTENNA__1837__A Tile_X0Y4_FrameData[4] VPWR VGND sg13cmos5l_antennanp
XFILLER_139_78 VPWR VGND sg13cmos5l_fill_1
XFILLER_99_27 VPWR VGND sg13cmos5l_fill_1
XFILLER_325_211 VPWR VGND sg13cmos5l_fill_2
XANTENNA__2781__A2 Tile_X0Y5_WW4END[12] VPWR VGND sg13cmos5l_antennanp
XFILLER_151_114 VPWR VGND sg13cmos5l_decap_4
XANTENNA__1572__A Tile_X0Y3_FrameData[18] VPWR VGND sg13cmos5l_antennanp
XANTENNA__2020__X Tile_X0Y5_FrameData_O[5] VPWR VGND sg13cmos5l_antennanp
XFILLER_305_58 VPWR VGND sg13cmos5l_decap_8
XANTENNA__2297__A1 AXIL_S_SOC_WDATA12 VPWR VGND sg13cmos5l_antennanp
XFILLER_48_53 VPWR VGND sg13cmos5l_fill_2
XANTENNA__0338__D Tile_X0Y1_FrameData[4] VPWR VGND sg13cmos5l_antennanp
XFILLER_104_70 VPWR VGND sg13cmos5l_fill_1
XFILLER_73_153 VPWR VGND sg13cmos5l_decap_8
XFILLER_206_137 VPWR VGND sg13cmos5l_decap_4
XFILLER_266_0 VPWR VGND sg13cmos5l_decap_8
XFILLER_159_214 VPWR VGND sg13cmos5l_decap_8
XFILLER_9_58 VPWR VGND sg13cmos5l_fill_1
XANTENNA__0073__D Tile_X0Y0_FrameData[29] VPWR VGND sg13cmos5l_antennanp
XANTENNA__1169__D Tile_X0Y4_FrameData[21] VPWR VGND sg13cmos5l_antennanp
XANTENNA__1747__A Tile_X0Y2_FrameData[7] VPWR VGND sg13cmos5l_antennanp
X_0750_ _0750_/Q Tile_X0Y2_FrameData[24] VGND VPWR Tile_X0Y5_FrameStrobe[6] latch
XFILLER_127_166 VPWR VGND sg13cmos5l_decap_8
XFILLER_346_21 VPWR VGND sg13cmos5l_decap_8
XANTENNA__0801__D Tile_X0Y3_FrameData[21] VPWR VGND sg13cmos5l_antennanp
XFILLER_142_125 VPWR VGND sg13cmos5l_fill_2
X_2420_ _2420_/X AXIL_S_SOC_AWADDR1 AXIL_S_SOC_AWADDR3 _2471_/X _2485_/X _0708_/Q
+ _0707_/Q VPWR VGND sg13cmos5l_mux4_1
X_0681_ _0681_/Q Tile_X0Y2_FrameData[29] VGND VPWR Tile_X0Y5_FrameStrobe[4] latch
XFILLER_346_54 VPWR VGND sg13cmos5l_decap_8
XFILLER_142_169 VPWR VGND sg13cmos5l_decap_8
XFILLER_215_25 VPWR VGND sg13cmos5l_decap_8
X_2351_ _2351_/X Tile_X0Y5_W1END[0] Tile_X0Y5_WW4END[0] Tile_X0Y5_WW4END[6] Tile_X0Y5_W6END[8]
+ _1472_/Q _1471_/Q VPWR VGND sg13cmos5l_mux4_1
XFILLER_96_201 VPWR VGND sg13cmos5l_fill_2
XFILLER_362_20 VPWR VGND sg13cmos5l_decap_8
X_1302_ _1302_/Q Tile_X0Y5_FrameData[26] VGND VPWR Tile_X0Y5_FrameStrobe[1] latch
X_2282_ _2282_/X _2583_/X _2581_/X _2574_/X _2573_/X _0997_/Q _0996_/Q VPWR VGND sg13cmos5l_mux4_1
XFILLER_296_173 VPWR VGND sg13cmos5l_decap_8
X_1233_ _1233_/Q Tile_X0Y4_FrameData[21] VGND VPWR Tile_X0Y5_FrameStrobe[6] latch
XFILLER_296_184 VPWR VGND sg13cmos5l_fill_2
XANTENNA__1152__GATE Tile_X0Y5_FrameStrobe[3] VPWR VGND sg13cmos5l_antennanp
XFILLER_49_172 VPWR VGND sg13cmos5l_decap_8
X_1164_ _1164_/Q Tile_X0Y4_FrameData[26] VGND VPWR Tile_X0Y5_FrameStrobe[4] latch
XFILLER_64_120 VPWR VGND sg13cmos5l_decap_8
XANTENNA__0248__D Tile_X0Y0_FrameData[14] VPWR VGND sg13cmos5l_antennanp
XFILLER_231_57 VPWR VGND sg13cmos5l_decap_8
X_1095_ _1095_/Q Tile_X0Y4_FrameData[31] VGND VPWR Tile_X0Y5_FrameStrobe[2] latch
X_0115_ _0115_/Q Tile_X0Y0_FrameData[19] VGND VPWR Tile_X0Y5_FrameStrobe[1] latch
X_0046_ _2069_/A _2449_/X _2450_/X _0626_/Q VPWR VGND sg13cmos5l_mux2_1
XFILLER_64_197 VPWR VGND sg13cmos5l_decap_4
XANTENNA__1167__GATE Tile_X0Y5_FrameStrobe[4] VPWR VGND sg13cmos5l_antennanp
XFILLER_311_90 VPWR VGND sg13cmos5l_decap_4
XANTENNA__2460__A1 Tile_X0Y3_W6END[5] VPWR VGND sg13cmos5l_antennanp
XANTENNA__1079__D Tile_X0Y4_FrameData[15] VPWR VGND sg13cmos5l_antennanp
X_1997_ Tile_X0Y5_E6BEG[10] _2767_/X VPWR VGND sg13cmos5l_buf_1
XANTENNA__1657__A Tile_X0Y5_FrameStrobe[17] VPWR VGND sg13cmos5l_antennanp
XANTENNA__2105__X AXIL_S_SOC_ARREADY VPWR VGND sg13cmos5l_antennanp
XANTENNA__2212__A1 Tile_X0Y0_S1END[3] VPWR VGND sg13cmos5l_antennanp
XFILLER_118_100 VPWR VGND sg13cmos5l_decap_8
X_0948_ _0948_/Q Tile_X0Y3_FrameData[2] VGND VPWR Tile_X0Y5_FrameStrobe[4] latch
XFILLER_109_26 VPWR VGND sg13cmos5l_fill_1
XFILLER_109_37 VPWR VGND sg13cmos5l_decap_8
XFILLER_256_21 VPWR VGND sg13cmos5l_decap_8
XFILLER_256_43 VPWR VGND sg13cmos5l_decap_8
XANTENNA__0711__D Tile_X0Y2_FrameData[31] VPWR VGND sg13cmos5l_antennanp
XANTENNA__1944__X Tile_X0Y1_E6BEG[9] VPWR VGND sg13cmos5l_antennanp
XFILLER_118_188 VPWR VGND sg13cmos5l_fill_1
XFILLER_133_114 VPWR VGND sg13cmos5l_decap_8
X_0879_ _0879_/Q Tile_X0Y3_FrameData[7] VGND VPWR Tile_X0Y5_FrameStrobe[2] latch
XANTENNA__1105__GATE Tile_X0Y5_FrameStrobe[2] VPWR VGND sg13cmos5l_antennanp
X_2618_ _2618_/X AXIL_S_SOC_WSTRB1 AXIL_S_SOC_WSTRB3 _2709_/X _2682_/X _1218_/Q _1217_/Q
+ VPWR VGND sg13cmos5l_mux4_1
X_2549_ _2549_/X AXIL_S_SOC_ARADDR0 _2583_/X _2581_/X _2593_/X _0906_/Q _0905_/Q VPWR
+ VGND sg13cmos5l_mux4_1
XANTENNA__0361__GATE Tile_X0Y5_FrameStrobe[1] VPWR VGND sg13cmos5l_antennanp
XFILLER_272_31 VPWR VGND sg13cmos5l_decap_8
XFILLER_287_162 VPWR VGND sg13cmos5l_decap_8
XFILLER_287_173 VPWR VGND sg13cmos5l_fill_1
XANTENNA__0991__GATE Tile_X0Y5_FrameStrobe[6] VPWR VGND sg13cmos5l_antennanp
XANTENNA__2279__A1 Tile_X0Y2_WW4END[0] VPWR VGND sg13cmos5l_antennanp
XFILLER_205_91 VPWR VGND sg13cmos5l_decap_8
XFILLER_141_35 VPWR VGND sg13cmos5l_decap_8
XFILLER_18_56 VPWR VGND sg13cmos5l_fill_1
XANTENNA__0158__D Tile_X0Y0_FrameData[8] VPWR VGND sg13cmos5l_antennanp
XANTENNA__0376__GATE Tile_X0Y5_FrameStrobe[2] VPWR VGND sg13cmos5l_antennanp
XFILLER_18_78 VPWR VGND sg13cmos5l_fill_1
XFILLER_203_129 VPWR VGND sg13cmos5l_fill_1
XFILLER_70_156 VPWR VGND sg13cmos5l_decap_8
XANTENNA__2451__A1 Tile_X0Y2_WW4END[11] VPWR VGND sg13cmos5l_antennanp
XFILLER_11_212 VPWR VGND sg13cmos5l_fill_1
XFILLER_211_140 VPWR VGND sg13cmos5l_decap_8
XFILLER_357_111 VPWR VGND sg13cmos5l_fill_2
XFILLER_297_50 VPWR VGND sg13cmos5l_fill_2
XFILLER_357_177 VPWR VGND sg13cmos5l_decap_4
XFILLER_357_166 VPWR VGND sg13cmos5l_fill_1
XANTENNA__1567__A Tile_X0Y3_FrameData[13] VPWR VGND sg13cmos5l_antennanp
XANTENNA__2015__X Tile_X0Y5_FrameData_O[0] VPWR VGND sg13cmos5l_antennanp
XANTENNA__0314__GATE Tile_X0Y5_FrameStrobe[0] VPWR VGND sg13cmos5l_antennanp
XANTENNA__0621__D Tile_X0Y2_FrameData[25] VPWR VGND sg13cmos5l_antennanp
XANTENNA__1854__X Tile_X0Y4_FrameData_O[21] VPWR VGND sg13cmos5l_antennanp
XFILLER_124_103 VPWR VGND sg13cmos5l_fill_1
XANTENNA__0944__GATE Tile_X0Y5_FrameStrobe[4] VPWR VGND sg13cmos5l_antennanp
XFILLER_124_158 VPWR VGND sg13cmos5l_decap_8
XFILLER_166_87 VPWR VGND sg13cmos5l_fill_1
XANTENNA__2506__A2 AXIL_S_SOC_ARADDR3 VPWR VGND sg13cmos5l_antennanp
XFILLER_182_20 VPWR VGND sg13cmos5l_fill_2
XANTENNA__0329__GATE Tile_X0Y5_FrameStrobe[0] VPWR VGND sg13cmos5l_antennanp
XFILLER_182_42 VPWR VGND sg13cmos5l_fill_1
XFILLER_182_53 VPWR VGND sg13cmos5l_fill_2
XANTENNA__0959__GATE Tile_X0Y5_FrameStrobe[5] VPWR VGND sg13cmos5l_antennanp
XFILLER_182_97 VPWR VGND sg13cmos5l_decap_8
XFILLER_278_184 VPWR VGND sg13cmos5l_decap_4
XANTENNA__1452__D Tile_X0Y5_FrameData[4] VPWR VGND sg13cmos5l_antennanp
XFILLER_234_210 VPWR VGND sg13cmos5l_fill_2
XFILLER_75_62 VPWR VGND sg13cmos5l_fill_1
XFILLER_46_120 VPWR VGND sg13cmos5l_decap_4
XFILLER_332_78 VPWR VGND sg13cmos5l_fill_2
XANTENNA__2690__A1 Tile_X0Y0_WW4END[9] VPWR VGND sg13cmos5l_antennanp
XFILLER_201_38 VPWR VGND sg13cmos5l_decap_8
XFILLER_46_197 VPWR VGND sg13cmos5l_fill_1
X_1920_ Tile_X0Y1_EE4BEG[1] _2310_/X VPWR VGND sg13cmos5l_buf_1
X_1851_ Tile_X0Y4_FrameData_O[18] Tile_X0Y4_FrameData[18] VPWR VGND sg13cmos5l_buf_1
XFILLER_348_144 VPWR VGND sg13cmos5l_decap_8
X_0802_ _0802_/Q Tile_X0Y3_FrameData[20] VGND VPWR Tile_X0Y5_FrameStrobe[0] latch
XFILLER_348_188 VPWR VGND sg13cmos5l_decap_8
X_1782_ Tile_X0Y2_E2BEG[5] _2406_/X VPWR VGND sg13cmos5l_buf_1
XANTENNA__0531__D Tile_X0Y1_FrameData[3] VPWR VGND sg13cmos5l_antennanp
XANTENNA__1764__X Tile_X0Y2_FrameData_O[24] VPWR VGND sg13cmos5l_antennanp
XFILLER_115_114 VPWR VGND sg13cmos5l_decap_8
X_0733_ _0733_/Q Tile_X0Y2_FrameData[9] VGND VPWR Tile_X0Y5_FrameStrobe[5] latch
XFILLER_115_136 VPWR VGND sg13cmos5l_decap_4
X_0664_ _0664_/Q Tile_X0Y2_FrameData[14] VGND VPWR Tile_X0Y5_FrameStrobe[3] latch
XFILLER_226_57 VPWR VGND sg13cmos5l_fill_1
XFILLER_226_68 VPWR VGND sg13cmos5l_decap_4
X_2403_ _2403_/X AXIL_S_SOC_AWADDR2 AXIL_S_SOC_AWPROT0 _2483_/X _2486_/X _0742_/Q
+ _0741_/Q VPWR VGND sg13cmos5l_mux4_1
XFILLER_269_173 VPWR VGND sg13cmos5l_decap_8
X_2334_ _2334_/X AXIL_S_SOC_WDATA1 _2368_/X _2366_/X _2378_/X _0424_/Q _0423_/Q VPWR
+ VGND sg13cmos5l_mux4_1
X_0595_ _0595_/Q Tile_X0Y2_FrameData[19] VGND VPWR Tile_X0Y5_FrameStrobe[1] latch
XANTENNA__1091__GATE Tile_X0Y5_FrameStrobe[1] VPWR VGND sg13cmos5l_antennanp
XFILLER_269_184 VPWR VGND sg13cmos5l_fill_1
XFILLER_27_0 VPWR VGND sg13cmos5l_fill_2
XFILLER_284_132 VPWR VGND sg13cmos5l_decap_4
XANTENNA__1362__D Tile_X0Y5_FrameData[30] VPWR VGND sg13cmos5l_antennanp
XFILLER_242_34 VPWR VGND sg13cmos5l_fill_2
XFILLER_284_143 VPWR VGND sg13cmos5l_decap_4
X_2265_ _2265_/X Tile_X0Y1_W1END[3] Tile_X0Y1_WW4END[3] Tile_X0Y1_WW4END[7] Tile_X0Y1_W6END[11]
+ _0517_/Q _0516_/Q VPWR VGND sg13cmos5l_mux4_1
XANTENNA__2130__A0 Tile_X0Y0_W2MID[0] VPWR VGND sg13cmos5l_antennanp
XFILLER_242_78 VPWR VGND sg13cmos5l_decap_8
X_2196_ _2196_/X AXIL_S_SOC_WDATA19 AXIL_S_SOC_WDATA31 _2240_/X _2241_/X _0204_/Q
+ _0203_/Q VPWR VGND sg13cmos5l_mux4_1
X_1216_ _1216_/Q Tile_X0Y4_FrameData[6] VGND VPWR Tile_X0Y5_FrameStrobe[5] latch
X_1147_ _1147_/Q Tile_X0Y4_FrameData[11] VGND VPWR Tile_X0Y5_FrameStrobe[3] latch
XANTENNA__2681__A1 Tile_X0Y5_N2MID[7] VPWR VGND sg13cmos5l_antennanp
XFILLER_240_202 VPWR VGND sg13cmos5l_fill_1
XFILLER_52_112 VPWR VGND sg13cmos5l_decap_8
XANTENNA__0706__D Tile_X0Y2_FrameData[4] VPWR VGND sg13cmos5l_antennanp
XANTENNA__1939__X Tile_X0Y1_E6BEG[4] VPWR VGND sg13cmos5l_antennanp
XFILLER_197_117 VPWR VGND sg13cmos5l_fill_1
X_1078_ _1078_/Q Tile_X0Y4_FrameData[16] VGND VPWR Tile_X0Y5_FrameStrobe[1] latch
XANTENNA__2433__A1 Tile_X0Y0_S4END[8] VPWR VGND sg13cmos5l_antennanp
X_0029_ _0029_/X _2363_/X _2364_/X _1461_/Q VPWR VGND sg13cmos5l_mux2_1
XFILLER_339_133 VPWR VGND sg13cmos5l_fill_1
XFILLER_267_31 VPWR VGND sg13cmos5l_decap_8
XFILLER_354_103 VPWR VGND sg13cmos5l_fill_2
XFILLER_153_209 VPWR VGND sg13cmos5l_decap_8
XFILLER_354_136 VPWR VGND sg13cmos5l_decap_8
XANTENNA__0441__D Tile_X0Y1_FrameData[29] VPWR VGND sg13cmos5l_antennanp
XANTENNA__1674__X Tile_X0Y0_FrameData_O[14] VPWR VGND sg13cmos5l_antennanp
XFILLER_112_8 VPWR VGND sg13cmos5l_fill_2
XANTENNA__1044__GATE Tile_X0Y5_FrameStrobe[0] VPWR VGND sg13cmos5l_antennanp
XFILLER_136_35 VPWR VGND sg13cmos5l_decap_8
XFILLER_20_68 VPWR VGND sg13cmos5l_decap_4
XFILLER_362_180 VPWR VGND sg13cmos5l_decap_8
XFILLER_136_57 VPWR VGND sg13cmos5l_fill_2
XFILLER_20_79 VPWR VGND sg13cmos5l_fill_2
XFILLER_283_85 VPWR VGND sg13cmos5l_decap_8
XFILLER_29_11 VPWR VGND sg13cmos5l_fill_2
XANTENNA__1059__GATE Tile_X0Y5_FrameStrobe[0] VPWR VGND sg13cmos5l_antennanp
XFILLER_275_121 VPWR VGND sg13cmos5l_decap_4
XFILLER_29_33 VPWR VGND sg13cmos5l_fill_2
XANTENNA__1272__D Tile_X0Y5_FrameData[24] VPWR VGND sg13cmos5l_antennanp
XANTENNA__1850__A Tile_X0Y4_FrameData[17] VPWR VGND sg13cmos5l_antennanp
XANTENNA__2121__A0 Tile_X0Y2_W2MID[7] VPWR VGND sg13cmos5l_antennanp
XFILLER_152_89 VPWR VGND sg13cmos5l_decap_8
XFILLER_275_176 VPWR VGND sg13cmos5l_decap_8
XFILLER_216_221 VPWR VGND sg13cmos5l_fill_2
XFILLER_28_175 VPWR VGND sg13cmos5l_decap_8
XFILLER_290_157 VPWR VGND sg13cmos5l_fill_1
XFILLER_290_179 VPWR VGND sg13cmos5l_decap_8
XFILLER_43_101 VPWR VGND sg13cmos5l_decap_8
XANTENNA__1849__X Tile_X0Y4_FrameData_O[16] VPWR VGND sg13cmos5l_antennanp
XANTENNA__0616__D Tile_X0Y2_FrameData[30] VPWR VGND sg13cmos5l_antennanp
XANTENNA__2424__A1 AXIL_S_SOC_AWPROT1 VPWR VGND sg13cmos5l_antennanp
XFILLER_188_139 VPWR VGND sg13cmos5l_fill_2
XFILLER_243_2 VPWR VGND sg13cmos5l_fill_1
XFILLER_129_206 VPWR VGND sg13cmos5l_fill_2
XFILLER_129_217 VPWR VGND sg13cmos5l_fill_1
XFILLER_131_0 VPWR VGND sg13cmos5l_fill_2
XFILLER_61_75 VPWR VGND sg13cmos5l_fill_2
XFILLER_345_125 VPWR VGND sg13cmos5l_fill_2
XANTENNA__0253__GATE Tile_X0Y5_FrameStrobe[5] VPWR VGND sg13cmos5l_antennanp
XANTENNA__2188__A0 AXIL_S_SOC_WDATA23 VPWR VGND sg13cmos5l_antennanp
XANTENNA__0351__D Tile_X0Y1_FrameData[23] VPWR VGND sg13cmos5l_antennanp
XANTENNA__0883__GATE Tile_X0Y5_FrameStrobe[2] VPWR VGND sg13cmos5l_antennanp
XANTENNA__1447__D Tile_X0Y5_FrameData[9] VPWR VGND sg13cmos5l_antennanp
XANTENNA__1584__X Tile_X0Y3_FrameData_O[30] VPWR VGND sg13cmos5l_antennanp
XFILLER_327_23 VPWR VGND sg13cmos5l_decap_8
XANTENNA__0268__GATE Tile_X0Y5_FrameStrobe[6] VPWR VGND sg13cmos5l_antennanp
XFILLER_112_106 VPWR VGND sg13cmos5l_decap_8
XFILLER_327_89 VPWR VGND sg13cmos5l_decap_8
XANTENNA__0898__GATE Tile_X0Y5_FrameStrobe[3] VPWR VGND sg13cmos5l_antennanp
XFILLER_343_22 VPWR VGND sg13cmos5l_decap_8
X_0380_ _0380_/Q Tile_X0Y1_FrameData[26] VGND VPWR Tile_X0Y5_FrameStrobe[2] latch
XFILLER_343_33 VPWR VGND sg13cmos5l_fill_2
XANTENNA__1182__D Tile_X0Y4_FrameData[8] VPWR VGND sg13cmos5l_antennanp
XANTENNA__1760__A Tile_X0Y2_FrameData[20] VPWR VGND sg13cmos5l_antennanp
XFILLER_266_165 VPWR VGND sg13cmos5l_decap_4
XFILLER_86_50 VPWR VGND sg13cmos5l_decap_8
XFILLER_343_77 VPWR VGND sg13cmos5l_decap_8
XANTENNA__0821__GATE Tile_X0Y5_FrameStrobe[0] VPWR VGND sg13cmos5l_antennanp
XFILLER_266_176 VPWR VGND sg13cmos5l_decap_8
X_2050_ Tile_X0Y5_S1BEG[3] _2772_/X VPWR VGND sg13cmos5l_buf_1
XANTENNA__2112__A0 Tile_X0Y3_W2MID[6] VPWR VGND sg13cmos5l_antennanp
XFILLER_207_221 VPWR VGND sg13cmos5l_fill_2
XFILLER_212_37 VPWR VGND sg13cmos5l_decap_4
XFILLER_212_48 VPWR VGND sg13cmos5l_decap_8
X_1001_ _1001_/Q Tile_X0Y3_FrameData[13] VGND VPWR Tile_X0Y5_FrameStrobe[6] latch
XANTENNA__2663__A1 Tile_X0Y4_WW4END[13] VPWR VGND sg13cmos5l_antennanp
XANTENNA__0206__GATE Tile_X0Y5_FrameStrobe[4] VPWR VGND sg13cmos5l_antennanp
XANTENNA__1759__X Tile_X0Y2_FrameData_O[19] VPWR VGND sg13cmos5l_antennanp
XFILLER_179_117 VPWR VGND sg13cmos5l_decap_8
XANTENNA__0526__D Tile_X0Y1_FrameData[8] VPWR VGND sg13cmos5l_antennanp
XANTENNA__0836__GATE Tile_X0Y5_FrameStrobe[1] VPWR VGND sg13cmos5l_antennanp
XANTENNA__2415__A1 AXIL_S_SOC_AWADDR6 VPWR VGND sg13cmos5l_antennanp
X_1903_ Tile_X0Y1_FrameData_O[16] Tile_X0Y1_FrameData[16] VPWR VGND sg13cmos5l_buf_1
XFILLER_336_125 VPWR VGND sg13cmos5l_fill_1
XFILLER_336_114 VPWR VGND sg13cmos5l_decap_8
XANTENNA__2179__A0 AXIL_S_SOC_WDATA22 VPWR VGND sg13cmos5l_antennanp
X_1834_ Tile_X0Y4_FrameData_O[1] Tile_X0Y4_FrameData[1] VPWR VGND sg13cmos5l_buf_1
XFILLER_336_147 VPWR VGND sg13cmos5l_decap_8
XANTENNA__1357__D Tile_X0Y5_FrameData[3] VPWR VGND sg13cmos5l_antennanp
XANTENNA__2718__A2 Tile_X0Y3_W2END[2] VPWR VGND sg13cmos5l_antennanp
XFILLER_237_23 VPWR VGND sg13cmos5l_fill_2
XFILLER_237_45 VPWR VGND sg13cmos5l_decap_8
X_1765_ Tile_X0Y2_FrameData_O[25] Tile_X0Y2_FrameData[25] VPWR VGND sg13cmos5l_buf_1
XFILLER_351_106 VPWR VGND sg13cmos5l_decap_8
XANTENNA__0261__D Tile_X0Y0_FrameData[1] VPWR VGND sg13cmos5l_antennanp
X_0716_ _0716_/Q Tile_X0Y2_FrameData[26] VGND VPWR Tile_X0Y5_FrameStrobe[5] latch
XFILLER_103_106 VPWR VGND sg13cmos5l_decap_8
X_1696_ Tile_X0Y0_EE4BEG[4] _2185_/X VPWR VGND sg13cmos5l_buf_1
XFILLER_103_117 VPWR VGND sg13cmos5l_fill_2
XFILLER_253_22 VPWR VGND sg13cmos5l_decap_4
X_0647_ _0647_/Q Tile_X0Y2_FrameData[31] VGND VPWR Tile_X0Y5_FrameStrobe[3] latch
XANTENNA__2351__A0 Tile_X0Y5_W1END[0] VPWR VGND sg13cmos5l_antennanp
X_0578_ _0578_/Q Tile_X0Y2_FrameData[4] VGND VPWR Tile_X0Y5_FrameStrobe[0] latch
XANTENNA__1092__D Tile_X0Y4_FrameData[2] VPWR VGND sg13cmos5l_antennanp
XFILLER_111_150 VPWR VGND sg13cmos5l_decap_8
XFILLER_253_88 VPWR VGND sg13cmos5l_decap_8
XFILLER_253_99 VPWR VGND sg13cmos5l_fill_1
X_2317_ _2317_/X AXIL_S_SOC_WDATA4 AXIL_S_SOC_WDATA8 _2365_/X _2380_/X _0458_/Q _0457_/Q
+ VPWR VGND sg13cmos5l_mux4_1
XANTENNA__1670__A Tile_X0Y0_FrameData[10] VPWR VGND sg13cmos5l_antennanp
XFILLER_111_194 VPWR VGND sg13cmos5l_fill_1
XFILLER_272_113 VPWR VGND sg13cmos5l_decap_8
X_2248_ _2248_/X _2264_/X _2263_/X Tile_X0Y0_S2MID[7] Tile_X0Y0_S2END[7] _0080_/Q
+ _0079_/Q VPWR VGND sg13cmos5l_mux4_1
XANTENNA__2103__A0 Tile_X0Y4_W2MID[3] VPWR VGND sg13cmos5l_antennanp
XFILLER_25_112 VPWR VGND sg13cmos5l_decap_4
X_2179_ _2179_/X AXIL_S_SOC_WDATA22 AXIL_S_SOC_WDATA30 _2242_/X _2247_/X _0238_/Q
+ _0237_/Q VPWR VGND sg13cmos5l_mux4_1
XANTENNA__0436__D Tile_X0Y1_FrameData[2] VPWR VGND sg13cmos5l_antennanp
XANTENNA__1669__X Tile_X0Y0_FrameData_O[9] VPWR VGND sg13cmos5l_antennanp
XANTENNA__2406__A1 AXIL_S_SOC_AWVALID VPWR VGND sg13cmos5l_antennanp
XFILLER_202_92 VPWR VGND sg13cmos5l_decap_8
XFILLER_178_161 VPWR VGND sg13cmos5l_decap_8
XANTENNA__1267__D Tile_X0Y5_FrameData[29] VPWR VGND sg13cmos5l_antennanp
XFILLER_193_175 VPWR VGND sg13cmos5l_decap_8
XANTENNA__0171__D Tile_X0Y0_FrameData[27] VPWR VGND sg13cmos5l_antennanp
XANTENNA__1845__A Tile_X0Y4_FrameData[12] VPWR VGND sg13cmos5l_antennanp
XFILLER_31_89 VPWR VGND sg13cmos5l_decap_8
XANTENNA__2342__A0 Tile_X0Y2_W1END[0] VPWR VGND sg13cmos5l_antennanp
XANTENNA__1580__A Tile_X0Y3_FrameData[26] VPWR VGND sg13cmos5l_antennanp
XFILLER_313_47 VPWR VGND sg13cmos5l_decap_8
XFILLER_263_135 VPWR VGND sg13cmos5l_decap_8
XANTENNA__2645__A1 AXIL_S_SOC_WSTRB0 VPWR VGND sg13cmos5l_antennanp
XFILLER_112_70 VPWR VGND sg13cmos5l_decap_8
XFILLER_16_134 VPWR VGND sg13cmos5l_fill_2
XANTENNA__0346__D Tile_X0Y1_FrameData[28] VPWR VGND sg13cmos5l_antennanp
XANTENNA__1579__X Tile_X0Y3_FrameData_O[25] VPWR VGND sg13cmos5l_antennanp
XFILLER_72_52 VPWR VGND sg13cmos5l_decap_8
XFILLER_72_30 VPWR VGND sg13cmos5l_fill_1
XFILLER_346_0 VPWR VGND sg13cmos5l_fill_1
XFILLER_31_115 VPWR VGND sg13cmos5l_decap_8
XFILLER_188_52 VPWR VGND sg13cmos5l_decap_8
XANTENNA__0192__GATE Tile_X0Y5_FrameStrobe[3] VPWR VGND sg13cmos5l_antennanp
XFILLER_82_9 VPWR VGND sg13cmos5l_fill_2
XFILLER_338_22 VPWR VGND sg13cmos5l_decap_8
XANTENNA__1177__D Tile_X0Y4_FrameData[13] VPWR VGND sg13cmos5l_antennanp
XFILLER_338_66 VPWR VGND sg13cmos5l_fill_1
XFILLER_333_106 VPWR VGND sg13cmos5l_decap_8
XANTENNA__0081__D Tile_X0Y0_FrameData[21] VPWR VGND sg13cmos5l_antennanp
XANTENNA__1755__A Tile_X0Y2_FrameData[15] VPWR VGND sg13cmos5l_antennanp
X_1550_ Tile_X0Y3_EE4BEG[12] _2537_/X VPWR VGND sg13cmos5l_buf_1
XFILLER_207_15 VPWR VGND sg13cmos5l_fill_1
XFILLER_207_26 VPWR VGND sg13cmos5l_decap_4
X_0501_ _0501_/Q Tile_X0Y1_FrameData[1] VGND VPWR Tile_X0Y5_FrameStrobe[5] latch
XFILLER_354_32 VPWR VGND sg13cmos5l_fill_1
X_1481_ _1481_/Q Tile_X0Y5_FrameData[7] VGND VPWR Tile_X0Y5_FrameStrobe[6] latch
XFILLER_354_43 VPWR VGND sg13cmos5l_decap_8
XFILLER_341_161 VPWR VGND sg13cmos5l_decap_8
XANTENNA__2333__A0 AXIL_S_SOC_WDATA0 VPWR VGND sg13cmos5l_antennanp
X_0432_ _0432_/Q Tile_X0Y1_FrameData[6] VGND VPWR Tile_X0Y5_FrameStrobe[3] latch
XFILLER_97_71 VPWR VGND sg13cmos5l_fill_1
XANTENNA__0130__GATE Tile_X0Y5_FrameStrobe[1] VPWR VGND sg13cmos5l_antennanp
XANTENNA__0760__GATE Tile_X0Y5_FrameStrobe[6] VPWR VGND sg13cmos5l_antennanp
X_0363_ _0363_/Q Tile_X0Y1_FrameData[11] VGND VPWR Tile_X0Y5_FrameStrobe[1] latch
X_2102_ AXIL_S_SOC_BRESP0 Tile_X0Y4_W2MID[2] Tile_X0Y4_W2END[2] Tile_X0Y4_W6END[2]
+ _2710_/X _1092_/Q _1091_/Q VPWR VGND sg13cmos5l_mux4_1
XFILLER_239_198 VPWR VGND sg13cmos5l_decap_8
X_0294_ _0294_/Q Tile_X0Y0_FrameData[0] VGND VPWR Tile_X0Y5_FrameStrobe[6] latch
XANTENNA__0145__GATE Tile_X0Y5_FrameStrobe[2] VPWR VGND sg13cmos5l_antennanp
XANTENNA__2636__A1 AXIL_S_SOC_WSTRB3 VPWR VGND sg13cmos5l_antennanp
X_2033_ Tile_X0Y5_FrameData_O[18] Tile_X0Y5_FrameData[18] VPWR VGND sg13cmos5l_buf_1
XANTENNA__0775__GATE Tile_X0Y5_FrameStrobe[7] VPWR VGND sg13cmos5l_antennanp
XANTENNA__0256__D Tile_X0Y0_FrameData[6] VPWR VGND sg13cmos5l_antennanp
XFILLER_22_115 VPWR VGND sg13cmos5l_decap_4
XFILLER_175_142 VPWR VGND sg13cmos5l_decap_8
XFILLER_30_181 VPWR VGND sg13cmos5l_decap_8
XANTENNA__1087__D Tile_X0Y4_FrameData[7] VPWR VGND sg13cmos5l_antennanp
X_1817_ Tile_X0Y4_EE4BEG[0] _2633_/X VPWR VGND sg13cmos5l_buf_1
XANTENNA__1665__A Tile_X0Y0_FrameData[5] VPWR VGND sg13cmos5l_antennanp
XANTENNA__2113__X AXIL_S_SOC_RDATA7 VPWR VGND sg13cmos5l_antennanp
X_2797_ _2797_/X Tile_X0Y5_N2MID[7] Tile_X0Y5_N2END[7] _2836_/X _2720_/X _1274_/Q
+ _1273_/Q VPWR VGND sg13cmos5l_mux4_1
XANTENNA__0713__GATE Tile_X0Y5_FrameStrobe[5] VPWR VGND sg13cmos5l_antennanp
XANTENNA__2572__A0 Tile_X0Y4_W1END[3] VPWR VGND sg13cmos5l_antennanp
XFILLER_190_156 VPWR VGND sg13cmos5l_fill_1
XFILLER_264_32 VPWR VGND sg13cmos5l_decap_8
X_1748_ Tile_X0Y2_FrameData_O[8] Tile_X0Y2_FrameData[8] VPWR VGND sg13cmos5l_buf_1
XANTENNA__1952__X Tile_X0Y1_E2BEGb[5] VPWR VGND sg13cmos5l_antennanp
X_1679_ Tile_X0Y0_FrameData_O[19] Tile_X0Y0_FrameData[19] VPWR VGND sg13cmos5l_buf_1
XANTENNA__2324__A0 AXIL_S_SOC_WDATA3 VPWR VGND sg13cmos5l_antennanp
XFILLER_264_76 VPWR VGND sg13cmos5l_decap_8
XANTENNA__0728__GATE Tile_X0Y5_FrameStrobe[5] VPWR VGND sg13cmos5l_antennanp
XFILLER_280_20 VPWR VGND sg13cmos5l_fill_1
XFILLER_280_31 VPWR VGND sg13cmos5l_decap_8
XFILLER_284_9 VPWR VGND sg13cmos5l_decap_4
XFILLER_133_58 VPWR VGND sg13cmos5l_decap_8
XANTENNA__2627__A1 AXIL_S_SOC_WVALID VPWR VGND sg13cmos5l_antennanp
XANTENNA__0166__D Tile_X0Y0_FrameData[0] VPWR VGND sg13cmos5l_antennanp
XFILLER_198_223 VPWR VGND sg13cmos5l_fill_1
XFILLER_26_78 VPWR VGND sg13cmos5l_fill_1
XFILLER_289_40 VPWR VGND sg13cmos5l_decap_4
XFILLER_289_51 VPWR VGND sg13cmos5l_decap_8
XFILLER_13_148 VPWR VGND sg13cmos5l_fill_1
XFILLER_201_205 VPWR VGND sg13cmos5l_decap_4
XFILLER_158_33 VPWR VGND sg13cmos5l_decap_8
XANTENNA__1575__A Tile_X0Y3_FrameData[21] VPWR VGND sg13cmos5l_antennanp
XANTENNA__2023__X Tile_X0Y5_FrameData_O[8] VPWR VGND sg13cmos5l_antennanp
XFILLER_166_197 VPWR VGND sg13cmos5l_decap_8
XANTENNA__1862__X Tile_X0Y4_FrameData_O[29] VPWR VGND sg13cmos5l_antennanp
XFILLER_324_13 VPWR VGND sg13cmos5l_fill_2
XANTENNA__2315__A0 AXIL_S_SOC_WDATA6 VPWR VGND sg13cmos5l_antennanp
XFILLER_296_0 VPWR VGND sg13cmos5l_fill_1
XANTENNA__1490__GATE Tile_X0Y5_FrameStrobe[7] VPWR VGND sg13cmos5l_antennanp
XFILLER_190_20 VPWR VGND sg13cmos5l_decap_8
XFILLER_190_31 VPWR VGND sg13cmos5l_fill_1
XFILLER_236_102 VPWR VGND sg13cmos5l_decap_8
XFILLER_88_192 VPWR VGND sg13cmos5l_decap_8
XFILLER_88_170 VPWR VGND sg13cmos5l_fill_1
XFILLER_67_74 VPWR VGND sg13cmos5l_decap_8
XANTENNA__1460__D Tile_X0Y5_FrameData[28] VPWR VGND sg13cmos5l_antennanp
XANTENNA__2618__A1 AXIL_S_SOC_WSTRB3 VPWR VGND sg13cmos5l_antennanp
XFILLER_251_105 VPWR VGND sg13cmos5l_decap_8
XFILLER_340_23 VPWR VGND sg13cmos5l_decap_4
XFILLER_251_116 VPWR VGND sg13cmos5l_fill_1
XFILLER_251_138 VPWR VGND sg13cmos5l_fill_2
XFILLER_83_51 VPWR VGND sg13cmos5l_decap_8
XANTENNA__0076__D Tile_X0Y0_FrameData[26] VPWR VGND sg13cmos5l_antennanp
XFILLER_189_223 VPWR VGND sg13cmos5l_fill_1
XFILLER_199_40 VPWR VGND sg13cmos5l_decap_4
X_0981_ _0981_/Q Tile_X0Y3_FrameData[1] VGND VPWR Tile_X0Y5_FrameStrobe[5] latch
XANTENNA__0804__D Tile_X0Y3_FrameData[18] VPWR VGND sg13cmos5l_antennanp
XANTENNA__2397__A3 AXIL_S_SOC_AWADDR7 VPWR VGND sg13cmos5l_antennanp
XFILLER_157_142 VPWR VGND sg13cmos5l_decap_8
X_2720_ _2720_/X Tile_X0Y3_W1END[3] Tile_X0Y3_W2MID[0] Tile_X0Y3_W2END[0] _2596_/X
+ _0876_/Q _0875_/Q VPWR VGND sg13cmos5l_mux4_1
XFILLER_80_6 VPWR VGND sg13cmos5l_decap_8
XFILLER_349_87 VPWR VGND sg13cmos5l_decap_8
XFILLER_157_153 VPWR VGND sg13cmos5l_fill_2
X_2651_ _2651_/X Tile_X0Y5_N4END[6] _0024_/X _2693_/X _2692_/X _1152_/Q _1151_/Q VPWR
+ VGND sg13cmos5l_mux4_1
XFILLER_361_201 VPWR VGND sg13cmos5l_fill_1
XFILLER_172_112 VPWR VGND sg13cmos5l_decap_8
XFILLER_218_14 VPWR VGND sg13cmos5l_decap_8
X_1602_ Tile_X0Y2_EE4BEG[15] _2432_/X VPWR VGND sg13cmos5l_buf_1
XFILLER_8_185 VPWR VGND sg13cmos5l_fill_1
X_2582_ _2582_/X _2570_/X Tile_X0Y5_N4END[10] _2569_/X Tile_X0Y0_S4END[14] _0834_/Q
+ _0833_/Q VPWR VGND sg13cmos5l_mux4_1
XANTENNA__1443__GATE Tile_X0Y5_FrameStrobe[5] VPWR VGND sg13cmos5l_antennanp
XANTENNA__1772__X Tile_X0Y2_UserCLKo VPWR VGND sg13cmos5l_antennanp
X_1533_ Tile_X0Y3_E6BEG[7] _2548_/X VPWR VGND sg13cmos5l_buf_1
X_1464_ _1464_/Q Tile_X0Y5_FrameData[24] VGND VPWR Tile_X0Y5_FrameStrobe[6] latch
XANTENNA__2306__A0 AXIL_S_SOC_WDATA5 VPWR VGND sg13cmos5l_antennanp
XFILLER_234_35 VPWR VGND sg13cmos5l_decap_8
X_0415_ _0415_/Q Tile_X0Y1_FrameData[23] VGND VPWR Tile_X0Y5_FrameStrobe[3] latch
XANTENNA__1458__GATE Tile_X0Y5_FrameStrobe[6] VPWR VGND sg13cmos5l_antennanp
X_1395_ _1395_/Q Tile_X0Y5_FrameData[29] VGND VPWR Tile_X0Y5_FrameStrobe[4] latch
XFILLER_79_192 VPWR VGND sg13cmos5l_fill_1
XANTENNA__0084__GATE Tile_X0Y5_FrameStrobe[0] VPWR VGND sg13cmos5l_antennanp
X_0346_ _0346_/Q Tile_X0Y1_FrameData[28] VGND VPWR Tile_X0Y5_FrameStrobe[1] latch
XANTENNA__1370__D Tile_X0Y5_FrameData[22] VPWR VGND sg13cmos5l_antennanp
XANTENNA__2609__A1 Tile_X0Y2_W2MID[1] VPWR VGND sg13cmos5l_antennanp
XFILLER_227_157 VPWR VGND sg13cmos5l_decap_8
XFILLER_250_23 VPWR VGND sg13cmos5l_decap_8
XFILLER_250_34 VPWR VGND sg13cmos5l_fill_1
X_0277_ _0277_/Q Tile_X0Y0_FrameData[17] VGND VPWR Tile_X0Y5_FrameStrobe[6] latch
XFILLER_94_184 VPWR VGND sg13cmos5l_fill_2
XFILLER_242_127 VPWR VGND sg13cmos5l_decap_8
XFILLER_242_138 VPWR VGND sg13cmos5l_decap_8
X_2016_ Tile_X0Y5_FrameData_O[1] Tile_X0Y5_FrameData[1] VPWR VGND sg13cmos5l_buf_1
XANTENNA__0099__GATE Tile_X0Y5_FrameStrobe[0] VPWR VGND sg13cmos5l_antennanp
XANTENNA__2108__X AXIL_S_SOC_RDATA2 VPWR VGND sg13cmos5l_antennanp
XFILLER_250_171 VPWR VGND sg13cmos5l_fill_2
XANTENNA__0714__D Tile_X0Y2_FrameData[28] VPWR VGND sg13cmos5l_antennanp
XANTENNA__1947__X Tile_X0Y1_E2BEGb[0] VPWR VGND sg13cmos5l_antennanp
XFILLER_148_120 VPWR VGND sg13cmos5l_fill_2
XFILLER_259_65 VPWR VGND sg13cmos5l_decap_8
XANTENNA__2793__A0 Tile_X0Y4_W1END[0] VPWR VGND sg13cmos5l_antennanp
XFILLER_12_14 VPWR VGND sg13cmos5l_fill_2
XANTENNA__0652__GATE Tile_X0Y5_FrameStrobe[3] VPWR VGND sg13cmos5l_antennanp
XFILLER_275_42 VPWR VGND sg13cmos5l_fill_2
XANTENNA__2545__A0 AXIL_S_SOC_ARADDR4 VPWR VGND sg13cmos5l_antennanp
XANTENNA__1682__X Tile_X0Y0_FrameData_O[22] VPWR VGND sg13cmos5l_antennanp
XANTENNA__0667__GATE Tile_X0Y5_FrameStrobe[3] VPWR VGND sg13cmos5l_antennanp
XFILLER_104_223 VPWR VGND sg13cmos5l_fill_1
XFILLER_320_131 VPWR VGND sg13cmos5l_decap_8
XFILLER_144_35 VPWR VGND sg13cmos5l_decap_8
XFILLER_320_142 VPWR VGND sg13cmos5l_fill_2
XFILLER_265_219 VPWR VGND sg13cmos5l_decap_4
XFILLER_282_6 VPWR VGND sg13cmos5l_fill_2
XFILLER_37_11 VPWR VGND sg13cmos5l_fill_2
XANTENNA__1280__D Tile_X0Y5_FrameData[16] VPWR VGND sg13cmos5l_antennanp
XFILLER_85_162 VPWR VGND sg13cmos5l_decap_8
XFILLER_37_66 VPWR VGND sg13cmos5l_fill_1
XFILLER_37_99 VPWR VGND sg13cmos5l_decap_4
XFILLER_37_77 VPWR VGND sg13cmos5l_decap_8
XFILLER_160_89 VPWR VGND sg13cmos5l_decap_8
XFILLER_310_26 VPWR VGND sg13cmos5l_decap_8
XANTENNA__0605__GATE Tile_X0Y5_FrameStrobe[1] VPWR VGND sg13cmos5l_antennanp
XANTENNA__2018__X Tile_X0Y5_FrameData_O[3] VPWR VGND sg13cmos5l_antennanp
XFILLER_53_54 VPWR VGND sg13cmos5l_fill_1
XFILLER_41_210 VPWR VGND sg13cmos5l_decap_4
XFILLER_169_32 VPWR VGND sg13cmos5l_fill_2
XANTENNA__0624__D Tile_X0Y2_FrameData[22] VPWR VGND sg13cmos5l_antennanp
XANTENNA__1857__X Tile_X0Y4_FrameData_O[24] VPWR VGND sg13cmos5l_antennanp
XANTENNA__2379__A3 Tile_X0Y0_S2MID[6] VPWR VGND sg13cmos5l_antennanp
XFILLER_319_13 VPWR VGND sg13cmos5l_fill_2
XFILLER_139_142 VPWR VGND sg13cmos5l_decap_8
XFILLER_139_153 VPWR VGND sg13cmos5l_fill_2
XFILLER_139_197 VPWR VGND sg13cmos5l_decap_8
XFILLER_211_0 VPWR VGND sg13cmos5l_fill_2
XFILLER_343_223 VPWR VGND sg13cmos5l_fill_1
XFILLER_319_68 VPWR VGND sg13cmos5l_decap_8
XANTENNA__2536__A0 AXIL_S_SOC_ARADDR1 VPWR VGND sg13cmos5l_antennanp
XFILLER_154_156 VPWR VGND sg13cmos5l_fill_1
XFILLER_185_64 VPWR VGND sg13cmos5l_decap_8
XANTENNA__1455__D Tile_X0Y5_FrameData[1] VPWR VGND sg13cmos5l_antennanp
XFILLER_303_109 VPWR VGND sg13cmos5l_fill_2
XANTENNA__1592__X Tile_X0Y2_EE4BEG[5] VPWR VGND sg13cmos5l_antennanp
XFILLER_78_51 VPWR VGND sg13cmos5l_decap_8
XFILLER_45_9 VPWR VGND sg13cmos5l_fill_2
XFILLER_335_56 VPWR VGND sg13cmos5l_decap_8
XFILLER_68_107 VPWR VGND sg13cmos5l_decap_8
XFILLER_204_16 VPWR VGND sg13cmos5l_fill_2
XFILLER_311_175 VPWR VGND sg13cmos5l_decap_4
X_1180_ _1180_/Q Tile_X0Y4_FrameData[10] VGND VPWR Tile_X0Y5_FrameStrobe[4] latch
X_0200_ _0200_/Q Tile_X0Y0_FrameData[30] VGND VPWR Tile_X0Y5_FrameStrobe[4] latch
XANTENNA__1190__D Tile_X0Y4_FrameData[0] VPWR VGND sg13cmos5l_antennanp
XFILLER_134_90 VPWR VGND sg13cmos5l_decap_8
X_0131_ _0131_/Q Tile_X0Y0_FrameData[3] VGND VPWR Tile_X0Y5_FrameStrobe[1] latch
XFILLER_94_72 VPWR VGND sg13cmos5l_decap_8
XFILLER_351_66 VPWR VGND sg13cmos5l_decap_8
X_0062_ _2076_/A _2663_/X _2664_/X _1103_/Q VPWR VGND sg13cmos5l_mux2_1
XFILLER_232_193 VPWR VGND sg13cmos5l_decap_8
XANTENNA__0534__D Tile_X0Y1_FrameData[0] VPWR VGND sg13cmos5l_antennanp
XANTENNA__1767__X Tile_X0Y2_FrameData_O[27] VPWR VGND sg13cmos5l_antennanp
XFILLER_300_81 VPWR VGND sg13cmos5l_decap_8
XANTENNA__2775__A0 Tile_X0Y5_W2MID[5] VPWR VGND sg13cmos5l_antennanp
X_0964_ _0964_/Q Tile_X0Y3_FrameData[18] VGND VPWR Tile_X0Y5_FrameStrobe[5] latch
XFILLER_229_68 VPWR VGND sg13cmos5l_decap_8
X_2703_ _2703_/X _2678_/X Tile_X0Y5_N4END[6] _2677_/X _0024_/X _1082_/Q _1081_/Q VPWR
+ VGND sg13cmos5l_mux4_1
X_0895_ _0895_/Q Tile_X0Y3_FrameData[23] VGND VPWR Tile_X0Y5_FrameStrobe[3] latch
XANTENNA__1382__GATE Tile_X0Y5_FrameStrobe[3] VPWR VGND sg13cmos5l_antennanp
XANTENNA__2527__A0 AXIL_S_SOC_ARADDR2 VPWR VGND sg13cmos5l_antennanp
X_2634_ _2634_/X Tile_X0Y4_WW4END[5] AXIL_S_SOC_WSTRB1 _2688_/X _2682_/X _1186_/Q
+ _1185_/Q VPWR VGND sg13cmos5l_mux4_1
XANTENNA__1365__D Tile_X0Y5_FrameData[27] VPWR VGND sg13cmos5l_antennanp
XFILLER_145_189 VPWR VGND sg13cmos5l_decap_8
X_2565_ _2565_/X Tile_X0Y2_W1END[0] Tile_X0Y2_W6END[8] _2471_/X _2453_/X _0658_/Q
+ _0657_/Q VPWR VGND sg13cmos5l_mux4_1
XFILLER_57_0 VPWR VGND sg13cmos5l_fill_1
XFILLER_245_45 VPWR VGND sg13cmos5l_decap_8
XFILLER_245_56 VPWR VGND sg13cmos5l_fill_2
X_1516_ _2212_/A3 VPWR VGND sg13cmos5l_tielo
XANTENNA__1397__GATE Tile_X0Y5_FrameStrobe[4] VPWR VGND sg13cmos5l_antennanp
X_2496_ _2496_/X Tile_X0Y4_W2MID[4] Tile_X0Y4_W2END[4] Tile_X0Y4_W6END[4] _2711_/X
+ _1250_/Q _1249_/Q VPWR VGND sg13cmos5l_mux4_1
XFILLER_59_118 VPWR VGND sg13cmos5l_decap_8
XFILLER_101_215 VPWR VGND sg13cmos5l_fill_2
X_1447_ _1447_/Q Tile_X0Y5_FrameData[9] VGND VPWR Tile_X0Y5_FrameStrobe[5] latch
X_1378_ _1378_/Q Tile_X0Y5_FrameData[14] VGND VPWR Tile_X0Y5_FrameStrobe[3] latch
XFILLER_67_140 VPWR VGND sg13cmos5l_fill_2
XANTENNA__0709__D Tile_X0Y2_FrameData[1] VPWR VGND sg13cmos5l_antennanp
XANTENNA__1320__GATE Tile_X0Y5_FrameStrobe[1] VPWR VGND sg13cmos5l_antennanp
XFILLER_261_55 VPWR VGND sg13cmos5l_fill_2
X_0329_ _0329_/Q Tile_X0Y1_FrameData[13] VGND VPWR Tile_X0Y5_FrameStrobe[0] latch
XFILLER_215_127 VPWR VGND sg13cmos5l_decap_8
XFILLER_130_26 VPWR VGND sg13cmos5l_decap_8
XANTENNA__1335__GATE Tile_X0Y5_FrameStrobe[2] VPWR VGND sg13cmos5l_antennanp
XANTENNA__0444__D Tile_X0Y1_FrameData[26] VPWR VGND sg13cmos5l_antennanp
XANTENNA__1677__X Tile_X0Y0_FrameData_O[17] VPWR VGND sg13cmos5l_antennanp
XFILLER_210_70 VPWR VGND sg13cmos5l_fill_1
XANTENNA__0591__GATE Tile_X0Y5_FrameStrobe[1] VPWR VGND sg13cmos5l_antennanp
XANTENNA__2766__A0 AXIL_S_SOC_ARPROT1 VPWR VGND sg13cmos5l_antennanp
XFILLER_135_7 VPWR VGND sg13cmos5l_decap_8
XANTENNA__2230__A2 Tile_X0Y0_S1END[0] VPWR VGND sg13cmos5l_antennanp
XFILLER_139_57 VPWR VGND sg13cmos5l_decap_8
XANTENNA__2781__A3 Tile_X0Y5_W6END[4] VPWR VGND sg13cmos5l_antennanp
XFILLER_136_167 VPWR VGND sg13cmos5l_fill_2
XFILLER_302_7 VPWR VGND sg13cmos5l_decap_4
XANTENNA__1275__D Tile_X0Y5_FrameData[21] VPWR VGND sg13cmos5l_antennanp
XANTENNA__2518__A0 AXIL_S_SOC_ARADDR1 VPWR VGND sg13cmos5l_antennanp
XFILLER_297_108 VPWR VGND sg13cmos5l_fill_2
XANTENNA__1853__A Tile_X0Y4_FrameData[20] VPWR VGND sg13cmos5l_antennanp
XFILLER_305_26 VPWR VGND sg13cmos5l_fill_2
XFILLER_305_48 VPWR VGND sg13cmos5l_decap_8
XANTENNA__0619__D Tile_X0Y2_FrameData[27] VPWR VGND sg13cmos5l_antennanp
XFILLER_273_2 VPWR VGND sg13cmos5l_fill_1
XFILLER_73_132 VPWR VGND sg13cmos5l_decap_8
XANTENNA__0544__GATE Tile_X0Y5_FrameStrobe[7] VPWR VGND sg13cmos5l_antennanp
XFILLER_259_0 VPWR VGND sg13cmos5l_fill_2
XANTENNA__0354__D Tile_X0Y1_FrameData[20] VPWR VGND sg13cmos5l_antennanp
XANTENNA__1587__X Tile_X0Y2_EE4BEG[0] VPWR VGND sg13cmos5l_antennanp
XANTENNA__0559__GATE Tile_X0Y5_FrameStrobe[0] VPWR VGND sg13cmos5l_antennanp
XANTENNA__2757__A0 Tile_X0Y5_N4END[0] VPWR VGND sg13cmos5l_antennanp
XFILLER_174_207 VPWR VGND sg13cmos5l_fill_1
XFILLER_80_63 VPWR VGND sg13cmos5l_decap_8
XANTENNA__2221__A2 Tile_X0Y0_S1END[2] VPWR VGND sg13cmos5l_antennanp
X_0680_ _0680_/Q Tile_X0Y2_FrameData[30] VGND VPWR Tile_X0Y5_FrameStrobe[4] latch
XANTENNA__2509__A0 AXIL_S_SOC_ARADDR0 VPWR VGND sg13cmos5l_antennanp
XFILLER_142_104 VPWR VGND sg13cmos5l_decap_8
XANTENNA__1185__D Tile_X0Y4_FrameData[5] VPWR VGND sg13cmos5l_antennanp
XANTENNA__1763__A Tile_X0Y2_FrameData[23] VPWR VGND sg13cmos5l_antennanp
XFILLER_89_72 VPWR VGND sg13cmos5l_decap_8
X_2350_ _2350_/X _2348_/X _0029_/X _2347_/X Tile_X0Y0_S4END[7] _0344_/Q _0343_/Q VPWR
+ VGND sg13cmos5l_mux4_1
XFILLER_150_192 VPWR VGND sg13cmos5l_decap_8
X_1301_ _1301_/Q Tile_X0Y5_FrameData[27] VGND VPWR Tile_X0Y5_FrameStrobe[1] latch
X_2281_ _2281_/X Tile_X0Y3_W1END[3] Tile_X0Y3_WW4END[3] Tile_X0Y3_WW4END[7] Tile_X0Y3_W6END[11]
+ _0997_/Q _0996_/Q VPWR VGND sg13cmos5l_mux4_1
X_1232_ _1232_/Q Tile_X0Y4_FrameData[22] VGND VPWR Tile_X0Y5_FrameStrobe[6] latch
XANTENNA__0529__D Tile_X0Y1_FrameData[5] VPWR VGND sg13cmos5l_antennanp
XFILLER_49_151 VPWR VGND sg13cmos5l_decap_8
XFILLER_231_36 VPWR VGND sg13cmos5l_decap_8
XFILLER_252_200 VPWR VGND sg13cmos5l_decap_4
XFILLER_252_211 VPWR VGND sg13cmos5l_fill_2
X_1163_ _1163_/Q Tile_X0Y4_FrameData[27] VGND VPWR Tile_X0Y5_FrameStrobe[4] latch
XFILLER_49_195 VPWR VGND sg13cmos5l_fill_2
X_1094_ _1094_/Q Tile_X0Y4_FrameData[0] VGND VPWR Tile_X0Y5_FrameStrobe[1] latch
X_0114_ _0114_/Q Tile_X0Y0_FrameData[20] VGND VPWR Tile_X0Y5_FrameStrobe[1] latch
X_0045_ _2070_/A _2451_/X _2452_/X _0623_/Q VPWR VGND sg13cmos5l_mux2_1
XFILLER_205_182 VPWR VGND sg13cmos5l_decap_8
XANTENNA__0264__D Tile_X0Y0_FrameData[30] VPWR VGND sg13cmos5l_antennanp
XFILLER_220_130 VPWR VGND sg13cmos5l_fill_2
XANTENNA__2748__A0 AXIL_S_SOC_ARPROT1 VPWR VGND sg13cmos5l_antennanp
XFILLER_220_174 VPWR VGND sg13cmos5l_decap_8
X_1996_ Tile_X0Y5_E6BEG[9] _2766_/X VPWR VGND sg13cmos5l_buf_1
XANTENNA__2212__A2 Tile_X0Y0_W6END[3] VPWR VGND sg13cmos5l_antennanp
X_0947_ _0947_/Q Tile_X0Y3_FrameData[3] VGND VPWR Tile_X0Y5_FrameStrobe[4] latch
X_0878_ _0878_/Q Tile_X0Y3_FrameData[8] VGND VPWR Tile_X0Y5_FrameStrobe[2] latch
XANTENNA__1095__D Tile_X0Y4_FrameData[31] VPWR VGND sg13cmos5l_antennanp
XANTENNA__1673__A Tile_X0Y0_FrameData[13] VPWR VGND sg13cmos5l_antennanp
XFILLER_256_88 VPWR VGND sg13cmos5l_fill_2
X_2617_ _2617_/X AXIL_S_SOC_WSTRB0 AXIL_S_SOC_WSTRB2 _2708_/X _2681_/X _1220_/Q _1219_/Q
+ VPWR VGND sg13cmos5l_mux4_1
XANTENNA__2121__X AXIL_S_SOC_RDATA15 VPWR VGND sg13cmos5l_antennanp
XFILLER_272_10 VPWR VGND sg13cmos5l_fill_1
X_2548_ _2548_/X AXIL_S_SOC_ARADDR7 _2587_/X _2580_/X _2592_/X _0908_/Q _0907_/Q VPWR
+ VGND sg13cmos5l_mux4_1
XFILLER_125_59 VPWR VGND sg13cmos5l_decap_4
XANTENNA__1960__X Tile_X0Y1_E2BEG[5] VPWR VGND sg13cmos5l_antennanp
XFILLER_272_87 VPWR VGND sg13cmos5l_decap_4
X_2479_ _2479_/X _2458_/X Tile_X0Y5_N4END[12] _2457_/X Tile_X0Y0_S4END[8] _0598_/Q
+ _0597_/Q VPWR VGND sg13cmos5l_mux4_1
XANTENNA__0439__D Tile_X0Y1_FrameData[31] VPWR VGND sg13cmos5l_antennanp
XANTENNA__2279__A2 Tile_X0Y2_WW4END[4] VPWR VGND sg13cmos5l_antennanp
XFILLER_18_13 VPWR VGND sg13cmos5l_fill_1
XFILLER_205_70 VPWR VGND sg13cmos5l_decap_8
XFILLER_141_14 VPWR VGND sg13cmos5l_decap_8
XFILLER_141_69 VPWR VGND sg13cmos5l_decap_8
XANTENNA__1274__GATE Tile_X0Y5_FrameStrobe[0] VPWR VGND sg13cmos5l_antennanp
XFILLER_252_7 VPWR VGND sg13cmos5l_decap_8
XFILLER_70_135 VPWR VGND sg13cmos5l_decap_8
XFILLER_221_80 VPWR VGND sg13cmos5l_decap_4
XANTENNA__0174__D Tile_X0Y0_FrameData[24] VPWR VGND sg13cmos5l_antennanp
XANTENNA__1848__A Tile_X0Y4_FrameData[15] VPWR VGND sg13cmos5l_antennanp
XANTENNA__2451__A2 Tile_X0Y2_WW4END[15] VPWR VGND sg13cmos5l_antennanp
XFILLER_357_134 VPWR VGND sg13cmos5l_decap_8
XANTENNA__2739__A0 AXIL_S_SOC_ARPROT1 VPWR VGND sg13cmos5l_antennanp
XFILLER_156_207 VPWR VGND sg13cmos5l_decap_8
XANTENNA__1289__GATE Tile_X0Y5_FrameStrobe[0] VPWR VGND sg13cmos5l_antennanp
XFILLER_357_189 VPWR VGND sg13cmos5l_decap_8
XANTENNA__0902__D Tile_X0Y3_FrameData[16] VPWR VGND sg13cmos5l_antennanp
XFILLER_166_11 VPWR VGND sg13cmos5l_fill_1
XFILLER_166_22 VPWR VGND sg13cmos5l_decap_8
XANTENNA__1212__GATE Tile_X0Y5_FrameStrobe[5] VPWR VGND sg13cmos5l_antennanp
XANTENNA__1583__A Tile_X0Y3_FrameData[29] VPWR VGND sg13cmos5l_antennanp
XFILLER_124_148 VPWR VGND sg13cmos5l_decap_4
XANTENNA__2031__X Tile_X0Y5_FrameData_O[16] VPWR VGND sg13cmos5l_antennanp
XANTENNA__2506__A3 AXIL_S_SOC_ARADDR6 VPWR VGND sg13cmos5l_antennanp
XFILLER_59_31 VPWR VGND sg13cmos5l_decap_8
XANTENNA__1227__GATE Tile_X0Y5_FrameStrobe[6] VPWR VGND sg13cmos5l_antennanp
XANTENNA__1870__X Tile_X0Y2_E2BEGb[4] VPWR VGND sg13cmos5l_antennanp
XFILLER_59_97 VPWR VGND sg13cmos5l_decap_8
XANTENNA__0349__D Tile_X0Y1_FrameData[25] VPWR VGND sg13cmos5l_antennanp
XANTENNA__0483__GATE Tile_X0Y5_FrameStrobe[5] VPWR VGND sg13cmos5l_antennanp
XFILLER_293_188 VPWR VGND sg13cmos5l_decap_8
XFILLER_75_41 VPWR VGND sg13cmos5l_decap_8
XANTENNA__2690__A2 Tile_X0Y0_WW4END[13] VPWR VGND sg13cmos5l_antennanp
XANTENNA__0084__D Tile_X0Y0_FrameData[18] VPWR VGND sg13cmos5l_antennanp
XANTENNA__0498__GATE Tile_X0Y5_FrameStrobe[5] VPWR VGND sg13cmos5l_antennanp
XANTENNA__1758__A Tile_X0Y2_FrameData[18] VPWR VGND sg13cmos5l_antennanp
XFILLER_202_141 VPWR VGND sg13cmos5l_fill_2
XFILLER_348_123 VPWR VGND sg13cmos5l_decap_8
XFILLER_202_185 VPWR VGND sg13cmos5l_decap_8
X_1850_ Tile_X0Y4_FrameData_O[17] Tile_X0Y4_FrameData[17] VPWR VGND sg13cmos5l_buf_1
X_1781_ Tile_X0Y2_E2BEG[4] _2405_/X VPWR VGND sg13cmos5l_buf_1
X_0801_ _0801_/Q Tile_X0Y3_FrameData[21] VGND VPWR Tile_X0Y5_FrameStrobe[0] latch
XANTENNA__0421__GATE Tile_X0Y5_FrameStrobe[3] VPWR VGND sg13cmos5l_antennanp
XANTENNA__0812__D Tile_X0Y3_FrameData[10] VPWR VGND sg13cmos5l_antennanp
X_0732_ _0732_/Q Tile_X0Y2_FrameData[10] VGND VPWR Tile_X0Y5_FrameStrobe[5] latch
X_0663_ _0663_/Q Tile_X0Y2_FrameData[15] VGND VPWR Tile_X0Y5_FrameStrobe[3] latch
XANTENNA__0436__GATE Tile_X0Y5_FrameStrobe[3] VPWR VGND sg13cmos5l_antennanp
X_2402_ _2402_/X AXIL_S_SOC_AWADDR1 AXIL_S_SOC_AWADDR9 _2482_/X _2487_/X _0744_/Q
+ _0743_/Q VPWR VGND sg13cmos5l_mux4_1
X_0594_ _0594_/Q Tile_X0Y2_FrameData[20] VGND VPWR Tile_X0Y5_FrameStrobe[1] latch
X_2333_ _2333_/X AXIL_S_SOC_WDATA0 _2367_/X _2365_/X _2377_/X _0426_/Q _0425_/Q VPWR
+ VGND sg13cmos5l_mux4_1
XANTENNA__1780__X Tile_X0Y2_E2BEG[3] VPWR VGND sg13cmos5l_antennanp
XFILLER_123_192 VPWR VGND sg13cmos5l_decap_4
XFILLER_242_13 VPWR VGND sg13cmos5l_fill_2
XFILLER_284_111 VPWR VGND sg13cmos5l_decap_8
XANTENNA__0259__D Tile_X0Y0_FrameData[3] VPWR VGND sg13cmos5l_antennanp
XFILLER_242_46 VPWR VGND sg13cmos5l_decap_4
X_2264_ _2264_/X Tile_X0Y1_W2MID[0] Tile_X0Y1_W2END[0] Tile_X0Y1_W6END[0] _2380_/X
+ _0528_/Q _0527_/Q VPWR VGND sg13cmos5l_mux4_1
XFILLER_284_177 VPWR VGND sg13cmos5l_fill_2
X_2195_ _2195_/X AXIL_S_SOC_WDATA18 AXIL_S_SOC_WDATA30 _2238_/X _2242_/X _0206_/Q
+ _0205_/Q VPWR VGND sg13cmos5l_mux4_1
X_1215_ _1215_/Q Tile_X0Y4_FrameData[7] VGND VPWR Tile_X0Y5_FrameStrobe[5] latch
XANTENNA__2130__A1 Tile_X0Y0_W2END[0] VPWR VGND sg13cmos5l_antennanp
X_1146_ _1146_/Q Tile_X0Y4_FrameData[12] VGND VPWR Tile_X0Y5_FrameStrobe[3] latch
X_1077_ _1077_/Q Tile_X0Y4_FrameData[17] VGND VPWR Tile_X0Y5_FrameStrobe[1] latch
XFILLER_52_168 VPWR VGND sg13cmos5l_decap_8
XANTENNA__1668__A Tile_X0Y0_FrameData[8] VPWR VGND sg13cmos5l_antennanp
X_0028_ _2079_/A _2781_/X _2782_/X _1338_/Q VPWR VGND sg13cmos5l_mux2_1
XANTENNA__2116__X AXIL_S_SOC_RDATA10 VPWR VGND sg13cmos5l_antennanp
XFILLER_138_207 VPWR VGND sg13cmos5l_decap_8
XFILLER_339_145 VPWR VGND sg13cmos5l_fill_2
XFILLER_354_115 VPWR VGND sg13cmos5l_decap_8
XFILLER_339_189 VPWR VGND sg13cmos5l_decap_8
XANTENNA__0722__D Tile_X0Y2_FrameData[20] VPWR VGND sg13cmos5l_antennanp
XANTENNA__1955__X Tile_X0Y1_E2BEG[0] VPWR VGND sg13cmos5l_antennanp
XANTENNA__2197__A1 Tile_X0Y0_S4END[0] VPWR VGND sg13cmos5l_antennanp
XFILLER_267_54 VPWR VGND sg13cmos5l_fill_2
X_1979_ Tile_X0Y5_E2BEGb[0] _2733_/X VPWR VGND sg13cmos5l_buf_1
XFILLER_106_115 VPWR VGND sg13cmos5l_decap_8
XFILLER_136_14 VPWR VGND sg13cmos5l_decap_4
XANTENNA__1690__X Tile_X0Y0_FrameData_O[30] VPWR VGND sg13cmos5l_antennanp
XANTENNA__0169__D Tile_X0Y0_FrameData[29] VPWR VGND sg13cmos5l_antennanp
XANTENNA__2121__A1 Tile_X0Y2_W2END[7] VPWR VGND sg13cmos5l_antennanp
XANTENNA__2672__A2 Tile_X0Y4_W6END[3] VPWR VGND sg13cmos5l_antennanp
XFILLER_231_203 VPWR VGND sg13cmos5l_fill_2
XFILLER_302_49 VPWR VGND sg13cmos5l_decap_4
XFILLER_188_129 VPWR VGND sg13cmos5l_decap_4
XFILLER_231_214 VPWR VGND sg13cmos5l_fill_1
XFILLER_45_77 VPWR VGND sg13cmos5l_decap_4
XFILLER_45_66 VPWR VGND sg13cmos5l_fill_1
XANTENNA__1578__A Tile_X0Y3_FrameData[24] VPWR VGND sg13cmos5l_antennanp
XANTENNA__2026__X Tile_X0Y5_FrameData_O[11] VPWR VGND sg13cmos5l_antennanp
XFILLER_101_72 VPWR VGND sg13cmos5l_fill_2
XFILLER_196_173 VPWR VGND sg13cmos5l_decap_8
XFILLER_345_104 VPWR VGND sg13cmos5l_decap_8
XANTENNA__0632__D Tile_X0Y2_FrameData[14] VPWR VGND sg13cmos5l_antennanp
XANTENNA__1865__X Tile_X0Y4_UserCLKo VPWR VGND sg13cmos5l_antennanp
XANTENNA__2188__A1 AXIL_S_SOC_WDATA27 VPWR VGND sg13cmos5l_antennanp
XANTENNA__1151__GATE Tile_X0Y5_FrameStrobe[3] VPWR VGND sg13cmos5l_antennanp
XFILLER_360_118 VPWR VGND sg13cmos5l_fill_1
XFILLER_360_129 VPWR VGND sg13cmos5l_fill_1
XFILLER_353_181 VPWR VGND sg13cmos5l_decap_8
XFILLER_193_31 VPWR VGND sg13cmos5l_decap_8
XANTENNA__1166__GATE Tile_X0Y5_FrameStrobe[4] VPWR VGND sg13cmos5l_antennanp
XFILLER_301_207 VPWR VGND sg13cmos5l_decap_8
XANTENNA__1463__D Tile_X0Y5_FrameData[25] VPWR VGND sg13cmos5l_antennanp
XFILLER_126_91 VPWR VGND sg13cmos5l_fill_1
XFILLER_266_111 VPWR VGND sg13cmos5l_fill_2
XFILLER_343_56 VPWR VGND sg13cmos5l_decap_8
XFILLER_343_45 VPWR VGND sg13cmos5l_decap_8
XANTENNA__0079__D Tile_X0Y0_FrameData[23] VPWR VGND sg13cmos5l_antennanp
XANTENNA__2112__A1 Tile_X0Y3_W2END[6] VPWR VGND sg13cmos5l_antennanp
XFILLER_212_16 VPWR VGND sg13cmos5l_decap_8
XFILLER_266_199 VPWR VGND sg13cmos5l_fill_1
X_1000_ _1000_/Q Tile_X0Y3_FrameData[14] VGND VPWR Tile_X0Y5_FrameStrobe[6] latch
XANTENNA__0807__D Tile_X0Y3_FrameData[15] VPWR VGND sg13cmos5l_antennanp
XANTENNA__2663__A2 Tile_X0Y4_W6END[5] VPWR VGND sg13cmos5l_antennanp
XFILLER_142_90 VPWR VGND sg13cmos5l_decap_8
XFILLER_34_146 VPWR VGND sg13cmos5l_fill_2
XFILLER_34_135 VPWR VGND sg13cmos5l_decap_8
XANTENNA__1104__GATE Tile_X0Y5_FrameStrobe[2] VPWR VGND sg13cmos5l_antennanp
X_1902_ Tile_X0Y1_FrameData_O[15] Tile_X0Y1_FrameData[15] VPWR VGND sg13cmos5l_buf_1
XANTENNA__0360__GATE Tile_X0Y5_FrameStrobe[1] VPWR VGND sg13cmos5l_antennanp
XANTENNA__0542__D Tile_X0Y1_FrameData[24] VPWR VGND sg13cmos5l_antennanp
XANTENNA__0990__GATE Tile_X0Y5_FrameStrobe[6] VPWR VGND sg13cmos5l_antennanp
XANTENNA__1119__GATE Tile_X0Y5_FrameStrobe[2] VPWR VGND sg13cmos5l_antennanp
XANTENNA__1775__X Tile_X0Y2_E1BEG[2] VPWR VGND sg13cmos5l_antennanp
XANTENNA__2179__A1 AXIL_S_SOC_WDATA30 VPWR VGND sg13cmos5l_antennanp
X_1833_ Tile_X0Y4_FrameData_O[0] Tile_X0Y4_FrameData[0] VPWR VGND sg13cmos5l_buf_1
X_1764_ Tile_X0Y2_FrameData_O[24] Tile_X0Y2_FrameData[24] VPWR VGND sg13cmos5l_buf_1
X_0715_ _0715_/Q Tile_X0Y2_FrameData[27] VGND VPWR Tile_X0Y5_FrameStrobe[5] latch
XANTENNA__0375__GATE Tile_X0Y5_FrameStrobe[2] VPWR VGND sg13cmos5l_antennanp
X_1695_ Tile_X0Y0_EE4BEG[3] _2184_/X VPWR VGND sg13cmos5l_buf_1
XFILLER_106_17 VPWR VGND sg13cmos5l_fill_2
X_0646_ _0646_/Q Tile_X0Y2_FrameData[0] VGND VPWR Tile_X0Y5_FrameStrobe[2] latch
XANTENNA__1373__D Tile_X0Y5_FrameData[19] VPWR VGND sg13cmos5l_antennanp
XANTENNA__2351__A1 Tile_X0Y5_WW4END[0] VPWR VGND sg13cmos5l_antennanp
XFILLER_106_28 VPWR VGND sg13cmos5l_fill_1
X_0577_ _0577_/Q Tile_X0Y2_FrameData[5] VGND VPWR Tile_X0Y5_FrameStrobe[0] latch
X_2316_ _2316_/X AXIL_S_SOC_WDATA7 AXIL_S_SOC_WDATA11 _2362_/X _2373_/X _0460_/Q _0459_/Q
+ VPWR VGND sg13cmos5l_mux4_1
X_2247_ _2247_/X _2262_/X _2261_/X Tile_X0Y0_S2MID[6] Tile_X0Y0_S2END[6] _0082_/Q
+ _0081_/Q VPWR VGND sg13cmos5l_mux4_1
XANTENNA__2103__A1 Tile_X0Y4_W2END[3] VPWR VGND sg13cmos5l_antennanp
XANTENNA__0313__GATE Tile_X0Y5_FrameStrobe[0] VPWR VGND sg13cmos5l_antennanp
XANTENNA__0717__D Tile_X0Y2_FrameData[25] VPWR VGND sg13cmos5l_antennanp
X_2178_ _2178_/X AXIL_S_SOC_WDATA21 AXIL_S_SOC_WDATA29 _2243_/X _2246_/X _0240_/Q
+ _0239_/Q VPWR VGND sg13cmos5l_mux4_1
XANTENNA__0943__GATE Tile_X0Y5_FrameStrobe[4] VPWR VGND sg13cmos5l_antennanp
XFILLER_202_71 VPWR VGND sg13cmos5l_decap_8
XFILLER_213_203 VPWR VGND sg13cmos5l_decap_8
X_1129_ _1129_/Q Tile_X0Y4_FrameData[29] VGND VPWR Tile_X0Y5_FrameStrobe[3] latch
XFILLER_178_140 VPWR VGND sg13cmos5l_decap_8
XANTENNA__0328__GATE Tile_X0Y5_FrameStrobe[0] VPWR VGND sg13cmos5l_antennanp
XANTENNA__0452__D Tile_X0Y1_FrameData[18] VPWR VGND sg13cmos5l_antennanp
XANTENNA__0958__GATE Tile_X0Y5_FrameStrobe[5] VPWR VGND sg13cmos5l_antennanp
XANTENNA__1685__X Tile_X0Y0_FrameData_O[25] VPWR VGND sg13cmos5l_antennanp
XFILLER_193_143 VPWR VGND sg13cmos5l_decap_8
XFILLER_31_24 VPWR VGND sg13cmos5l_fill_2
XFILLER_294_41 VPWR VGND sg13cmos5l_decap_8
XFILLER_342_107 VPWR VGND sg13cmos5l_decap_4
XFILLER_134_210 VPWR VGND sg13cmos5l_decap_4
XFILLER_193_198 VPWR VGND sg13cmos5l_fill_1
XFILLER_294_74 VPWR VGND sg13cmos5l_fill_2
XFILLER_335_181 VPWR VGND sg13cmos5l_decap_4
XANTENNA__2022__A Tile_X0Y5_FrameData[7] VPWR VGND sg13cmos5l_antennanp
XFILLER_350_151 VPWR VGND sg13cmos5l_decap_8
XANTENNA__1283__D Tile_X0Y5_FrameData[13] VPWR VGND sg13cmos5l_antennanp
XANTENNA__1861__A Tile_X0Y4_FrameData[28] VPWR VGND sg13cmos5l_antennanp
XANTENNA__2342__A1 Tile_X0Y2_W6END[4] VPWR VGND sg13cmos5l_antennanp
XFILLER_48_205 VPWR VGND sg13cmos5l_fill_1
XFILLER_263_103 VPWR VGND sg13cmos5l_decap_4
XANTENNA__0627__D Tile_X0Y2_FrameData[19] VPWR VGND sg13cmos5l_antennanp
XFILLER_263_169 VPWR VGND sg13cmos5l_decap_4
XFILLER_56_98 VPWR VGND sg13cmos5l_fill_1
XFILLER_188_20 VPWR VGND sg13cmos5l_decap_8
XFILLER_188_31 VPWR VGND sg13cmos5l_decap_8
XFILLER_241_0 VPWR VGND sg13cmos5l_fill_1
XFILLER_339_0 VPWR VGND sg13cmos5l_decap_8
XFILLER_188_75 VPWR VGND sg13cmos5l_decap_8
XANTENNA__0362__D Tile_X0Y1_FrameData[12] VPWR VGND sg13cmos5l_antennanp
XANTENNA__1090__GATE Tile_X0Y5_FrameStrobe[1] VPWR VGND sg13cmos5l_antennanp
XANTENNA__1458__D Tile_X0Y5_FrameData[30] VPWR VGND sg13cmos5l_antennanp
XANTENNA__1595__X Tile_X0Y2_EE4BEG[8] VPWR VGND sg13cmos5l_antennanp
XFILLER_184_165 VPWR VGND sg13cmos5l_decap_4
XFILLER_326_181 VPWR VGND sg13cmos5l_decap_4
XANTENNA__2581__A1 Tile_X0Y5_N4END[11] VPWR VGND sg13cmos5l_antennanp
X_0500_ _0500_/Q Tile_X0Y1_FrameData[2] VGND VPWR Tile_X0Y5_FrameStrobe[5] latch
XFILLER_207_38 VPWR VGND sg13cmos5l_decap_8
X_1480_ _1480_/Q Tile_X0Y5_FrameData[8] VGND VPWR Tile_X0Y5_FrameStrobe[6] latch
XANTENNA__1193__D Tile_X0Y4_FrameData[29] VPWR VGND sg13cmos5l_antennanp
XANTENNA__1771__A Tile_X0Y2_FrameData[31] VPWR VGND sg13cmos5l_antennanp
XFILLER_239_111 VPWR VGND sg13cmos5l_decap_8
X_0431_ _0431_/Q Tile_X0Y1_FrameData[7] VGND VPWR Tile_X0Y5_FrameStrobe[3] latch
XFILLER_98_149 VPWR VGND sg13cmos5l_decap_8
XFILLER_97_83 VPWR VGND sg13cmos5l_decap_8
XFILLER_354_99 VPWR VGND sg13cmos5l_decap_4
XFILLER_354_88 VPWR VGND sg13cmos5l_fill_2
X_0362_ _0362_/Q Tile_X0Y1_FrameData[12] VGND VPWR Tile_X0Y5_FrameStrobe[1] latch
XFILLER_254_103 VPWR VGND sg13cmos5l_decap_4
X_2101_ AXIL_S_SOC_WREADY Tile_X0Y4_W2MID[1] Tile_X0Y4_W2END[1] Tile_X0Y4_W6END[1]
+ _2709_/X _1094_/Q _1093_/Q VPWR VGND sg13cmos5l_mux4_1
X_2032_ Tile_X0Y5_FrameData_O[17] Tile_X0Y5_FrameData[17] VPWR VGND sg13cmos5l_buf_1
X_0293_ _0293_/Q Tile_X0Y0_FrameData[1] VGND VPWR Tile_X0Y5_FrameStrobe[6] latch
XFILLER_54_208 VPWR VGND sg13cmos5l_decap_8
XANTENNA__0537__D Tile_X0Y1_FrameData[29] VPWR VGND sg13cmos5l_antennanp
XANTENNA__1043__GATE Tile_X0Y5_FrameStrobe[0] VPWR VGND sg13cmos5l_antennanp
XFILLER_248_12 VPWR VGND sg13cmos5l_decap_4
XFILLER_87_0 VPWR VGND sg13cmos5l_fill_2
XANTENNA__0272__D Tile_X0Y0_FrameData[22] VPWR VGND sg13cmos5l_antennanp
XANTENNA__1058__GATE Tile_X0Y5_FrameStrobe[0] VPWR VGND sg13cmos5l_antennanp
XANTENNA__1368__D Tile_X0Y5_FrameData[24] VPWR VGND sg13cmos5l_antennanp
XFILLER_248_23 VPWR VGND sg13cmos5l_fill_2
XFILLER_248_45 VPWR VGND sg13cmos5l_decap_8
XFILLER_248_56 VPWR VGND sg13cmos5l_fill_2
X_1816_ Tile_X0Y4_E6BEG[11] _2660_/X VPWR VGND sg13cmos5l_buf_1
XFILLER_175_198 VPWR VGND sg13cmos5l_decap_4
XFILLER_190_135 VPWR VGND sg13cmos5l_decap_8
X_2796_ _2796_/X Tile_X0Y4_W1END[3] Tile_X0Y4_W6END[11] _2684_/X _2672_/X _1126_/Q
+ _1125_/Q VPWR VGND sg13cmos5l_mux4_1
XANTENNA__2572__A1 Tile_X0Y4_W6END[7] VPWR VGND sg13cmos5l_antennanp
X_1747_ Tile_X0Y2_FrameData_O[7] Tile_X0Y2_FrameData[7] VPWR VGND sg13cmos5l_buf_1
XFILLER_277_206 VPWR VGND sg13cmos5l_decap_4
X_1678_ Tile_X0Y0_FrameData_O[18] Tile_X0Y0_FrameData[18] VPWR VGND sg13cmos5l_buf_1
XANTENNA__1681__A Tile_X0Y0_FrameData[21] VPWR VGND sg13cmos5l_antennanp
X_0629_ _0629_/Q Tile_X0Y2_FrameData[17] VGND VPWR Tile_X0Y5_FrameStrobe[2] latch
XANTENNA__2324__A1 AXIL_S_SOC_WDATA15 VPWR VGND sg13cmos5l_antennanp
XANTENNA__0252__GATE Tile_X0Y5_FrameStrobe[5] VPWR VGND sg13cmos5l_antennanp
XFILLER_280_54 VPWR VGND sg13cmos5l_fill_1
XANTENNA__0882__GATE Tile_X0Y5_FrameStrobe[2] VPWR VGND sg13cmos5l_antennanp
XANTENNA__0447__D Tile_X0Y1_FrameData[23] VPWR VGND sg13cmos5l_antennanp
XFILLER_260_139 VPWR VGND sg13cmos5l_decap_8
XANTENNA__0267__GATE Tile_X0Y5_FrameStrobe[6] VPWR VGND sg13cmos5l_antennanp
XFILLER_289_85 VPWR VGND sg13cmos5l_decap_8
XANTENNA__0897__GATE Tile_X0Y5_FrameStrobe[3] VPWR VGND sg13cmos5l_antennanp
XANTENNA__2017__A Tile_X0Y5_FrameData[2] VPWR VGND sg13cmos5l_antennanp
XFILLER_332_7 VPWR VGND sg13cmos5l_decap_4
XANTENNA__1278__D Tile_X0Y5_FrameData[18] VPWR VGND sg13cmos5l_antennanp
XANTENNA__2260__A0 Tile_X0Y1_W2MID[2] VPWR VGND sg13cmos5l_antennanp
XFILLER_21_160 VPWR VGND sg13cmos5l_fill_1
XFILLER_42_45 VPWR VGND sg13cmos5l_fill_2
XFILLER_355_210 VPWR VGND sg13cmos5l_fill_2
XANTENNA__0182__D Tile_X0Y0_FrameData[16] VPWR VGND sg13cmos5l_antennanp
XANTENNA__1856__A Tile_X0Y4_FrameData[23] VPWR VGND sg13cmos5l_antennanp
XFILLER_166_176 VPWR VGND sg13cmos5l_decap_8
XANTENNA__0820__GATE Tile_X0Y5_FrameStrobe[0] VPWR VGND sg13cmos5l_antennanp
XFILLER_158_89 VPWR VGND sg13cmos5l_fill_1
XANTENNA__0910__D Tile_X0Y3_FrameData[8] VPWR VGND sg13cmos5l_antennanp
XANTENNA__0205__GATE Tile_X0Y5_FrameStrobe[4] VPWR VGND sg13cmos5l_antennanp
XANTENNA__0835__GATE Tile_X0Y5_FrameStrobe[1] VPWR VGND sg13cmos5l_antennanp
XFILLER_174_88 VPWR VGND sg13cmos5l_decap_8
XANTENNA__2315__A1 AXIL_S_SOC_WDATA10 VPWR VGND sg13cmos5l_antennanp
XFILLER_67_31 VPWR VGND sg13cmos5l_decap_8
XFILLER_324_36 VPWR VGND sg13cmos5l_decap_8
XFILLER_191_0 VPWR VGND sg13cmos5l_decap_8
XFILLER_283_209 VPWR VGND sg13cmos5l_fill_2
XFILLER_289_0 VPWR VGND sg13cmos5l_fill_1
XFILLER_36_208 VPWR VGND sg13cmos5l_decap_8
XANTENNA__0357__D Tile_X0Y1_FrameData[17] VPWR VGND sg13cmos5l_antennanp
XFILLER_340_68 VPWR VGND sg13cmos5l_fill_1
XFILLER_340_57 VPWR VGND sg13cmos5l_decap_8
XFILLER_189_213 VPWR VGND sg13cmos5l_fill_2
XFILLER_244_191 VPWR VGND sg13cmos5l_decap_8
XFILLER_199_96 VPWR VGND sg13cmos5l_decap_8
X_0980_ _0980_/Q Tile_X0Y3_FrameData[2] VGND VPWR Tile_X0Y5_FrameStrobe[5] latch
XANTENNA__1188__D Tile_X0Y4_FrameData[2] VPWR VGND sg13cmos5l_antennanp
XANTENNA__2251__A0 Tile_X0Y2_W2MID[6] VPWR VGND sg13cmos5l_antennanp
XFILLER_157_121 VPWR VGND sg13cmos5l_decap_8
XFILLER_349_66 VPWR VGND sg13cmos5l_decap_8
XANTENNA__0092__D Tile_X0Y0_FrameData[10] VPWR VGND sg13cmos5l_antennanp
XANTENNA__1766__A Tile_X0Y2_FrameData[26] VPWR VGND sg13cmos5l_antennanp
XFILLER_157_176 VPWR VGND sg13cmos5l_decap_8
X_2650_ _2650_/X Tile_X0Y5_N4END[5] _0071_/X _2689_/X _2688_/X _1154_/Q _1153_/Q VPWR
+ VGND sg13cmos5l_mux4_1
XFILLER_73_6 VPWR VGND sg13cmos5l_decap_8
X_1601_ Tile_X0Y2_EE4BEG[14] _2431_/X VPWR VGND sg13cmos5l_buf_1
XFILLER_306_107 VPWR VGND sg13cmos5l_decap_8
XANTENNA__0820__D Tile_X0Y3_FrameData[2] VPWR VGND sg13cmos5l_antennanp
X_2581_ _2581_/X _2572_/X Tile_X0Y5_N4END[11] _2571_/X Tile_X0Y0_S4END[15] _0832_/Q
+ _0831_/Q VPWR VGND sg13cmos5l_mux4_1
X_1532_ Tile_X0Y3_E6BEG[6] _2547_/X VPWR VGND sg13cmos5l_buf_1
XFILLER_314_162 VPWR VGND sg13cmos5l_decap_4
X_1463_ _1463_/Q Tile_X0Y5_FrameData[25] VGND VPWR Tile_X0Y5_FrameStrobe[6] latch
XANTENNA__2306__A1 AXIL_S_SOC_WDATA13 VPWR VGND sg13cmos5l_antennanp
X_0414_ _0414_/Q Tile_X0Y1_FrameData[24] VGND VPWR Tile_X0Y5_FrameStrobe[3] latch
X_1394_ _1394_/Q Tile_X0Y5_FrameData[30] VGND VPWR Tile_X0Y5_FrameStrobe[4] latch
XFILLER_227_125 VPWR VGND sg13cmos5l_decap_8
X_0345_ _0345_/Q Tile_X0Y1_FrameData[29] VGND VPWR Tile_X0Y5_FrameStrobe[1] latch
XANTENNA__2609__A2 Tile_X0Y2_W2END[1] VPWR VGND sg13cmos5l_antennanp
X_0276_ _0276_/Q Tile_X0Y0_FrameData[18] VGND VPWR Tile_X0Y5_FrameStrobe[6] latch
XFILLER_94_163 VPWR VGND sg13cmos5l_decap_8
XANTENNA__0267__D Tile_X0Y0_FrameData[27] VPWR VGND sg13cmos5l_antennanp
XFILLER_242_106 VPWR VGND sg13cmos5l_decap_8
X_2015_ Tile_X0Y5_FrameData_O[0] Tile_X0Y5_FrameData[0] VPWR VGND sg13cmos5l_buf_1
XANTENNA__2490__A0 Tile_X0Y4_W2MID[7] VPWR VGND sg13cmos5l_antennanp
XFILLER_50_211 VPWR VGND sg13cmos5l_fill_1
XFILLER_259_44 VPWR VGND sg13cmos5l_decap_8
XANTENNA__1098__D Tile_X0Y4_FrameData[28] VPWR VGND sg13cmos5l_antennanp
XANTENNA__1676__A Tile_X0Y0_FrameData[16] VPWR VGND sg13cmos5l_antennanp
XANTENNA__2124__X AXIL_S_SOC_RDATA18 VPWR VGND sg13cmos5l_antennanp
XANTENNA__2793__A1 Tile_X0Y4_W6END[8] VPWR VGND sg13cmos5l_antennanp
XFILLER_148_165 VPWR VGND sg13cmos5l_decap_4
XFILLER_12_48 VPWR VGND sg13cmos5l_fill_2
XFILLER_12_59 VPWR VGND sg13cmos5l_fill_1
XFILLER_148_198 VPWR VGND sg13cmos5l_decap_8
XFILLER_275_21 VPWR VGND sg13cmos5l_decap_8
XANTENNA__0730__D Tile_X0Y2_FrameData[12] VPWR VGND sg13cmos5l_antennanp
XANTENNA__1963__X Tile_X0Y1_E1BEG[0] VPWR VGND sg13cmos5l_antennanp
X_2779_ _2779_/X Tile_X0Y5_W1END[2] Tile_X0Y5_W2MID[1] Tile_X0Y5_W2END[1] _2798_/X
+ _1344_/Q _1343_/Q VPWR VGND sg13cmos5l_mux4_1
XFILLER_305_162 VPWR VGND sg13cmos5l_decap_8
XFILLER_144_14 VPWR VGND sg13cmos5l_decap_8
XFILLER_291_42 VPWR VGND sg13cmos5l_fill_2
XFILLER_77_108 VPWR VGND sg13cmos5l_decap_4
XFILLER_265_209 VPWR VGND sg13cmos5l_fill_2
XFILLER_291_86 VPWR VGND sg13cmos5l_decap_8
XANTENNA__0191__GATE Tile_X0Y5_FrameStrobe[3] VPWR VGND sg13cmos5l_antennanp
XFILLER_218_103 VPWR VGND sg13cmos5l_decap_8
XFILLER_218_169 VPWR VGND sg13cmos5l_decap_8
XANTENNA__0177__D Tile_X0Y0_FrameData[21] VPWR VGND sg13cmos5l_antennanp
XFILLER_233_106 VPWR VGND sg13cmos5l_fill_1
XANTENNA__0905__D Tile_X0Y3_FrameData[13] VPWR VGND sg13cmos5l_antennanp
XFILLER_53_44 VPWR VGND sg13cmos5l_fill_2
XFILLER_149_2 VPWR VGND sg13cmos5l_fill_1
XFILLER_241_183 VPWR VGND sg13cmos5l_fill_1
XFILLER_241_194 VPWR VGND sg13cmos5l_decap_8
XFILLER_169_88 VPWR VGND sg13cmos5l_fill_1
XANTENNA__1586__A Tile_X0Y3_UserCLK VPWR VGND sg13cmos5l_antennanp
XANTENNA__2034__X Tile_X0Y5_FrameData_O[19] VPWR VGND sg13cmos5l_antennanp
XFILLER_319_25 VPWR VGND sg13cmos5l_decap_4
XFILLER_185_21 VPWR VGND sg13cmos5l_decap_8
XFILLER_319_58 VPWR VGND sg13cmos5l_decap_4
XANTENNA__0640__D Tile_X0Y2_FrameData[6] VPWR VGND sg13cmos5l_antennanp
XANTENNA__1873__X Tile_X0Y2_E2BEGb[7] VPWR VGND sg13cmos5l_antennanp
XANTENNA__2536__A1 AXIL_S_SOC_ARADDR7 VPWR VGND sg13cmos5l_antennanp
XFILLER_185_43 VPWR VGND sg13cmos5l_decap_8
XFILLER_204_0 VPWR VGND sg13cmos5l_fill_1
XANTENNA__0144__GATE Tile_X0Y5_FrameStrobe[2] VPWR VGND sg13cmos5l_antennanp
XANTENNA__0774__GATE Tile_X0Y5_FrameStrobe[6] VPWR VGND sg13cmos5l_antennanp
XFILLER_335_35 VPWR VGND sg13cmos5l_decap_8
XFILLER_38_9 VPWR VGND sg13cmos5l_fill_1
XANTENNA__0159__GATE Tile_X0Y5_FrameStrobe[2] VPWR VGND sg13cmos5l_antennanp
XANTENNA__0789__GATE Tile_X0Y5_FrameStrobe[7] VPWR VGND sg13cmos5l_antennanp
XANTENNA__1471__D Tile_X0Y5_FrameData[17] VPWR VGND sg13cmos5l_antennanp
XFILLER_204_28 VPWR VGND sg13cmos5l_decap_8
XFILLER_351_45 VPWR VGND sg13cmos5l_decap_8
XFILLER_351_34 VPWR VGND sg13cmos5l_decap_8
XFILLER_209_169 VPWR VGND sg13cmos5l_fill_1
X_0130_ _0130_/Q Tile_X0Y0_FrameData[4] VGND VPWR Tile_X0Y5_FrameStrobe[1] latch
XANTENNA__0087__D Tile_X0Y0_FrameData[15] VPWR VGND sg13cmos5l_antennanp
X_0061_ _2078_/A _2667_/X _2668_/X _1097_/Q VPWR VGND sg13cmos5l_mux2_1
XANTENNA__0712__GATE Tile_X0Y5_FrameStrobe[5] VPWR VGND sg13cmos5l_antennanp
XFILLER_220_16 VPWR VGND sg13cmos5l_decap_8
XFILLER_150_90 VPWR VGND sg13cmos5l_decap_4
XFILLER_91_188 VPWR VGND sg13cmos5l_decap_8
XANTENNA__0815__D Tile_X0Y3_FrameData[7] VPWR VGND sg13cmos5l_antennanp
XANTENNA__0727__GATE Tile_X0Y5_FrameStrobe[5] VPWR VGND sg13cmos5l_antennanp
XANTENNA__2775__A1 Tile_X0Y5_W2END[5] VPWR VGND sg13cmos5l_antennanp
XFILLER_229_36 VPWR VGND sg13cmos5l_decap_8
X_2702_ _2702_/X _2680_/X Tile_X0Y5_N4END[7] _2679_/X _0025_/X _1080_/Q _1079_/Q VPWR
+ VGND sg13cmos5l_mux4_1
X_0963_ _0963_/Q Tile_X0Y3_FrameData[19] VGND VPWR Tile_X0Y5_FrameStrobe[5] latch
X_0894_ _0894_/Q Tile_X0Y3_FrameData[24] VGND VPWR Tile_X0Y5_FrameStrobe[3] latch
XANTENNA__0550__D Tile_X0Y1_FrameData[16] VPWR VGND sg13cmos5l_antennanp
XANTENNA__1783__X Tile_X0Y2_E2BEG[6] VPWR VGND sg13cmos5l_antennanp
XFILLER_145_135 VPWR VGND sg13cmos5l_decap_8
X_2633_ _2633_/X Tile_X0Y4_WW4END[4] AXIL_S_SOC_WSTRB0 _2684_/X _2681_/X _1188_/Q
+ _1187_/Q VPWR VGND sg13cmos5l_mux4_1
XANTENNA__2527__A1 AXIL_S_SOC_ARADDR4 VPWR VGND sg13cmos5l_antennanp
XFILLER_145_168 VPWR VGND sg13cmos5l_decap_8
X_2564_ _2564_/X _2572_/X _2571_/X Tile_X0Y3_W6END[3] _2564_/A3 _0792_/Q _1031_/Q
+ VPWR VGND sg13cmos5l_mux4_1
X_1515_ _2211_/A3 VPWR VGND sg13cmos5l_tielo
XFILLER_302_121 VPWR VGND sg13cmos5l_fill_2
X_2495_ _2495_/X Tile_X0Y1_W2MID[4] Tile_X0Y1_W2END[4] Tile_X0Y1_W6END[11] _2376_/X
+ _0404_/Q _0403_/Q VPWR VGND sg13cmos5l_mux4_1
XFILLER_302_132 VPWR VGND sg13cmos5l_decap_8
XFILLER_299_183 VPWR VGND sg13cmos5l_decap_8
X_1446_ _1446_/Q Tile_X0Y5_FrameData[10] VGND VPWR Tile_X0Y5_FrameStrobe[5] latch
XFILLER_302_187 VPWR VGND sg13cmos5l_fill_1
XANTENNA__1381__D Tile_X0Y5_FrameData[11] VPWR VGND sg13cmos5l_antennanp
XFILLER_261_34 VPWR VGND sg13cmos5l_decap_8
X_1377_ _1377_/Q Tile_X0Y5_FrameData[15] VGND VPWR Tile_X0Y5_FrameStrobe[3] latch
X_0328_ _0328_/Q Tile_X0Y1_FrameData[14] VGND VPWR Tile_X0Y5_FrameStrobe[0] latch
XFILLER_82_111 VPWR VGND sg13cmos5l_fill_2
XFILLER_215_106 VPWR VGND sg13cmos5l_decap_8
XANTENNA__2119__X AXIL_S_SOC_RDATA13 VPWR VGND sg13cmos5l_antennanp
XFILLER_215_139 VPWR VGND sg13cmos5l_fill_1
X_0259_ _0259_/Q Tile_X0Y0_FrameData[3] VGND VPWR Tile_X0Y5_FrameStrobe[5] latch
XANTENNA__1958__X Tile_X0Y1_E2BEG[3] VPWR VGND sg13cmos5l_antennanp
XANTENNA__2463__A0 Tile_X0Y1_W1END[3] VPWR VGND sg13cmos5l_antennanp
XFILLER_223_150 VPWR VGND sg13cmos5l_decap_8
XFILLER_82_199 VPWR VGND sg13cmos5l_decap_8
XANTENNA__0725__D Tile_X0Y2_FrameData[17] VPWR VGND sg13cmos5l_antennanp
XANTENNA__2215__A0 Tile_X0Y1_W1END[2] VPWR VGND sg13cmos5l_antennanp
XFILLER_139_36 VPWR VGND sg13cmos5l_decap_8
XFILLER_183_208 VPWR VGND sg13cmos5l_fill_2
XANTENNA__2230__A3 Tile_X0Y0_S4END[0] VPWR VGND sg13cmos5l_antennanp
XANTENNA__1693__X Tile_X0Y0_EE4BEG[1] VPWR VGND sg13cmos5l_antennanp
XFILLER_136_146 VPWR VGND sg13cmos5l_decap_8
XANTENNA__0460__D Tile_X0Y1_FrameData[10] VPWR VGND sg13cmos5l_antennanp
XANTENNA__2518__A1 AXIL_S_SOC_ARADDR9 VPWR VGND sg13cmos5l_antennanp
XFILLER_155_13 VPWR VGND sg13cmos5l_decap_8
XFILLER_151_127 VPWR VGND sg13cmos5l_decap_4
XFILLER_155_57 VPWR VGND sg13cmos5l_fill_2
XFILLER_155_68 VPWR VGND sg13cmos5l_decap_4
XFILLER_155_79 VPWR VGND sg13cmos5l_fill_1
XANTENNA__2030__A Tile_X0Y5_FrameData[15] VPWR VGND sg13cmos5l_antennanp
XANTENNA__1291__D Tile_X0Y5_FrameData[5] VPWR VGND sg13cmos5l_antennanp
XFILLER_58_130 VPWR VGND sg13cmos5l_fill_2
XFILLER_73_122 VPWR VGND sg13cmos5l_fill_2
XFILLER_58_185 VPWR VGND sg13cmos5l_fill_1
XFILLER_321_15 VPWR VGND sg13cmos5l_fill_2
XANTENNA__2029__X Tile_X0Y5_FrameData_O[14] VPWR VGND sg13cmos5l_antennanp
XANTENNA__1442__GATE Tile_X0Y5_FrameStrobe[5] VPWR VGND sg13cmos5l_antennanp
XFILLER_14_222 VPWR VGND sg13cmos5l_fill_2
XFILLER_73_188 VPWR VGND sg13cmos5l_decap_8
XANTENNA__0635__D Tile_X0Y2_FrameData[11] VPWR VGND sg13cmos5l_antennanp
XANTENNA__1868__X Tile_X0Y2_E2BEGb[2] VPWR VGND sg13cmos5l_antennanp
XANTENNA__2206__A0 AXIL_S_SOC_WDATA17 VPWR VGND sg13cmos5l_antennanp
XFILLER_80_42 VPWR VGND sg13cmos5l_decap_8
XANTENNA__1457__GATE Tile_X0Y5_FrameStrobe[6] VPWR VGND sg13cmos5l_antennanp
XANTENNA__2221__A3 Tile_X0Y0_S4END[2] VPWR VGND sg13cmos5l_antennanp
XANTENNA__0083__GATE Tile_X0Y5_FrameStrobe[0] VPWR VGND sg13cmos5l_antennanp
XANTENNA__1466__D Tile_X0Y5_FrameData[22] VPWR VGND sg13cmos5l_antennanp
XFILLER_13_91 VPWR VGND sg13cmos5l_decap_4
XFILLER_196_97 VPWR VGND sg13cmos5l_fill_2
XANTENNA__0370__D Tile_X0Y1_FrameData[4] VPWR VGND sg13cmos5l_antennanp
XANTENNA__2509__A1 AXIL_S_SOC_ARADDR8 VPWR VGND sg13cmos5l_antennanp
XFILLER_89_51 VPWR VGND sg13cmos5l_decap_8
XFILLER_346_89 VPWR VGND sg13cmos5l_decap_8
XANTENNA__0098__GATE Tile_X0Y5_FrameStrobe[0] VPWR VGND sg13cmos5l_antennanp
XFILLER_215_16 VPWR VGND sg13cmos5l_decap_4
XFILLER_215_49 VPWR VGND sg13cmos5l_fill_1
X_2280_ _2280_/X _2480_/X _2479_/X _2472_/X _2471_/X _0766_/Q _0765_/Q VPWR VGND sg13cmos5l_mux4_1
X_1300_ _1300_/Q Tile_X0Y5_FrameData[28] VGND VPWR Tile_X0Y5_FrameStrobe[1] latch
X_1231_ _1231_/Q Tile_X0Y4_FrameData[23] VGND VPWR Tile_X0Y5_FrameStrobe[6] latch
XFILLER_362_66 VPWR VGND sg13cmos5l_decap_8
XANTENNA__0651__GATE Tile_X0Y5_FrameStrobe[3] VPWR VGND sg13cmos5l_antennanp
X_1162_ _1162_/Q Tile_X0Y4_FrameData[28] VGND VPWR Tile_X0Y5_FrameStrobe[4] latch
X_1093_ _1093_/Q Tile_X0Y4_FrameData[1] VGND VPWR Tile_X0Y5_FrameStrobe[1] latch
X_0113_ _0113_/Q Tile_X0Y0_FrameData[21] VGND VPWR Tile_X0Y5_FrameStrobe[1] latch
XFILLER_64_155 VPWR VGND sg13cmos5l_fill_2
XANTENNA__2445__A0 Tile_X0Y2_W1END[0] VPWR VGND sg13cmos5l_antennanp
XFILLER_205_150 VPWR VGND sg13cmos5l_decap_4
X_0044_ _1604_/A _2287_/X _2288_/X _1004_/Q VPWR VGND sg13cmos5l_mux2_1
XANTENNA__0545__D Tile_X0Y1_FrameData[21] VPWR VGND sg13cmos5l_antennanp
XANTENNA__1778__X Tile_X0Y2_E2BEG[1] VPWR VGND sg13cmos5l_antennanp
XFILLER_205_161 VPWR VGND sg13cmos5l_decap_8
XANTENNA__0666__GATE Tile_X0Y5_FrameStrobe[3] VPWR VGND sg13cmos5l_antennanp
XANTENNA__2748__A1 AXIL_S_SOC_ARPROT2 VPWR VGND sg13cmos5l_antennanp
XFILLER_165_208 VPWR VGND sg13cmos5l_decap_8
XFILLER_220_153 VPWR VGND sg13cmos5l_decap_8
X_1995_ Tile_X0Y5_E6BEG[8] _2765_/X VPWR VGND sg13cmos5l_buf_1
X_0946_ _0946_/Q Tile_X0Y3_FrameData[4] VGND VPWR Tile_X0Y5_FrameStrobe[4] latch
XANTENNA__1376__D Tile_X0Y5_FrameData[16] VPWR VGND sg13cmos5l_antennanp
XANTENNA__0280__D Tile_X0Y0_FrameData[14] VPWR VGND sg13cmos5l_antennanp
XFILLER_256_67 VPWR VGND sg13cmos5l_decap_8
X_2616_ _2616_/X _2680_/X _2679_/X AXIL_S_SOC_WSTRB1 AXIL_S_SOC_WVALID _1222_/Q _1221_/Q
+ VPWR VGND sg13cmos5l_mux4_1
X_0877_ _0877_/Q Tile_X0Y3_FrameData[9] VGND VPWR Tile_X0Y5_FrameStrobe[2] latch
XFILLER_133_149 VPWR VGND sg13cmos5l_decap_8
XANTENNA__0604__GATE Tile_X0Y5_FrameStrobe[1] VPWR VGND sg13cmos5l_antennanp
X_2547_ _2547_/X AXIL_S_SOC_ARADDR6 _2585_/X _2578_/X _2591_/X _0910_/Q _0909_/Q VPWR
+ VGND sg13cmos5l_mux4_1
X_2478_ _2478_/X _2460_/X Tile_X0Y5_N4END[13] _2459_/X Tile_X0Y0_S4END[9] _0604_/Q
+ _0603_/Q VPWR VGND sg13cmos5l_mux4_1
XFILLER_141_193 VPWR VGND sg13cmos5l_decap_4
XFILLER_272_66 VPWR VGND sg13cmos5l_decap_8
X_1429_ _1429_/Q Tile_X0Y5_FrameData[27] VGND VPWR Tile_X0Y5_FrameStrobe[5] latch
XANTENNA__2279__A3 Tile_X0Y2_W6END[8] VPWR VGND sg13cmos5l_antennanp
XANTENNA__0619__GATE Tile_X0Y5_FrameStrobe[2] VPWR VGND sg13cmos5l_antennanp
XFILLER_18_36 VPWR VGND sg13cmos5l_fill_2
XFILLER_18_47 VPWR VGND sg13cmos5l_fill_1
XFILLER_243_223 VPWR VGND sg13cmos5l_fill_1
XFILLER_55_155 VPWR VGND sg13cmos5l_fill_2
XANTENNA__2436__A0 Tile_X0Y5_N4END[15] VPWR VGND sg13cmos5l_antennanp
XFILLER_70_125 VPWR VGND sg13cmos5l_fill_2
XANTENNA__0455__D Tile_X0Y1_FrameData[15] VPWR VGND sg13cmos5l_antennanp
XANTENNA__1688__X Tile_X0Y0_FrameData_O[28] VPWR VGND sg13cmos5l_antennanp
XANTENNA__2451__A3 Tile_X0Y2_W6END[7] VPWR VGND sg13cmos5l_antennanp
XFILLER_140_6 VPWR VGND sg13cmos5l_decap_4
XFILLER_357_113 VPWR VGND sg13cmos5l_fill_1
XFILLER_357_102 VPWR VGND sg13cmos5l_fill_2
XFILLER_34_68 VPWR VGND sg13cmos5l_decap_8
XANTENNA__2739__A1 AXIL_S_SOC_RREADY VPWR VGND sg13cmos5l_antennanp
XANTENNA__2025__A Tile_X0Y5_FrameData[10] VPWR VGND sg13cmos5l_antennanp
XFILLER_211_186 VPWR VGND sg13cmos5l_decap_4
XANTENNA__1286__D Tile_X0Y5_FrameData[10] VPWR VGND sg13cmos5l_antennanp
XANTENNA__0190__D Tile_X0Y0_FrameData[8] VPWR VGND sg13cmos5l_antennanp
XANTENNA__1864__A Tile_X0Y4_FrameData[31] VPWR VGND sg13cmos5l_antennanp
XFILLER_109_179 VPWR VGND sg13cmos5l_decap_4
XFILLER_166_67 VPWR VGND sg13cmos5l_decap_8
XFILLER_316_15 VPWR VGND sg13cmos5l_fill_2
XFILLER_117_190 VPWR VGND sg13cmos5l_fill_1
XFILLER_182_22 VPWR VGND sg13cmos5l_fill_1
XFILLER_182_33 VPWR VGND sg13cmos5l_decap_4
XFILLER_278_142 VPWR VGND sg13cmos5l_decap_4
XFILLER_78_214 VPWR VGND sg13cmos5l_fill_1
XFILLER_332_36 VPWR VGND sg13cmos5l_decap_4
XANTENNA__2675__A0 Tile_X0Y3_W1END[1] VPWR VGND sg13cmos5l_antennanp
XFILLER_115_93 VPWR VGND sg13cmos5l_decap_8
XFILLER_271_0 VPWR VGND sg13cmos5l_fill_2
XFILLER_293_167 VPWR VGND sg13cmos5l_decap_8
XFILLER_46_133 VPWR VGND sg13cmos5l_fill_1
XFILLER_332_58 VPWR VGND sg13cmos5l_decap_4
XANTENNA__1381__GATE Tile_X0Y5_FrameStrobe[3] VPWR VGND sg13cmos5l_antennanp
XFILLER_46_155 VPWR VGND sg13cmos5l_decap_8
XANTENNA__2427__A0 AXIL_S_SOC_AWADDR6 VPWR VGND sg13cmos5l_antennanp
XANTENNA__2690__A3 Tile_X0Y0_W6END[5] VPWR VGND sg13cmos5l_antennanp
XFILLER_61_114 VPWR VGND sg13cmos5l_fill_2
XANTENNA__0365__D Tile_X0Y1_FrameData[9] VPWR VGND sg13cmos5l_antennanp
XANTENNA__1598__X Tile_X0Y2_EE4BEG[11] VPWR VGND sg13cmos5l_antennanp
XFILLER_91_85 VPWR VGND sg13cmos5l_decap_8
XFILLER_348_102 VPWR VGND sg13cmos5l_decap_8
XANTENNA__1396__GATE Tile_X0Y5_FrameStrobe[4] VPWR VGND sg13cmos5l_antennanp
XFILLER_202_164 VPWR VGND sg13cmos5l_decap_8
XFILLER_24_90 VPWR VGND sg13cmos5l_decap_8
X_1780_ Tile_X0Y2_E2BEG[3] _2404_/X VPWR VGND sg13cmos5l_buf_1
X_0800_ _0800_/Q Tile_X0Y3_FrameData[22] VGND VPWR Tile_X0Y5_FrameStrobe[0] latch
XANTENNA__1196__D Tile_X0Y4_FrameData[26] VPWR VGND sg13cmos5l_antennanp
X_0731_ _0731_/Q Tile_X0Y2_FrameData[11] VGND VPWR Tile_X0Y5_FrameStrobe[5] latch
X_0662_ _0662_/Q Tile_X0Y2_FrameData[16] VGND VPWR Tile_X0Y5_FrameStrobe[3] latch
XFILLER_226_37 VPWR VGND sg13cmos5l_decap_4
XFILLER_226_48 VPWR VGND sg13cmos5l_decap_8
X_2401_ _2401_/X AXIL_S_SOC_AWADDR0 AXIL_S_SOC_AWADDR8 _2481_/X _2488_/X _0746_/Q
+ _0745_/Q VPWR VGND sg13cmos5l_mux4_1
X_0593_ _0593_/Q Tile_X0Y2_FrameData[21] VGND VPWR Tile_X0Y5_FrameStrobe[1] latch
XANTENNA__1334__GATE Tile_X0Y5_FrameStrobe[2] VPWR VGND sg13cmos5l_antennanp
XFILLER_123_160 VPWR VGND sg13cmos5l_fill_2
X_2332_ _2332_/X AXIL_S_SOC_WDATA7 _2371_/X _2362_/X _2376_/X _0428_/Q _0427_/Q VPWR
+ VGND sg13cmos5l_mux4_1
XFILLER_306_92 VPWR VGND sg13cmos5l_decap_8
XFILLER_242_36 VPWR VGND sg13cmos5l_fill_1
X_2263_ _2263_/X Tile_X0Y2_W2MID[0] Tile_X0Y2_W2END[0] Tile_X0Y2_W6END[0] _2488_/X
+ _0768_/Q _0767_/Q VPWR VGND sg13cmos5l_mux4_1
XANTENNA__0590__GATE Tile_X0Y5_FrameStrobe[1] VPWR VGND sg13cmos5l_antennanp
XFILLER_1_50 VPWR VGND sg13cmos5l_fill_2
XFILLER_284_189 VPWR VGND sg13cmos5l_fill_2
X_2194_ _2194_/X AXIL_S_SOC_WDATA17 AXIL_S_SOC_WDATA29 _2236_/X _2243_/X _0208_/Q
+ _0207_/Q VPWR VGND sg13cmos5l_mux4_1
X_1214_ _1214_/Q Tile_X0Y4_FrameData[8] VGND VPWR Tile_X0Y5_FrameStrobe[5] latch
XANTENNA__1349__GATE Tile_X0Y5_FrameStrobe[2] VPWR VGND sg13cmos5l_antennanp
XANTENNA__2130__A2 Tile_X0Y0_W6END[0] VPWR VGND sg13cmos5l_antennanp
X_1145_ _1145_/Q Tile_X0Y4_FrameData[13] VGND VPWR Tile_X0Y5_FrameStrobe[3] latch
XANTENNA__2418__A0 AXIL_S_SOC_AWADDR1 VPWR VGND sg13cmos5l_antennanp
XFILLER_37_188 VPWR VGND sg13cmos5l_decap_8
XANTENNA__0275__D Tile_X0Y0_FrameData[19] VPWR VGND sg13cmos5l_antennanp
X_1076_ _1076_/Q Tile_X0Y4_FrameData[18] VGND VPWR Tile_X0Y5_FrameStrobe[1] latch
XFILLER_52_147 VPWR VGND sg13cmos5l_decap_8
X_0027_ _2080_/A _2783_/X _2784_/X _1335_/Q VPWR VGND sg13cmos5l_mux2_1
X_1978_ Tile_X0Y5_E2BEG[7] _2732_/X VPWR VGND sg13cmos5l_buf_1
XANTENNA__1684__A Tile_X0Y0_FrameData[24] VPWR VGND sg13cmos5l_antennanp
XFILLER_20_15 VPWR VGND sg13cmos5l_fill_2
X_0929_ _0929_/Q Tile_X0Y3_FrameData[21] VGND VPWR Tile_X0Y5_FrameStrobe[4] latch
XANTENNA__2132__X AXIL_S_SOC_RDATA26 VPWR VGND sg13cmos5l_antennanp
XFILLER_136_26 VPWR VGND sg13cmos5l_fill_2
XFILLER_20_26 VPWR VGND sg13cmos5l_fill_1
XANTENNA__0543__GATE Tile_X0Y5_FrameStrobe[7] VPWR VGND sg13cmos5l_antennanp
XANTENNA__1971__X Tile_X0Y5_E2BEG[0] VPWR VGND sg13cmos5l_antennanp
XFILLER_136_59 VPWR VGND sg13cmos5l_fill_1
XFILLER_283_76 VPWR VGND sg13cmos5l_fill_2
XANTENNA__0558__GATE Tile_X0Y5_FrameStrobe[0] VPWR VGND sg13cmos5l_antennanp
XFILLER_152_25 VPWR VGND sg13cmos5l_decap_8
XANTENNA__2657__A0 AXIL_S_SOC_WSTRB0 VPWR VGND sg13cmos5l_antennanp
XFILLER_152_69 VPWR VGND sg13cmos5l_fill_2
XANTENNA__2121__A2 Tile_X0Y2_W6END[7] VPWR VGND sg13cmos5l_antennanp
XFILLER_216_223 VPWR VGND sg13cmos5l_fill_1
XFILLER_28_144 VPWR VGND sg13cmos5l_fill_2
XFILLER_290_126 VPWR VGND sg13cmos5l_decap_8
XFILLER_290_148 VPWR VGND sg13cmos5l_decap_8
XFILLER_302_28 VPWR VGND sg13cmos5l_decap_8
XANTENNA__2409__A0 AXIL_S_SOC_AWADDR0 VPWR VGND sg13cmos5l_antennanp
XANTENNA__0185__D Tile_X0Y0_FrameData[13] VPWR VGND sg13cmos5l_antennanp
XANTENNA__1859__A Tile_X0Y4_FrameData[26] VPWR VGND sg13cmos5l_antennanp
XFILLER_43_136 VPWR VGND sg13cmos5l_decap_8
XFILLER_129_208 VPWR VGND sg13cmos5l_fill_1
XFILLER_196_152 VPWR VGND sg13cmos5l_decap_8
XFILLER_61_22 VPWR VGND sg13cmos5l_fill_2
XANTENNA__0913__D Tile_X0Y3_FrameData[5] VPWR VGND sg13cmos5l_antennanp
XFILLER_131_2 VPWR VGND sg13cmos5l_fill_1
XFILLER_61_77 VPWR VGND sg13cmos5l_fill_1
XFILLER_61_55 VPWR VGND sg13cmos5l_fill_2
XFILLER_61_99 VPWR VGND sg13cmos5l_fill_1
XFILLER_345_127 VPWR VGND sg13cmos5l_fill_1
XFILLER_117_0 VPWR VGND sg13cmos5l_fill_1
XFILLER_327_14 VPWR VGND sg13cmos5l_decap_4
XANTENNA__2042__X Tile_X0Y5_FrameData_O[27] VPWR VGND sg13cmos5l_antennanp
XFILLER_353_160 VPWR VGND sg13cmos5l_decap_8
XANTENNA__1881__X Tile_X0Y2_E6BEG[7] VPWR VGND sg13cmos5l_antennanp
XFILLER_343_13 VPWR VGND sg13cmos5l_decap_4
XFILLER_105_193 VPWR VGND sg13cmos5l_decap_8
XFILLER_266_145 VPWR VGND sg13cmos5l_decap_4
XANTENNA__2648__A0 Tile_X0Y4_WW4END[11] VPWR VGND sg13cmos5l_antennanp
XFILLER_86_85 VPWR VGND sg13cmos5l_decap_8
XANTENNA__2112__A2 Tile_X0Y3_W6END[6] VPWR VGND sg13cmos5l_antennanp
XFILLER_207_223 VPWR VGND sg13cmos5l_fill_1
XFILLER_281_137 VPWR VGND sg13cmos5l_decap_8
XFILLER_281_159 VPWR VGND sg13cmos5l_decap_8
XANTENNA__0095__D Tile_X0Y0_FrameData[7] VPWR VGND sg13cmos5l_antennanp
XANTENNA__1769__A Tile_X0Y2_FrameData[29] VPWR VGND sg13cmos5l_antennanp
XFILLER_34_169 VPWR VGND sg13cmos5l_decap_4
XANTENNA__2820__A0 Tile_X0Y5_N1END[2] VPWR VGND sg13cmos5l_antennanp
X_1901_ Tile_X0Y1_FrameData_O[14] Tile_X0Y1_FrameData[14] VPWR VGND sg13cmos5l_buf_1
XANTENNA__0823__D Tile_X0Y3_FrameData[31] VPWR VGND sg13cmos5l_antennanp
X_1832_ Tile_X0Y4_EE4BEG[15] _2648_/X VPWR VGND sg13cmos5l_buf_1
XFILLER_89_4 VPWR VGND sg13cmos5l_fill_2
X_1763_ Tile_X0Y2_FrameData_O[23] Tile_X0Y2_FrameData[23] VPWR VGND sg13cmos5l_buf_1
X_1694_ Tile_X0Y0_EE4BEG[2] _2183_/X VPWR VGND sg13cmos5l_buf_1
X_0714_ _0714_/Q Tile_X0Y2_FrameData[28] VGND VPWR Tile_X0Y5_FrameStrobe[5] latch
X_0645_ _0645_/Q Tile_X0Y2_FrameData[1] VGND VPWR Tile_X0Y5_FrameStrobe[2] latch
XANTENNA__1273__GATE Tile_X0Y5_FrameStrobe[0] VPWR VGND sg13cmos5l_antennanp
XANTENNA__1791__X Tile_X0Y4_E2BEG[2] VPWR VGND sg13cmos5l_antennanp
X_0576_ _0576_/Q Tile_X0Y2_FrameData[6] VGND VPWR Tile_X0Y5_FrameStrobe[0] latch
XFILLER_32_0 VPWR VGND sg13cmos5l_fill_1
XANTENNA__2351__A2 Tile_X0Y5_WW4END[6] VPWR VGND sg13cmos5l_antennanp
XFILLER_253_68 VPWR VGND sg13cmos5l_decap_4
X_2315_ _2315_/X AXIL_S_SOC_WDATA6 AXIL_S_SOC_WDATA10 _2358_/X _2374_/X _0462_/Q _0461_/Q
+ VPWR VGND sg13cmos5l_mux4_1
XANTENNA__1288__GATE Tile_X0Y5_FrameStrobe[0] VPWR VGND sg13cmos5l_antennanp
XANTENNA__2639__A0 AXIL_S_SOC_WSTRB0 VPWR VGND sg13cmos5l_antennanp
XFILLER_111_185 VPWR VGND sg13cmos5l_decap_8
XFILLER_257_189 VPWR VGND sg13cmos5l_fill_2
X_2246_ _2246_/X _2260_/X _2259_/X Tile_X0Y0_S2MID[5] Tile_X0Y0_S2END[5] _0084_/Q
+ _0083_/Q VPWR VGND sg13cmos5l_mux4_1
XANTENNA__2103__A2 Tile_X0Y4_W6END[3] VPWR VGND sg13cmos5l_antennanp
XFILLER_272_137 VPWR VGND sg13cmos5l_decap_8
X_2177_ _2177_/X AXIL_S_SOC_WDATA20 AXIL_S_SOC_WDATA28 _2244_/X _2245_/X _0242_/Q
+ _0241_/Q VPWR VGND sg13cmos5l_mux4_1
XANTENNA__1211__GATE Tile_X0Y5_FrameStrobe[5] VPWR VGND sg13cmos5l_antennanp
XANTENNA__1679__A Tile_X0Y0_FrameData[19] VPWR VGND sg13cmos5l_antennanp
XFILLER_202_50 VPWR VGND sg13cmos5l_decap_8
XFILLER_25_158 VPWR VGND sg13cmos5l_decap_4
X_1128_ _1128_/Q Tile_X0Y4_FrameData[30] VGND VPWR Tile_X0Y5_FrameStrobe[3] latch
XANTENNA__2127__X AXIL_S_SOC_RDATA21 VPWR VGND sg13cmos5l_antennanp
XFILLER_25_169 VPWR VGND sg13cmos5l_fill_2
XFILLER_280_192 VPWR VGND sg13cmos5l_fill_2
X_1059_ _1059_/Q Tile_X0Y4_FrameData[3] VGND VPWR Tile_X0Y5_FrameStrobe[0] latch
XANTENNA__2811__A0 Tile_X0Y1_W1END[2] VPWR VGND sg13cmos5l_antennanp
XFILLER_33_180 VPWR VGND sg13cmos5l_decap_8
XANTENNA__0733__D Tile_X0Y2_FrameData[9] VPWR VGND sg13cmos5l_antennanp
XANTENNA__1966__X Tile_X0Y1_E1BEG[3] VPWR VGND sg13cmos5l_antennanp
XANTENNA__1226__GATE Tile_X0Y5_FrameStrobe[6] VPWR VGND sg13cmos5l_antennanp
XFILLER_178_196 VPWR VGND sg13cmos5l_decap_8
XFILLER_193_133 VPWR VGND sg13cmos5l_fill_2
XFILLER_147_14 VPWR VGND sg13cmos5l_decap_8
XANTENNA__0482__GATE Tile_X0Y5_FrameStrobe[5] VPWR VGND sg13cmos5l_antennanp
XFILLER_110_7 VPWR VGND sg13cmos5l_fill_1
XFILLER_147_69 VPWR VGND sg13cmos5l_decap_8
XFILLER_208_7 VPWR VGND sg13cmos5l_decap_4
XFILLER_31_69 VPWR VGND sg13cmos5l_fill_2
XFILLER_350_130 VPWR VGND sg13cmos5l_decap_8
XANTENNA__0497__GATE Tile_X0Y5_FrameStrobe[5] VPWR VGND sg13cmos5l_antennanp
XFILLER_163_24 VPWR VGND sg13cmos5l_decap_8
XFILLER_163_35 VPWR VGND sg13cmos5l_fill_1
XFILLER_350_185 VPWR VGND sg13cmos5l_decap_8
XFILLER_102_152 VPWR VGND sg13cmos5l_decap_4
XFILLER_163_57 VPWR VGND sg13cmos5l_fill_1
XFILLER_102_185 VPWR VGND sg13cmos5l_decap_8
XFILLER_56_11 VPWR VGND sg13cmos5l_fill_1
XANTENNA__0420__GATE Tile_X0Y5_FrameStrobe[3] VPWR VGND sg13cmos5l_antennanp
XANTENNA__0908__D Tile_X0Y3_FrameData[10] VPWR VGND sg13cmos5l_antennanp
XFILLER_263_126 VPWR VGND sg13cmos5l_fill_2
XFILLER_56_55 VPWR VGND sg13cmos5l_fill_1
XFILLER_16_136 VPWR VGND sg13cmos5l_fill_1
XANTENNA__2037__X Tile_X0Y5_FrameData_O[22] VPWR VGND sg13cmos5l_antennanp
XFILLER_188_10 VPWR VGND sg13cmos5l_fill_2
XANTENNA__0435__GATE Tile_X0Y5_FrameStrobe[3] VPWR VGND sg13cmos5l_antennanp
XANTENNA__2802__A0 Tile_X0Y5_N1END[3] VPWR VGND sg13cmos5l_antennanp
XANTENNA__0643__D Tile_X0Y2_FrameData[3] VPWR VGND sg13cmos5l_antennanp
XANTENNA__1876__X Tile_X0Y2_E6BEG[2] VPWR VGND sg13cmos5l_antennanp
XFILLER_234_0 VPWR VGND sg13cmos5l_fill_2
XFILLER_72_87 VPWR VGND sg13cmos5l_decap_8
XFILLER_184_144 VPWR VGND sg13cmos5l_decap_8
XFILLER_188_98 VPWR VGND sg13cmos5l_decap_4
XFILLER_338_13 VPWR VGND sg13cmos5l_decap_4
XFILLER_338_57 VPWR VGND sg13cmos5l_decap_8
XFILLER_354_23 VPWR VGND sg13cmos5l_decap_8
XFILLER_326_193 VPWR VGND sg13cmos5l_decap_4
XANTENNA__1474__D Tile_X0Y5_FrameData[14] VPWR VGND sg13cmos5l_antennanp
XFILLER_98_128 VPWR VGND sg13cmos5l_decap_8
X_0430_ _0430_/Q Tile_X0Y1_FrameData[8] VGND VPWR Tile_X0Y5_FrameStrobe[3] latch
XFILLER_239_134 VPWR VGND sg13cmos5l_decap_8
X_0361_ _0361_/Q Tile_X0Y1_FrameData[13] VGND VPWR Tile_X0Y5_FrameStrobe[1] latch
XFILLER_39_206 VPWR VGND sg13cmos5l_fill_2
XFILLER_239_156 VPWR VGND sg13cmos5l_fill_1
X_2100_ AXIL_S_SOC_AWREADY Tile_X0Y4_W2MID[0] Tile_X0Y4_W2END[0] Tile_X0Y4_W6END[0]
+ _2708_/X _1096_/Q _1095_/Q VPWR VGND sg13cmos5l_mux4_1
XANTENNA__0818__D Tile_X0Y3_FrameData[4] VPWR VGND sg13cmos5l_antennanp
XFILLER_153_90 VPWR VGND sg13cmos5l_decap_8
XFILLER_223_49 VPWR VGND sg13cmos5l_decap_8
XFILLER_254_126 VPWR VGND sg13cmos5l_decap_8
XFILLER_254_137 VPWR VGND sg13cmos5l_fill_1
X_2031_ Tile_X0Y5_FrameData_O[16] Tile_X0Y5_FrameData[16] VPWR VGND sg13cmos5l_buf_1
X_0292_ _0292_/Q Tile_X0Y0_FrameData[2] VGND VPWR Tile_X0Y5_FrameStrobe[6] latch
XFILLER_303_71 VPWR VGND sg13cmos5l_fill_2
XFILLER_303_60 VPWR VGND sg13cmos5l_decap_8
XANTENNA__0553__D Tile_X0Y2_FrameData[29] VPWR VGND sg13cmos5l_antennanp
XANTENNA__1786__X Tile_X0Y4_E1BEG[1] VPWR VGND sg13cmos5l_antennanp
XFILLER_30_150 VPWR VGND sg13cmos5l_decap_8
XFILLER_175_177 VPWR VGND sg13cmos5l_decap_8
XFILLER_248_68 VPWR VGND sg13cmos5l_decap_4
XFILLER_248_79 VPWR VGND sg13cmos5l_decap_8
X_1815_ Tile_X0Y4_E6BEG[10] _2659_/X VPWR VGND sg13cmos5l_buf_1
X_2795_ _2795_/X Tile_X0Y4_W1END[2] Tile_X0Y4_W6END[10] _2688_/X _2671_/X _1128_/Q
+ _1127_/Q VPWR VGND sg13cmos5l_mux4_1
XFILLER_190_114 VPWR VGND sg13cmos5l_decap_8
X_1746_ Tile_X0Y2_FrameData_O[6] Tile_X0Y2_FrameData[6] VPWR VGND sg13cmos5l_buf_1
XANTENNA__1384__D Tile_X0Y5_FrameData[8] VPWR VGND sg13cmos5l_antennanp
X_1677_ Tile_X0Y0_FrameData_O[17] Tile_X0Y0_FrameData[17] VPWR VGND sg13cmos5l_buf_1
XFILLER_332_174 VPWR VGND sg13cmos5l_decap_8
XFILLER_264_67 VPWR VGND sg13cmos5l_fill_2
X_0628_ _0628_/Q Tile_X0Y2_FrameData[18] VGND VPWR Tile_X0Y5_FrameStrobe[2] latch
X_0559_ _0559_/Q Tile_X0Y2_FrameData[23] VGND VPWR Tile_X0Y5_FrameStrobe[0] latch
XANTENNA__0728__D Tile_X0Y2_FrameData[14] VPWR VGND sg13cmos5l_antennanp
XFILLER_133_49 VPWR VGND sg13cmos5l_fill_2
XANTENNA__1150__GATE Tile_X0Y5_FrameStrobe[3] VPWR VGND sg13cmos5l_antennanp
XFILLER_245_159 VPWR VGND sg13cmos5l_fill_1
X_2229_ _2229_/X _2213_/X _0049_/X Tile_X0Y0_S1END[0] Tile_X0Y0_S4END[0] _0102_/Q
+ _0101_/Q VPWR VGND sg13cmos5l_mux4_1
XFILLER_213_82 VPWR VGND sg13cmos5l_decap_8
XFILLER_260_118 VPWR VGND sg13cmos5l_decap_8
XANTENNA__0463__D Tile_X0Y1_FrameData[7] VPWR VGND sg13cmos5l_antennanp
XANTENNA__1165__GATE Tile_X0Y5_FrameStrobe[4] VPWR VGND sg13cmos5l_antennanp
XANTENNA__1696__X Tile_X0Y0_EE4BEG[4] VPWR VGND sg13cmos5l_antennanp
XANTENNA__2260__A1 Tile_X0Y1_W2END[2] VPWR VGND sg13cmos5l_antennanp
XFILLER_158_68 VPWR VGND sg13cmos5l_decap_8
XANTENNA__2033__A Tile_X0Y5_FrameData[18] VPWR VGND sg13cmos5l_antennanp
XFILLER_181_114 VPWR VGND sg13cmos5l_decap_8
XFILLER_181_125 VPWR VGND sg13cmos5l_fill_1
XANTENNA__2563__A2 Tile_X0Y3_W6END[2] VPWR VGND sg13cmos5l_antennanp
XFILLER_181_147 VPWR VGND sg13cmos5l_decap_8
XFILLER_181_158 VPWR VGND sg13cmos5l_fill_1
XANTENNA__1294__D Tile_X0Y5_FrameData[2] VPWR VGND sg13cmos5l_antennanp
XANTENNA__1103__GATE Tile_X0Y5_FrameStrobe[2] VPWR VGND sg13cmos5l_antennanp
XFILLER_324_15 VPWR VGND sg13cmos5l_fill_1
XFILLER_107_83 VPWR VGND sg13cmos5l_decap_8
XFILLER_67_10 VPWR VGND sg13cmos5l_decap_8
XFILLER_324_26 VPWR VGND sg13cmos5l_decap_8
XANTENNA__0638__D Tile_X0Y2_FrameData[8] VPWR VGND sg13cmos5l_antennanp
XFILLER_184_0 VPWR VGND sg13cmos5l_fill_1
XFILLER_236_137 VPWR VGND sg13cmos5l_decap_8
XANTENNA__1118__GATE Tile_X0Y5_FrameStrobe[2] VPWR VGND sg13cmos5l_antennanp
XFILLER_236_159 VPWR VGND sg13cmos5l_decap_8
XFILLER_340_36 VPWR VGND sg13cmos5l_decap_8
XFILLER_340_14 VPWR VGND sg13cmos5l_decap_4
XFILLER_83_20 VPWR VGND sg13cmos5l_decap_8
XANTENNA__0374__GATE Tile_X0Y5_FrameStrobe[1] VPWR VGND sg13cmos5l_antennanp
XFILLER_199_53 VPWR VGND sg13cmos5l_fill_1
XANTENNA__0373__D Tile_X0Y1_FrameData[1] VPWR VGND sg13cmos5l_antennanp
XANTENNA__1469__D Tile_X0Y5_FrameData[19] VPWR VGND sg13cmos5l_antennanp
XFILLER_349_45 VPWR VGND sg13cmos5l_decap_8
XFILLER_349_23 VPWR VGND sg13cmos5l_decap_8
XANTENNA__2251__A1 Tile_X0Y2_W2END[6] VPWR VGND sg13cmos5l_antennanp
XANTENNA__0389__GATE Tile_X0Y5_FrameStrobe[2] VPWR VGND sg13cmos5l_antennanp
X_1600_ Tile_X0Y2_EE4BEG[13] _2430_/X VPWR VGND sg13cmos5l_buf_1
X_2580_ _2580_/X _2566_/X Tile_X0Y5_N4END[8] _2565_/X Tile_X0Y0_S4END[12] _0830_/Q
+ _0829_/Q VPWR VGND sg13cmos5l_mux4_1
XANTENNA__0312__GATE Tile_X0Y5_FrameStrobe[0] VPWR VGND sg13cmos5l_antennanp
X_1531_ Tile_X0Y3_E6BEG[5] _2546_/X VPWR VGND sg13cmos5l_buf_1
XANTENNA__0942__GATE Tile_X0Y5_FrameStrobe[4] VPWR VGND sg13cmos5l_antennanp
X_1462_ _1462_/Q Tile_X0Y5_FrameData[26] VGND VPWR Tile_X0Y5_FrameStrobe[6] latch
XFILLER_314_174 VPWR VGND sg13cmos5l_fill_2
X_0413_ _0413_/Q Tile_X0Y1_FrameData[25] VGND VPWR Tile_X0Y5_FrameStrobe[3] latch
XANTENNA__0327__GATE Tile_X0Y5_FrameStrobe[0] VPWR VGND sg13cmos5l_antennanp
X_1393_ _1393_/Q Tile_X0Y5_FrameData[31] VGND VPWR Tile_X0Y5_FrameStrobe[4] latch
XFILLER_79_183 VPWR VGND sg13cmos5l_decap_8
XANTENNA__0548__D Tile_X0Y1_FrameData[18] VPWR VGND sg13cmos5l_antennanp
XANTENNA__0957__GATE Tile_X0Y5_FrameStrobe[5] VPWR VGND sg13cmos5l_antennanp
X_0344_ _0344_/Q Tile_X0Y1_FrameData[30] VGND VPWR Tile_X0Y5_FrameStrobe[1] latch
XFILLER_94_142 VPWR VGND sg13cmos5l_decap_8
X_0275_ _0275_/Q Tile_X0Y0_FrameData[19] VGND VPWR Tile_X0Y5_FrameStrobe[6] latch
XFILLER_94_186 VPWR VGND sg13cmos5l_fill_1
X_2014_ Tile_X0Y5_EE4BEG[15] _2756_/X VPWR VGND sg13cmos5l_buf_1
XANTENNA__2490__A1 Tile_X0Y4_W2END[7] VPWR VGND sg13cmos5l_antennanp
XFILLER_250_151 VPWR VGND sg13cmos5l_fill_1
XFILLER_50_223 VPWR VGND sg13cmos5l_fill_1
XANTENNA__0283__D Tile_X0Y0_FrameData[11] VPWR VGND sg13cmos5l_antennanp
XANTENNA__1379__D Tile_X0Y5_FrameData[13] VPWR VGND sg13cmos5l_antennanp
XFILLER_259_34 VPWR VGND sg13cmos5l_decap_8
XFILLER_12_27 VPWR VGND sg13cmos5l_fill_2
XFILLER_148_144 VPWR VGND sg13cmos5l_decap_8
XFILLER_148_177 VPWR VGND sg13cmos5l_decap_8
XFILLER_163_125 VPWR VGND sg13cmos5l_decap_8
XFILLER_352_203 VPWR VGND sg13cmos5l_decap_4
XFILLER_128_49 VPWR VGND sg13cmos5l_decap_8
X_2778_ _2778_/X Tile_X0Y5_W1END[1] Tile_X0Y5_W2MID[2] Tile_X0Y5_W2END[2] _2799_/X
+ _1346_/Q _1345_/Q VPWR VGND sg13cmos5l_mux4_1
XFILLER_104_203 VPWR VGND sg13cmos5l_fill_2
X_1729_ Tile_X0Y0_E2BEG[1] _2166_/X VPWR VGND sg13cmos5l_buf_1
XANTENNA__2140__X AXIL_S_SOC_RVALID VPWR VGND sg13cmos5l_antennanp
XANTENNA__0458__D Tile_X0Y1_FrameData[12] VPWR VGND sg13cmos5l_antennanp
XFILLER_273_221 VPWR VGND sg13cmos5l_fill_2
XFILLER_160_14 VPWR VGND sg13cmos5l_fill_1
XFILLER_160_25 VPWR VGND sg13cmos5l_decap_8
XFILLER_275_7 VPWR VGND sg13cmos5l_decap_8
XFILLER_160_47 VPWR VGND sg13cmos5l_decap_8
XFILLER_85_197 VPWR VGND sg13cmos5l_fill_1
XANTENNA__2028__A Tile_X0Y5_FrameData[13] VPWR VGND sg13cmos5l_antennanp
XFILLER_41_223 VPWR VGND sg13cmos5l_fill_1
XANTENNA__0193__D Tile_X0Y0_FrameData[5] VPWR VGND sg13cmos5l_antennanp
XANTENNA__1289__D Tile_X0Y5_FrameData[7] VPWR VGND sg13cmos5l_antennanp
XFILLER_53_78 VPWR VGND sg13cmos5l_fill_2
XFILLER_319_37 VPWR VGND sg13cmos5l_decap_8
XANTENNA__0921__D Tile_X0Y3_FrameData[29] VPWR VGND sg13cmos5l_antennanp
XFILLER_154_125 VPWR VGND sg13cmos5l_decap_8
XFILLER_335_14 VPWR VGND sg13cmos5l_decap_8
XANTENNA__1042__GATE Tile_X0Y5_FrameStrobe[0] VPWR VGND sg13cmos5l_antennanp
XANTENNA__2050__X Tile_X0Y5_S1BEG[3] VPWR VGND sg13cmos5l_antennanp
XFILLER_118_93 VPWR VGND sg13cmos5l_decap_8
XFILLER_162_180 VPWR VGND sg13cmos5l_decap_8
XFILLER_78_86 VPWR VGND sg13cmos5l_decap_4
XFILLER_311_166 VPWR VGND sg13cmos5l_fill_2
XANTENNA__1057__GATE Tile_X0Y5_FrameStrobe[0] VPWR VGND sg13cmos5l_antennanp
XANTENNA__0368__D Tile_X0Y1_FrameData[6] VPWR VGND sg13cmos5l_antennanp
XFILLER_94_41 VPWR VGND sg13cmos5l_fill_2
XFILLER_76_164 VPWR VGND sg13cmos5l_decap_4
X_0060_ _2077_/A _2665_/X _2666_/X _1100_/Q VPWR VGND sg13cmos5l_mux2_1
XFILLER_224_129 VPWR VGND sg13cmos5l_fill_2
XANTENNA__2472__A1 Tile_X0Y5_N4END[12] VPWR VGND sg13cmos5l_antennanp
XFILLER_220_39 VPWR VGND sg13cmos5l_decap_8
XFILLER_232_151 VPWR VGND sg13cmos5l_decap_8
XANTENNA__1199__D Tile_X0Y4_FrameData[23] VPWR VGND sg13cmos5l_antennanp
XFILLER_232_162 VPWR VGND sg13cmos5l_fill_1
X_0962_ _0962_/Q Tile_X0Y3_FrameData[20] VGND VPWR Tile_X0Y5_FrameStrobe[5] latch
XFILLER_319_222 VPWR VGND sg13cmos5l_fill_2
XFILLER_319_211 VPWR VGND sg13cmos5l_fill_1
XFILLER_300_72 VPWR VGND sg13cmos5l_fill_1
XANTENNA__2775__A2 Tile_X0Y5_W6END[10] VPWR VGND sg13cmos5l_antennanp
X_2701_ _2701_/X _2678_/X Tile_X0Y5_N4END[6] _2677_/X _0024_/X _1074_/Q _1073_/Q VPWR
+ VGND sg13cmos5l_mux4_1
XANTENNA__0831__D Tile_X0Y3_FrameData[23] VPWR VGND sg13cmos5l_antennanp
XFILLER_145_114 VPWR VGND sg13cmos5l_decap_8
X_0893_ _0893_/Q Tile_X0Y3_FrameData[25] VGND VPWR Tile_X0Y5_FrameStrobe[3] latch
XANTENNA__0251__GATE Tile_X0Y5_FrameStrobe[5] VPWR VGND sg13cmos5l_antennanp
X_2632_ _2632_/X AXIL_S_SOC_WSTRB1 AXIL_S_SOC_WSTRB3 _2708_/X _2681_/X _1190_/Q _1189_/Q
+ VPWR VGND sg13cmos5l_mux4_1
XANTENNA__0881__GATE Tile_X0Y5_FrameStrobe[2] VPWR VGND sg13cmos5l_antennanp
XFILLER_160_117 VPWR VGND sg13cmos5l_decap_4
X_2563_ _2563_/X _2570_/X _2569_/X Tile_X0Y3_W6END[2] _2563_/A3 _0794_/Q _0793_/Q
+ VPWR VGND sg13cmos5l_mux4_1
XFILLER_99_201 VPWR VGND sg13cmos5l_decap_8
XFILLER_160_128 VPWR VGND sg13cmos5l_decap_8
X_1514_ _2210_/A3 VPWR VGND sg13cmos5l_tielo
XFILLER_302_100 VPWR VGND sg13cmos5l_decap_4
X_2494_ _2494_/X Tile_X0Y4_W2MID[5] Tile_X0Y4_W2END[5] Tile_X0Y4_W6END[5] _2710_/X
+ _1252_/Q _1251_/Q VPWR VGND sg13cmos5l_mux4_1
XANTENNA__0266__GATE Tile_X0Y5_FrameStrobe[6] VPWR VGND sg13cmos5l_antennanp
XANTENNA__0896__GATE Tile_X0Y5_FrameStrobe[3] VPWR VGND sg13cmos5l_antennanp
X_1445_ _1445_/Q Tile_X0Y5_FrameData[11] VGND VPWR Tile_X0Y5_FrameStrobe[5] latch
X_1376_ _1376_/Q Tile_X0Y5_FrameData[16] VGND VPWR Tile_X0Y5_FrameStrobe[3] latch
XANTENNA__0278__D Tile_X0Y0_FrameData[16] VPWR VGND sg13cmos5l_antennanp
XFILLER_261_57 VPWR VGND sg13cmos5l_fill_1
X_0327_ _0327_/Q Tile_X0Y1_FrameData[15] VGND VPWR Tile_X0Y5_FrameStrobe[0] latch
XFILLER_67_153 VPWR VGND sg13cmos5l_fill_1
XFILLER_82_134 VPWR VGND sg13cmos5l_decap_8
XFILLER_208_181 VPWR VGND sg13cmos5l_fill_1
X_0258_ _0258_/Q Tile_X0Y0_FrameData[4] VGND VPWR Tile_X0Y5_FrameStrobe[5] latch
XFILLER_82_178 VPWR VGND sg13cmos5l_decap_8
XANTENNA__2463__A1 Tile_X0Y1_W6END[11] VPWR VGND sg13cmos5l_antennanp
X_0189_ _0189_/Q Tile_X0Y0_FrameData[9] VGND VPWR Tile_X0Y5_FrameStrobe[3] latch
XANTENNA__0204__GATE Tile_X0Y5_FrameStrobe[4] VPWR VGND sg13cmos5l_antennanp
XFILLER_168_206 VPWR VGND sg13cmos5l_fill_1
XANTENNA__0834__GATE Tile_X0Y5_FrameStrobe[1] VPWR VGND sg13cmos5l_antennanp
XANTENNA__1687__A Tile_X0Y0_FrameData[27] VPWR VGND sg13cmos5l_antennanp
XANTENNA__2135__X AXIL_S_SOC_RDATA29 VPWR VGND sg13cmos5l_antennanp
XANTENNA__2215__A1 Tile_X0Y1_W6END[6] VPWR VGND sg13cmos5l_antennanp
XFILLER_223_195 VPWR VGND sg13cmos5l_fill_2
XFILLER_139_26 VPWR VGND sg13cmos5l_fill_2
XFILLER_23_48 VPWR VGND sg13cmos5l_fill_2
XANTENNA__0741__D Tile_X0Y2_FrameData[1] VPWR VGND sg13cmos5l_antennanp
XANTENNA__1974__X Tile_X0Y5_E2BEG[3] VPWR VGND sg13cmos5l_antennanp
XFILLER_286_54 VPWR VGND sg13cmos5l_fill_2
XFILLER_99_19 VPWR VGND sg13cmos5l_fill_2
XANTENNA__0219__GATE Tile_X0Y5_FrameStrobe[4] VPWR VGND sg13cmos5l_antennanp
XFILLER_136_125 VPWR VGND sg13cmos5l_decap_8
XFILLER_286_87 VPWR VGND sg13cmos5l_decap_8
XANTENNA__0849__GATE Tile_X0Y5_FrameStrobe[1] VPWR VGND sg13cmos5l_antennanp
XFILLER_340_217 VPWR VGND sg13cmos5l_fill_1
XFILLER_2_105 VPWR VGND sg13cmos5l_fill_2
XFILLER_2_149 VPWR VGND sg13cmos5l_fill_1
XANTENNA__2151__A0 Tile_X0Y0_W2MID[1] VPWR VGND sg13cmos5l_antennanp
XFILLER_171_35 VPWR VGND sg13cmos5l_decap_8
XFILLER_246_210 VPWR VGND sg13cmos5l_fill_1
XANTENNA__0188__D Tile_X0Y0_FrameData[10] VPWR VGND sg13cmos5l_antennanp
XFILLER_58_153 VPWR VGND sg13cmos5l_decap_4
XFILLER_321_27 VPWR VGND sg13cmos5l_decap_8
XANTENNA__0916__D Tile_X0Y3_FrameData[2] VPWR VGND sg13cmos5l_antennanp
XFILLER_251_90 VPWR VGND sg13cmos5l_decap_8
XFILLER_73_167 VPWR VGND sg13cmos5l_decap_8
XFILLER_259_2 VPWR VGND sg13cmos5l_fill_1
XFILLER_214_173 VPWR VGND sg13cmos5l_decap_8
XFILLER_214_184 VPWR VGND sg13cmos5l_fill_2
XANTENNA__2045__X Tile_X0Y5_FrameData_O[30] VPWR VGND sg13cmos5l_antennanp
XFILLER_147_0 VPWR VGND sg13cmos5l_decap_8
XFILLER_196_21 VPWR VGND sg13cmos5l_fill_2
XANTENNA__0651__D Tile_X0Y2_FrameData[27] VPWR VGND sg13cmos5l_antennanp
XANTENNA__1884__X Tile_X0Y2_E6BEG[10] VPWR VGND sg13cmos5l_antennanp
XFILLER_127_114 VPWR VGND sg13cmos5l_fill_2
XFILLER_196_43 VPWR VGND sg13cmos5l_decap_4
XFILLER_196_54 VPWR VGND sg13cmos5l_fill_1
XFILLER_13_70 VPWR VGND sg13cmos5l_decap_8
XFILLER_346_35 VPWR VGND sg13cmos5l_fill_2
XFILLER_89_30 VPWR VGND sg13cmos5l_decap_8
XFILLER_346_68 VPWR VGND sg13cmos5l_decap_8
XANTENNA__2390__A0 Tile_X0Y3_W2MID[3] VPWR VGND sg13cmos5l_antennanp
XFILLER_43_8 VPWR VGND sg13cmos5l_fill_1
XANTENNA__1482__D Tile_X0Y5_FrameData[6] VPWR VGND sg13cmos5l_antennanp
XFILLER_150_161 VPWR VGND sg13cmos5l_decap_8
XFILLER_215_39 VPWR VGND sg13cmos5l_decap_4
XANTENNA__2142__A0 Tile_X0Y0_W1END[1] VPWR VGND sg13cmos5l_antennanp
X_1230_ _1230_/Q Tile_X0Y4_FrameData[24] VGND VPWR Tile_X0Y5_FrameStrobe[6] latch
XFILLER_362_89 VPWR VGND sg13cmos5l_fill_2
XANTENNA__0098__D Tile_X0Y0_FrameData[4] VPWR VGND sg13cmos5l_antennanp
X_1161_ _1161_/Q Tile_X0Y4_FrameData[29] VGND VPWR Tile_X0Y5_FrameStrobe[4] latch
XANTENNA__2693__A1 Tile_X0Y5_N4END[5] VPWR VGND sg13cmos5l_antennanp
XFILLER_231_16 VPWR VGND sg13cmos5l_fill_1
X_0112_ _0112_/Q Tile_X0Y0_FrameData[22] VGND VPWR Tile_X0Y5_FrameStrobe[1] latch
XFILLER_64_134 VPWR VGND sg13cmos5l_decap_8
XFILLER_49_197 VPWR VGND sg13cmos5l_fill_1
XANTENNA__0826__D Tile_X0Y3_FrameData[28] VPWR VGND sg13cmos5l_antennanp
X_1092_ _1092_/Q Tile_X0Y4_FrameData[2] VGND VPWR Tile_X0Y5_FrameStrobe[1] latch
XANTENNA__2445__A1 Tile_X0Y2_WW4END[8] VPWR VGND sg13cmos5l_antennanp
X_0043_ _1611_/A _2273_/X _2274_/X _0755_/Q VPWR VGND sg13cmos5l_mux2_1
X_1994_ Tile_X0Y5_E6BEG[7] _2764_/X VPWR VGND sg13cmos5l_buf_1
XANTENNA__0190__GATE Tile_X0Y5_FrameStrobe[3] VPWR VGND sg13cmos5l_antennanp
XANTENNA__0561__D Tile_X0Y2_FrameData[21] VPWR VGND sg13cmos5l_antennanp
XANTENNA__1794__X Tile_X0Y4_E2BEG[5] VPWR VGND sg13cmos5l_antennanp
XFILLER_118_114 VPWR VGND sg13cmos5l_decap_8
X_0945_ _0945_/Q Tile_X0Y3_FrameData[5] VGND VPWR Tile_X0Y5_FrameStrobe[4] latch
X_0876_ _0876_/Q Tile_X0Y3_FrameData[10] VGND VPWR Tile_X0Y5_FrameStrobe[2] latch
XFILLER_118_158 VPWR VGND sg13cmos5l_decap_8
X_2615_ _2615_/X _2678_/X _2677_/X AXIL_S_SOC_WSTRB0 AXIL_S_SOC_BREADY _1224_/Q _1223_/Q
+ VPWR VGND sg13cmos5l_mux4_1
XFILLER_133_128 VPWR VGND sg13cmos5l_decap_8
XANTENNA__2381__A0 Tile_X0Y0_W2MID[7] VPWR VGND sg13cmos5l_antennanp
XFILLER_126_191 VPWR VGND sg13cmos5l_fill_2
XFILLER_287_121 VPWR VGND sg13cmos5l_decap_4
X_2546_ _2546_/X AXIL_S_SOC_ARADDR5 _2582_/X _2576_/X _2590_/X _0912_/Q _0911_/Q VPWR
+ VGND sg13cmos5l_mux4_1
XANTENNA__1392__D Tile_X0Y5_FrameData[0] VPWR VGND sg13cmos5l_antennanp
XFILLER_141_172 VPWR VGND sg13cmos5l_decap_8
XFILLER_272_45 VPWR VGND sg13cmos5l_decap_8
X_2477_ _2477_/X _2460_/X Tile_X0Y5_N4END[13] _2459_/X Tile_X0Y0_S4END[9] _0596_/Q
+ _0595_/Q VPWR VGND sg13cmos5l_mux4_1
X_1428_ _1428_/Q Tile_X0Y5_FrameData[28] VGND VPWR Tile_X0Y5_FrameStrobe[5] latch
XANTENNA__2133__A0 Tile_X0Y0_W2MID[3] VPWR VGND sg13cmos5l_antennanp
XANTENNA__2684__A1 Tile_X0Y5_N4END[7] VPWR VGND sg13cmos5l_antennanp
X_1359_ _1359_/Q Tile_X0Y5_FrameData[1] VGND VPWR Tile_X0Y5_FrameStrobe[2] latch
XANTENNA__1969__X Tile_X0Y5_E1BEG[2] VPWR VGND sg13cmos5l_antennanp
XFILLER_141_49 VPWR VGND sg13cmos5l_decap_8
XANTENNA__0143__GATE Tile_X0Y5_FrameStrobe[2] VPWR VGND sg13cmos5l_antennanp
XANTENNA__0736__D Tile_X0Y2_FrameData[6] VPWR VGND sg13cmos5l_antennanp
XANTENNA__2436__A1 Tile_X0Y0_S4END[11] VPWR VGND sg13cmos5l_antennanp
XFILLER_70_104 VPWR VGND sg13cmos5l_decap_8
XANTENNA__0773__GATE Tile_X0Y5_FrameStrobe[6] VPWR VGND sg13cmos5l_antennanp
XFILLER_34_25 VPWR VGND sg13cmos5l_fill_2
XFILLER_34_47 VPWR VGND sg13cmos5l_decap_8
XFILLER_211_154 VPWR VGND sg13cmos5l_decap_4
XFILLER_211_165 VPWR VGND sg13cmos5l_decap_8
XFILLER_238_7 VPWR VGND sg13cmos5l_fill_2
XANTENNA__0158__GATE Tile_X0Y5_FrameStrobe[2] VPWR VGND sg13cmos5l_antennanp
XANTENNA__0471__D Tile_X0Y1_FrameData[31] VPWR VGND sg13cmos5l_antennanp
XFILLER_133_6 VPWR VGND sg13cmos5l_fill_1
XFILLER_50_24 VPWR VGND sg13cmos5l_fill_1
XANTENNA__0788__GATE Tile_X0Y5_FrameStrobe[7] VPWR VGND sg13cmos5l_antennanp
XFILLER_109_158 VPWR VGND sg13cmos5l_decap_8
XFILLER_166_46 VPWR VGND sg13cmos5l_decap_8
XFILLER_300_6 VPWR VGND sg13cmos5l_fill_2
XFILLER_124_139 VPWR VGND sg13cmos5l_fill_2
XANTENNA__0711__GATE Tile_X0Y5_FrameStrobe[5] VPWR VGND sg13cmos5l_antennanp
XANTENNA__2041__A Tile_X0Y5_FrameData[26] VPWR VGND sg13cmos5l_antennanp
XFILLER_278_121 VPWR VGND sg13cmos5l_decap_8
XFILLER_59_22 VPWR VGND sg13cmos5l_fill_2
XANTENNA__0726__GATE Tile_X0Y5_FrameStrobe[5] VPWR VGND sg13cmos5l_antennanp
XANTENNA__2124__A0 Tile_X0Y1_W2MID[2] VPWR VGND sg13cmos5l_antennanp
XFILLER_115_72 VPWR VGND sg13cmos5l_decap_8
XFILLER_219_221 VPWR VGND sg13cmos5l_fill_2
XANTENNA__2675__A1 Tile_X0Y3_W6END[9] VPWR VGND sg13cmos5l_antennanp
XFILLER_234_202 VPWR VGND sg13cmos5l_fill_1
XFILLER_46_112 VPWR VGND sg13cmos5l_fill_2
XFILLER_46_101 VPWR VGND sg13cmos5l_decap_4
XANTENNA__1879__X Tile_X0Y2_E6BEG[5] VPWR VGND sg13cmos5l_antennanp
XANTENNA__0646__D Tile_X0Y2_FrameData[0] VPWR VGND sg13cmos5l_antennanp
XANTENNA__2427__A1 AXIL_S_SOC_AWPROT0 VPWR VGND sg13cmos5l_antennanp
XFILLER_131_60 VPWR VGND sg13cmos5l_fill_1
XFILLER_201_19 VPWR VGND sg13cmos5l_fill_2
XFILLER_264_0 VPWR VGND sg13cmos5l_decap_8
XFILLER_46_178 VPWR VGND sg13cmos5l_fill_2
XFILLER_91_42 VPWR VGND sg13cmos5l_decap_8
XFILLER_147_209 VPWR VGND sg13cmos5l_fill_2
XFILLER_348_158 VPWR VGND sg13cmos5l_fill_2
XANTENNA__1477__D Tile_X0Y5_FrameData[11] VPWR VGND sg13cmos5l_antennanp
XANTENNA__0381__D Tile_X0Y1_FrameData[25] VPWR VGND sg13cmos5l_antennanp
X_0730_ _0730_/Q Tile_X0Y2_FrameData[12] VGND VPWR Tile_X0Y5_FrameStrobe[5] latch
XFILLER_357_89 VPWR VGND sg13cmos5l_fill_1
XFILLER_115_128 VPWR VGND sg13cmos5l_fill_1
X_2400_ _2400_/X _2464_/X _2463_/X AXIL_S_SOC_AWADDR1 AXIL_S_SOC_AWADDR4 _0748_/Q
+ _0747_/Q VPWR VGND sg13cmos5l_mux4_1
X_0661_ _0661_/Q Tile_X0Y2_FrameData[17] VGND VPWR Tile_X0Y5_FrameStrobe[3] latch
XANTENNA__2363__A0 Tile_X0Y5_W1END[3] VPWR VGND sg13cmos5l_antennanp
X_0592_ _0592_/Q Tile_X0Y2_FrameData[22] VGND VPWR Tile_X0Y5_FrameStrobe[1] latch
XFILLER_269_143 VPWR VGND sg13cmos5l_fill_2
X_2331_ _2331_/X AXIL_S_SOC_WDATA6 _2369_/X _2358_/X _2375_/X _0430_/Q _0429_/Q VPWR
+ VGND sg13cmos5l_mux4_1
X_2262_ _2262_/X Tile_X0Y1_W2MID[1] Tile_X0Y1_W2END[1] Tile_X0Y1_W6END[1] _2379_/X
+ _0530_/Q _0529_/Q VPWR VGND sg13cmos5l_mux4_1
XANTENNA__2115__A0 Tile_X0Y2_W2MID[1] VPWR VGND sg13cmos5l_antennanp
X_1213_ _1213_/Q Tile_X0Y4_FrameData[9] VGND VPWR Tile_X0Y5_FrameStrobe[5] latch
XFILLER_284_179 VPWR VGND sg13cmos5l_fill_1
X_2193_ _2193_/X AXIL_S_SOC_WDATA16 AXIL_S_SOC_WDATA28 _2235_/X _2244_/X _0210_/Q
+ _0209_/Q VPWR VGND sg13cmos5l_mux4_1
XFILLER_37_112 VPWR VGND sg13cmos5l_fill_2
X_1144_ _1144_/Q Tile_X0Y4_FrameData[14] VGND VPWR Tile_X0Y5_FrameStrobe[3] latch
XANTENNA__0556__D Tile_X0Y2_FrameData[26] VPWR VGND sg13cmos5l_antennanp
XANTENNA__1789__X Tile_X0Y4_E2BEG[0] VPWR VGND sg13cmos5l_antennanp
XANTENNA__2418__A1 AXIL_S_SOC_AWVALID VPWR VGND sg13cmos5l_antennanp
X_1075_ _1075_/Q Tile_X0Y4_FrameData[19] VGND VPWR Tile_X0Y5_FrameStrobe[1] latch
X_0026_ _1612_/A _2271_/X _2272_/X _0524_/Q VPWR VGND sg13cmos5l_mux2_1
XFILLER_60_181 VPWR VGND sg13cmos5l_decap_8
XANTENNA__1387__D Tile_X0Y5_FrameData[5] VPWR VGND sg13cmos5l_antennanp
XFILLER_267_23 VPWR VGND sg13cmos5l_fill_1
XANTENNA__0291__D Tile_X0Y0_FrameData[3] VPWR VGND sg13cmos5l_antennanp
XFILLER_267_56 VPWR VGND sg13cmos5l_fill_1
X_1977_ Tile_X0Y5_E2BEG[6] _2731_/X VPWR VGND sg13cmos5l_buf_1
XFILLER_267_78 VPWR VGND sg13cmos5l_decap_4
X_0928_ _0928_/Q Tile_X0Y3_FrameData[22] VGND VPWR Tile_X0Y5_FrameStrobe[4] latch
XFILLER_161_212 VPWR VGND sg13cmos5l_fill_2
X_0859_ _0859_/Q Tile_X0Y3_FrameData[27] VGND VPWR Tile_X0Y5_FrameStrobe[2] latch
XFILLER_283_44 VPWR VGND sg13cmos5l_decap_4
XFILLER_362_194 VPWR VGND sg13cmos5l_decap_8
XANTENNA__1441__GATE Tile_X0Y5_FrameStrobe[5] VPWR VGND sg13cmos5l_antennanp
X_2529_ _2529_/X AXIL_S_SOC_ARADDR4 AXIL_S_SOC_ARADDR8 _2574_/X _2592_/X _0946_/Q
+ _0945_/Q VPWR VGND sg13cmos5l_mux4_1
XFILLER_114_183 VPWR VGND sg13cmos5l_decap_8
XFILLER_29_25 VPWR VGND sg13cmos5l_fill_2
XANTENNA__2106__A0 Tile_X0Y3_W2MID[0] VPWR VGND sg13cmos5l_antennanp
XANTENNA__1456__GATE Tile_X0Y5_FrameStrobe[5] VPWR VGND sg13cmos5l_antennanp
XFILLER_152_48 VPWR VGND sg13cmos5l_decap_8
XFILLER_290_105 VPWR VGND sg13cmos5l_decap_8
XANTENNA__0082__GATE Tile_X0Y5_FrameStrobe[0] VPWR VGND sg13cmos5l_antennanp
XFILLER_216_202 VPWR VGND sg13cmos5l_decap_4
XFILLER_216_213 VPWR VGND sg13cmos5l_fill_2
XANTENNA__0466__D Tile_X0Y1_FrameData[4] VPWR VGND sg13cmos5l_antennanp
XANTENNA__1699__X Tile_X0Y0_EE4BEG[7] VPWR VGND sg13cmos5l_antennanp
XANTENNA__2409__A1 AXIL_S_SOC_AWADDR8 VPWR VGND sg13cmos5l_antennanp
XFILLER_45_46 VPWR VGND sg13cmos5l_fill_2
XFILLER_43_115 VPWR VGND sg13cmos5l_decap_8
XANTENNA__0097__GATE Tile_X0Y5_FrameStrobe[0] VPWR VGND sg13cmos5l_antennanp
XANTENNA__2036__A Tile_X0Y5_FrameData[21] VPWR VGND sg13cmos5l_antennanp
XFILLER_101_63 VPWR VGND sg13cmos5l_fill_2
XFILLER_101_74 VPWR VGND sg13cmos5l_fill_1
XFILLER_196_131 VPWR VGND sg13cmos5l_decap_8
XFILLER_61_12 VPWR VGND sg13cmos5l_fill_1
XANTENNA__1297__D Tile_X0Y5_FrameData[31] VPWR VGND sg13cmos5l_antennanp
XFILLER_101_96 VPWR VGND sg13cmos5l_decap_8
XFILLER_177_45 VPWR VGND sg13cmos5l_decap_4
XFILLER_360_109 VPWR VGND sg13cmos5l_decap_8
XANTENNA__0650__GATE Tile_X0Y5_FrameStrobe[3] VPWR VGND sg13cmos5l_antennanp
XFILLER_327_37 VPWR VGND sg13cmos5l_decap_8
XFILLER_298_216 VPWR VGND sg13cmos5l_fill_2
XANTENNA__1409__GATE Tile_X0Y5_FrameStrobe[4] VPWR VGND sg13cmos5l_antennanp
XANTENNA__2345__A0 Tile_X0Y0_W1END[2] VPWR VGND sg13cmos5l_antennanp
XFILLER_193_22 VPWR VGND sg13cmos5l_fill_2
XFILLER_105_172 VPWR VGND sg13cmos5l_decap_8
XFILLER_126_60 VPWR VGND sg13cmos5l_decap_8
XANTENNA__0665__GATE Tile_X0Y5_FrameStrobe[3] VPWR VGND sg13cmos5l_antennanp
XFILLER_120_131 VPWR VGND sg13cmos5l_fill_2
XFILLER_266_124 VPWR VGND sg13cmos5l_decap_8
XFILLER_86_64 VPWR VGND sg13cmos5l_decap_8
XANTENNA__2648__A1 AXIL_S_SOC_WSTRB3 VPWR VGND sg13cmos5l_antennanp
XFILLER_19_112 VPWR VGND sg13cmos5l_decap_8
XFILLER_19_91 VPWR VGND sg13cmos5l_decap_8
XFILLER_207_202 VPWR VGND sg13cmos5l_decap_8
XFILLER_281_116 VPWR VGND sg13cmos5l_decap_8
XANTENNA__0376__D Tile_X0Y1_FrameData[30] VPWR VGND sg13cmos5l_antennanp
XANTENNA__0603__GATE Tile_X0Y5_FrameStrobe[1] VPWR VGND sg13cmos5l_antennanp
XANTENNA__2820__A1 Tile_X0Y5_N4END[2] VPWR VGND sg13cmos5l_antennanp
X_1900_ Tile_X0Y1_FrameData_O[13] Tile_X0Y1_FrameData[13] VPWR VGND sg13cmos5l_buf_1
XFILLER_42_181 VPWR VGND sg13cmos5l_fill_1
XFILLER_42_170 VPWR VGND sg13cmos5l_decap_8
XFILLER_187_153 VPWR VGND sg13cmos5l_decap_8
X_1831_ Tile_X0Y4_EE4BEG[14] _2647_/X VPWR VGND sg13cmos5l_buf_1
XANTENNA__1000__D Tile_X0Y3_FrameData[14] VPWR VGND sg13cmos5l_antennanp
X_1762_ Tile_X0Y2_FrameData_O[22] Tile_X0Y2_FrameData[22] VPWR VGND sg13cmos5l_buf_1
XANTENNA__0618__GATE Tile_X0Y5_FrameStrobe[2] VPWR VGND sg13cmos5l_antennanp
XFILLER_143_201 VPWR VGND sg13cmos5l_decap_8
X_1693_ Tile_X0Y0_EE4BEG[1] _2182_/X VPWR VGND sg13cmos5l_buf_1
X_0713_ _0713_/Q Tile_X0Y2_FrameData[29] VGND VPWR Tile_X0Y5_FrameStrobe[5] latch
XANTENNA__2336__A0 AXIL_S_SOC_WDATA3 VPWR VGND sg13cmos5l_antennanp
X_0644_ _0644_/Q Tile_X0Y2_FrameData[2] VGND VPWR Tile_X0Y5_FrameStrobe[2] latch
XFILLER_253_14 VPWR VGND sg13cmos5l_decap_4
XFILLER_253_47 VPWR VGND sg13cmos5l_decap_8
X_0575_ _0575_/Q Tile_X0Y2_FrameData[7] VGND VPWR Tile_X0Y5_FrameStrobe[0] latch
XANTENNA__2351__A3 Tile_X0Y5_W6END[8] VPWR VGND sg13cmos5l_antennanp
X_2314_ _2314_/X AXIL_S_SOC_WDATA5 AXIL_S_SOC_WDATA9 _2354_/X _2375_/X _0464_/Q _0463_/Q
+ VPWR VGND sg13cmos5l_mux4_1
XANTENNA__2639__A1 AXIL_S_SOC_WVALID VPWR VGND sg13cmos5l_antennanp
XFILLER_111_164 VPWR VGND sg13cmos5l_decap_8
X_2245_ _2245_/X _2258_/X _2257_/X Tile_X0Y0_S2MID[4] Tile_X0Y0_S2END[4] _0086_/Q
+ _0085_/Q VPWR VGND sg13cmos5l_mux4_1
XFILLER_122_18 VPWR VGND sg13cmos5l_fill_1
XFILLER_272_127 VPWR VGND sg13cmos5l_fill_2
X_2176_ _2176_/X AXIL_S_SOC_WDATA19 AXIL_S_SOC_WDATA27 _2244_/X _2245_/X _0244_/Q
+ _0243_/Q VPWR VGND sg13cmos5l_mux4_1
XANTENNA__0286__D Tile_X0Y0_FrameData[8] VPWR VGND sg13cmos5l_antennanp
X_1127_ _1127_/Q Tile_X0Y4_FrameData[31] VGND VPWR Tile_X0Y5_FrameStrobe[3] latch
XFILLER_280_171 VPWR VGND sg13cmos5l_decap_8
X_1058_ _1058_/Q Tile_X0Y4_FrameData[4] VGND VPWR Tile_X0Y5_FrameStrobe[0] latch
XANTENNA__2811__A1 Tile_X0Y1_WW4END[10] VPWR VGND sg13cmos5l_antennanp
XFILLER_40_129 VPWR VGND sg13cmos5l_fill_1
XFILLER_40_118 VPWR VGND sg13cmos5l_decap_4
XFILLER_178_175 VPWR VGND sg13cmos5l_decap_8
XFILLER_327_128 VPWR VGND sg13cmos5l_fill_2
XANTENNA__1982__X Tile_X0Y5_E2BEGb[3] VPWR VGND sg13cmos5l_antennanp
XFILLER_134_223 VPWR VGND sg13cmos5l_fill_1
XFILLER_147_37 VPWR VGND sg13cmos5l_decap_4
XFILLER_193_189 VPWR VGND sg13cmos5l_decap_8
XANTENNA__1380__GATE Tile_X0Y5_FrameStrobe[3] VPWR VGND sg13cmos5l_antennanp
XFILLER_103_7 VPWR VGND sg13cmos5l_fill_1
XFILLER_294_76 VPWR VGND sg13cmos5l_fill_1
XFILLER_335_194 VPWR VGND sg13cmos5l_fill_2
XFILLER_350_175 VPWR VGND sg13cmos5l_fill_2
XFILLER_350_197 VPWR VGND sg13cmos5l_fill_2
XANTENNA__1395__GATE Tile_X0Y5_FrameStrobe[4] VPWR VGND sg13cmos5l_antennanp
XFILLER_102_131 VPWR VGND sg13cmos5l_decap_8
XFILLER_163_69 VPWR VGND sg13cmos5l_decap_8
XFILLER_102_164 VPWR VGND sg13cmos5l_decap_8
XFILLER_56_34 VPWR VGND sg13cmos5l_fill_1
XANTENNA__0196__D Tile_X0Y0_FrameData[2] VPWR VGND sg13cmos5l_antennanp
XFILLER_263_149 VPWR VGND sg13cmos5l_decap_4
XFILLER_16_148 VPWR VGND sg13cmos5l_fill_2
XFILLER_31_107 VPWR VGND sg13cmos5l_fill_1
XANTENNA__0924__D Tile_X0Y3_FrameData[26] VPWR VGND sg13cmos5l_antennanp
XANTENNA__2802__A1 Tile_X0Y5_N4END[3] VPWR VGND sg13cmos5l_antennanp
XFILLER_169_131 VPWR VGND sg13cmos5l_decap_8
XFILLER_72_66 VPWR VGND sg13cmos5l_decap_8
XFILLER_31_129 VPWR VGND sg13cmos5l_decap_8
XANTENNA__1333__GATE Tile_X0Y5_FrameStrobe[2] VPWR VGND sg13cmos5l_antennanp
XFILLER_184_101 VPWR VGND sg13cmos5l_fill_1
XFILLER_184_123 VPWR VGND sg13cmos5l_decap_8
XFILLER_338_36 VPWR VGND sg13cmos5l_decap_8
XANTENNA__2053__X Tile_X0Y5_S2BEG[2] VPWR VGND sg13cmos5l_antennanp
XANTENNA__2566__A0 Tile_X0Y4_W1END[0] VPWR VGND sg13cmos5l_antennanp
XANTENNA__1892__X Tile_X0Y1_FrameData_O[5] VPWR VGND sg13cmos5l_antennanp
XFILLER_184_178 VPWR VGND sg13cmos5l_decap_8
XANTENNA__1348__GATE Tile_X0Y5_FrameStrobe[2] VPWR VGND sg13cmos5l_antennanp
XANTENNA__2581__A3 Tile_X0Y0_S4END[15] VPWR VGND sg13cmos5l_antennanp
XANTENNA__2318__A0 AXIL_S_SOC_WDATA5 VPWR VGND sg13cmos5l_antennanp
XFILLER_98_107 VPWR VGND sg13cmos5l_decap_8
XFILLER_354_57 VPWR VGND sg13cmos5l_decap_8
XFILLER_97_52 VPWR VGND sg13cmos5l_decap_4
X_0360_ _0360_/Q Tile_X0Y1_FrameData[14] VGND VPWR Tile_X0Y5_FrameStrobe[1] latch
XANTENNA__1490__D Tile_X0Y5_FrameData[30] VPWR VGND sg13cmos5l_antennanp
X_0291_ _0291_/Q Tile_X0Y0_FrameData[3] VGND VPWR Tile_X0Y5_FrameStrobe[6] latch
X_2030_ Tile_X0Y5_FrameData_O[15] Tile_X0Y5_FrameData[15] VPWR VGND sg13cmos5l_buf_1
XANTENNA__0542__GATE Tile_X0Y5_FrameStrobe[7] VPWR VGND sg13cmos5l_antennanp
XFILLER_262_171 VPWR VGND sg13cmos5l_decap_8
XANTENNA__0834__D Tile_X0Y3_FrameData[20] VPWR VGND sg13cmos5l_antennanp
XFILLER_210_208 VPWR VGND sg13cmos5l_fill_1
XFILLER_175_123 VPWR VGND sg13cmos5l_decap_8
XFILLER_175_134 VPWR VGND sg13cmos5l_fill_1
XFILLER_87_2 VPWR VGND sg13cmos5l_fill_1
XFILLER_309_128 VPWR VGND sg13cmos5l_fill_1
XANTENNA__0557__GATE Tile_X0Y5_FrameStrobe[0] VPWR VGND sg13cmos5l_antennanp
XANTENNA__2557__A0 Tile_X0Y3_W1END[2] VPWR VGND sg13cmos5l_antennanp
XFILLER_175_156 VPWR VGND sg13cmos5l_decap_8
X_1814_ Tile_X0Y4_E6BEG[9] _2658_/X VPWR VGND sg13cmos5l_buf_1
X_2794_ _2794_/X Tile_X0Y4_W1END[1] Tile_X0Y4_W6END[9] _2692_/X _2670_/X _1130_/Q
+ _1129_/Q VPWR VGND sg13cmos5l_mux4_1
XFILLER_30_195 VPWR VGND sg13cmos5l_decap_8
X_1745_ Tile_X0Y2_FrameData_O[5] Tile_X0Y2_FrameData[5] VPWR VGND sg13cmos5l_buf_1
XFILLER_7_50 VPWR VGND sg13cmos5l_fill_2
XFILLER_317_161 VPWR VGND sg13cmos5l_decap_8
XFILLER_264_13 VPWR VGND sg13cmos5l_fill_2
XFILLER_317_183 VPWR VGND sg13cmos5l_fill_2
XANTENNA__2309__A0 AXIL_S_SOC_WDATA0 VPWR VGND sg13cmos5l_antennanp
XFILLER_264_46 VPWR VGND sg13cmos5l_decap_8
X_1676_ Tile_X0Y0_FrameData_O[16] Tile_X0Y0_FrameData[16] VPWR VGND sg13cmos5l_buf_1
X_0627_ _0627_/Q Tile_X0Y2_FrameData[19] VGND VPWR Tile_X0Y5_FrameStrobe[2] latch
X_0558_ _0558_/Q Tile_X0Y2_FrameData[24] VGND VPWR Tile_X0Y5_FrameStrobe[0] latch
XFILLER_97_184 VPWR VGND sg13cmos5l_fill_1
XFILLER_344_90 VPWR VGND sg13cmos5l_decap_8
XFILLER_280_45 VPWR VGND sg13cmos5l_decap_8
X_0489_ _0489_/Q Tile_X0Y1_FrameData[13] VGND VPWR Tile_X0Y5_FrameStrobe[5] latch
X_2228_ _2228_/X _2701_/X _2689_/X _2688_/X _2710_/X _1234_/Q _1233_/Q VPWR VGND sg13cmos5l_mux4_1
XANTENNA__2138__X AXIL_S_SOC_RRESP0 VPWR VGND sg13cmos5l_antennanp
XFILLER_253_160 VPWR VGND sg13cmos5l_decap_8
XFILLER_289_10 VPWR VGND sg13cmos5l_fill_1
X_2159_ _2159_/X Tile_X0Y0_W1END[3] Tile_X0Y0_WW4END[3] Tile_X0Y0_WW4END[7] Tile_X0Y0_W6END[11]
+ _0277_/Q _0276_/Q VPWR VGND sg13cmos5l_mux4_1
XFILLER_253_171 VPWR VGND sg13cmos5l_fill_1
XANTENNA__0744__D Tile_X0Y2_FrameData[30] VPWR VGND sg13cmos5l_antennanp
XANTENNA__1977__X Tile_X0Y5_E2BEG[6] VPWR VGND sg13cmos5l_antennanp
XFILLER_289_65 VPWR VGND sg13cmos5l_decap_8
XFILLER_289_76 VPWR VGND sg13cmos5l_fill_2
XANTENNA__2796__A0 Tile_X0Y4_W1END[3] VPWR VGND sg13cmos5l_antennanp
XANTENNA__2260__A2 Tile_X0Y1_W6END[2] VPWR VGND sg13cmos5l_antennanp
XFILLER_166_123 VPWR VGND sg13cmos5l_decap_8
XFILLER_42_69 VPWR VGND sg13cmos5l_fill_2
XFILLER_42_47 VPWR VGND sg13cmos5l_fill_1
XFILLER_355_223 VPWR VGND sg13cmos5l_fill_1
XANTENNA__2548__A0 AXIL_S_SOC_ARADDR7 VPWR VGND sg13cmos5l_antennanp
XFILLER_158_47 VPWR VGND sg13cmos5l_decap_8
XFILLER_166_145 VPWR VGND sg13cmos5l_fill_2
XFILLER_174_24 VPWR VGND sg13cmos5l_fill_1
XANTENNA__0919__D Tile_X0Y3_FrameData[31] VPWR VGND sg13cmos5l_antennanp
XANTENNA__2720__A0 Tile_X0Y3_W1END[3] VPWR VGND sg13cmos5l_antennanp
XFILLER_67_88 VPWR VGND sg13cmos5l_decap_8
XFILLER_190_78 VPWR VGND sg13cmos5l_decap_8
XFILLER_229_190 VPWR VGND sg13cmos5l_decap_4
XANTENNA__2048__X Tile_X0Y5_S1BEG[1] VPWR VGND sg13cmos5l_antennanp
XFILLER_123_72 VPWR VGND sg13cmos5l_decap_8
XFILLER_177_0 VPWR VGND sg13cmos5l_fill_2
XFILLER_199_10 VPWR VGND sg13cmos5l_fill_2
XFILLER_83_65 VPWR VGND sg13cmos5l_decap_8
XANTENNA__0654__D Tile_X0Y2_FrameData[24] VPWR VGND sg13cmos5l_antennanp
XANTENNA__1272__GATE Tile_X0Y5_FrameStrobe[0] VPWR VGND sg13cmos5l_antennanp
XANTENNA__1887__X Tile_X0Y1_FrameData_O[0] VPWR VGND sg13cmos5l_antennanp
XFILLER_344_0 VPWR VGND sg13cmos5l_fill_2
XANTENNA__2787__A0 Tile_X0Y5_W1END[3] VPWR VGND sg13cmos5l_antennanp
XFILLER_16_92 VPWR VGND sg13cmos5l_decap_8
XANTENNA__2251__A2 Tile_X0Y2_W6END[6] VPWR VGND sg13cmos5l_antennanp
XANTENNA__2539__A0 AXIL_S_SOC_ARADDR2 VPWR VGND sg13cmos5l_antennanp
XANTENNA__1287__GATE Tile_X0Y5_FrameStrobe[0] VPWR VGND sg13cmos5l_antennanp
XANTENNA__1485__D Tile_X0Y5_FrameData[3] VPWR VGND sg13cmos5l_antennanp
XFILLER_172_126 VPWR VGND sg13cmos5l_decap_8
XFILLER_218_28 VPWR VGND sg13cmos5l_decap_8
XFILLER_172_137 VPWR VGND sg13cmos5l_fill_1
XFILLER_113_204 VPWR VGND sg13cmos5l_fill_2
X_1530_ Tile_X0Y3_E6BEG[4] _2545_/X VPWR VGND sg13cmos5l_buf_1
XFILLER_314_153 VPWR VGND sg13cmos5l_decap_4
XANTENNA__1210__GATE Tile_X0Y5_FrameStrobe[5] VPWR VGND sg13cmos5l_antennanp
X_1461_ _1461_/Q Tile_X0Y5_FrameData[27] VGND VPWR Tile_X0Y5_FrameStrobe[6] latch
XFILLER_234_16 VPWR VGND sg13cmos5l_decap_4
XFILLER_234_27 VPWR VGND sg13cmos5l_fill_2
XFILLER_234_49 VPWR VGND sg13cmos5l_decap_8
X_1392_ _1392_/Q Tile_X0Y5_FrameData[0] VGND VPWR Tile_X0Y5_FrameStrobe[3] latch
X_0412_ _0412_/Q Tile_X0Y1_FrameData[26] VGND VPWR Tile_X0Y5_FrameStrobe[3] latch
XANTENNA__0829__D Tile_X0Y3_FrameData[25] VPWR VGND sg13cmos5l_antennanp
X_0343_ _0343_/Q Tile_X0Y1_FrameData[31] VGND VPWR Tile_X0Y5_FrameStrobe[1] latch
XFILLER_79_162 VPWR VGND sg13cmos5l_decap_8
XANTENNA__1225__GATE Tile_X0Y5_FrameStrobe[6] VPWR VGND sg13cmos5l_antennanp
XFILLER_94_121 VPWR VGND sg13cmos5l_decap_8
X_0274_ _0274_/Q Tile_X0Y0_FrameData[20] VGND VPWR Tile_X0Y5_FrameStrobe[6] latch
XANTENNA__0481__GATE Tile_X0Y5_FrameStrobe[5] VPWR VGND sg13cmos5l_antennanp
XFILLER_235_160 VPWR VGND sg13cmos5l_decap_8
X_2013_ Tile_X0Y5_EE4BEG[14] _2755_/X VPWR VGND sg13cmos5l_buf_1
XANTENNA__0564__D Tile_X0Y2_FrameData[18] VPWR VGND sg13cmos5l_antennanp
XANTENNA__1797__X Tile_X0Y4_E2BEGb[0] VPWR VGND sg13cmos5l_antennanp
XANTENNA__2490__A2 Tile_X0Y4_W6END[7] VPWR VGND sg13cmos5l_antennanp
XFILLER_330_70 VPWR VGND sg13cmos5l_decap_4
XANTENNA__2778__A0 Tile_X0Y5_W1END[1] VPWR VGND sg13cmos5l_antennanp
XFILLER_195_207 VPWR VGND sg13cmos5l_decap_8
XFILLER_250_163 VPWR VGND sg13cmos5l_fill_1
XFILLER_259_13 VPWR VGND sg13cmos5l_decap_8
XFILLER_92_0 VPWR VGND sg13cmos5l_fill_2
XANTENNA__0496__GATE Tile_X0Y5_FrameStrobe[5] VPWR VGND sg13cmos5l_antennanp
XANTENNA__2242__A2 Tile_X0Y0_S2MID[1] VPWR VGND sg13cmos5l_antennanp
XFILLER_259_79 VPWR VGND sg13cmos5l_decap_8
XFILLER_163_104 VPWR VGND sg13cmos5l_decap_8
XANTENNA__1395__D Tile_X0Y5_FrameData[29] VPWR VGND sg13cmos5l_antennanp
X_2777_ _2777_/X Tile_X0Y5_W1END[0] Tile_X0Y5_W2MID[3] Tile_X0Y5_W2END[3] _2800_/X
+ _1348_/Q _1347_/Q VPWR VGND sg13cmos5l_mux4_1
X_1728_ Tile_X0Y0_E2BEG[0] _2165_/X VPWR VGND sg13cmos5l_buf_1
XFILLER_305_142 VPWR VGND sg13cmos5l_fill_1
XFILLER_208_83 VPWR VGND sg13cmos5l_decap_8
X_1659_ Tile_X0Y0_FrameStrobe_O[19] Tile_X0Y5_FrameStrobe[19] VPWR VGND sg13cmos5l_buf_1
XFILLER_291_44 VPWR VGND sg13cmos5l_fill_1
XANTENNA__0434__GATE Tile_X0Y5_FrameStrobe[3] VPWR VGND sg13cmos5l_antennanp
XANTENNA__0739__D Tile_X0Y2_FrameData[3] VPWR VGND sg13cmos5l_antennanp
XFILLER_144_49 VPWR VGND sg13cmos5l_decap_8
XFILLER_291_55 VPWR VGND sg13cmos5l_decap_4
XFILLER_224_60 VPWR VGND sg13cmos5l_decap_4
XFILLER_85_176 VPWR VGND sg13cmos5l_decap_8
XANTENNA__0449__GATE Tile_X0Y5_FrameStrobe[4] VPWR VGND sg13cmos5l_antennanp
XFILLER_226_160 VPWR VGND sg13cmos5l_decap_4
XFILLER_268_7 VPWR VGND sg13cmos5l_decap_4
XANTENNA__0474__D Tile_X0Y1_FrameData[28] VPWR VGND sg13cmos5l_antennanp
XANTENNA__2769__A0 Tile_X0Y5_W1END[0] VPWR VGND sg13cmos5l_antennanp
XFILLER_241_174 VPWR VGND sg13cmos5l_decap_8
XFILLER_330_6 VPWR VGND sg13cmos5l_decap_8
XANTENNA__2233__A2 Tile_X0Y0_S1END[3] VPWR VGND sg13cmos5l_antennanp
XFILLER_169_79 VPWR VGND sg13cmos5l_decap_8
XANTENNA__2044__A Tile_X0Y5_FrameData[29] VPWR VGND sg13cmos5l_antennanp
XFILLER_328_223 VPWR VGND sg13cmos5l_fill_1
XFILLER_154_104 VPWR VGND sg13cmos5l_decap_8
XFILLER_118_72 VPWR VGND sg13cmos5l_decap_8
XFILLER_311_101 VPWR VGND sg13cmos5l_fill_1
XANTENNA__0649__D Tile_X0Y2_FrameData[29] VPWR VGND sg13cmos5l_antennanp
XFILLER_294_0 VPWR VGND sg13cmos5l_fill_1
XFILLER_264_211 VPWR VGND sg13cmos5l_fill_1
XFILLER_94_20 VPWR VGND sg13cmos5l_decap_8
XFILLER_76_143 VPWR VGND sg13cmos5l_decap_8
XFILLER_224_108 VPWR VGND sg13cmos5l_decap_8
XFILLER_94_86 VPWR VGND sg13cmos5l_decap_8
XFILLER_91_113 VPWR VGND sg13cmos5l_decap_8
XFILLER_217_182 VPWR VGND sg13cmos5l_decap_8
XANTENNA__0384__D Tile_X0Y1_FrameData[22] VPWR VGND sg13cmos5l_antennanp
XFILLER_177_207 VPWR VGND sg13cmos5l_fill_1
X_0961_ _0961_/Q Tile_X0Y3_FrameData[21] VGND VPWR Tile_X0Y5_FrameStrobe[5] latch
X_2700_ _2700_/X _2680_/X Tile_X0Y5_N4END[7] _2679_/X _0025_/X _1072_/Q _1071_/Q VPWR
+ VGND sg13cmos5l_mux4_1
X_0892_ _0892_/Q Tile_X0Y3_FrameData[26] VGND VPWR Tile_X0Y5_FrameStrobe[3] latch
X_2631_ _2631_/X AXIL_S_SOC_WSTRB0 AXIL_S_SOC_WSTRB2 _2709_/X _2682_/X _1192_/Q _1191_/Q
+ VPWR VGND sg13cmos5l_mux4_1
X_2562_ _2562_/X _2568_/X _2567_/X Tile_X0Y3_W6END[1] _2562_/A3 _0796_/Q _0795_/Q
+ VPWR VGND sg13cmos5l_mux4_1
XFILLER_299_130 VPWR VGND sg13cmos5l_fill_2
XFILLER_153_181 VPWR VGND sg13cmos5l_decap_8
X_1513_ _2789_/A3 VPWR VGND sg13cmos5l_tielo
X_2493_ _2493_/X Tile_X0Y1_W2MID[5] Tile_X0Y1_W2END[5] Tile_X0Y1_W6END[10] _2375_/X
+ _0406_/Q _0405_/Q VPWR VGND sg13cmos5l_mux4_1
XANTENNA__0559__D Tile_X0Y2_FrameData[23] VPWR VGND sg13cmos5l_antennanp
X_1444_ _1444_/Q Tile_X0Y5_FrameData[12] VGND VPWR Tile_X0Y5_FrameStrobe[5] latch
XANTENNA__1164__GATE Tile_X0Y5_FrameStrobe[4] VPWR VGND sg13cmos5l_antennanp
XFILLER_261_14 VPWR VGND sg13cmos5l_fill_2
X_1375_ _1375_/Q Tile_X0Y5_FrameData[17] VGND VPWR Tile_X0Y5_FrameStrobe[3] latch
X_0326_ _0326_/Q Tile_X0Y1_FrameData[16] VGND VPWR Tile_X0Y5_FrameStrobe[0] latch
X_0257_ _0257_/Q Tile_X0Y0_FrameData[5] VGND VPWR Tile_X0Y5_FrameStrobe[5] latch
XANTENNA__1179__GATE Tile_X0Y5_FrameStrobe[4] VPWR VGND sg13cmos5l_antennanp
XANTENNA__0294__D Tile_X0Y0_FrameData[0] VPWR VGND sg13cmos5l_antennanp
XFILLER_23_213 VPWR VGND sg13cmos5l_fill_2
X_0188_ _0188_/Q Tile_X0Y0_FrameData[10] VGND VPWR Tile_X0Y5_FrameStrobe[3] latch
XFILLER_210_40 VPWR VGND sg13cmos5l_fill_2
XFILLER_90_190 VPWR VGND sg13cmos5l_fill_1
XANTENNA__1102__GATE Tile_X0Y5_FrameStrobe[2] VPWR VGND sg13cmos5l_antennanp
XFILLER_23_27 VPWR VGND sg13cmos5l_fill_2
XFILLER_286_22 VPWR VGND sg13cmos5l_fill_2
X_2829_ _2829_/X Tile_X0Y4_W2MID[7] Tile_X0Y4_W2END[7] Tile_X0Y4_W6END[8] _2708_/X
+ _1124_/Q _1123_/Q VPWR VGND sg13cmos5l_mux4_1
XANTENNA__1117__GATE Tile_X0Y5_FrameStrobe[2] VPWR VGND sg13cmos5l_antennanp
XFILLER_219_82 VPWR VGND sg13cmos5l_decap_8
XFILLER_151_118 VPWR VGND sg13cmos5l_fill_2
XANTENNA__0373__GATE Tile_X0Y5_FrameStrobe[1] VPWR VGND sg13cmos5l_antennanp
XANTENNA__1990__X Tile_X0Y5_E6BEG[3] VPWR VGND sg13cmos5l_antennanp
XANTENNA__0469__D Tile_X0Y1_FrameData[1] VPWR VGND sg13cmos5l_antennanp
XFILLER_171_14 VPWR VGND sg13cmos5l_fill_2
XFILLER_171_25 VPWR VGND sg13cmos5l_fill_1
XANTENNA__0388__GATE Tile_X0Y5_FrameStrobe[2] VPWR VGND sg13cmos5l_antennanp
XANTENNA__2151__A1 Tile_X0Y0_W2END[1] VPWR VGND sg13cmos5l_antennanp
XANTENNA__2039__A Tile_X0Y5_FrameData[24] VPWR VGND sg13cmos5l_antennanp
XFILLER_104_63 VPWR VGND sg13cmos5l_decap_8
XFILLER_73_124 VPWR VGND sg13cmos5l_fill_1
XFILLER_73_146 VPWR VGND sg13cmos5l_decap_8
XFILLER_64_23 VPWR VGND sg13cmos5l_fill_2
XANTENNA__0311__GATE Tile_X0Y5_FrameStrobe[0] VPWR VGND sg13cmos5l_antennanp
XANTENNA__2454__A2 Tile_X0Y2_W6END[1] VPWR VGND sg13cmos5l_antennanp
XANTENNA__0941__GATE Tile_X0Y5_FrameStrobe[4] VPWR VGND sg13cmos5l_antennanp
XFILLER_159_207 VPWR VGND sg13cmos5l_decap_8
XFILLER_214_152 VPWR VGND sg13cmos5l_decap_8
XANTENNA__0932__D Tile_X0Y3_FrameData[18] VPWR VGND sg13cmos5l_antennanp
XANTENNA__0326__GATE Tile_X0Y5_FrameStrobe[0] VPWR VGND sg13cmos5l_antennanp
XFILLER_80_77 VPWR VGND sg13cmos5l_decap_4
XANTENNA__0956__GATE Tile_X0Y5_FrameStrobe[5] VPWR VGND sg13cmos5l_antennanp
XFILLER_182_221 VPWR VGND sg13cmos5l_fill_2
XFILLER_346_14 VPWR VGND sg13cmos5l_decap_8
XANTENNA__2061__X Tile_X0Y5_S2BEGb[2] VPWR VGND sg13cmos5l_antennanp
XFILLER_127_159 VPWR VGND sg13cmos5l_decap_8
XFILLER_129_71 VPWR VGND sg13cmos5l_fill_2
XFILLER_346_47 VPWR VGND sg13cmos5l_decap_8
XFILLER_135_170 VPWR VGND sg13cmos5l_decap_8
XFILLER_142_118 VPWR VGND sg13cmos5l_decap_8
XANTENNA__2390__A1 Tile_X0Y3_W2END[3] VPWR VGND sg13cmos5l_antennanp
XFILLER_150_140 VPWR VGND sg13cmos5l_decap_8
XFILLER_89_86 VPWR VGND sg13cmos5l_decap_8
XANTENNA__0379__D Tile_X0Y1_FrameData[27] VPWR VGND sg13cmos5l_antennanp
XFILLER_1_150 VPWR VGND sg13cmos5l_fill_1
XFILLER_36_8 VPWR VGND sg13cmos5l_fill_1
XFILLER_362_46 VPWR VGND sg13cmos5l_fill_2
XFILLER_49_132 VPWR VGND sg13cmos5l_fill_2
XFILLER_296_166 VPWR VGND sg13cmos5l_decap_8
XANTENNA__2142__A1 Tile_X0Y0_W6END[5] VPWR VGND sg13cmos5l_antennanp
XFILLER_237_222 VPWR VGND sg13cmos5l_fill_2
X_1160_ _1160_/Q Tile_X0Y4_FrameData[30] VGND VPWR Tile_X0Y5_FrameStrobe[4] latch
XFILLER_49_165 VPWR VGND sg13cmos5l_decap_8
X_0111_ _0111_/Q Tile_X0Y0_FrameData[23] VGND VPWR Tile_X0Y5_FrameStrobe[1] latch
XFILLER_64_113 VPWR VGND sg13cmos5l_decap_8
XFILLER_38_90 VPWR VGND sg13cmos5l_fill_1
XFILLER_161_91 VPWR VGND sg13cmos5l_decap_8
X_1091_ _1091_/Q Tile_X0Y4_FrameData[3] VGND VPWR Tile_X0Y5_FrameStrobe[1] latch
XFILLER_64_157 VPWR VGND sg13cmos5l_fill_1
XANTENNA__2445__A2 Tile_X0Y2_WW4END[12] VPWR VGND sg13cmos5l_antennanp
X_0042_ _2067_/A _2445_/X _2446_/X _0632_/Q VPWR VGND sg13cmos5l_mux2_1
XANTENNA__0909__GATE Tile_X0Y5_FrameStrobe[3] VPWR VGND sg13cmos5l_antennanp
XANTENNA__1003__D Tile_X0Y3_FrameData[11] VPWR VGND sg13cmos5l_antennanp
XFILLER_205_196 VPWR VGND sg13cmos5l_decap_8
XANTENNA__0842__D Tile_X0Y3_FrameData[12] VPWR VGND sg13cmos5l_antennanp
X_1993_ Tile_X0Y5_E6BEG[6] _2763_/X VPWR VGND sg13cmos5l_buf_1
X_0944_ _0944_/Q Tile_X0Y3_FrameData[6] VGND VPWR Tile_X0Y5_FrameStrobe[4] latch
XFILLER_256_14 VPWR VGND sg13cmos5l_decap_8
X_0875_ _0875_/Q Tile_X0Y3_FrameData[11] VGND VPWR Tile_X0Y5_FrameStrobe[2] latch
XFILLER_133_107 VPWR VGND sg13cmos5l_decap_8
X_2614_ _2614_/X _2676_/X _2675_/X AXIL_S_SOC_WSTRB0 AXIL_S_SOC_WSTRB3 _1226_/Q _1225_/Q
+ VPWR VGND sg13cmos5l_mux4_1
XFILLER_55_0 VPWR VGND sg13cmos5l_fill_1
XANTENNA__2381__A1 Tile_X0Y0_W2END[7] VPWR VGND sg13cmos5l_antennanp
X_2545_ _2545_/X AXIL_S_SOC_ARADDR4 _2581_/X _2574_/X _2589_/X _0914_/Q _0913_/Q VPWR
+ VGND sg13cmos5l_mux4_1
XFILLER_141_151 VPWR VGND sg13cmos5l_decap_8
XFILLER_272_24 VPWR VGND sg13cmos5l_decap_8
X_2476_ _2476_/X _2462_/X Tile_X0Y5_N4END[14] _2461_/X Tile_X0Y0_S4END[10] _0602_/Q
+ _0601_/Q VPWR VGND sg13cmos5l_mux4_1
XANTENNA__0289__D Tile_X0Y0_FrameData[5] VPWR VGND sg13cmos5l_antennanp
XFILLER_228_200 VPWR VGND sg13cmos5l_fill_1
X_1427_ _1427_/Q Tile_X0Y5_FrameData[29] VGND VPWR Tile_X0Y5_FrameStrobe[5] latch
XANTENNA__2133__A1 Tile_X0Y0_W2END[3] VPWR VGND sg13cmos5l_antennanp
XFILLER_141_28 VPWR VGND sg13cmos5l_decap_8
XFILLER_205_84 VPWR VGND sg13cmos5l_decap_8
X_1358_ _1358_/Q Tile_X0Y5_FrameData[2] VGND VPWR Tile_X0Y5_FrameStrobe[2] latch
XFILLER_55_102 VPWR VGND sg13cmos5l_decap_8
X_1289_ _1289_/Q Tile_X0Y5_FrameData[7] VGND VPWR Tile_X0Y5_FrameStrobe[0] latch
X_0309_ _0309_/Q Tile_X0Y0_FrameData[17] VGND VPWR Tile_X0Y5_FrameStrobe[7] latch
XFILLER_55_146 VPWR VGND sg13cmos5l_fill_2
XANTENNA__1041__GATE Tile_X0Y5_FrameStrobe[0] VPWR VGND sg13cmos5l_antennanp
XFILLER_70_149 VPWR VGND sg13cmos5l_decap_8
XFILLER_70_127 VPWR VGND sg13cmos5l_fill_1
XFILLER_211_122 VPWR VGND sg13cmos5l_decap_8
XFILLER_211_133 VPWR VGND sg13cmos5l_decap_8
XFILLER_297_43 VPWR VGND sg13cmos5l_decap_4
XANTENNA__0752__D Tile_X0Y2_FrameData[22] VPWR VGND sg13cmos5l_antennanp
XANTENNA__1985__X Tile_X0Y5_E2BEGb[6] VPWR VGND sg13cmos5l_antennanp
XFILLER_357_159 VPWR VGND sg13cmos5l_decap_8
XANTENNA__1056__GATE Tile_X0Y5_FrameStrobe[0] VPWR VGND sg13cmos5l_antennanp
XFILLER_109_126 VPWR VGND sg13cmos5l_decap_4
XFILLER_166_36 VPWR VGND sg13cmos5l_fill_2
XFILLER_117_170 VPWR VGND sg13cmos5l_fill_1
XFILLER_117_181 VPWR VGND sg13cmos5l_decap_8
XFILLER_132_140 VPWR VGND sg13cmos5l_fill_1
XFILLER_182_13 VPWR VGND sg13cmos5l_decap_8
XFILLER_278_155 VPWR VGND sg13cmos5l_fill_1
XANTENNA__0199__D Tile_X0Y0_FrameData[31] VPWR VGND sg13cmos5l_antennanp
XFILLER_182_46 VPWR VGND sg13cmos5l_decap_8
XFILLER_59_89 VPWR VGND sg13cmos5l_fill_1
XANTENNA__2124__A1 Tile_X0Y1_W2END[2] VPWR VGND sg13cmos5l_antennanp
XFILLER_115_51 VPWR VGND sg13cmos5l_decap_8
XANTENNA__0927__D Tile_X0Y3_FrameData[23] VPWR VGND sg13cmos5l_antennanp
XFILLER_75_55 VPWR VGND sg13cmos5l_decap_8
XFILLER_46_124 VPWR VGND sg13cmos5l_fill_2
XFILLER_271_2 VPWR VGND sg13cmos5l_fill_1
XFILLER_75_77 VPWR VGND sg13cmos5l_fill_1
XANTENNA__0250__GATE Tile_X0Y5_FrameStrobe[5] VPWR VGND sg13cmos5l_antennanp
XANTENNA__0880__GATE Tile_X0Y5_FrameStrobe[2] VPWR VGND sg13cmos5l_antennanp
XFILLER_61_116 VPWR VGND sg13cmos5l_fill_1
XANTENNA__1009__GATE Tile_X0Y5_FrameStrobe[6] VPWR VGND sg13cmos5l_antennanp
XANTENNA__2056__X Tile_X0Y5_S2BEG[5] VPWR VGND sg13cmos5l_antennanp
XFILLER_257_0 VPWR VGND sg13cmos5l_fill_1
XFILLER_61_138 VPWR VGND sg13cmos5l_fill_2
XFILLER_202_122 VPWR VGND sg13cmos5l_decap_8
XANTENNA__0265__GATE Tile_X0Y5_FrameStrobe[6] VPWR VGND sg13cmos5l_antennanp
XANTENNA__0662__D Tile_X0Y2_FrameData[16] VPWR VGND sg13cmos5l_antennanp
XANTENNA__1895__X Tile_X0Y1_FrameData_O[8] VPWR VGND sg13cmos5l_antennanp
XFILLER_348_137 VPWR VGND sg13cmos5l_decap_8
XANTENNA__0895__GATE Tile_X0Y5_FrameStrobe[3] VPWR VGND sg13cmos5l_antennanp
XFILLER_202_199 VPWR VGND sg13cmos5l_decap_8
XFILLER_115_107 VPWR VGND sg13cmos5l_decap_8
X_0660_ _0660_/Q Tile_X0Y2_FrameData[18] VGND VPWR Tile_X0Y5_FrameStrobe[3] latch
XANTENNA__1493__D Tile_X0Y5_FrameData[27] VPWR VGND sg13cmos5l_antennanp
XANTENNA__2363__A1 Tile_X0Y5_WW4END[3] VPWR VGND sg13cmos5l_antennanp
XFILLER_108_192 VPWR VGND sg13cmos5l_decap_8
X_0591_ _0591_/Q Tile_X0Y2_FrameData[23] VGND VPWR Tile_X0Y5_FrameStrobe[1] latch
X_2330_ _2330_/X AXIL_S_SOC_WDATA5 _2366_/X _2354_/X _2374_/X _0432_/Q _0431_/Q VPWR
+ VGND sg13cmos5l_mux4_1
XANTENNA__0203__GATE Tile_X0Y5_FrameStrobe[4] VPWR VGND sg13cmos5l_antennanp
X_2261_ _2261_/X Tile_X0Y2_W2MID[1] Tile_X0Y2_W2END[1] Tile_X0Y2_W6END[1] _2487_/X
+ _0770_/Q _0769_/Q VPWR VGND sg13cmos5l_mux4_1
XANTENNA__0833__GATE Tile_X0Y5_FrameStrobe[1] VPWR VGND sg13cmos5l_antennanp
XANTENNA__2115__A1 Tile_X0Y2_W2END[1] VPWR VGND sg13cmos5l_antennanp
XFILLER_284_125 VPWR VGND sg13cmos5l_decap_8
XFILLER_284_147 VPWR VGND sg13cmos5l_fill_2
X_1212_ _1212_/Q Tile_X0Y4_FrameData[10] VGND VPWR Tile_X0Y5_FrameStrobe[5] latch
XFILLER_84_208 VPWR VGND sg13cmos5l_decap_4
XANTENNA__0837__D Tile_X0Y3_FrameData[17] VPWR VGND sg13cmos5l_antennanp
X_2192_ _2192_/X AXIL_S_SOC_WDATA23 AXIL_S_SOC_WDATA27 _2239_/X _2245_/X _0212_/Q
+ _0211_/Q VPWR VGND sg13cmos5l_mux4_1
XANTENNA__0218__GATE Tile_X0Y5_FrameStrobe[4] VPWR VGND sg13cmos5l_antennanp
XFILLER_225_214 VPWR VGND sg13cmos5l_fill_1
X_1143_ _1143_/Q Tile_X0Y4_FrameData[15] VGND VPWR Tile_X0Y5_FrameStrobe[3] latch
XFILLER_37_135 VPWR VGND sg13cmos5l_decap_4
XANTENNA__0848__GATE Tile_X0Y5_FrameStrobe[1] VPWR VGND sg13cmos5l_antennanp
X_1074_ _1074_/Q Tile_X0Y4_FrameData[20] VGND VPWR Tile_X0Y5_FrameStrobe[1] latch
XFILLER_52_105 VPWR VGND sg13cmos5l_decap_8
XFILLER_322_82 VPWR VGND sg13cmos5l_decap_4
XFILLER_240_217 VPWR VGND sg13cmos5l_fill_1
X_0025_ _0025_/X _2698_/X _2699_/X _0143_/Q VPWR VGND sg13cmos5l_mux2_1
XFILLER_45_190 VPWR VGND sg13cmos5l_fill_2
XFILLER_339_104 VPWR VGND sg13cmos5l_fill_1
XANTENNA__0572__D Tile_X0Y2_FrameData[10] VPWR VGND sg13cmos5l_antennanp
XFILLER_339_126 VPWR VGND sg13cmos5l_decap_8
X_1976_ Tile_X0Y5_E2BEG[5] _2730_/X VPWR VGND sg13cmos5l_buf_1
X_0927_ _0927_/Q Tile_X0Y3_FrameData[23] VGND VPWR Tile_X0Y5_FrameStrobe[4] latch
XFILLER_354_129 VPWR VGND sg13cmos5l_decap_8
XFILLER_347_181 VPWR VGND sg13cmos5l_fill_1
XFILLER_106_129 VPWR VGND sg13cmos5l_decap_4
XFILLER_283_12 VPWR VGND sg13cmos5l_decap_8
X_0858_ _0858_/Q Tile_X0Y3_FrameData[28] VGND VPWR Tile_X0Y5_FrameStrobe[2] latch
XFILLER_362_173 VPWR VGND sg13cmos5l_decap_8
X_0789_ _0789_/Q Tile_X0Y2_FrameData[17] VGND VPWR Tile_X0Y5_FrameStrobe[7] latch
XFILLER_114_162 VPWR VGND sg13cmos5l_decap_8
X_2528_ _2528_/X AXIL_S_SOC_ARADDR3 AXIL_S_SOC_ARADDR5 _2579_/X _2593_/X _0948_/Q
+ _0947_/Q VPWR VGND sg13cmos5l_mux4_1
XFILLER_216_72 VPWR VGND sg13cmos5l_fill_1
XFILLER_275_114 VPWR VGND sg13cmos5l_decap_8
XANTENNA__2106__A1 Tile_X0Y3_W2END[0] VPWR VGND sg13cmos5l_antennanp
XFILLER_195_9 VPWR VGND sg13cmos5l_fill_1
XFILLER_216_94 VPWR VGND sg13cmos5l_decap_8
X_2459_ _2459_/X Tile_X0Y1_W1END[1] Tile_X0Y1_W6END[9] _2357_/X _2338_/X _0416_/Q
+ _0415_/Q VPWR VGND sg13cmos5l_mux4_1
XANTENNA__0747__D Tile_X0Y2_FrameData[27] VPWR VGND sg13cmos5l_antennanp
XFILLER_28_102 VPWR VGND sg13cmos5l_decap_8
XFILLER_28_146 VPWR VGND sg13cmos5l_fill_1
XFILLER_28_168 VPWR VGND sg13cmos5l_decap_8
XFILLER_45_36 VPWR VGND sg13cmos5l_fill_1
XANTENNA__0482__D Tile_X0Y1_FrameData[20] VPWR VGND sg13cmos5l_antennanp
XFILLER_243_6 VPWR VGND sg13cmos5l_decap_8
XFILLER_61_24 VPWR VGND sg13cmos5l_fill_1
XFILLER_51_171 VPWR VGND sg13cmos5l_fill_2
XFILLER_177_24 VPWR VGND sg13cmos5l_fill_2
XFILLER_137_221 VPWR VGND sg13cmos5l_fill_2
XFILLER_196_187 VPWR VGND sg13cmos5l_fill_1
XFILLER_345_118 VPWR VGND sg13cmos5l_decap_8
XFILLER_152_202 VPWR VGND sg13cmos5l_decap_8
XANTENNA__1891__A Tile_X0Y1_FrameData[4] VPWR VGND sg13cmos5l_antennanp
XFILLER_193_45 VPWR VGND sg13cmos5l_fill_2
XFILLER_3_223 VPWR VGND sg13cmos5l_fill_1
XFILLER_353_195 VPWR VGND sg13cmos5l_decap_8
XANTENNA__2345__A1 Tile_X0Y0_W6END[10] VPWR VGND sg13cmos5l_antennanp
XFILLER_105_151 VPWR VGND sg13cmos5l_decap_8
XFILLER_126_50 VPWR VGND sg13cmos5l_fill_2
XFILLER_86_43 VPWR VGND sg13cmos5l_decap_8
XFILLER_266_158 VPWR VGND sg13cmos5l_decap_8
XANTENNA__0657__D Tile_X0Y2_FrameData[21] VPWR VGND sg13cmos5l_antennanp
XFILLER_142_60 VPWR VGND sg13cmos5l_fill_1
XANTENNA__0392__D Tile_X0Y1_FrameData[14] VPWR VGND sg13cmos5l_antennanp
XANTENNA__1488__D Tile_X0Y5_FrameData[0] VPWR VGND sg13cmos5l_antennanp
XANTENNA__2281__A0 Tile_X0Y3_W1END[3] VPWR VGND sg13cmos5l_antennanp
XFILLER_187_132 VPWR VGND sg13cmos5l_decap_8
X_1830_ Tile_X0Y4_EE4BEG[13] _2646_/X VPWR VGND sg13cmos5l_buf_1
XFILLER_336_107 VPWR VGND sg13cmos5l_fill_2
XANTENNA__2584__A1 Tile_X0Y5_N4END[10] VPWR VGND sg13cmos5l_antennanp
X_1761_ Tile_X0Y2_FrameData_O[21] Tile_X0Y2_FrameData[21] VPWR VGND sg13cmos5l_buf_1
X_1692_ Tile_X0Y0_EE4BEG[0] _2181_/X VPWR VGND sg13cmos5l_buf_1
X_0712_ _0712_/Q Tile_X0Y2_FrameData[30] VGND VPWR Tile_X0Y5_FrameStrobe[5] latch
X_0643_ _0643_/Q Tile_X0Y2_FrameData[3] VGND VPWR Tile_X0Y5_FrameStrobe[2] latch
XANTENNA__0142__GATE Tile_X0Y5_FrameStrobe[2] VPWR VGND sg13cmos5l_antennanp
XANTENNA__0772__GATE Tile_X0Y5_FrameStrobe[6] VPWR VGND sg13cmos5l_antennanp
XFILLER_257_103 VPWR VGND sg13cmos5l_fill_2
X_2313_ _2313_/X AXIL_S_SOC_WDATA4 AXIL_S_SOC_WDATA8 _2350_/X _2376_/X _0466_/Q _0465_/Q
+ VPWR VGND sg13cmos5l_mux4_1
X_0574_ _0574_/Q Tile_X0Y2_FrameData[8] VGND VPWR Tile_X0Y5_FrameStrobe[0] latch
XFILLER_111_143 VPWR VGND sg13cmos5l_decap_8
XANTENNA__0157__GATE Tile_X0Y5_FrameStrobe[2] VPWR VGND sg13cmos5l_antennanp
X_2244_ _2244_/X _2256_/X _2255_/X Tile_X0Y0_S2MID[3] Tile_X0Y0_S2END[3] _0088_/Q
+ _0087_/Q VPWR VGND sg13cmos5l_mux4_1
XANTENNA__0567__D Tile_X0Y2_FrameData[15] VPWR VGND sg13cmos5l_antennanp
XANTENNA__0787__GATE Tile_X0Y5_FrameStrobe[7] VPWR VGND sg13cmos5l_antennanp
XFILLER_18_0 VPWR VGND sg13cmos5l_fill_1
X_2175_ _2175_/X AXIL_S_SOC_WDATA18 AXIL_S_SOC_WDATA26 _2243_/X _2246_/X _0246_/Q
+ _0245_/Q VPWR VGND sg13cmos5l_mux4_1
XFILLER_333_92 VPWR VGND sg13cmos5l_decap_8
X_1126_ _1126_/Q Tile_X0Y4_FrameData[0] VGND VPWR Tile_X0Y5_FrameStrobe[2] latch
XFILLER_80_222 VPWR VGND sg13cmos5l_fill_2
XANTENNA__0710__GATE Tile_X0Y5_FrameStrobe[4] VPWR VGND sg13cmos5l_antennanp
XFILLER_15_39 VPWR VGND sg13cmos5l_fill_2
XFILLER_202_85 VPWR VGND sg13cmos5l_decap_8
XFILLER_280_194 VPWR VGND sg13cmos5l_fill_1
X_1057_ _1057_/Q Tile_X0Y4_FrameData[5] VGND VPWR Tile_X0Y5_FrameStrobe[0] latch
XANTENNA__1398__D Tile_X0Y5_FrameData[26] VPWR VGND sg13cmos5l_antennanp
XANTENNA__2811__A2 Tile_X0Y1_WW4END[14] VPWR VGND sg13cmos5l_antennanp
XFILLER_178_154 VPWR VGND sg13cmos5l_decap_8
XFILLER_193_135 VPWR VGND sg13cmos5l_fill_1
XANTENNA__0725__GATE Tile_X0Y5_FrameStrobe[5] VPWR VGND sg13cmos5l_antennanp
XANTENNA__2575__A1 Tile_X0Y5_N4END[10] VPWR VGND sg13cmos5l_antennanp
XFILLER_193_168 VPWR VGND sg13cmos5l_decap_8
X_1959_ Tile_X0Y1_E2BEG[4] _2297_/X VPWR VGND sg13cmos5l_buf_1
XFILLER_294_33 VPWR VGND sg13cmos5l_decap_4
XFILLER_294_55 VPWR VGND sg13cmos5l_decap_4
XFILLER_294_88 VPWR VGND sg13cmos5l_fill_2
XANTENNA__2327__A1 Tile_X0Y0_S4END[6] VPWR VGND sg13cmos5l_antennanp
XFILLER_243_70 VPWR VGND sg13cmos5l_fill_2
XANTENNA__0477__D Tile_X0Y1_FrameData[25] VPWR VGND sg13cmos5l_antennanp
XFILLER_112_41 VPWR VGND sg13cmos5l_fill_1
XFILLER_16_127 VPWR VGND sg13cmos5l_fill_2
XFILLER_204_217 VPWR VGND sg13cmos5l_fill_1
XFILLER_112_63 VPWR VGND sg13cmos5l_decap_8
XFILLER_72_12 VPWR VGND sg13cmos5l_decap_8
XANTENNA__2263__A0 Tile_X0Y2_W2MID[0] VPWR VGND sg13cmos5l_antennanp
XFILLER_188_12 VPWR VGND sg13cmos5l_fill_1
XFILLER_72_45 VPWR VGND sg13cmos5l_decap_8
XFILLER_358_221 VPWR VGND sg13cmos5l_fill_2
XANTENNA__1101__D Tile_X0Y4_FrameData[25] VPWR VGND sg13cmos5l_antennanp
XANTENNA__1886__A Tile_X0Y1_UserCLK VPWR VGND sg13cmos5l_antennanp
XFILLER_169_165 VPWR VGND sg13cmos5l_decap_4
XFILLER_188_45 VPWR VGND sg13cmos5l_decap_8
XFILLER_24_182 VPWR VGND sg13cmos5l_fill_2
XFILLER_169_198 VPWR VGND sg13cmos5l_decap_8
XFILLER_184_113 VPWR VGND sg13cmos5l_fill_2
XFILLER_188_89 VPWR VGND sg13cmos5l_fill_2
XANTENNA__0940__D Tile_X0Y3_FrameData[10] VPWR VGND sg13cmos5l_antennanp
XANTENNA__2566__A1 Tile_X0Y4_W6END[4] VPWR VGND sg13cmos5l_antennanp
XFILLER_125_213 VPWR VGND sg13cmos5l_fill_2
XFILLER_326_140 VPWR VGND sg13cmos5l_fill_1
XFILLER_207_19 VPWR VGND sg13cmos5l_decap_8
XANTENNA__2318__A1 AXIL_S_SOC_WDATA9 VPWR VGND sg13cmos5l_antennanp
XFILLER_137_71 VPWR VGND sg13cmos5l_decap_8
XFILLER_97_31 VPWR VGND sg13cmos5l_decap_8
XFILLER_354_36 VPWR VGND sg13cmos5l_decap_8
XFILLER_341_154 VPWR VGND sg13cmos5l_decap_8
XFILLER_341_143 VPWR VGND sg13cmos5l_decap_4
XFILLER_97_64 VPWR VGND sg13cmos5l_decap_8
XFILLER_239_125 VPWR VGND sg13cmos5l_fill_2
XFILLER_97_97 VPWR VGND sg13cmos5l_decap_8
X_0290_ _0290_/Q Tile_X0Y0_FrameData[4] VGND VPWR Tile_X0Y5_FrameStrobe[6] latch
XANTENNA__0387__D Tile_X0Y1_FrameData[19] VPWR VGND sg13cmos5l_antennanp
XFILLER_262_150 VPWR VGND sg13cmos5l_decap_8
XFILLER_303_95 VPWR VGND sg13cmos5l_decap_8
XANTENNA__1440__GATE Tile_X0Y5_FrameStrobe[5] VPWR VGND sg13cmos5l_antennanp
XANTENNA__2254__A0 Tile_X0Y1_W2MID[5] VPWR VGND sg13cmos5l_antennanp
XFILLER_22_108 VPWR VGND sg13cmos5l_decap_8
XFILLER_22_119 VPWR VGND sg13cmos5l_fill_1
XANTENNA__1011__D Tile_X0Y3_FrameData[3] VPWR VGND sg13cmos5l_antennanp
XFILLER_175_102 VPWR VGND sg13cmos5l_decap_8
XANTENNA__0850__D Tile_X0Y3_FrameData[4] VPWR VGND sg13cmos5l_antennanp
XANTENNA__2557__A1 Tile_X0Y3_WW4END[10] VPWR VGND sg13cmos5l_antennanp
X_1813_ Tile_X0Y4_E6BEG[8] _2657_/X VPWR VGND sg13cmos5l_buf_1
X_2793_ _2793_/X Tile_X0Y4_W1END[0] Tile_X0Y4_W6END[8] _2696_/X _2669_/X _1132_/Q
+ _1131_/Q VPWR VGND sg13cmos5l_mux4_1
XFILLER_30_174 VPWR VGND sg13cmos5l_decap_8
XANTENNA__1455__GATE Tile_X0Y5_FrameStrobe[5] VPWR VGND sg13cmos5l_antennanp
X_1744_ Tile_X0Y2_FrameData_O[4] Tile_X0Y2_FrameData[4] VPWR VGND sg13cmos5l_buf_1
XFILLER_7_73 VPWR VGND sg13cmos5l_fill_1
XANTENNA__0081__GATE Tile_X0Y5_FrameStrobe[0] VPWR VGND sg13cmos5l_antennanp
XFILLER_190_149 VPWR VGND sg13cmos5l_decap_8
XFILLER_328_92 VPWR VGND sg13cmos5l_fill_2
XANTENNA__2309__A1 AXIL_S_SOC_WDATA12 VPWR VGND sg13cmos5l_antennanp
XFILLER_264_25 VPWR VGND sg13cmos5l_decap_8
X_1675_ Tile_X0Y0_FrameData_O[15] Tile_X0Y0_FrameData[15] VPWR VGND sg13cmos5l_buf_1
X_0626_ _0626_/Q Tile_X0Y2_FrameData[20] VGND VPWR Tile_X0Y5_FrameStrobe[2] latch
X_0557_ _0557_/Q Tile_X0Y2_FrameData[25] VGND VPWR Tile_X0Y5_FrameStrobe[0] latch
XANTENNA__0096__GATE Tile_X0Y5_FrameStrobe[0] VPWR VGND sg13cmos5l_antennanp
XFILLER_280_24 VPWR VGND sg13cmos5l_decap_8
XANTENNA__0297__D Tile_X0Y0_FrameData[29] VPWR VGND sg13cmos5l_antennanp
XFILLER_245_106 VPWR VGND sg13cmos5l_decap_4
X_2227_ _2227_/X Tile_X0Y4_W1END[2] Tile_X0Y4_WW4END[2] Tile_X0Y4_W6END[10] _2703_/X
+ _1234_/Q _1233_/Q VPWR VGND sg13cmos5l_mux4_1
X_0488_ _0488_/Q Tile_X0Y1_FrameData[14] VGND VPWR Tile_X0Y5_FrameStrobe[5] latch
XANTENNA__2493__A0 Tile_X0Y1_W2MID[5] VPWR VGND sg13cmos5l_antennanp
X_2158_ _2158_/X _2236_/X _2234_/X _2222_/X _2221_/X _0280_/Q _0279_/Q VPWR VGND sg13cmos5l_mux4_1
XFILLER_253_183 VPWR VGND sg13cmos5l_fill_1
XFILLER_289_44 VPWR VGND sg13cmos5l_fill_1
X_2089_ Tile_X0Y3_E2BEG[1] _2510_/X VPWR VGND sg13cmos5l_buf_1
X_1109_ _1109_/Q Tile_X0Y4_FrameData[17] VGND VPWR Tile_X0Y5_FrameStrobe[2] latch
XANTENNA__1408__GATE Tile_X0Y5_FrameStrobe[4] VPWR VGND sg13cmos5l_antennanp
XFILLER_201_209 VPWR VGND sg13cmos5l_fill_2
XANTENNA__2796__A1 Tile_X0Y4_W6END[11] VPWR VGND sg13cmos5l_antennanp
XANTENNA__0664__GATE Tile_X0Y5_FrameStrobe[3] VPWR VGND sg13cmos5l_antennanp
XFILLER_158_15 VPWR VGND sg13cmos5l_decap_4
XFILLER_158_26 VPWR VGND sg13cmos5l_decap_8
XANTENNA__0760__D Tile_X0Y2_FrameData[14] VPWR VGND sg13cmos5l_antennanp
XANTENNA__1993__X Tile_X0Y5_E6BEG[6] VPWR VGND sg13cmos5l_antennanp
XFILLER_213_7 VPWR VGND sg13cmos5l_fill_1
XFILLER_238_70 VPWR VGND sg13cmos5l_fill_1
XFILLER_238_81 VPWR VGND sg13cmos5l_decap_8
XANTENNA__0679__GATE Tile_X0Y5_FrameStrobe[4] VPWR VGND sg13cmos5l_antennanp
XFILLER_107_41 VPWR VGND sg13cmos5l_fill_2
XANTENNA__0602__GATE Tile_X0Y5_FrameStrobe[1] VPWR VGND sg13cmos5l_antennanp
XANTENNA__2720__A1 Tile_X0Y3_W2MID[0] VPWR VGND sg13cmos5l_antennanp
XFILLER_190_13 VPWR VGND sg13cmos5l_decap_8
XFILLER_88_185 VPWR VGND sg13cmos5l_decap_8
XFILLER_88_152 VPWR VGND sg13cmos5l_decap_8
XFILLER_67_67 VPWR VGND sg13cmos5l_decap_8
XFILLER_229_180 VPWR VGND sg13cmos5l_fill_2
XFILLER_340_27 VPWR VGND sg13cmos5l_fill_1
XANTENNA__0617__GATE Tile_X0Y5_FrameStrobe[2] VPWR VGND sg13cmos5l_antennanp
XFILLER_270_90 VPWR VGND sg13cmos5l_decap_8
XFILLER_83_44 VPWR VGND sg13cmos5l_decap_8
XFILLER_44_222 VPWR VGND sg13cmos5l_fill_2
XANTENNA__0935__D Tile_X0Y3_FrameData[15] VPWR VGND sg13cmos5l_antennanp
XFILLER_199_44 VPWR VGND sg13cmos5l_fill_2
XFILLER_16_71 VPWR VGND sg13cmos5l_decap_8
XANTENNA__2064__X Tile_X0Y5_S2BEGb[5] VPWR VGND sg13cmos5l_antennanp
XANTENNA__2787__A1 Tile_X0Y5_WW4END[15] VPWR VGND sg13cmos5l_antennanp
XFILLER_337_0 VPWR VGND sg13cmos5l_decap_4
XFILLER_346_213 VPWR VGND sg13cmos5l_fill_1
XFILLER_157_135 VPWR VGND sg13cmos5l_decap_8
XFILLER_8_134 VPWR VGND sg13cmos5l_fill_2
XANTENNA__0670__D Tile_X0Y2_FrameData[8] VPWR VGND sg13cmos5l_antennanp
XANTENNA__2539__A1 AXIL_S_SOC_ARADDR4 VPWR VGND sg13cmos5l_antennanp
XFILLER_172_105 VPWR VGND sg13cmos5l_decap_8
XFILLER_148_92 VPWR VGND sg13cmos5l_decap_8
X_1460_ _1460_/Q Tile_X0Y5_FrameData[28] VGND VPWR Tile_X0Y5_FrameStrobe[6] latch
XFILLER_314_176 VPWR VGND sg13cmos5l_fill_1
X_1391_ _1391_/Q Tile_X0Y5_FrameData[1] VGND VPWR Tile_X0Y5_FrameStrobe[3] latch
X_0411_ _0411_/Q Tile_X0Y1_FrameData[27] VGND VPWR Tile_X0Y5_FrameStrobe[3] latch
XFILLER_79_141 VPWR VGND sg13cmos5l_decap_8
XANTENNA__2711__A1 Tile_X0Y5_N2MID[3] VPWR VGND sg13cmos5l_antennanp
X_0342_ _0342_/Q Tile_X0Y1_FrameData[0] VGND VPWR Tile_X0Y5_FrameStrobe[0] latch
XFILLER_94_100 VPWR VGND sg13cmos5l_decap_8
XANTENNA__1006__D Tile_X0Y3_FrameData[8] VPWR VGND sg13cmos5l_antennanp
XFILLER_250_16 VPWR VGND sg13cmos5l_decap_8
X_0273_ _0273_/Q Tile_X0Y0_FrameData[21] VGND VPWR Tile_X0Y5_FrameStrobe[6] latch
XFILLER_94_177 VPWR VGND sg13cmos5l_decap_8
X_2012_ Tile_X0Y5_EE4BEG[13] _2754_/X VPWR VGND sg13cmos5l_buf_1
XFILLER_35_200 VPWR VGND sg13cmos5l_fill_1
XANTENNA__0845__D Tile_X0Y3_FrameData[9] VPWR VGND sg13cmos5l_antennanp
XANTENNA__2227__A0 Tile_X0Y4_W1END[2] VPWR VGND sg13cmos5l_antennanp
XFILLER_50_203 VPWR VGND sg13cmos5l_decap_4
XANTENNA__2778__A1 Tile_X0Y5_W2MID[2] VPWR VGND sg13cmos5l_antennanp
XANTENNA__2242__A3 Tile_X0Y0_S2END[1] VPWR VGND sg13cmos5l_antennanp
XFILLER_148_113 VPWR VGND sg13cmos5l_decap_8
XFILLER_259_58 VPWR VGND sg13cmos5l_decap_8
XFILLER_85_0 VPWR VGND sg13cmos5l_decap_4
XANTENNA__1394__GATE Tile_X0Y5_FrameStrobe[4] VPWR VGND sg13cmos5l_antennanp
XANTENNA__0580__D Tile_X0Y2_FrameData[2] VPWR VGND sg13cmos5l_antennanp
XFILLER_275_35 VPWR VGND sg13cmos5l_decap_8
X_2776_ _2776_/X Tile_X0Y5_W2MID[4] Tile_X0Y5_W2END[4] Tile_X0Y5_W6END[11] _2828_/X
+ _1350_/Q _1349_/Q VPWR VGND sg13cmos5l_mux4_1
X_1727_ Tile_X0Y0_E2BEGb[7] _2180_/X VPWR VGND sg13cmos5l_buf_1
XFILLER_171_160 VPWR VGND sg13cmos5l_decap_8
XFILLER_208_62 VPWR VGND sg13cmos5l_decap_8
X_1658_ Tile_X0Y0_FrameStrobe_O[18] Tile_X0Y5_FrameStrobe[18] VPWR VGND sg13cmos5l_buf_1
XFILLER_320_102 VPWR VGND sg13cmos5l_fill_1
XFILLER_305_176 VPWR VGND sg13cmos5l_fill_2
XFILLER_144_28 VPWR VGND sg13cmos5l_decap_8
XFILLER_291_23 VPWR VGND sg13cmos5l_fill_2
X_0609_ _0609_/Q Tile_X0Y2_FrameData[5] VGND VPWR Tile_X0Y5_FrameStrobe[1] latch
XANTENNA__2702__A1 Tile_X0Y5_N4END[7] VPWR VGND sg13cmos5l_antennanp
XFILLER_291_78 VPWR VGND sg13cmos5l_fill_2
X_1589_ Tile_X0Y2_EE4BEG[2] _2419_/X VPWR VGND sg13cmos5l_buf_1
XANTENNA__1332__GATE Tile_X0Y5_FrameStrobe[2] VPWR VGND sg13cmos5l_antennanp
XFILLER_218_117 VPWR VGND sg13cmos5l_fill_2
XFILLER_85_133 VPWR VGND sg13cmos5l_fill_1
XFILLER_224_94 VPWR VGND sg13cmos5l_decap_8
XFILLER_273_223 VPWR VGND sg13cmos5l_fill_1
XFILLER_85_155 VPWR VGND sg13cmos5l_decap_8
XANTENNA__0755__D Tile_X0Y2_FrameData[19] VPWR VGND sg13cmos5l_antennanp
XANTENNA__1347__GATE Tile_X0Y5_FrameStrobe[2] VPWR VGND sg13cmos5l_antennanp
XANTENNA__1988__X Tile_X0Y5_E6BEG[1] VPWR VGND sg13cmos5l_antennanp
XFILLER_226_172 VPWR VGND sg13cmos5l_fill_2
XFILLER_241_131 VPWR VGND sg13cmos5l_decap_8
XFILLER_41_203 VPWR VGND sg13cmos5l_decap_8
XANTENNA__2769__A1 Tile_X0Y5_W6END[8] VPWR VGND sg13cmos5l_antennanp
XFILLER_169_25 VPWR VGND sg13cmos5l_decap_8
XANTENNA__2233__A3 Tile_X0Y0_S4END[3] VPWR VGND sg13cmos5l_antennanp
XFILLER_139_135 VPWR VGND sg13cmos5l_decap_8
XANTENNA__0490__D Tile_X0Y1_FrameData[12] VPWR VGND sg13cmos5l_antennanp
XFILLER_185_13 VPWR VGND sg13cmos5l_decap_4
XFILLER_249_80 VPWR VGND sg13cmos5l_decap_8
XFILLER_154_149 VPWR VGND sg13cmos5l_decap_8
XFILLER_185_35 VPWR VGND sg13cmos5l_fill_2
XFILLER_185_57 VPWR VGND sg13cmos5l_decap_8
XFILLER_335_49 VPWR VGND sg13cmos5l_decap_8
XANTENNA__0541__GATE Tile_X0Y5_FrameStrobe[7] VPWR VGND sg13cmos5l_antennanp
XFILLER_78_44 VPWR VGND sg13cmos5l_decap_8
XFILLER_110_208 VPWR VGND sg13cmos5l_fill_2
XFILLER_311_179 VPWR VGND sg13cmos5l_fill_1
XFILLER_209_106 VPWR VGND sg13cmos5l_decap_4
XANTENNA__0556__GATE Tile_X0Y5_FrameStrobe[0] VPWR VGND sg13cmos5l_antennanp
XANTENNA__2059__X Tile_X0Y5_S2BEGb[0] VPWR VGND sg13cmos5l_antennanp
XFILLER_134_83 VPWR VGND sg13cmos5l_decap_8
XFILLER_287_0 VPWR VGND sg13cmos5l_fill_1
XFILLER_94_43 VPWR VGND sg13cmos5l_fill_1
XFILLER_351_59 VPWR VGND sg13cmos5l_decap_8
XANTENNA__2457__A0 Tile_X0Y1_W1END[0] VPWR VGND sg13cmos5l_antennanp
XANTENNA__0665__D Tile_X0Y2_FrameData[13] VPWR VGND sg13cmos5l_antennanp
XANTENNA__1898__X Tile_X0Y1_FrameData_O[11] VPWR VGND sg13cmos5l_antennanp
XANTENNA__2472__A3 Tile_X0Y0_S4END[8] VPWR VGND sg13cmos5l_antennanp
XFILLER_232_131 VPWR VGND sg13cmos5l_decap_4
XFILLER_232_186 VPWR VGND sg13cmos5l_decap_8
X_0960_ _0960_/Q Tile_X0Y3_FrameData[22] VGND VPWR Tile_X0Y5_FrameStrobe[5] latch
XFILLER_300_63 VPWR VGND sg13cmos5l_fill_2
XANTENNA__1496__D Tile_X0Y5_FrameData[24] VPWR VGND sg13cmos5l_antennanp
X_2630_ _2630_/X AXIL_S_SOC_WSTRB1 AXIL_S_SOC_BREADY _2710_/X _2683_/X _1194_/Q _1193_/Q
+ VPWR VGND sg13cmos5l_mux4_1
X_0891_ _0891_/Q Tile_X0Y3_FrameData[27] VGND VPWR Tile_X0Y5_FrameStrobe[3] latch
XFILLER_145_149 VPWR VGND sg13cmos5l_decap_4
X_2561_ _2561_/X _2566_/X _2565_/X Tile_X0Y3_W6END[0] _2561_/A3 _0798_/Q _0797_/Q
+ VPWR VGND sg13cmos5l_mux4_1
XANTENNA__0509__GATE Tile_X0Y5_FrameStrobe[6] VPWR VGND sg13cmos5l_antennanp
XFILLER_245_38 VPWR VGND sg13cmos5l_decap_8
X_1512_ _2339_/A3 VPWR VGND sg13cmos5l_tielo
X_2492_ _2492_/X Tile_X0Y4_W2MID[6] Tile_X0Y4_W2END[6] Tile_X0Y4_W6END[6] _2709_/X
+ _1254_/Q _1253_/Q VPWR VGND sg13cmos5l_mux4_1
X_1443_ _1443_/Q Tile_X0Y5_FrameData[13] VGND VPWR Tile_X0Y5_FrameStrobe[5] latch
XFILLER_4_30 VPWR VGND sg13cmos5l_fill_1
XFILLER_299_197 VPWR VGND sg13cmos5l_decap_8
XFILLER_325_82 VPWR VGND sg13cmos5l_decap_4
XFILLER_325_60 VPWR VGND sg13cmos5l_fill_1
X_1374_ _1374_/Q Tile_X0Y5_FrameData[18] VGND VPWR Tile_X0Y5_FrameStrobe[3] latch
XFILLER_67_122 VPWR VGND sg13cmos5l_decap_8
XFILLER_261_48 VPWR VGND sg13cmos5l_decap_8
X_0325_ _0325_/Q Tile_X0Y1_FrameData[17] VGND VPWR Tile_X0Y5_FrameStrobe[0] latch
X_0256_ _0256_/Q Tile_X0Y0_FrameData[6] VGND VPWR Tile_X0Y5_FrameStrobe[5] latch
XANTENNA__0575__D Tile_X0Y2_FrameData[7] VPWR VGND sg13cmos5l_antennanp
XANTENNA__1601__X Tile_X0Y2_EE4BEG[14] VPWR VGND sg13cmos5l_antennanp
XFILLER_130_19 VPWR VGND sg13cmos5l_decap_8
X_0187_ _0187_/Q Tile_X0Y0_FrameData[11] VGND VPWR Tile_X0Y5_FrameStrobe[3] latch
XANTENNA__2620__A0 AXIL_S_SOC_WSTRB3 VPWR VGND sg13cmos5l_antennanp
XFILLER_139_28 VPWR VGND sg13cmos5l_fill_1
XFILLER_191_222 VPWR VGND sg13cmos5l_fill_2
XFILLER_219_61 VPWR VGND sg13cmos5l_decap_8
X_2828_ _2828_/X Tile_X0Y5_N2MID[3] Tile_X0Y5_N2END[3] _2832_/X _2716_/X _1282_/Q
+ _1281_/Q VPWR VGND sg13cmos5l_mux4_1
X_2759_ _2759_/X Tile_X0Y5_N4END[2] _0058_/X _2810_/X _2809_/X _1384_/Q _1383_/Q VPWR
+ VGND sg13cmos5l_mux4_1
XFILLER_144_171 VPWR VGND sg13cmos5l_decap_8
XFILLER_2_129 VPWR VGND sg13cmos5l_fill_1
XANTENNA__1271__GATE Tile_X0Y5_FrameStrobe[0] VPWR VGND sg13cmos5l_antennanp
XFILLER_48_58 VPWR VGND sg13cmos5l_fill_2
XANTENNA__2151__A2 Tile_X0Y0_W6END[1] VPWR VGND sg13cmos5l_antennanp
XANTENNA__1286__GATE Tile_X0Y5_FrameStrobe[0] VPWR VGND sg13cmos5l_antennanp
XANTENNA__2439__A0 AXIL_S_SOC_AWADDR6 VPWR VGND sg13cmos5l_antennanp
XFILLER_104_42 VPWR VGND sg13cmos5l_decap_8
XFILLER_273_6 VPWR VGND sg13cmos5l_decap_4
XANTENNA__0485__D Tile_X0Y1_FrameData[17] VPWR VGND sg13cmos5l_antennanp
XFILLER_64_13 VPWR VGND sg13cmos5l_fill_1
XFILLER_214_131 VPWR VGND sg13cmos5l_decap_8
XFILLER_9_19 VPWR VGND sg13cmos5l_fill_2
XANTENNA__2611__A0 Tile_X0Y2_W1END[3] VPWR VGND sg13cmos5l_antennanp
XFILLER_80_56 VPWR VGND sg13cmos5l_decap_8
XANTENNA__1894__A Tile_X0Y1_FrameData[7] VPWR VGND sg13cmos5l_antennanp
XANTENNA__1224__GATE Tile_X0Y5_FrameStrobe[6] VPWR VGND sg13cmos5l_antennanp
XFILLER_127_116 VPWR VGND sg13cmos5l_fill_1
XFILLER_182_211 VPWR VGND sg13cmos5l_decap_4
XFILLER_202_0 VPWR VGND sg13cmos5l_fill_2
XANTENNA__0480__GATE Tile_X0Y5_FrameStrobe[5] VPWR VGND sg13cmos5l_antennanp
XFILLER_89_65 VPWR VGND sg13cmos5l_decap_8
XANTENNA__1239__GATE Tile_X0Y5_FrameStrobe[6] VPWR VGND sg13cmos5l_antennanp
XANTENNA__2390__A2 Tile_X0Y3_W6END[3] VPWR VGND sg13cmos5l_antennanp
XFILLER_296_112 VPWR VGND sg13cmos5l_decap_8
XFILLER_145_60 VPWR VGND sg13cmos5l_decap_8
XFILLER_145_71 VPWR VGND sg13cmos5l_fill_1
XFILLER_1_140 VPWR VGND sg13cmos5l_fill_2
XANTENNA__2678__A0 Tile_X0Y5_W1END[2] VPWR VGND sg13cmos5l_antennanp
XFILLER_145_93 VPWR VGND sg13cmos5l_decap_8
XFILLER_150_185 VPWR VGND sg13cmos5l_decap_8
XFILLER_237_201 VPWR VGND sg13cmos5l_fill_2
XANTENNA__0495__GATE Tile_X0Y5_FrameStrobe[5] VPWR VGND sg13cmos5l_antennanp
X_0110_ _0110_/Q Tile_X0Y0_FrameData[24] VGND VPWR Tile_X0Y5_FrameStrobe[1] latch
XFILLER_49_188 VPWR VGND sg13cmos5l_decap_8
XANTENNA__0395__D Tile_X0Y1_FrameData[11] VPWR VGND sg13cmos5l_antennanp
XFILLER_161_70 VPWR VGND sg13cmos5l_decap_8
XFILLER_231_29 VPWR VGND sg13cmos5l_decap_8
X_1090_ _1090_/Q Tile_X0Y4_FrameData[4] VGND VPWR Tile_X0Y5_FrameStrobe[1] latch
XANTENNA__2445__A3 Tile_X0Y2_W6END[4] VPWR VGND sg13cmos5l_antennanp
XFILLER_205_131 VPWR VGND sg13cmos5l_fill_1
X_0041_ _1615_/A _2265_/X _2266_/X _0515_/Q VPWR VGND sg13cmos5l_mux2_1
XFILLER_205_175 VPWR VGND sg13cmos5l_decap_8
XFILLER_220_112 VPWR VGND sg13cmos5l_decap_8
XANTENNA__0433__GATE Tile_X0Y5_FrameStrobe[3] VPWR VGND sg13cmos5l_antennanp
XANTENNA__2602__A0 Tile_X0Y5_W2MID[5] VPWR VGND sg13cmos5l_antennanp
XFILLER_220_167 VPWR VGND sg13cmos5l_decap_8
X_1992_ Tile_X0Y5_E6BEG[5] _2762_/X VPWR VGND sg13cmos5l_buf_1
XFILLER_359_190 VPWR VGND sg13cmos5l_decap_8
X_0943_ _0943_/Q Tile_X0Y3_FrameData[7] VGND VPWR Tile_X0Y5_FrameStrobe[4] latch
X_0874_ _0874_/Q Tile_X0Y3_FrameData[12] VGND VPWR Tile_X0Y5_FrameStrobe[2] latch
X_2613_ _2613_/X _2674_/X _2673_/X AXIL_S_SOC_WSTRB1 AXIL_S_SOC_WSTRB2 _1228_/Q _1227_/Q
+ VPWR VGND sg13cmos5l_mux4_1
XANTENNA__0448__GATE Tile_X0Y5_FrameStrobe[4] VPWR VGND sg13cmos5l_antennanp
X_2544_ _2544_/X Tile_X0Y5_N4END[11] Tile_X0Y0_S4END[15] _2580_/X _2579_/X _0916_/Q
+ _0915_/Q VPWR VGND sg13cmos5l_mux4_1
XANTENNA__2381__A2 Tile_X0Y0_W6END[8] VPWR VGND sg13cmos5l_antennanp
XFILLER_48_0 VPWR VGND sg13cmos5l_fill_1
X_2475_ _2475_/X _2464_/X Tile_X0Y5_N4END[15] _2463_/X Tile_X0Y0_S4END[11] _0600_/Q
+ _0599_/Q VPWR VGND sg13cmos5l_mux4_1
XFILLER_287_178 VPWR VGND sg13cmos5l_decap_4
X_1426_ _1426_/Q Tile_X0Y5_FrameData[30] VGND VPWR Tile_X0Y5_FrameStrobe[5] latch
XANTENNA__2133__A2 Tile_X0Y0_W6END[3] VPWR VGND sg13cmos5l_antennanp
XFILLER_205_63 VPWR VGND sg13cmos5l_decap_8
X_1357_ _1357_/Q Tile_X0Y5_FrameData[3] VGND VPWR Tile_X0Y5_FrameStrobe[2] latch
X_0308_ _0308_/Q Tile_X0Y0_FrameData[18] VGND VPWR Tile_X0Y5_FrameStrobe[7] latch
XFILLER_352_80 VPWR VGND sg13cmos5l_decap_8
X_1288_ _1288_/Q Tile_X0Y5_FrameData[8] VGND VPWR Tile_X0Y5_FrameStrobe[0] latch
X_0239_ _0239_/Q Tile_X0Y0_FrameData[23] VGND VPWR Tile_X0Y5_FrameStrobe[5] latch
XFILLER_221_73 VPWR VGND sg13cmos5l_fill_2
XFILLER_221_84 VPWR VGND sg13cmos5l_fill_2
XFILLER_297_22 VPWR VGND sg13cmos5l_fill_2
XFILLER_357_127 VPWR VGND sg13cmos5l_decap_8
XFILLER_164_222 VPWR VGND sg13cmos5l_fill_2
XFILLER_166_15 VPWR VGND sg13cmos5l_decap_8
XFILLER_50_48 VPWR VGND sg13cmos5l_fill_2
XFILLER_132_152 VPWR VGND sg13cmos5l_fill_2
XFILLER_59_57 VPWR VGND sg13cmos5l_fill_1
XFILLER_59_79 VPWR VGND sg13cmos5l_fill_1
XANTENNA__2124__A2 Tile_X0Y1_W6END[2] VPWR VGND sg13cmos5l_antennanp
XFILLER_219_223 VPWR VGND sg13cmos5l_fill_1
XFILLER_293_137 VPWR VGND sg13cmos5l_fill_2
XFILLER_75_12 VPWR VGND sg13cmos5l_decap_4
XFILLER_262_80 VPWR VGND sg13cmos5l_decap_8
XFILLER_75_34 VPWR VGND sg13cmos5l_decap_8
XANTENNA__1889__A Tile_X0Y1_FrameData[2] VPWR VGND sg13cmos5l_antennanp
XFILLER_75_89 VPWR VGND sg13cmos5l_decap_4
XANTENNA__1104__D Tile_X0Y4_FrameData[22] VPWR VGND sg13cmos5l_antennanp
XFILLER_46_169 VPWR VGND sg13cmos5l_decap_4
XANTENNA__2832__A0 Tile_X0Y4_W2MID[4] VPWR VGND sg13cmos5l_antennanp
XANTENNA__0943__D Tile_X0Y3_FrameData[7] VPWR VGND sg13cmos5l_antennanp
XFILLER_152_0 VPWR VGND sg13cmos5l_fill_2
XFILLER_348_116 VPWR VGND sg13cmos5l_decap_8
XFILLER_202_134 VPWR VGND sg13cmos5l_decap_8
XFILLER_91_99 VPWR VGND sg13cmos5l_decap_8
XANTENNA__1163__GATE Tile_X0Y5_FrameStrobe[4] VPWR VGND sg13cmos5l_antennanp
XFILLER_202_178 VPWR VGND sg13cmos5l_decap_8
XANTENNA__2072__X Tile_X0Y5_S4BEG[5] VPWR VGND sg13cmos5l_antennanp
XFILLER_357_47 VPWR VGND sg13cmos5l_decap_4
XFILLER_356_171 VPWR VGND sg13cmos5l_decap_8
XFILLER_356_160 VPWR VGND sg13cmos5l_decap_8
XANTENNA__1178__GATE Tile_X0Y5_FrameStrobe[4] VPWR VGND sg13cmos5l_antennanp
XFILLER_123_130 VPWR VGND sg13cmos5l_decap_4
X_0590_ _0590_/Q Tile_X0Y2_FrameData[24] VGND VPWR Tile_X0Y5_FrameStrobe[1] latch
XANTENNA__2363__A2 Tile_X0Y5_WW4END[9] VPWR VGND sg13cmos5l_antennanp
XFILLER_123_185 VPWR VGND sg13cmos5l_decap_8
XFILLER_284_104 VPWR VGND sg13cmos5l_decap_8
X_2260_ _2260_/X Tile_X0Y1_W2MID[2] Tile_X0Y1_W2END[2] Tile_X0Y1_W6END[2] _2378_/X
+ _0532_/Q _0531_/Q VPWR VGND sg13cmos5l_mux4_1
XANTENNA__1101__GATE Tile_X0Y5_FrameStrobe[2] VPWR VGND sg13cmos5l_antennanp
XANTENNA__2115__A2 Tile_X0Y2_W6END[1] VPWR VGND sg13cmos5l_antennanp
X_1211_ _1211_/Q Tile_X0Y4_FrameData[11] VGND VPWR Tile_X0Y5_FrameStrobe[5] latch
XFILLER_49_90 VPWR VGND sg13cmos5l_decap_4
XFILLER_172_91 VPWR VGND sg13cmos5l_decap_8
X_2191_ _2191_/X AXIL_S_SOC_WDATA22 AXIL_S_SOC_WDATA26 _2237_/X _2246_/X _0214_/Q
+ _0213_/Q VPWR VGND sg13cmos5l_mux4_1
XFILLER_37_103 VPWR VGND sg13cmos5l_fill_1
X_1142_ _1142_/Q Tile_X0Y4_FrameData[16] VGND VPWR Tile_X0Y5_FrameStrobe[3] latch
XFILLER_37_147 VPWR VGND sg13cmos5l_decap_4
XANTENNA__1014__D Tile_X0Y3_FrameData[0] VPWR VGND sg13cmos5l_antennanp
XANTENNA__1116__GATE Tile_X0Y5_FrameStrobe[2] VPWR VGND sg13cmos5l_antennanp
X_1073_ _1073_/Q Tile_X0Y4_FrameData[21] VGND VPWR Tile_X0Y5_FrameStrobe[1] latch
XFILLER_322_94 VPWR VGND sg13cmos5l_fill_2
XANTENNA__2823__A0 Tile_X0Y5_N1END[0] VPWR VGND sg13cmos5l_antennanp
X_0024_ _0024_/X _2694_/X _2695_/X _0146_/Q VPWR VGND sg13cmos5l_mux2_1
XFILLER_45_180 VPWR VGND sg13cmos5l_decap_4
XANTENNA__0372__GATE Tile_X0Y5_FrameStrobe[1] VPWR VGND sg13cmos5l_antennanp
XANTENNA__0853__D Tile_X0Y3_FrameData[1] VPWR VGND sg13cmos5l_antennanp
X_1975_ Tile_X0Y5_E2BEG[4] _2729_/X VPWR VGND sg13cmos5l_buf_1
XFILLER_354_108 VPWR VGND sg13cmos5l_decap_8
XFILLER_267_47 VPWR VGND sg13cmos5l_decap_8
X_0926_ _0926_/Q Tile_X0Y3_FrameData[24] VGND VPWR Tile_X0Y5_FrameStrobe[4] latch
XANTENNA__0387__GATE Tile_X0Y5_FrameStrobe[2] VPWR VGND sg13cmos5l_antennanp
XFILLER_267_69 VPWR VGND sg13cmos5l_fill_2
XFILLER_362_130 VPWR VGND sg13cmos5l_fill_1
XFILLER_106_108 VPWR VGND sg13cmos5l_decap_8
XFILLER_161_214 VPWR VGND sg13cmos5l_fill_1
X_0857_ _0857_/Q Tile_X0Y3_FrameData[29] VGND VPWR Tile_X0Y5_FrameStrobe[2] latch
XFILLER_347_91 VPWR VGND sg13cmos5l_decap_8
XFILLER_136_18 VPWR VGND sg13cmos5l_fill_1
XFILLER_283_24 VPWR VGND sg13cmos5l_fill_1
XFILLER_283_35 VPWR VGND sg13cmos5l_fill_2
X_0788_ _0788_/Q Tile_X0Y2_FrameData[18] VGND VPWR Tile_X0Y5_FrameStrobe[7] latch
XANTENNA__0310__GATE Tile_X0Y5_FrameStrobe[7] VPWR VGND sg13cmos5l_antennanp
XFILLER_114_141 VPWR VGND sg13cmos5l_decap_8
X_2527_ _2527_/X AXIL_S_SOC_ARADDR2 AXIL_S_SOC_ARADDR4 _2577_/X _2594_/X _0950_/Q
+ _0949_/Q VPWR VGND sg13cmos5l_mux4_1
XANTENNA__0940__GATE Tile_X0Y5_FrameStrobe[4] VPWR VGND sg13cmos5l_antennanp
X_2458_ _2458_/X Tile_X0Y3_W1END[0] Tile_X0Y3_W6END[4] _2579_/X _2561_/X _1030_/Q
+ _1029_/Q VPWR VGND sg13cmos5l_mux4_1
XANTENNA__2106__A2 Tile_X0Y3_W6END[0] VPWR VGND sg13cmos5l_antennanp
X_1409_ _1409_/Q Tile_X0Y5_FrameData[15] VGND VPWR Tile_X0Y5_FrameStrobe[4] latch
XFILLER_29_49 VPWR VGND sg13cmos5l_fill_2
XANTENNA__0325__GATE Tile_X0Y5_FrameStrobe[0] VPWR VGND sg13cmos5l_antennanp
X_2389_ _2389_/X Tile_X0Y0_W1END[0] Tile_X0Y0_W2MID[3] Tile_X0Y0_W2END[3] _2245_/X
+ _0162_/Q _0161_/Q VPWR VGND sg13cmos5l_mux4_1
XANTENNA__0955__GATE Tile_X0Y5_FrameStrobe[5] VPWR VGND sg13cmos5l_antennanp
XFILLER_232_61 VPWR VGND sg13cmos5l_decap_4
XFILLER_283_181 VPWR VGND sg13cmos5l_decap_4
XANTENNA__2814__A0 Tile_X0Y5_N1END[0] VPWR VGND sg13cmos5l_antennanp
XANTENNA__0763__D Tile_X0Y2_FrameData[11] VPWR VGND sg13cmos5l_antennanp
XANTENNA__1996__X Tile_X0Y5_E6BEG[9] VPWR VGND sg13cmos5l_antennanp
XFILLER_101_43 VPWR VGND sg13cmos5l_decap_4
XFILLER_353_174 VPWR VGND sg13cmos5l_decap_8
XFILLER_298_207 VPWR VGND sg13cmos5l_fill_1
XANTENNA__0908__GATE Tile_X0Y5_FrameStrobe[3] VPWR VGND sg13cmos5l_antennanp
XFILLER_193_68 VPWR VGND sg13cmos5l_fill_1
XFILLER_86_22 VPWR VGND sg13cmos5l_decap_8
XFILLER_86_11 VPWR VGND sg13cmos5l_decap_8
XFILLER_343_38 VPWR VGND sg13cmos5l_decap_8
XANTENNA__0938__D Tile_X0Y3_FrameData[12] VPWR VGND sg13cmos5l_antennanp
XFILLER_120_133 VPWR VGND sg13cmos5l_fill_1
XFILLER_273_90 VPWR VGND sg13cmos5l_decap_8
XFILLER_86_99 VPWR VGND sg13cmos5l_decap_8
XANTENNA__2067__X Tile_X0Y5_S4BEG[0] VPWR VGND sg13cmos5l_antennanp
XFILLER_142_83 VPWR VGND sg13cmos5l_decap_8
XFILLER_274_181 VPWR VGND sg13cmos5l_fill_2
XFILLER_34_106 VPWR VGND sg13cmos5l_fill_1
XANTENNA__2805__A0 Tile_X0Y5_N1END[2] VPWR VGND sg13cmos5l_antennanp
XFILLER_27_180 VPWR VGND sg13cmos5l_decap_8
XANTENNA__0673__D Tile_X0Y2_FrameData[5] VPWR VGND sg13cmos5l_antennanp
XANTENNA__2281__A1 Tile_X0Y3_WW4END[3] VPWR VGND sg13cmos5l_antennanp
XFILLER_187_177 VPWR VGND sg13cmos5l_decap_8
X_1760_ Tile_X0Y2_FrameData_O[20] Tile_X0Y2_FrameData[20] VPWR VGND sg13cmos5l_buf_1
XFILLER_329_160 VPWR VGND sg13cmos5l_fill_2
X_0711_ _0711_/Q Tile_X0Y2_FrameData[31] VGND VPWR Tile_X0Y5_FrameStrobe[5] latch
XFILLER_167_80 VPWR VGND sg13cmos5l_decap_8
X_1691_ Tile_X0Y0_FrameData_O[31] Tile_X0Y0_FrameData[31] VPWR VGND sg13cmos5l_buf_1
X_0642_ _0642_/Q Tile_X0Y2_FrameData[4] VGND VPWR Tile_X0Y5_FrameStrobe[2] latch
XFILLER_317_50 VPWR VGND sg13cmos5l_fill_1
XANTENNA__1009__D Tile_X0Y3_FrameData[5] VPWR VGND sg13cmos5l_antennanp
X_0573_ _0573_/Q Tile_X0Y2_FrameData[9] VGND VPWR Tile_X0Y5_FrameStrobe[0] latch
XANTENNA__1040__GATE Tile_X0Y5_FrameStrobe[0] VPWR VGND sg13cmos5l_antennanp
X_2312_ _2312_/X AXIL_S_SOC_WDATA3 AXIL_S_SOC_WDATA15 _2361_/X _2377_/X _0468_/Q _0467_/Q
+ VPWR VGND sg13cmos5l_mux4_1
XANTENNA__0848__D Tile_X0Y3_FrameData[6] VPWR VGND sg13cmos5l_antennanp
XFILLER_111_133 VPWR VGND sg13cmos5l_decap_4
XFILLER_183_90 VPWR VGND sg13cmos5l_decap_8
X_2243_ _2243_/X _2254_/X _2253_/X Tile_X0Y0_S2MID[2] Tile_X0Y0_S2END[2] _0090_/Q
+ _0089_/Q VPWR VGND sg13cmos5l_mux4_1
XANTENNA__1055__GATE Tile_X0Y5_FrameStrobe[0] VPWR VGND sg13cmos5l_antennanp
XFILLER_272_129 VPWR VGND sg13cmos5l_fill_1
X_2174_ _2174_/X AXIL_S_SOC_WDATA17 AXIL_S_SOC_WDATA25 _2242_/X _2247_/X _0248_/Q
+ _0247_/Q VPWR VGND sg13cmos5l_mux4_1
X_1125_ _1125_/Q Tile_X0Y4_FrameData[1] VGND VPWR Tile_X0Y5_FrameStrobe[2] latch
XFILLER_280_162 VPWR VGND sg13cmos5l_fill_2
XFILLER_80_201 VPWR VGND sg13cmos5l_fill_2
XANTENNA__0583__D Tile_X0Y2_FrameData[31] VPWR VGND sg13cmos5l_antennanp
XFILLER_202_64 VPWR VGND sg13cmos5l_decap_8
X_1056_ _1056_/Q Tile_X0Y4_FrameData[6] VGND VPWR Tile_X0Y5_FrameStrobe[0] latch
XFILLER_178_133 VPWR VGND sg13cmos5l_decap_8
XFILLER_33_161 VPWR VGND sg13cmos5l_fill_2
XANTENNA__2811__A3 Tile_X0Y1_W6END[6] VPWR VGND sg13cmos5l_antennanp
XFILLER_119_222 VPWR VGND sg13cmos5l_fill_2
X_1958_ Tile_X0Y1_E2BEG[3] _2296_/X VPWR VGND sg13cmos5l_buf_1
XFILLER_134_203 VPWR VGND sg13cmos5l_decap_8
XFILLER_134_214 VPWR VGND sg13cmos5l_fill_1
X_1889_ Tile_X0Y1_FrameData_O[2] Tile_X0Y1_FrameData[2] VPWR VGND sg13cmos5l_buf_1
X_0909_ _0909_/Q Tile_X0Y3_FrameData[9] VGND VPWR Tile_X0Y5_FrameStrobe[3] latch
XFILLER_335_196 VPWR VGND sg13cmos5l_fill_1
XFILLER_335_185 VPWR VGND sg13cmos5l_fill_2
XFILLER_350_144 VPWR VGND sg13cmos5l_decap_8
XANTENNA__1008__GATE Tile_X0Y5_FrameStrobe[6] VPWR VGND sg13cmos5l_antennanp
XFILLER_350_199 VPWR VGND sg13cmos5l_fill_1
XFILLER_350_177 VPWR VGND sg13cmos5l_fill_1
XANTENNA__0758__D Tile_X0Y2_FrameData[16] VPWR VGND sg13cmos5l_antennanp
XANTENNA__0264__GATE Tile_X0Y5_FrameStrobe[6] VPWR VGND sg13cmos5l_antennanp
XFILLER_193_7 VPWR VGND sg13cmos5l_decap_8
XANTENNA__0894__GATE Tile_X0Y5_FrameStrobe[3] VPWR VGND sg13cmos5l_antennanp
XFILLER_102_199 VPWR VGND sg13cmos5l_decap_4
XFILLER_243_93 VPWR VGND sg13cmos5l_decap_8
XFILLER_263_107 VPWR VGND sg13cmos5l_fill_1
XANTENNA__0279__GATE Tile_X0Y5_FrameStrobe[6] VPWR VGND sg13cmos5l_antennanp
XFILLER_16_106 VPWR VGND sg13cmos5l_decap_4
XFILLER_71_223 VPWR VGND sg13cmos5l_fill_1
XANTENNA__0493__D Tile_X0Y1_FrameData[9] VPWR VGND sg13cmos5l_antennanp
XFILLER_271_184 VPWR VGND sg13cmos5l_decap_8
XANTENNA__2263__A1 Tile_X0Y2_W2END[0] VPWR VGND sg13cmos5l_antennanp
XANTENNA__0202__GATE Tile_X0Y5_FrameStrobe[4] VPWR VGND sg13cmos5l_antennanp
XANTENNA__0832__GATE Tile_X0Y5_FrameStrobe[1] VPWR VGND sg13cmos5l_antennanp
XFILLER_184_158 VPWR VGND sg13cmos5l_decap_8
XFILLER_184_169 VPWR VGND sg13cmos5l_fill_2
XFILLER_326_152 VPWR VGND sg13cmos5l_fill_1
XANTENNA__0217__GATE Tile_X0Y5_FrameStrobe[4] VPWR VGND sg13cmos5l_antennanp
XFILLER_115_0 VPWR VGND sg13cmos5l_fill_2
XFILLER_21_72 VPWR VGND sg13cmos5l_decap_8
XFILLER_326_185 VPWR VGND sg13cmos5l_fill_1
XANTENNA__0847__GATE Tile_X0Y5_FrameStrobe[1] VPWR VGND sg13cmos5l_antennanp
XANTENNA__0668__D Tile_X0Y2_FrameData[10] VPWR VGND sg13cmos5l_antennanp
XFILLER_239_104 VPWR VGND sg13cmos5l_decap_8
XFILLER_97_76 VPWR VGND sg13cmos5l_decap_8
XFILLER_153_60 VPWR VGND sg13cmos5l_fill_2
XFILLER_254_107 VPWR VGND sg13cmos5l_fill_1
XFILLER_303_30 VPWR VGND sg13cmos5l_fill_2
XFILLER_62_212 VPWR VGND sg13cmos5l_fill_2
XANTENNA__2254__A1 Tile_X0Y1_W2END[5] VPWR VGND sg13cmos5l_antennanp
XFILLER_349_211 VPWR VGND sg13cmos5l_fill_1
XFILLER_248_16 VPWR VGND sg13cmos5l_fill_1
XFILLER_30_164 VPWR VGND sg13cmos5l_fill_2
XFILLER_309_119 VPWR VGND sg13cmos5l_fill_2
XFILLER_248_38 VPWR VGND sg13cmos5l_decap_8
X_1812_ Tile_X0Y4_E6BEG[7] _2656_/X VPWR VGND sg13cmos5l_buf_1
X_2792_ _2792_/X Tile_X0Y5_N1END[3] _2796_/X Tile_X0Y5_W6END[3] _2792_/A3 _1266_/Q
+ _1497_/Q VPWR VGND sg13cmos5l_mux4_1
XANTENNA__2557__A2 Tile_X0Y3_WW4END[14] VPWR VGND sg13cmos5l_antennanp
X_1743_ Tile_X0Y2_FrameData_O[3] Tile_X0Y2_FrameData[3] VPWR VGND sg13cmos5l_buf_1
XFILLER_328_60 VPWR VGND sg13cmos5l_decap_4
XFILLER_317_152 VPWR VGND sg13cmos5l_decap_4
XFILLER_317_141 VPWR VGND sg13cmos5l_decap_4
XFILLER_190_128 VPWR VGND sg13cmos5l_decap_8
X_1674_ Tile_X0Y0_FrameData_O[14] Tile_X0Y0_FrameData[14] VPWR VGND sg13cmos5l_buf_1
X_0625_ _0625_/Q Tile_X0Y2_FrameData[21] VGND VPWR Tile_X0Y5_FrameStrobe[2] latch
XANTENNA__2190__A0 AXIL_S_SOC_WDATA21 VPWR VGND sg13cmos5l_antennanp
X_0556_ _0556_/Q Tile_X0Y2_FrameData[26] VGND VPWR Tile_X0Y5_FrameStrobe[0] latch
XFILLER_97_142 VPWR VGND sg13cmos5l_decap_8
XANTENNA__0578__D Tile_X0Y2_FrameData[4] VPWR VGND sg13cmos5l_antennanp
X_0487_ _0487_/Q Tile_X0Y1_FrameData[15] VGND VPWR Tile_X0Y5_FrameStrobe[5] latch
XANTENNA__1604__X Tile_X0Y0_N4BEG[0] VPWR VGND sg13cmos5l_antennanp
X_2226_ _2226_/X _2214_/X _0066_/X Tile_X0Y0_S1END[1] Tile_X0Y0_S4END[1] _0108_/Q
+ _0107_/Q VPWR VGND sg13cmos5l_mux4_1
XFILLER_238_170 VPWR VGND sg13cmos5l_decap_8
XFILLER_238_192 VPWR VGND sg13cmos5l_decap_4
XANTENNA__2493__A1 Tile_X0Y1_W2END[5] VPWR VGND sg13cmos5l_antennanp
XFILLER_213_96 VPWR VGND sg13cmos5l_decap_8
XFILLER_253_140 VPWR VGND sg13cmos5l_decap_8
X_2157_ _2157_/X Tile_X0Y0_W1END[2] Tile_X0Y0_WW4END[2] Tile_X0Y0_WW4END[6] Tile_X0Y0_W6END[10]
+ _0280_/Q _0279_/Q VPWR VGND sg13cmos5l_mux4_1
XFILLER_360_91 VPWR VGND sg13cmos5l_fill_1
X_2088_ Tile_X0Y3_E2BEG[0] _2509_/X VPWR VGND sg13cmos5l_buf_1
X_1108_ _1108_/Q Tile_X0Y4_FrameData[18] VGND VPWR Tile_X0Y5_FrameStrobe[2] latch
XANTENNA__1202__D Tile_X0Y4_FrameData[20] VPWR VGND sg13cmos5l_antennanp
X_1039_ _1039_/Q Tile_X0Y4_FrameData[23] VGND VPWR Tile_X0Y5_FrameStrobe[0] latch
XFILLER_21_142 VPWR VGND sg13cmos5l_decap_4
XFILLER_21_153 VPWR VGND sg13cmos5l_decap_8
XFILLER_42_38 VPWR VGND sg13cmos5l_fill_1
XFILLER_166_147 VPWR VGND sg13cmos5l_fill_1
XFILLER_220_9 VPWR VGND sg13cmos5l_decap_8
XFILLER_308_19 VPWR VGND sg13cmos5l_decap_4
XFILLER_308_141 VPWR VGND sg13cmos5l_fill_2
XFILLER_206_7 VPWR VGND sg13cmos5l_decap_8
XFILLER_323_111 VPWR VGND sg13cmos5l_decap_4
XFILLER_323_100 VPWR VGND sg13cmos5l_decap_4
XFILLER_323_155 VPWR VGND sg13cmos5l_decap_4
XFILLER_323_133 VPWR VGND sg13cmos5l_fill_1
XFILLER_323_122 VPWR VGND sg13cmos5l_decap_8
XANTENNA__2181__A0 AXIL_S_SOC_WDATA16 VPWR VGND sg13cmos5l_antennanp
XFILLER_107_53 VPWR VGND sg13cmos5l_fill_2
XFILLER_88_142 VPWR VGND sg13cmos5l_fill_2
XANTENNA__0488__D Tile_X0Y1_FrameData[14] VPWR VGND sg13cmos5l_antennanp
XANTENNA__2720__A2 Tile_X0Y3_W2END[0] VPWR VGND sg13cmos5l_antennanp
XFILLER_107_97 VPWR VGND sg13cmos5l_fill_2
XFILLER_67_24 VPWR VGND sg13cmos5l_decap_8
XFILLER_244_140 VPWR VGND sg13cmos5l_decap_8
XFILLER_244_184 VPWR VGND sg13cmos5l_decap_8
XANTENNA__0141__GATE Tile_X0Y5_FrameStrobe[2] VPWR VGND sg13cmos5l_antennanp
XANTENNA__1112__D Tile_X0Y4_FrameData[14] VPWR VGND sg13cmos5l_antennanp
XANTENNA__1897__A Tile_X0Y1_FrameData[10] VPWR VGND sg13cmos5l_antennanp
XFILLER_344_2 VPWR VGND sg13cmos5l_fill_1
XANTENNA__0771__GATE Tile_X0Y5_FrameStrobe[6] VPWR VGND sg13cmos5l_antennanp
XANTENNA__2787__A2 Tile_X0Y5_W6END[7] VPWR VGND sg13cmos5l_antennanp
XFILLER_199_89 VPWR VGND sg13cmos5l_decap_8
XFILLER_349_37 VPWR VGND sg13cmos5l_decap_4
XANTENNA__0951__D Tile_X0Y3_FrameData[31] VPWR VGND sg13cmos5l_antennanp
XFILLER_8_102 VPWR VGND sg13cmos5l_decap_4
XFILLER_349_59 VPWR VGND sg13cmos5l_decap_8
XFILLER_12_175 VPWR VGND sg13cmos5l_fill_1
XANTENNA__0156__GATE Tile_X0Y5_FrameStrobe[2] VPWR VGND sg13cmos5l_antennanp
XANTENNA__0786__GATE Tile_X0Y5_FrameStrobe[7] VPWR VGND sg13cmos5l_antennanp
XANTENNA__2080__X Tile_X0Y5_S4BEG[13] VPWR VGND sg13cmos5l_antennanp
XFILLER_148_71 VPWR VGND sg13cmos5l_decap_8
XFILLER_113_206 VPWR VGND sg13cmos5l_fill_1
XFILLER_180_172 VPWR VGND sg13cmos5l_fill_1
XFILLER_314_166 VPWR VGND sg13cmos5l_fill_1
XANTENNA__2172__A0 AXIL_S_SOC_WDATA23 VPWR VGND sg13cmos5l_antennanp
X_1390_ _1390_/Q Tile_X0Y5_FrameData[2] VGND VPWR Tile_X0Y5_FrameStrobe[3] latch
X_0410_ _0410_/Q Tile_X0Y1_FrameData[28] VGND VPWR Tile_X0Y5_FrameStrobe[3] latch
XFILLER_79_120 VPWR VGND sg13cmos5l_decap_8
XANTENNA__0398__D Tile_X0Y1_FrameData[8] VPWR VGND sg13cmos5l_antennanp
XFILLER_164_81 VPWR VGND sg13cmos5l_decap_4
XFILLER_267_221 VPWR VGND sg13cmos5l_fill_2
X_0341_ _0341_/Q Tile_X0Y1_FrameData[1] VGND VPWR Tile_X0Y5_FrameStrobe[0] latch
XFILLER_227_118 VPWR VGND sg13cmos5l_decap_8
XANTENNA__0724__GATE Tile_X0Y5_FrameStrobe[5] VPWR VGND sg13cmos5l_antennanp
X_2011_ Tile_X0Y5_EE4BEG[12] _2753_/X VPWR VGND sg13cmos5l_buf_1
X_0272_ _0272_/Q Tile_X0Y0_FrameData[22] VGND VPWR Tile_X0Y5_FrameStrobe[6] latch
XFILLER_94_156 VPWR VGND sg13cmos5l_decap_8
XFILLER_314_84 VPWR VGND sg13cmos5l_decap_8
XANTENNA__2475__A1 Tile_X0Y5_N4END[15] VPWR VGND sg13cmos5l_antennanp
XFILLER_180_91 VPWR VGND sg13cmos5l_fill_1
XFILLER_35_212 VPWR VGND sg13cmos5l_fill_2
XFILLER_250_110 VPWR VGND sg13cmos5l_fill_1
XFILLER_35_223 VPWR VGND sg13cmos5l_fill_1
XANTENNA__0109__GATE Tile_X0Y5_FrameStrobe[1] VPWR VGND sg13cmos5l_antennanp
XANTENNA__1022__D Tile_X0Y3_FrameData[24] VPWR VGND sg13cmos5l_antennanp
XANTENNA__2227__A1 Tile_X0Y4_WW4END[2] VPWR VGND sg13cmos5l_antennanp
XFILLER_235_195 VPWR VGND sg13cmos5l_decap_8
XANTENNA__0739__GATE Tile_X0Y5_FrameStrobe[5] VPWR VGND sg13cmos5l_antennanp
XANTENNA__2778__A2 Tile_X0Y5_W2END[2] VPWR VGND sg13cmos5l_antennanp
XFILLER_92_2 VPWR VGND sg13cmos5l_fill_1
XANTENNA__0861__D Tile_X0Y3_FrameData[25] VPWR VGND sg13cmos5l_antennanp
XFILLER_148_136 VPWR VGND sg13cmos5l_fill_1
XFILLER_148_158 VPWR VGND sg13cmos5l_decap_8
XFILLER_148_169 VPWR VGND sg13cmos5l_fill_1
XFILLER_275_14 VPWR VGND sg13cmos5l_decap_8
XFILLER_339_92 VPWR VGND sg13cmos5l_decap_4
XFILLER_339_81 VPWR VGND sg13cmos5l_decap_4
XFILLER_163_139 VPWR VGND sg13cmos5l_decap_4
X_2775_ _2775_/X Tile_X0Y5_W2MID[5] Tile_X0Y5_W2END[5] Tile_X0Y5_W6END[10] _2827_/X
+ _1352_/Q _1351_/Q VPWR VGND sg13cmos5l_mux4_1
XFILLER_352_217 VPWR VGND sg13cmos5l_fill_1
XFILLER_208_41 VPWR VGND sg13cmos5l_decap_8
XFILLER_275_58 VPWR VGND sg13cmos5l_decap_4
X_1726_ Tile_X0Y0_E2BEGb[6] _2179_/X VPWR VGND sg13cmos5l_buf_1
X_1657_ Tile_X0Y0_FrameStrobe_O[17] Tile_X0Y5_FrameStrobe[17] VPWR VGND sg13cmos5l_buf_1
XFILLER_305_155 VPWR VGND sg13cmos5l_decap_8
XFILLER_291_35 VPWR VGND sg13cmos5l_decap_8
X_1588_ Tile_X0Y2_EE4BEG[1] _2418_/X VPWR VGND sg13cmos5l_buf_1
X_0608_ _0608_/Q Tile_X0Y2_FrameData[6] VGND VPWR Tile_X0Y5_FrameStrobe[1] latch
XFILLER_355_91 VPWR VGND sg13cmos5l_decap_8
X_0539_ _0539_/Q Tile_X0Y1_FrameData[27] VGND VPWR Tile_X0Y5_FrameStrobe[7] latch
XANTENNA__0101__D Tile_X0Y0_FrameData[1] VPWR VGND sg13cmos5l_antennanp
XFILLER_273_213 VPWR VGND sg13cmos5l_decap_4
XANTENNA__2466__A1 Tile_X0Y5_N4END[15] VPWR VGND sg13cmos5l_antennanp
XFILLER_160_39 VPWR VGND sg13cmos5l_fill_1
XFILLER_26_201 VPWR VGND sg13cmos5l_fill_1
X_2209_ _2209_/X _2213_/X Tile_X0Y0_S1END[0] Tile_X0Y0_W6END[0] _2209_/A3 _0078_/Q
+ _0077_/Q VPWR VGND sg13cmos5l_mux4_1
XFILLER_226_195 VPWR VGND sg13cmos5l_decap_8
XFILLER_240_83 VPWR VGND sg13cmos5l_fill_2
XFILLER_240_94 VPWR VGND sg13cmos5l_decap_4
XFILLER_241_154 VPWR VGND sg13cmos5l_decap_4
XANTENNA__0771__D Tile_X0Y2_FrameData[3] VPWR VGND sg13cmos5l_antennanp
XFILLER_139_114 VPWR VGND sg13cmos5l_decap_8
XFILLER_149_6 VPWR VGND sg13cmos5l_decap_8
XFILLER_169_37 VPWR VGND sg13cmos5l_decap_8
XFILLER_241_187 VPWR VGND sg13cmos5l_decap_8
XFILLER_319_29 VPWR VGND sg13cmos5l_fill_2
XFILLER_319_18 VPWR VGND sg13cmos5l_decap_8
XFILLER_154_139 VPWR VGND sg13cmos5l_fill_2
XFILLER_335_28 VPWR VGND sg13cmos5l_decap_4
XFILLER_162_194 VPWR VGND sg13cmos5l_decap_8
XANTENNA__1107__D Tile_X0Y4_FrameData[19] VPWR VGND sg13cmos5l_antennanp
XFILLER_134_62 VPWR VGND sg13cmos5l_decap_8
XFILLER_76_101 VPWR VGND sg13cmos5l_decap_8
XFILLER_351_27 VPWR VGND sg13cmos5l_decap_8
XFILLER_182_0 VPWR VGND sg13cmos5l_fill_1
XANTENNA__0946__D Tile_X0Y3_FrameData[4] VPWR VGND sg13cmos5l_antennanp
XANTENNA__1454__GATE Tile_X0Y5_FrameStrobe[5] VPWR VGND sg13cmos5l_antennanp
XANTENNA__2457__A1 Tile_X0Y1_W6END[8] VPWR VGND sg13cmos5l_antennanp
XFILLER_27_71 VPWR VGND sg13cmos5l_fill_2
XFILLER_91_159 VPWR VGND sg13cmos5l_fill_1
XANTENNA__0080__GATE Tile_X0Y5_FrameStrobe[0] VPWR VGND sg13cmos5l_antennanp
XANTENNA__2075__X Tile_X0Y5_S4BEG[8] VPWR VGND sg13cmos5l_antennanp
XANTENNA__2209__A1 Tile_X0Y0_S1END[0] VPWR VGND sg13cmos5l_antennanp
XFILLER_150_83 VPWR VGND sg13cmos5l_decap_8
XFILLER_232_110 VPWR VGND sg13cmos5l_decap_8
XFILLER_150_94 VPWR VGND sg13cmos5l_fill_2
XFILLER_300_42 VPWR VGND sg13cmos5l_decap_8
XFILLER_300_20 VPWR VGND sg13cmos5l_fill_2
XANTENNA__0681__D Tile_X0Y2_FrameData[29] VPWR VGND sg13cmos5l_antennanp
XANTENNA__1469__GATE Tile_X0Y5_FrameStrobe[6] VPWR VGND sg13cmos5l_antennanp
XANTENNA__0095__GATE Tile_X0Y5_FrameStrobe[0] VPWR VGND sg13cmos5l_antennanp
XFILLER_229_29 VPWR VGND sg13cmos5l_decap_8
X_0890_ _0890_/Q Tile_X0Y3_FrameData[28] VGND VPWR Tile_X0Y5_FrameStrobe[3] latch
XFILLER_43_92 VPWR VGND sg13cmos5l_fill_2
XFILLER_43_81 VPWR VGND sg13cmos5l_decap_8
XFILLER_159_81 VPWR VGND sg13cmos5l_decap_8
XFILLER_145_128 VPWR VGND sg13cmos5l_decap_8
XFILLER_64_6 VPWR VGND sg13cmos5l_fill_1
XFILLER_309_51 VPWR VGND sg13cmos5l_decap_8
XANTENNA__2393__A0 Tile_X0Y0_W1END[2] VPWR VGND sg13cmos5l_antennanp
X_2560_ _2560_/X _2583_/X _2581_/X _2574_/X _2573_/X _0865_/Q _0864_/Q VPWR VGND sg13cmos5l_mux4_1
XFILLER_309_62 VPWR VGND sg13cmos5l_fill_1
XFILLER_245_17 VPWR VGND sg13cmos5l_fill_1
XFILLER_245_28 VPWR VGND sg13cmos5l_decap_8
X_1511_ _2338_/A3 VPWR VGND sg13cmos5l_tielo
X_2491_ _2491_/X Tile_X0Y1_W2MID[6] Tile_X0Y1_W2END[6] Tile_X0Y1_W6END[9] _2374_/X
+ _0408_/Q _0407_/Q VPWR VGND sg13cmos5l_mux4_1
XFILLER_299_132 VPWR VGND sg13cmos5l_fill_1
XANTENNA__1407__GATE Tile_X0Y5_FrameStrobe[4] VPWR VGND sg13cmos5l_antennanp
X_1442_ _1442_/Q Tile_X0Y5_FrameData[14] VGND VPWR Tile_X0Y5_FrameStrobe[5] latch
XFILLER_302_114 VPWR VGND sg13cmos5l_decap_4
XFILLER_299_176 VPWR VGND sg13cmos5l_decap_8
XANTENNA__2145__A0 Tile_X0Y0_W2MID[7] VPWR VGND sg13cmos5l_antennanp
XANTENNA__1017__D Tile_X0Y3_FrameData[29] VPWR VGND sg13cmos5l_antennanp
XANTENNA__2696__A1 Tile_X0Y5_N4END[4] VPWR VGND sg13cmos5l_antennanp
XFILLER_261_16 VPWR VGND sg13cmos5l_fill_1
XFILLER_261_27 VPWR VGND sg13cmos5l_decap_8
X_1373_ _1373_/Q Tile_X0Y5_FrameData[19] VGND VPWR Tile_X0Y5_FrameStrobe[3] latch
XANTENNA__0663__GATE Tile_X0Y5_FrameStrobe[3] VPWR VGND sg13cmos5l_antennanp
X_0324_ _0324_/Q Tile_X0Y1_FrameData[18] VGND VPWR Tile_X0Y5_FrameStrobe[0] latch
XFILLER_310_180 VPWR VGND sg13cmos5l_decap_4
XANTENNA__0856__D Tile_X0Y3_FrameData[30] VPWR VGND sg13cmos5l_antennanp
X_0255_ _0255_/Q Tile_X0Y0_FrameData[7] VGND VPWR Tile_X0Y5_FrameStrobe[5] latch
XANTENNA__0678__GATE Tile_X0Y5_FrameStrobe[3] VPWR VGND sg13cmos5l_antennanp
X_0186_ _0186_/Q Tile_X0Y0_FrameData[12] VGND VPWR Tile_X0Y5_FrameStrobe[3] latch
XFILLER_223_165 VPWR VGND sg13cmos5l_fill_2
XANTENNA__0591__D Tile_X0Y2_FrameData[23] VPWR VGND sg13cmos5l_antennanp
XANTENNA__0601__GATE Tile_X0Y5_FrameStrobe[1] VPWR VGND sg13cmos5l_antennanp
XANTENNA__2620__A1 AXIL_S_SOC_BREADY VPWR VGND sg13cmos5l_antennanp
XFILLER_136_139 VPWR VGND sg13cmos5l_decap_8
X_2827_ _2827_/X Tile_X0Y5_N2MID[2] Tile_X0Y5_N2END[2] _2831_/X _2715_/X _1284_/Q
+ _1283_/Q VPWR VGND sg13cmos5l_mux4_1
XFILLER_325_217 VPWR VGND sg13cmos5l_fill_1
XANTENNA__2384__A0 Tile_X0Y3_W2MID[6] VPWR VGND sg13cmos5l_antennanp
X_2758_ _2758_/X Tile_X0Y5_N4END[1] _0059_/X _2806_/X _2805_/X _1386_/Q _1385_/Q VPWR
+ VGND sg13cmos5l_mux4_1
XANTENNA__0616__GATE Tile_X0Y5_FrameStrobe[2] VPWR VGND sg13cmos5l_antennanp
XFILLER_144_150 VPWR VGND sg13cmos5l_decap_8
X_1709_ Tile_X0Y0_E6BEG[1] _2198_/X VPWR VGND sg13cmos5l_buf_1
XFILLER_340_209 VPWR VGND sg13cmos5l_fill_1
X_2689_ _2689_/X _2678_/X Tile_X0Y5_N4END[6] _2677_/X _0024_/X _1066_/Q _1065_/Q VPWR
+ VGND sg13cmos5l_mux4_1
XANTENNA__2136__A0 Tile_X0Y0_W2MID[6] VPWR VGND sg13cmos5l_antennanp
XFILLER_48_48 VPWR VGND sg13cmos5l_fill_2
XFILLER_301_191 VPWR VGND sg13cmos5l_decap_8
XANTENNA__0766__D Tile_X0Y2_FrameData[8] VPWR VGND sg13cmos5l_antennanp
XANTENNA__1999__X Tile_X0Y5_EE4BEG[0] VPWR VGND sg13cmos5l_antennanp
XFILLER_104_32 VPWR VGND sg13cmos5l_fill_2
XFILLER_251_71 VPWR VGND sg13cmos5l_fill_1
XFILLER_120_31 VPWR VGND sg13cmos5l_fill_1
XFILLER_81_170 VPWR VGND sg13cmos5l_decap_8
XFILLER_80_13 VPWR VGND sg13cmos5l_fill_1
XANTENNA__2611__A1 Tile_X0Y2_W2MID[0] VPWR VGND sg13cmos5l_antennanp
XFILLER_120_97 VPWR VGND sg13cmos5l_fill_1
XFILLER_13_84 VPWR VGND sg13cmos5l_decap_8
XFILLER_182_223 VPWR VGND sg13cmos5l_fill_1
XFILLER_89_44 VPWR VGND sg13cmos5l_decap_8
XANTENNA__2127__A0 Tile_X0Y1_W2MID[5] VPWR VGND sg13cmos5l_antennanp
XFILLER_1_130 VPWR VGND sg13cmos5l_fill_2
XFILLER_296_135 VPWR VGND sg13cmos5l_decap_8
XANTENNA__2678__A1 Tile_X0Y5_W6END[6] VPWR VGND sg13cmos5l_antennanp
XFILLER_150_175 VPWR VGND sg13cmos5l_fill_2
XFILLER_362_59 VPWR VGND sg13cmos5l_decap_8
XFILLER_362_48 VPWR VGND sg13cmos5l_fill_1
XFILLER_49_134 VPWR VGND sg13cmos5l_fill_1
XANTENNA__0676__D Tile_X0Y2_FrameData[2] VPWR VGND sg13cmos5l_antennanp
XANTENNA__1393__GATE Tile_X0Y5_FrameStrobe[4] VPWR VGND sg13cmos5l_antennanp
XFILLER_38_81 VPWR VGND sg13cmos5l_fill_2
XANTENNA__1702__X Tile_X0Y0_EE4BEG[10] VPWR VGND sg13cmos5l_antennanp
X_0040_ _1614_/A _2267_/X _2268_/X _0518_/Q VPWR VGND sg13cmos5l_mux2_1
XFILLER_64_148 VPWR VGND sg13cmos5l_decap_8
XFILLER_311_41 VPWR VGND sg13cmos5l_fill_2
XFILLER_311_30 VPWR VGND sg13cmos5l_decap_4
XFILLER_205_143 VPWR VGND sg13cmos5l_decap_8
XFILLER_311_85 VPWR VGND sg13cmos5l_fill_2
XANTENNA__1300__D Tile_X0Y5_FrameData[28] VPWR VGND sg13cmos5l_antennanp
XFILLER_220_146 VPWR VGND sg13cmos5l_decap_8
X_1991_ Tile_X0Y5_E6BEG[4] _2761_/X VPWR VGND sg13cmos5l_buf_1
XANTENNA__1331__GATE Tile_X0Y5_FrameStrobe[2] VPWR VGND sg13cmos5l_antennanp
XANTENNA__2602__A1 Tile_X0Y5_W2END[5] VPWR VGND sg13cmos5l_antennanp
X_0942_ _0942_/Q Tile_X0Y3_FrameData[8] VGND VPWR Tile_X0Y5_FrameStrobe[4] latch
XFILLER_118_128 VPWR VGND sg13cmos5l_fill_1
X_0873_ _0873_/Q Tile_X0Y3_FrameData[13] VGND VPWR Tile_X0Y5_FrameStrobe[2] latch
XFILLER_256_38 VPWR VGND sg13cmos5l_fill_2
X_2612_ _2612_/X Tile_X0Y5_W2MID[0] Tile_X0Y5_W2END[0] Tile_X0Y5_W6END[0] _2797_/X
+ _1474_/Q _1473_/Q VPWR VGND sg13cmos5l_mux4_1
X_2543_ _2543_/X Tile_X0Y5_N4END[10] Tile_X0Y0_S4END[14] _2578_/X _2577_/X _0918_/Q
+ _0917_/Q VPWR VGND sg13cmos5l_mux4_1
XANTENNA__1346__GATE Tile_X0Y5_FrameStrobe[2] VPWR VGND sg13cmos5l_antennanp
XANTENNA__2118__A0 Tile_X0Y2_W2MID[4] VPWR VGND sg13cmos5l_antennanp
X_2474_ _2474_/X _2462_/X Tile_X0Y5_N4END[14] _2461_/X Tile_X0Y0_S4END[10] _0594_/Q
+ _0593_/Q VPWR VGND sg13cmos5l_mux4_1
XFILLER_336_93 VPWR VGND sg13cmos5l_decap_8
XFILLER_141_186 VPWR VGND sg13cmos5l_decap_8
XFILLER_141_197 VPWR VGND sg13cmos5l_fill_1
XFILLER_272_59 VPWR VGND sg13cmos5l_decap_8
X_1425_ _1425_/Q Tile_X0Y5_FrameData[31] VGND VPWR Tile_X0Y5_FrameStrobe[5] latch
XFILLER_205_42 VPWR VGND sg13cmos5l_decap_8
X_1356_ _1356_/Q Tile_X0Y5_FrameData[4] VGND VPWR Tile_X0Y5_FrameStrobe[2] latch
XANTENNA__0586__D Tile_X0Y2_FrameData[28] VPWR VGND sg13cmos5l_antennanp
X_0307_ _0307_/Q Tile_X0Y0_FrameData[19] VGND VPWR Tile_X0Y5_FrameStrobe[7] latch
XANTENNA__1612__X Tile_X0Y0_N4BEG[8] VPWR VGND sg13cmos5l_antennanp
X_1287_ _1287_/Q Tile_X0Y5_FrameData[9] VGND VPWR Tile_X0Y5_FrameStrobe[0] latch
X_0238_ _0238_/Q Tile_X0Y0_FrameData[24] VGND VPWR Tile_X0Y5_FrameStrobe[5] latch
X_0169_ _0169_/Q Tile_X0Y0_FrameData[29] VGND VPWR Tile_X0Y5_FrameStrobe[3] latch
XFILLER_70_118 VPWR VGND sg13cmos5l_decap_8
XANTENNA__0540__GATE Tile_X0Y5_FrameStrobe[7] VPWR VGND sg13cmos5l_antennanp
XFILLER_34_39 VPWR VGND sg13cmos5l_fill_1
XFILLER_297_34 VPWR VGND sg13cmos5l_fill_2
XANTENNA__1210__D Tile_X0Y4_FrameData[12] VPWR VGND sg13cmos5l_antennanp
XFILLER_211_179 VPWR VGND sg13cmos5l_decap_8
XFILLER_126_8 VPWR VGND sg13cmos5l_fill_1
XANTENNA__0555__GATE Tile_X0Y5_FrameStrobe[0] VPWR VGND sg13cmos5l_antennanp
XFILLER_166_38 VPWR VGND sg13cmos5l_fill_1
XFILLER_117_194 VPWR VGND sg13cmos5l_decap_8
XFILLER_246_82 VPWR VGND sg13cmos5l_decap_8
XANTENNA__2109__A0 Tile_X0Y3_W2MID[3] VPWR VGND sg13cmos5l_antennanp
XANTENNA__2372__A3 Tile_X0Y0_S4END[4] VPWR VGND sg13cmos5l_antennanp
XFILLER_132_131 VPWR VGND sg13cmos5l_fill_1
XFILLER_182_26 VPWR VGND sg13cmos5l_decap_8
XFILLER_278_135 VPWR VGND sg13cmos5l_decap_8
XFILLER_278_146 VPWR VGND sg13cmos5l_fill_2
XFILLER_78_207 VPWR VGND sg13cmos5l_decap_8
XFILLER_182_37 VPWR VGND sg13cmos5l_fill_2
XFILLER_219_213 VPWR VGND sg13cmos5l_fill_2
XFILLER_332_29 VPWR VGND sg13cmos5l_decap_8
XANTENNA__0496__D Tile_X0Y1_FrameData[6] VPWR VGND sg13cmos5l_antennanp
XFILLER_115_86 VPWR VGND sg13cmos5l_decap_8
XFILLER_286_190 VPWR VGND sg13cmos5l_decap_8
XANTENNA__1522__X Tile_X0Y3_E2BEGb[4] VPWR VGND sg13cmos5l_antennanp
XANTENNA__2832__A1 Tile_X0Y4_W2END[4] VPWR VGND sg13cmos5l_antennanp
XFILLER_199_120 VPWR VGND sg13cmos5l_decap_8
XFILLER_199_142 VPWR VGND sg13cmos5l_decap_8
XANTENNA__0508__GATE Tile_X0Y5_FrameStrobe[6] VPWR VGND sg13cmos5l_antennanp
XFILLER_202_113 VPWR VGND sg13cmos5l_fill_2
XFILLER_145_0 VPWR VGND sg13cmos5l_decap_8
XFILLER_202_157 VPWR VGND sg13cmos5l_decap_8
XFILLER_91_78 VPWR VGND sg13cmos5l_decap_8
XANTENNA__1120__D Tile_X0Y4_FrameData[6] VPWR VGND sg13cmos5l_antennanp
XFILLER_24_83 VPWR VGND sg13cmos5l_decap_8
XFILLER_312_0 VPWR VGND sg13cmos5l_fill_1
XANTENNA__2348__A0 Tile_X0Y2_W1END[3] VPWR VGND sg13cmos5l_antennanp
XFILLER_108_183 VPWR VGND sg13cmos5l_decap_4
XFILLER_123_120 VPWR VGND sg13cmos5l_fill_2
XFILLER_156_60 VPWR VGND sg13cmos5l_decap_8
XANTENNA__2363__A3 Tile_X0Y5_W6END[11] VPWR VGND sg13cmos5l_antennanp
XFILLER_123_153 VPWR VGND sg13cmos5l_decap_8
XFILLER_269_113 VPWR VGND sg13cmos5l_fill_2
XFILLER_306_30 VPWR VGND sg13cmos5l_decap_4
XFILLER_242_18 VPWR VGND sg13cmos5l_decap_4
XFILLER_242_29 VPWR VGND sg13cmos5l_fill_2
X_2190_ _2190_/X AXIL_S_SOC_WDATA21 AXIL_S_SOC_WDATA25 _2234_/X _2247_/X _0216_/Q
+ _0215_/Q VPWR VGND sg13cmos5l_mux4_1
X_1210_ _1210_/Q Tile_X0Y4_FrameData[12] VGND VPWR Tile_X0Y5_FrameStrobe[5] latch
XFILLER_306_85 VPWR VGND sg13cmos5l_decap_8
XANTENNA__2520__A0 AXIL_S_SOC_ARADDR1 VPWR VGND sg13cmos5l_antennanp
XFILLER_172_70 VPWR VGND sg13cmos5l_decap_8
X_1141_ _1141_/Q Tile_X0Y4_FrameData[17] VGND VPWR Tile_X0Y5_FrameStrobe[3] latch
XFILLER_225_205 VPWR VGND sg13cmos5l_decap_4
XFILLER_92_221 VPWR VGND sg13cmos5l_fill_2
XFILLER_92_210 VPWR VGND sg13cmos5l_decap_4
XFILLER_292_193 VPWR VGND sg13cmos5l_decap_8
X_1072_ _1072_/Q Tile_X0Y4_FrameData[22] VGND VPWR Tile_X0Y5_FrameStrobe[1] latch
XANTENNA__2823__A1 Tile_X0Y5_N4END[0] VPWR VGND sg13cmos5l_antennanp
XANTENNA__1270__GATE Tile_X0Y5_FrameStrobe[0] VPWR VGND sg13cmos5l_antennanp
XFILLER_60_151 VPWR VGND sg13cmos5l_fill_2
XANTENNA__1030__D Tile_X0Y3_FrameData[16] VPWR VGND sg13cmos5l_antennanp
X_1974_ Tile_X0Y5_E2BEG[3] _2728_/X VPWR VGND sg13cmos5l_buf_1
XFILLER_146_223 VPWR VGND sg13cmos5l_fill_1
X_0925_ _0925_/Q Tile_X0Y3_FrameData[25] VGND VPWR Tile_X0Y5_FrameStrobe[4] latch
XANTENNA__1285__GATE Tile_X0Y5_FrameStrobe[0] VPWR VGND sg13cmos5l_antennanp
X_0856_ _0856_/Q Tile_X0Y3_FrameData[30] VGND VPWR Tile_X0Y5_FrameStrobe[2] latch
XFILLER_362_164 VPWR VGND sg13cmos5l_fill_1
XFILLER_362_153 VPWR VGND sg13cmos5l_decap_4
XFILLER_347_70 VPWR VGND sg13cmos5l_decap_8
XANTENNA__1607__X Tile_X0Y0_N4BEG[3] VPWR VGND sg13cmos5l_antennanp
XFILLER_114_120 VPWR VGND sg13cmos5l_decap_8
X_0787_ _0787_/Q Tile_X0Y2_FrameData[19] VGND VPWR Tile_X0Y5_FrameStrobe[7] latch
XANTENNA__2354__A3 Tile_X0Y0_S4END[6] VPWR VGND sg13cmos5l_antennanp
X_2526_ _2526_/X AXIL_S_SOC_ARADDR1 AXIL_S_SOC_ARADDR3 _2575_/X _2595_/X _0952_/Q
+ _0951_/Q VPWR VGND sg13cmos5l_mux4_1
X_2457_ _2457_/X Tile_X0Y1_W1END[0] Tile_X0Y1_W6END[8] _2361_/X _2337_/X _0418_/Q
+ _0417_/Q VPWR VGND sg13cmos5l_mux4_1
XFILLER_114_197 VPWR VGND sg13cmos5l_decap_8
XFILLER_152_18 VPWR VGND sg13cmos5l_decap_8
X_1408_ _1408_/Q Tile_X0Y5_FrameData[16] VGND VPWR Tile_X0Y5_FrameStrobe[4] latch
XANTENNA__2511__A0 AXIL_S_SOC_ARADDR0 VPWR VGND sg13cmos5l_antennanp
X_2388_ _2388_/X Tile_X0Y3_W2MID[4] Tile_X0Y3_W2END[4] Tile_X0Y3_W6END[4] _2592_/X
+ _1016_/Q _1015_/Q VPWR VGND sg13cmos5l_mux4_1
XANTENNA__1205__D Tile_X0Y4_FrameData[17] VPWR VGND sg13cmos5l_antennanp
XANTENNA__1223__GATE Tile_X0Y5_FrameStrobe[6] VPWR VGND sg13cmos5l_antennanp
XFILLER_290_119 VPWR VGND sg13cmos5l_decap_8
X_1339_ _1339_/Q Tile_X0Y5_FrameData[21] VGND VPWR Tile_X0Y5_FrameStrobe[2] latch
XFILLER_83_210 VPWR VGND sg13cmos5l_fill_1
XANTENNA__2814__A1 Tile_X0Y5_N4END[0] VPWR VGND sg13cmos5l_antennanp
XFILLER_231_208 VPWR VGND sg13cmos5l_fill_2
XFILLER_101_22 VPWR VGND sg13cmos5l_decap_8
XFILLER_250_9 VPWR VGND sg13cmos5l_decap_8
XANTENNA__1238__GATE Tile_X0Y5_FrameStrobe[6] VPWR VGND sg13cmos5l_antennanp
XANTENNA__2290__A2 AXIL_S_SOC_WDATA3 VPWR VGND sg13cmos5l_antennanp
XFILLER_51_173 VPWR VGND sg13cmos5l_fill_1
XFILLER_51_151 VPWR VGND sg13cmos5l_decap_8
XFILLER_196_145 VPWR VGND sg13cmos5l_decap_8
XFILLER_236_7 VPWR VGND sg13cmos5l_fill_1
XANTENNA__0494__GATE Tile_X0Y5_FrameStrobe[5] VPWR VGND sg13cmos5l_antennanp
XFILLER_131_6 VPWR VGND sg13cmos5l_decap_4
XFILLER_137_212 VPWR VGND sg13cmos5l_decap_4
XFILLER_137_223 VPWR VGND sg13cmos5l_fill_1
XFILLER_338_183 VPWR VGND sg13cmos5l_decap_4
XFILLER_327_18 VPWR VGND sg13cmos5l_fill_2
XFILLER_353_153 VPWR VGND sg13cmos5l_decap_8
XFILLER_193_14 VPWR VGND sg13cmos5l_fill_2
XFILLER_257_92 VPWR VGND sg13cmos5l_decap_8
XANTENNA__2750__A0 AXIL_S_SOC_ARPROT0 VPWR VGND sg13cmos5l_antennanp
XFILLER_105_186 VPWR VGND sg13cmos5l_decap_8
XFILLER_126_52 VPWR VGND sg13cmos5l_fill_1
XFILLER_343_17 VPWR VGND sg13cmos5l_fill_2
XFILLER_120_145 VPWR VGND sg13cmos5l_decap_8
XFILLER_266_138 VPWR VGND sg13cmos5l_decap_8
XANTENNA__0432__GATE Tile_X0Y5_FrameStrobe[3] VPWR VGND sg13cmos5l_antennanp
XANTENNA__2502__A0 Tile_X0Y4_W2MID[1] VPWR VGND sg13cmos5l_antennanp
XFILLER_266_149 VPWR VGND sg13cmos5l_fill_2
XFILLER_86_78 VPWR VGND sg13cmos5l_decap_8
XANTENNA__1115__D Tile_X0Y4_FrameData[11] VPWR VGND sg13cmos5l_antennanp
XFILLER_19_50 VPWR VGND sg13cmos5l_decap_8
XFILLER_19_148 VPWR VGND sg13cmos5l_fill_2
XANTENNA__0447__GATE Tile_X0Y5_FrameStrobe[4] VPWR VGND sg13cmos5l_antennanp
XANTENNA__0954__D Tile_X0Y3_FrameData[28] VPWR VGND sg13cmos5l_antennanp
XFILLER_262_0 VPWR VGND sg13cmos5l_decap_8
XANTENNA__2805__A1 Tile_X0Y5_N4END[2] VPWR VGND sg13cmos5l_antennanp
XANTENNA__2281__A2 Tile_X0Y3_WW4END[7] VPWR VGND sg13cmos5l_antennanp
XFILLER_35_82 VPWR VGND sg13cmos5l_decap_8
XANTENNA__2083__X Tile_X0Y5_UserCLKo VPWR VGND sg13cmos5l_antennanp
XANTENNA__2569__A0 Tile_X0Y2_W1END[2] VPWR VGND sg13cmos5l_antennanp
XFILLER_187_167 VPWR VGND sg13cmos5l_fill_2
XFILLER_336_109 VPWR VGND sg13cmos5l_fill_1
X_0710_ _0710_/Q Tile_X0Y2_FrameData[0] VGND VPWR Tile_X0Y5_FrameStrobe[4] latch
XFILLER_51_70 VPWR VGND sg13cmos5l_fill_1
XFILLER_329_183 VPWR VGND sg13cmos5l_fill_2
XANTENNA__2584__A3 Tile_X0Y0_S4END[14] VPWR VGND sg13cmos5l_antennanp
X_1690_ Tile_X0Y0_FrameData_O[30] Tile_X0Y0_FrameData[30] VPWR VGND sg13cmos5l_buf_1
X_0641_ _0641_/Q Tile_X0Y2_FrameData[5] VGND VPWR Tile_X0Y5_FrameStrobe[2] latch
XFILLER_344_175 VPWR VGND sg13cmos5l_decap_4
X_0572_ _0572_/Q Tile_X0Y2_FrameData[10] VGND VPWR Tile_X0Y5_FrameStrobe[0] latch
XANTENNA__2741__A0 AXIL_S_SOC_ARPROT0 VPWR VGND sg13cmos5l_antennanp
XFILLER_111_112 VPWR VGND sg13cmos5l_decap_4
X_2311_ _2311_/X AXIL_S_SOC_WDATA2 AXIL_S_SOC_WDATA14 _2357_/X _2378_/X _0470_/Q _0469_/Q
+ VPWR VGND sg13cmos5l_mux4_1
XFILLER_253_39 VPWR VGND sg13cmos5l_decap_4
XFILLER_111_178 VPWR VGND sg13cmos5l_decap_8
XFILLER_257_149 VPWR VGND sg13cmos5l_decap_4
X_2242_ _2242_/X _2252_/X _2251_/X Tile_X0Y0_S2MID[1] Tile_X0Y0_S2END[1] _0092_/Q
+ _0091_/Q VPWR VGND sg13cmos5l_mux4_1
XANTENNA__1025__D Tile_X0Y3_FrameData[21] VPWR VGND sg13cmos5l_antennanp
XANTENNA__1603__A Tile_X0Y0_UserCLK VPWR VGND sg13cmos5l_antennanp
X_2173_ _2173_/X AXIL_S_SOC_WDATA16 AXIL_S_SOC_WDATA24 _2241_/X _2248_/X _0250_/Q
+ _0249_/Q VPWR VGND sg13cmos5l_mux4_1
X_1124_ _1124_/Q Tile_X0Y4_FrameData[2] VGND VPWR Tile_X0Y5_FrameStrobe[2] latch
XANTENNA__0864__D Tile_X0Y3_FrameData[22] VPWR VGND sg13cmos5l_antennanp
XFILLER_202_43 VPWR VGND sg13cmos5l_decap_8
X_1055_ _1055_/Q Tile_X0Y4_FrameData[7] VGND VPWR Tile_X0Y5_FrameStrobe[0] latch
XFILLER_15_19 VPWR VGND sg13cmos5l_fill_2
XFILLER_280_185 VPWR VGND sg13cmos5l_decap_8
XFILLER_178_112 VPWR VGND sg13cmos5l_decap_8
XFILLER_33_173 VPWR VGND sg13cmos5l_decap_8
XFILLER_193_126 VPWR VGND sg13cmos5l_fill_2
X_1957_ Tile_X0Y1_E2BEG[2] _2295_/X VPWR VGND sg13cmos5l_buf_1
XFILLER_335_120 VPWR VGND sg13cmos5l_decap_4
XFILLER_31_29 VPWR VGND sg13cmos5l_fill_2
XANTENNA__2575__A3 Tile_X0Y0_S4END[14] VPWR VGND sg13cmos5l_antennanp
X_1888_ Tile_X0Y1_FrameData_O[1] Tile_X0Y1_FrameData[1] VPWR VGND sg13cmos5l_buf_1
X_0908_ _0908_/Q Tile_X0Y3_FrameData[10] VGND VPWR Tile_X0Y5_FrameStrobe[3] latch
X_0839_ _0839_/Q Tile_X0Y3_FrameData[15] VGND VPWR Tile_X0Y5_FrameStrobe[1] latch
XFILLER_350_123 VPWR VGND sg13cmos5l_decap_8
XANTENNA__0104__D Tile_X0Y0_FrameData[30] VPWR VGND sg13cmos5l_antennanp
XFILLER_227_51 VPWR VGND sg13cmos5l_decap_4
XANTENNA__2732__A0 AXIL_S_SOC_ARPROT0 VPWR VGND sg13cmos5l_antennanp
XFILLER_163_17 VPWR VGND sg13cmos5l_decap_8
X_2509_ _2509_/X AXIL_S_SOC_ARADDR0 AXIL_S_SOC_ARADDR8 _2589_/X _2596_/X _0986_/Q
+ _0985_/Q VPWR VGND sg13cmos5l_mux4_1
XFILLER_102_145 VPWR VGND sg13cmos5l_decap_8
XFILLER_298_9 VPWR VGND sg13cmos5l_fill_1
XFILLER_102_156 VPWR VGND sg13cmos5l_fill_1
XFILLER_102_178 VPWR VGND sg13cmos5l_decap_8
XFILLER_248_149 VPWR VGND sg13cmos5l_fill_1
XANTENNA__1162__GATE Tile_X0Y5_FrameStrobe[4] VPWR VGND sg13cmos5l_antennanp
XFILLER_263_119 VPWR VGND sg13cmos5l_decap_8
XANTENNA__0774__D Tile_X0Y2_FrameData[0] VPWR VGND sg13cmos5l_antennanp
XFILLER_16_118 VPWR VGND sg13cmos5l_fill_2
XFILLER_16_129 VPWR VGND sg13cmos5l_fill_1
XFILLER_271_152 VPWR VGND sg13cmos5l_decap_4
XANTENNA__1177__GATE Tile_X0Y5_FrameStrobe[4] VPWR VGND sg13cmos5l_antennanp
XANTENNA__1800__X Tile_X0Y4_E2BEGb[3] VPWR VGND sg13cmos5l_antennanp
XANTENNA__2799__A0 Tile_X0Y5_N2MID[5] VPWR VGND sg13cmos5l_antennanp
XANTENNA__2263__A2 Tile_X0Y2_W6END[0] VPWR VGND sg13cmos5l_antennanp
XFILLER_358_223 VPWR VGND sg13cmos5l_fill_1
XFILLER_188_69 VPWR VGND sg13cmos5l_fill_2
XANTENNA__1100__GATE Tile_X0Y5_FrameStrobe[2] VPWR VGND sg13cmos5l_antennanp
XFILLER_184_115 VPWR VGND sg13cmos5l_fill_1
XFILLER_338_17 VPWR VGND sg13cmos5l_fill_2
XFILLER_184_137 VPWR VGND sg13cmos5l_decap_8
XFILLER_326_131 VPWR VGND sg13cmos5l_decap_8
XFILLER_192_192 VPWR VGND sg13cmos5l_decap_8
XFILLER_341_101 VPWR VGND sg13cmos5l_decap_8
XFILLER_326_197 VPWR VGND sg13cmos5l_fill_2
XANTENNA__1115__GATE Tile_X0Y5_FrameStrobe[2] VPWR VGND sg13cmos5l_antennanp
XFILLER_137_62 VPWR VGND sg13cmos5l_fill_2
XFILLER_354_16 VPWR VGND sg13cmos5l_decap_8
XANTENNA__0949__D Tile_X0Y3_FrameData[1] VPWR VGND sg13cmos5l_antennanp
XANTENNA__2723__A0 Tile_X0Y5_N1END[2] VPWR VGND sg13cmos5l_antennanp
XFILLER_137_95 VPWR VGND sg13cmos5l_decap_8
XFILLER_140_207 VPWR VGND sg13cmos5l_decap_4
XFILLER_284_90 VPWR VGND sg13cmos5l_decap_8
XANTENNA__0371__GATE Tile_X0Y5_FrameStrobe[1] VPWR VGND sg13cmos5l_antennanp
XFILLER_239_149 VPWR VGND sg13cmos5l_decap_8
XFILLER_294_222 VPWR VGND sg13cmos5l_fill_2
XANTENNA__2078__X Tile_X0Y5_S4BEG[11] VPWR VGND sg13cmos5l_antennanp
XFILLER_11_9 VPWR VGND sg13cmos5l_fill_2
XFILLER_153_83 VPWR VGND sg13cmos5l_decap_8
XFILLER_254_119 VPWR VGND sg13cmos5l_decap_8
XFILLER_303_53 VPWR VGND sg13cmos5l_decap_8
XANTENNA__0386__GATE Tile_X0Y5_FrameStrobe[2] VPWR VGND sg13cmos5l_antennanp
XANTENNA__0684__D Tile_X0Y2_FrameData[26] VPWR VGND sg13cmos5l_antennanp
XANTENNA__1710__X Tile_X0Y0_E6BEG[2] VPWR VGND sg13cmos5l_antennanp
XANTENNA__2254__A2 Tile_X0Y1_W6END[5] VPWR VGND sg13cmos5l_antennanp
X_1811_ Tile_X0Y4_E6BEG[6] _2655_/X VPWR VGND sg13cmos5l_buf_1
XFILLER_178_91 VPWR VGND sg13cmos5l_decap_8
X_2791_ _2791_/X Tile_X0Y5_N1END[2] _2795_/X Tile_X0Y5_W6END[2] _2791_/A3 _1268_/Q
+ _1267_/Q VPWR VGND sg13cmos5l_mux4_1
XFILLER_7_20 VPWR VGND sg13cmos5l_fill_1
XANTENNA__0324__GATE Tile_X0Y5_FrameStrobe[0] VPWR VGND sg13cmos5l_antennanp
XANTENNA__2557__A3 Tile_X0Y3_W6END[6] VPWR VGND sg13cmos5l_antennanp
XFILLER_190_107 VPWR VGND sg13cmos5l_decap_8
X_1742_ Tile_X0Y2_FrameData_O[2] Tile_X0Y2_FrameData[2] VPWR VGND sg13cmos5l_buf_1
XANTENNA__0954__GATE Tile_X0Y5_FrameStrobe[5] VPWR VGND sg13cmos5l_antennanp
X_1673_ Tile_X0Y0_FrameData_O[13] Tile_X0Y0_FrameData[13] VPWR VGND sg13cmos5l_buf_1
XFILLER_317_175 VPWR VGND sg13cmos5l_fill_1
X_0624_ _0624_/Q Tile_X0Y2_FrameData[22] VGND VPWR Tile_X0Y5_FrameStrobe[2] latch
XFILLER_332_156 VPWR VGND sg13cmos5l_decap_4
XFILLER_328_94 VPWR VGND sg13cmos5l_fill_1
XANTENNA__0859__D Tile_X0Y3_FrameData[27] VPWR VGND sg13cmos5l_antennanp
XANTENNA__2714__A0 Tile_X0Y3_W2MID[6] VPWR VGND sg13cmos5l_antennanp
XFILLER_131_207 VPWR VGND sg13cmos5l_decap_4
XFILLER_332_189 VPWR VGND sg13cmos5l_fill_1
XANTENNA__0339__GATE Tile_X0Y5_FrameStrobe[0] VPWR VGND sg13cmos5l_antennanp
XANTENNA__2190__A1 AXIL_S_SOC_WDATA25 VPWR VGND sg13cmos5l_antennanp
X_0555_ _0555_/Q Tile_X0Y2_FrameData[27] VGND VPWR Tile_X0Y5_FrameStrobe[0] latch
XFILLER_344_71 VPWR VGND sg13cmos5l_decap_8
XANTENNA__0969__GATE Tile_X0Y5_FrameStrobe[5] VPWR VGND sg13cmos5l_antennanp
X_0486_ _0486_/Q Tile_X0Y1_FrameData[16] VGND VPWR Tile_X0Y5_FrameStrobe[5] latch
X_2225_ _2225_/X _2214_/X _0066_/X Tile_X0Y0_S1END[1] Tile_X0Y0_S4END[1] _0100_/Q
+ _0099_/Q VPWR VGND sg13cmos5l_mux4_1
XFILLER_38_221 VPWR VGND sg13cmos5l_fill_2
XANTENNA__0594__D Tile_X0Y2_FrameData[20] VPWR VGND sg13cmos5l_antennanp
XANTENNA__2493__A2 Tile_X0Y1_W6END[10] VPWR VGND sg13cmos5l_antennanp
XFILLER_213_75 VPWR VGND sg13cmos5l_decap_8
X_2156_ _2156_/X _2238_/X _2237_/X _2226_/X _2225_/X _0283_/Q _0282_/Q VPWR VGND sg13cmos5l_mux4_1
XANTENNA__1620__X Tile_X0Y0_N2BEGb[0] VPWR VGND sg13cmos5l_antennanp
XFILLER_289_24 VPWR VGND sg13cmos5l_decap_4
X_2087_ Tile_X0Y3_E1BEG[3] _2508_/X VPWR VGND sg13cmos5l_buf_1
X_1107_ _1107_/Q Tile_X0Y4_FrameData[19] VGND VPWR Tile_X0Y5_FrameStrobe[2] latch
XANTENNA__2245__A2 Tile_X0Y0_S2MID[4] VPWR VGND sg13cmos5l_antennanp
X_1038_ _1038_/Q Tile_X0Y4_FrameData[24] VGND VPWR Tile_X0Y5_FrameStrobe[0] latch
XANTENNA__0907__GATE Tile_X0Y5_FrameStrobe[3] VPWR VGND sg13cmos5l_antennanp
XFILLER_21_121 VPWR VGND sg13cmos5l_decap_8
XFILLER_166_137 VPWR VGND sg13cmos5l_decap_4
XFILLER_181_107 VPWR VGND sg13cmos5l_decap_8
XFILLER_174_16 VPWR VGND sg13cmos5l_fill_2
XANTENNA__0769__D Tile_X0Y2_FrameData[5] VPWR VGND sg13cmos5l_antennanp
XFILLER_122_207 VPWR VGND sg13cmos5l_decap_4
XFILLER_174_49 VPWR VGND sg13cmos5l_decap_4
XANTENNA__2181__A1 AXIL_S_SOC_WDATA28 VPWR VGND sg13cmos5l_antennanp
XFILLER_324_19 VPWR VGND sg13cmos5l_decap_8
XFILLER_254_93 VPWR VGND sg13cmos5l_fill_2
XFILLER_29_221 VPWR VGND sg13cmos5l_fill_2
XFILLER_229_182 VPWR VGND sg13cmos5l_fill_1
XFILLER_340_18 VPWR VGND sg13cmos5l_fill_2
XFILLER_83_13 VPWR VGND sg13cmos5l_decap_8
XANTENNA__1530__X Tile_X0Y3_E6BEG[4] VPWR VGND sg13cmos5l_antennanp
XANTENNA__2236__A2 Tile_X0Y0_S1END[2] VPWR VGND sg13cmos5l_antennanp
XFILLER_16_40 VPWR VGND sg13cmos5l_decap_8
XFILLER_83_79 VPWR VGND sg13cmos5l_decap_4
XFILLER_349_16 VPWR VGND sg13cmos5l_decap_8
XFILLER_279_90 VPWR VGND sg13cmos5l_decap_8
XFILLER_148_50 VPWR VGND sg13cmos5l_decap_8
XFILLER_32_50 VPWR VGND sg13cmos5l_decap_4
XANTENNA__1054__GATE Tile_X0Y5_FrameStrobe[0] VPWR VGND sg13cmos5l_antennanp
XFILLER_165_192 VPWR VGND sg13cmos5l_decap_4
XANTENNA__0679__D Tile_X0Y2_FrameData[31] VPWR VGND sg13cmos5l_antennanp
XANTENNA__1705__X Tile_X0Y0_EE4BEG[13] VPWR VGND sg13cmos5l_antennanp
XANTENNA__2172__A1 AXIL_S_SOC_WDATA31 VPWR VGND sg13cmos5l_antennanp
XFILLER_164_60 VPWR VGND sg13cmos5l_decap_8
XFILLER_180_195 VPWR VGND sg13cmos5l_decap_4
XANTENNA__1069__GATE Tile_X0Y5_FrameStrobe[1] VPWR VGND sg13cmos5l_antennanp
XFILLER_164_93 VPWR VGND sg13cmos5l_decap_8
X_0340_ _0340_/Q Tile_X0Y1_FrameData[2] VGND VPWR Tile_X0Y5_FrameStrobe[0] latch
X_0271_ _0271_/Q Tile_X0Y0_FrameData[23] VGND VPWR Tile_X0Y5_FrameStrobe[6] latch
XFILLER_94_135 VPWR VGND sg13cmos5l_decap_8
XFILLER_79_176 VPWR VGND sg13cmos5l_decap_8
X_2010_ Tile_X0Y5_EE4BEG[11] _2752_/X VPWR VGND sg13cmos5l_buf_1
XANTENNA__1303__D Tile_X0Y5_FrameData[25] VPWR VGND sg13cmos5l_antennanp
XANTENNA__2227__A2 Tile_X0Y4_W6END[10] VPWR VGND sg13cmos5l_antennanp
XANTENNA__1007__GATE Tile_X0Y5_FrameStrobe[6] VPWR VGND sg13cmos5l_antennanp
XFILLER_259_27 VPWR VGND sg13cmos5l_decap_8
XFILLER_330_95 VPWR VGND sg13cmos5l_fill_2
XANTENNA__0263__GATE Tile_X0Y5_FrameStrobe[6] VPWR VGND sg13cmos5l_antennanp
XANTENNA__0893__GATE Tile_X0Y5_FrameStrobe[3] VPWR VGND sg13cmos5l_antennanp
X_2774_ _2774_/X Tile_X0Y5_W2MID[6] Tile_X0Y5_W2END[6] Tile_X0Y5_W6END[9] _2826_/X
+ _1354_/Q _1353_/Q VPWR VGND sg13cmos5l_mux4_1
XFILLER_352_207 VPWR VGND sg13cmos5l_fill_2
XFILLER_163_118 VPWR VGND sg13cmos5l_decap_8
X_1725_ Tile_X0Y0_E2BEGb[5] _2178_/X VPWR VGND sg13cmos5l_buf_1
XANTENNA__0278__GATE Tile_X0Y5_FrameStrobe[6] VPWR VGND sg13cmos5l_antennanp
XANTENNA__0589__D Tile_X0Y2_FrameData[25] VPWR VGND sg13cmos5l_antennanp
XFILLER_171_151 VPWR VGND sg13cmos5l_fill_2
X_1656_ Tile_X0Y0_FrameStrobe_O[16] Tile_X0Y5_FrameStrobe[16] VPWR VGND sg13cmos5l_buf_1
XFILLER_355_81 VPWR VGND sg13cmos5l_decap_8
XFILLER_305_178 VPWR VGND sg13cmos5l_fill_1
XANTENNA__1615__X Tile_X0Y0_N4BEG[11] VPWR VGND sg13cmos5l_antennanp
XFILLER_171_195 VPWR VGND sg13cmos5l_decap_8
XFILLER_208_97 VPWR VGND sg13cmos5l_decap_4
X_1587_ Tile_X0Y2_EE4BEG[0] _2417_/X VPWR VGND sg13cmos5l_buf_1
X_0607_ _0607_/Q Tile_X0Y2_FrameData[7] VGND VPWR Tile_X0Y5_FrameStrobe[1] latch
XANTENNA__2163__A1 Tile_X0Y0_S1END[2] VPWR VGND sg13cmos5l_antennanp
XFILLER_258_222 VPWR VGND sg13cmos5l_fill_2
X_0538_ _0538_/Q Tile_X0Y1_FrameData[28] VGND VPWR Tile_X0Y5_FrameStrobe[7] latch
XANTENNA__0201__GATE Tile_X0Y5_FrameStrobe[4] VPWR VGND sg13cmos5l_antennanp
XANTENNA__0831__GATE Tile_X0Y5_FrameStrobe[1] VPWR VGND sg13cmos5l_antennanp
XFILLER_218_119 VPWR VGND sg13cmos5l_fill_1
X_0469_ _0469_/Q Tile_X0Y1_FrameData[1] VGND VPWR Tile_X0Y5_FrameStrobe[4] latch
XFILLER_160_18 VPWR VGND sg13cmos5l_decap_8
X_2208_ _2208_/X AXIL_S_SOC_WDATA19 _2240_/X _2239_/X _2248_/X _0180_/Q _0179_/Q VPWR
+ VGND sg13cmos5l_mux4_1
XANTENNA__0216__GATE Tile_X0Y5_FrameStrobe[4] VPWR VGND sg13cmos5l_antennanp
XANTENNA__1213__D Tile_X0Y4_FrameData[9] VPWR VGND sg13cmos5l_antennanp
XFILLER_240_40 VPWR VGND sg13cmos5l_decap_4
X_2139_ AXIL_S_SOC_RRESP1 Tile_X0Y5_W2MID[2] Tile_X0Y5_W2END[2] Tile_X0Y5_W6END[2]
+ _2827_/X _1324_/Q _1323_/Q VPWR VGND sg13cmos5l_mux4_1
XANTENNA__0846__GATE Tile_X0Y5_FrameStrobe[1] VPWR VGND sg13cmos5l_antennanp
XFILLER_241_111 VPWR VGND sg13cmos5l_decap_4
XANTENNA__2218__A2 Tile_X0Y0_S1END[3] VPWR VGND sg13cmos5l_antennanp
XFILLER_316_7 VPWR VGND sg13cmos5l_fill_2
XFILLER_154_118 VPWR VGND sg13cmos5l_decap_8
XFILLER_147_192 VPWR VGND sg13cmos5l_fill_2
XFILLER_162_173 VPWR VGND sg13cmos5l_decap_8
XFILLER_78_24 VPWR VGND sg13cmos5l_decap_4
XFILLER_78_13 VPWR VGND sg13cmos5l_fill_1
XANTENNA__0499__D Tile_X0Y1_FrameData[3] VPWR VGND sg13cmos5l_antennanp
XFILLER_118_86 VPWR VGND sg13cmos5l_decap_8
XFILLER_265_92 VPWR VGND sg13cmos5l_decap_8
XANTENNA__1525__X Tile_X0Y3_E2BEGb[7] VPWR VGND sg13cmos5l_antennanp
XFILLER_78_79 VPWR VGND sg13cmos5l_decap_8
XFILLER_94_34 VPWR VGND sg13cmos5l_decap_8
XFILLER_94_12 VPWR VGND sg13cmos5l_fill_2
XFILLER_76_157 VPWR VGND sg13cmos5l_decap_8
XFILLER_76_168 VPWR VGND sg13cmos5l_fill_2
XANTENNA__1123__D Tile_X0Y4_FrameData[3] VPWR VGND sg13cmos5l_antennanp
XFILLER_175_0 VPWR VGND sg13cmos5l_fill_1
XFILLER_217_196 VPWR VGND sg13cmos5l_decap_8
XFILLER_27_94 VPWR VGND sg13cmos5l_decap_8
XANTENNA__0962__D Tile_X0Y3_FrameData[20] VPWR VGND sg13cmos5l_antennanp
XANTENNA__2209__A2 Tile_X0Y0_W6END[0] VPWR VGND sg13cmos5l_antennanp
XFILLER_232_144 VPWR VGND sg13cmos5l_decap_8
XFILLER_342_0 VPWR VGND sg13cmos5l_decap_8
XFILLER_232_177 VPWR VGND sg13cmos5l_fill_2
XFILLER_300_76 VPWR VGND sg13cmos5l_fill_2
XFILLER_300_98 VPWR VGND sg13cmos5l_fill_2
XANTENNA__2091__X Tile_X0Y3_E2BEG[3] VPWR VGND sg13cmos5l_antennanp
XFILLER_145_107 VPWR VGND sg13cmos5l_decap_8
XFILLER_309_30 VPWR VGND sg13cmos5l_decap_8
XANTENNA__2393__A1 Tile_X0Y0_W2MID[1] VPWR VGND sg13cmos5l_antennanp
XFILLER_299_100 VPWR VGND sg13cmos5l_fill_2
X_1510_ _2340_/A3 VPWR VGND sg13cmos5l_tielo
X_2490_ _2490_/X Tile_X0Y4_W2MID[7] Tile_X0Y4_W2END[7] Tile_X0Y4_W6END[7] _2708_/X
+ _1256_/Q _1255_/Q VPWR VGND sg13cmos5l_mux4_1
XFILLER_153_195 VPWR VGND sg13cmos5l_decap_8
XFILLER_175_81 VPWR VGND sg13cmos5l_decap_8
X_1441_ _1441_/Q Tile_X0Y5_FrameData[15] VGND VPWR Tile_X0Y5_FrameStrobe[5] latch
XANTENNA__0202__D Tile_X0Y0_FrameData[28] VPWR VGND sg13cmos5l_antennanp
XANTENNA__2145__A1 Tile_X0Y0_W2END[7] VPWR VGND sg13cmos5l_antennanp
XFILLER_325_51 VPWR VGND sg13cmos5l_decap_8
X_1372_ _1372_/Q Tile_X0Y5_FrameData[20] VGND VPWR Tile_X0Y5_FrameStrobe[3] latch
XFILLER_67_102 VPWR VGND sg13cmos5l_decap_8
XFILLER_325_95 VPWR VGND sg13cmos5l_fill_2
X_0323_ _0323_/Q Tile_X0Y1_FrameData[19] VGND VPWR Tile_X0Y5_FrameStrobe[0] latch
X_0254_ _0254_/Q Tile_X0Y0_FrameData[8] VGND VPWR Tile_X0Y5_FrameStrobe[5] latch
XANTENNA__1033__D Tile_X0Y4_FrameData[29] VPWR VGND sg13cmos5l_antennanp
XFILLER_208_174 VPWR VGND sg13cmos5l_decap_8
X_0185_ _0185_/Q Tile_X0Y0_FrameData[13] VGND VPWR Tile_X0Y5_FrameStrobe[3] latch
XFILLER_82_127 VPWR VGND sg13cmos5l_decap_8
XFILLER_341_61 VPWR VGND sg13cmos5l_decap_8
XFILLER_208_196 VPWR VGND sg13cmos5l_decap_8
XFILLER_341_94 VPWR VGND sg13cmos5l_decap_8
XANTENNA__0872__D Tile_X0Y3_FrameData[14] VPWR VGND sg13cmos5l_antennanp
XFILLER_210_10 VPWR VGND sg13cmos5l_fill_2
XFILLER_90_0 VPWR VGND sg13cmos5l_fill_2
XFILLER_139_19 VPWR VGND sg13cmos5l_decap_8
X_2826_ _2826_/X Tile_X0Y5_N2MID[1] Tile_X0Y5_N2END[1] _2830_/X _2714_/X _1286_/Q
+ _1285_/Q VPWR VGND sg13cmos5l_mux4_1
XANTENNA__2384__A1 Tile_X0Y3_W2END[6] VPWR VGND sg13cmos5l_antennanp
XFILLER_129_192 VPWR VGND sg13cmos5l_decap_8
X_2757_ _2757_/X Tile_X0Y5_N4END[0] _0032_/X _2802_/X _2801_/X _1388_/Q _1387_/Q VPWR
+ VGND sg13cmos5l_mux4_1
XFILLER_219_96 VPWR VGND sg13cmos5l_decap_8
X_1708_ Tile_X0Y0_E6BEG[0] _2197_/X VPWR VGND sg13cmos5l_buf_1
X_2688_ _2688_/X _2678_/X Tile_X0Y5_N4END[6] _2677_/X _0024_/X _1058_/Q _1057_/Q VPWR
+ VGND sg13cmos5l_mux4_1
XANTENNA__1208__D Tile_X0Y4_FrameData[14] VPWR VGND sg13cmos5l_antennanp
X_1639_ Tile_X0Y0_N1BEG[3] _2144_/X VPWR VGND sg13cmos5l_buf_1
XANTENNA__0112__D Tile_X0Y0_FrameData[22] VPWR VGND sg13cmos5l_antennanp
XANTENNA__0140__GATE Tile_X0Y5_FrameStrobe[2] VPWR VGND sg13cmos5l_antennanp
XANTENNA__2136__A1 Tile_X0Y0_W2END[6] VPWR VGND sg13cmos5l_antennanp
XANTENNA__0770__GATE Tile_X0Y5_FrameStrobe[6] VPWR VGND sg13cmos5l_antennanp
XFILLER_100_210 VPWR VGND sg13cmos5l_fill_1
XFILLER_48_38 VPWR VGND sg13cmos5l_fill_1
XFILLER_280_9 VPWR VGND sg13cmos5l_decap_8
XFILLER_251_50 VPWR VGND sg13cmos5l_decap_8
XFILLER_73_116 VPWR VGND sg13cmos5l_fill_2
XANTENNA__0155__GATE Tile_X0Y5_FrameStrobe[2] VPWR VGND sg13cmos5l_antennanp
XANTENNA__0785__GATE Tile_X0Y5_FrameStrobe[7] VPWR VGND sg13cmos5l_antennanp
XFILLER_266_7 VPWR VGND sg13cmos5l_fill_2
XANTENNA__0782__D Tile_X0Y2_FrameData[24] VPWR VGND sg13cmos5l_antennanp
XFILLER_214_166 VPWR VGND sg13cmos5l_decap_8
XFILLER_259_6 VPWR VGND sg13cmos5l_decap_8
XANTENNA__2611__A2 Tile_X0Y2_W2END[0] VPWR VGND sg13cmos5l_antennanp
XFILLER_196_36 VPWR VGND sg13cmos5l_decap_8
XFILLER_127_107 VPWR VGND sg13cmos5l_decap_8
XANTENNA__0723__GATE Tile_X0Y5_FrameStrobe[5] VPWR VGND sg13cmos5l_antennanp
XFILLER_89_23 VPWR VGND sg13cmos5l_decap_8
XFILLER_346_28 VPWR VGND sg13cmos5l_decap_8
XFILLER_202_2 VPWR VGND sg13cmos5l_fill_1
XFILLER_276_91 VPWR VGND sg13cmos5l_decap_8
XFILLER_150_110 VPWR VGND sg13cmos5l_decap_8
XANTENNA__0108__GATE Tile_X0Y5_FrameStrobe[1] VPWR VGND sg13cmos5l_antennanp
XANTENNA__1118__D Tile_X0Y4_FrameData[8] VPWR VGND sg13cmos5l_antennanp
XANTENNA__2127__A1 Tile_X0Y1_W2END[5] VPWR VGND sg13cmos5l_antennanp
XFILLER_150_154 VPWR VGND sg13cmos5l_decap_8
XFILLER_1_120 VPWR VGND sg13cmos5l_fill_2
XANTENNA__0738__GATE Tile_X0Y5_FrameStrobe[5] VPWR VGND sg13cmos5l_antennanp
XANTENNA__0957__D Tile_X0Y3_FrameData[25] VPWR VGND sg13cmos5l_antennanp
XFILLER_292_0 VPWR VGND sg13cmos5l_fill_2
XFILLER_292_90 VPWR VGND sg13cmos5l_decap_8
XFILLER_49_113 VPWR VGND sg13cmos5l_fill_2
XFILLER_49_146 VPWR VGND sg13cmos5l_fill_2
XFILLER_49_179 VPWR VGND sg13cmos5l_fill_2
XANTENNA__2086__X Tile_X0Y3_E1BEG[2] VPWR VGND sg13cmos5l_antennanp
XFILLER_64_127 VPWR VGND sg13cmos5l_decap_8
XFILLER_311_20 VPWR VGND sg13cmos5l_fill_1
XANTENNA__0692__D Tile_X0Y2_FrameData[18] VPWR VGND sg13cmos5l_antennanp
X_1990_ Tile_X0Y5_E6BEG[3] _2760_/X VPWR VGND sg13cmos5l_buf_1
XFILLER_54_81 VPWR VGND sg13cmos5l_fill_2
XFILLER_54_70 VPWR VGND sg13cmos5l_fill_2
XFILLER_158_210 VPWR VGND sg13cmos5l_fill_2
X_0941_ _0941_/Q Tile_X0Y3_FrameData[9] VGND VPWR Tile_X0Y5_FrameStrobe[4] latch
XANTENNA__2602__A2 Tile_X0Y5_W6END[5] VPWR VGND sg13cmos5l_antennanp
XFILLER_118_107 VPWR VGND sg13cmos5l_decap_8
XFILLER_173_202 VPWR VGND sg13cmos5l_decap_4
X_0872_ _0872_/Q Tile_X0Y3_FrameData[14] VGND VPWR Tile_X0Y5_FrameStrobe[2] latch
XFILLER_256_28 VPWR VGND sg13cmos5l_decap_8
X_2611_ _2611_/X Tile_X0Y2_W1END[3] Tile_X0Y2_W2MID[0] Tile_X0Y2_W2END[0] _2488_/X
+ _0636_/Q _0635_/Q VPWR VGND sg13cmos5l_mux4_1
XFILLER_70_91 VPWR VGND sg13cmos5l_decap_4
XFILLER_126_151 VPWR VGND sg13cmos5l_fill_1
XFILLER_186_91 VPWR VGND sg13cmos5l_decap_8
X_2542_ _2542_/X Tile_X0Y5_N4END[9] Tile_X0Y0_S4END[13] _2576_/X _2575_/X _0920_/Q
+ _0919_/Q VPWR VGND sg13cmos5l_mux4_1
XFILLER_336_61 VPWR VGND sg13cmos5l_decap_4
XANTENNA__1028__D Tile_X0Y3_FrameData[18] VPWR VGND sg13cmos5l_antennanp
XANTENNA__2118__A1 Tile_X0Y2_W2END[4] VPWR VGND sg13cmos5l_antennanp
XFILLER_141_132 VPWR VGND sg13cmos5l_fill_1
XFILLER_287_114 VPWR VGND sg13cmos5l_decap_8
XFILLER_287_125 VPWR VGND sg13cmos5l_fill_2
X_2473_ _2473_/X _2464_/X Tile_X0Y5_N4END[15] _2463_/X Tile_X0Y0_S4END[11] _0592_/Q
+ _0591_/Q VPWR VGND sg13cmos5l_mux4_1
XANTENNA__2669__A2 Tile_X0Y4_W6END[0] VPWR VGND sg13cmos5l_antennanp
XFILLER_141_165 VPWR VGND sg13cmos5l_decap_8
XFILLER_272_38 VPWR VGND sg13cmos5l_decap_8
XFILLER_287_169 VPWR VGND sg13cmos5l_decap_4
X_1424_ _1424_/Q Tile_X0Y5_FrameData[0] VGND VPWR Tile_X0Y5_FrameStrobe[4] latch
XANTENNA__0867__D Tile_X0Y3_FrameData[19] VPWR VGND sg13cmos5l_antennanp
X_1355_ _1355_/Q Tile_X0Y5_FrameData[5] VGND VPWR Tile_X0Y5_FrameStrobe[2] latch
XFILLER_205_98 VPWR VGND sg13cmos5l_decap_8
X_0306_ _0306_/Q Tile_X0Y0_FrameData[20] VGND VPWR Tile_X0Y5_FrameStrobe[7] latch
XFILLER_55_116 VPWR VGND sg13cmos5l_fill_2
X_1286_ _1286_/Q Tile_X0Y5_FrameData[10] VGND VPWR Tile_X0Y5_FrameStrobe[0] latch
X_0237_ _0237_/Q Tile_X0Y0_FrameData[25] VGND VPWR Tile_X0Y5_FrameStrobe[5] latch
XFILLER_48_190 VPWR VGND sg13cmos5l_fill_1
XFILLER_221_75 VPWR VGND sg13cmos5l_fill_1
X_0168_ _0168_/Q Tile_X0Y0_FrameData[30] VGND VPWR Tile_X0Y5_FrameStrobe[3] latch
XFILLER_357_107 VPWR VGND sg13cmos5l_fill_1
XFILLER_211_147 VPWR VGND sg13cmos5l_decap_8
X_0099_ _0099_/Q Tile_X0Y0_FrameData[3] VGND VPWR Tile_X0Y5_FrameStrobe[0] latch
XANTENNA__0107__D Tile_X0Y0_FrameData[27] VPWR VGND sg13cmos5l_antennanp
X_2809_ _2809_/X Tile_X0Y5_N1END[1] Tile_X0Y5_N4END[1] _2794_/X _0059_/X _1294_/Q
+ _1293_/Q VPWR VGND sg13cmos5l_mux4_1
XANTENNA__1453__GATE Tile_X0Y5_FrameStrobe[5] VPWR VGND sg13cmos5l_antennanp
XFILLER_117_151 VPWR VGND sg13cmos5l_decap_4
XANTENNA__2109__A1 Tile_X0Y3_W2END[3] VPWR VGND sg13cmos5l_antennanp
XFILLER_278_114 VPWR VGND sg13cmos5l_decap_8
XANTENNA__0777__D Tile_X0Y2_FrameData[29] VPWR VGND sg13cmos5l_antennanp
XANTENNA__1468__GATE Tile_X0Y5_FrameStrobe[6] VPWR VGND sg13cmos5l_antennanp
XFILLER_332_19 VPWR VGND sg13cmos5l_decap_8
XANTENNA__0094__GATE Tile_X0Y5_FrameStrobe[0] VPWR VGND sg13cmos5l_antennanp
XANTENNA__1803__X Tile_X0Y4_E2BEGb[6] VPWR VGND sg13cmos5l_antennanp
XFILLER_115_65 VPWR VGND sg13cmos5l_decap_8
XFILLER_46_105 VPWR VGND sg13cmos5l_fill_1
XANTENNA__2293__A0 AXIL_S_SOC_WDATA0 VPWR VGND sg13cmos5l_antennanp
XANTENNA__2832__A2 Tile_X0Y4_W6END[11] VPWR VGND sg13cmos5l_antennanp
XFILLER_131_53 VPWR VGND sg13cmos5l_decap_8
XFILLER_91_13 VPWR VGND sg13cmos5l_fill_1
XANTENNA__1401__D Tile_X0Y5_FrameData[23] VPWR VGND sg13cmos5l_antennanp
XFILLER_54_182 VPWR VGND sg13cmos5l_decap_8
XANTENNA__1406__GATE Tile_X0Y5_FrameStrobe[4] VPWR VGND sg13cmos5l_antennanp
XFILLER_138_0 VPWR VGND sg13cmos5l_fill_2
XANTENNA__0662__GATE Tile_X0Y5_FrameStrobe[3] VPWR VGND sg13cmos5l_antennanp
XFILLER_155_202 VPWR VGND sg13cmos5l_decap_8
XFILLER_155_213 VPWR VGND sg13cmos5l_fill_2
XFILLER_6_201 VPWR VGND sg13cmos5l_fill_2
XFILLER_210_191 VPWR VGND sg13cmos5l_decap_8
XFILLER_356_195 VPWR VGND sg13cmos5l_fill_2
XANTENNA__2348__A1 Tile_X0Y2_W6END[7] VPWR VGND sg13cmos5l_antennanp
XFILLER_108_162 VPWR VGND sg13cmos5l_decap_8
XANTENNA__0677__GATE Tile_X0Y5_FrameStrobe[3] VPWR VGND sg13cmos5l_antennanp
XFILLER_41_9 VPWR VGND sg13cmos5l_fill_1
XFILLER_123_176 VPWR VGND sg13cmos5l_fill_2
XANTENNA__0687__D Tile_X0Y2_FrameData[23] VPWR VGND sg13cmos5l_antennanp
XANTENNA__0600__GATE Tile_X0Y5_FrameStrobe[1] VPWR VGND sg13cmos5l_antennanp
XANTENNA__1713__X Tile_X0Y0_E6BEG[5] VPWR VGND sg13cmos5l_antennanp
XANTENNA__2520__A1 AXIL_S_SOC_ARADDR3 VPWR VGND sg13cmos5l_antennanp
X_1140_ _1140_/Q Tile_X0Y4_FrameData[18] VGND VPWR Tile_X0Y5_FrameStrobe[3] latch
X_1071_ _1071_/Q Tile_X0Y4_FrameData[23] VGND VPWR Tile_X0Y5_FrameStrobe[1] latch
XANTENNA__0615__GATE Tile_X0Y5_FrameStrobe[2] VPWR VGND sg13cmos5l_antennanp
XFILLER_65_80 VPWR VGND sg13cmos5l_decap_4
XFILLER_52_119 VPWR VGND sg13cmos5l_decap_8
XFILLER_45_171 VPWR VGND sg13cmos5l_fill_1
XFILLER_45_160 VPWR VGND sg13cmos5l_decap_8
XANTENNA__1311__D Tile_X0Y5_FrameData[17] VPWR VGND sg13cmos5l_antennanp
XFILLER_60_174 VPWR VGND sg13cmos5l_decap_8
XANTENNA__2587__A1 Tile_X0Y5_N4END[8] VPWR VGND sg13cmos5l_antennanp
XFILLER_267_16 VPWR VGND sg13cmos5l_decap_8
X_1973_ Tile_X0Y5_E2BEG[2] _2727_/X VPWR VGND sg13cmos5l_buf_1
XFILLER_267_38 VPWR VGND sg13cmos5l_fill_2
X_0924_ _0924_/Q Tile_X0Y3_FrameData[26] VGND VPWR Tile_X0Y5_FrameStrobe[4] latch
XFILLER_347_140 VPWR VGND sg13cmos5l_decap_8
X_0855_ _0855_/Q Tile_X0Y3_FrameData[31] VGND VPWR Tile_X0Y5_FrameStrobe[2] latch
XFILLER_161_205 VPWR VGND sg13cmos5l_decap_8
XFILLER_362_143 VPWR VGND sg13cmos5l_decap_8
XFILLER_283_37 VPWR VGND sg13cmos5l_fill_1
X_0786_ _0786_/Q Tile_X0Y2_FrameData[20] VGND VPWR Tile_X0Y5_FrameStrobe[7] latch
XFILLER_362_187 VPWR VGND sg13cmos5l_decap_8
X_2525_ _2525_/X AXIL_S_SOC_ARADDR0 AXIL_S_SOC_ARADDR2 _2573_/X _2596_/X _0954_/Q
+ _0953_/Q VPWR VGND sg13cmos5l_mux4_1
XFILLER_114_176 VPWR VGND sg13cmos5l_decap_8
X_2456_ _2456_/X _2464_/X _2463_/X Tile_X0Y2_W6END[3] _2456_/A3 _0552_/Q _0791_/Q
+ VPWR VGND sg13cmos5l_mux4_1
XANTENNA__0597__D Tile_X0Y2_FrameData[17] VPWR VGND sg13cmos5l_antennanp
X_1407_ _1407_/Q Tile_X0Y5_FrameData[17] VGND VPWR Tile_X0Y5_FrameStrobe[4] latch
XANTENNA__1623__X Tile_X0Y0_N2BEGb[3] VPWR VGND sg13cmos5l_antennanp
XANTENNA__2511__A1 AXIL_S_SOC_ARADDR2 VPWR VGND sg13cmos5l_antennanp
X_2387_ _2387_/X Tile_X0Y0_W2MID[4] Tile_X0Y0_W2END[4] Tile_X0Y0_W6END[11] _2244_/X
+ _0164_/Q _0163_/Q VPWR VGND sg13cmos5l_mux4_1
X_1338_ _1338_/Q Tile_X0Y5_FrameData[22] VGND VPWR Tile_X0Y5_FrameStrobe[2] latch
X_1269_ _1269_/Q Tile_X0Y5_FrameData[27] VGND VPWR Tile_X0Y5_FrameStrobe[0] latch
XFILLER_45_17 VPWR VGND sg13cmos5l_fill_1
XANTENNA__2275__A0 Tile_X0Y2_W1END[2] VPWR VGND sg13cmos5l_antennanp
XFILLER_232_96 VPWR VGND sg13cmos5l_decap_8
XFILLER_43_108 VPWR VGND sg13cmos5l_decap_8
XANTENNA__1221__D Tile_X0Y4_FrameData[1] VPWR VGND sg13cmos5l_antennanp
XFILLER_36_193 VPWR VGND sg13cmos5l_decap_4
XANTENNA__2290__A3 AXIL_S_SOC_WDATA6 VPWR VGND sg13cmos5l_antennanp
XFILLER_101_56 VPWR VGND sg13cmos5l_decap_8
XANTENNA__2578__A1 Tile_X0Y5_N4END[9] VPWR VGND sg13cmos5l_antennanp
XFILLER_177_16 VPWR VGND sg13cmos5l_fill_2
XFILLER_51_196 VPWR VGND sg13cmos5l_fill_2
XFILLER_177_38 VPWR VGND sg13cmos5l_decap_8
XANTENNA__1392__GATE Tile_X0Y5_FrameStrobe[3] VPWR VGND sg13cmos5l_antennanp
XFILLER_124_6 VPWR VGND sg13cmos5l_fill_2
XFILLER_353_132 VPWR VGND sg13cmos5l_decap_8
XFILLER_105_110 VPWR VGND sg13cmos5l_fill_2
XANTENNA__2750__A1 AXIL_S_SOC_RREADY VPWR VGND sg13cmos5l_antennanp
XFILLER_105_165 VPWR VGND sg13cmos5l_decap_8
XFILLER_120_102 VPWR VGND sg13cmos5l_decap_8
XFILLER_343_29 VPWR VGND sg13cmos5l_decap_4
XFILLER_266_117 VPWR VGND sg13cmos5l_decap_8
XANTENNA__0300__D Tile_X0Y0_FrameData[26] VPWR VGND sg13cmos5l_antennanp
XANTENNA__1533__X Tile_X0Y3_E6BEG[7] VPWR VGND sg13cmos5l_antennanp
XANTENNA__2502__A1 Tile_X0Y4_W2END[1] VPWR VGND sg13cmos5l_antennanp
XFILLER_19_105 VPWR VGND sg13cmos5l_decap_8
XFILLER_86_57 VPWR VGND sg13cmos5l_decap_8
XANTENNA__1330__GATE Tile_X0Y5_FrameStrobe[2] VPWR VGND sg13cmos5l_antennanp
XFILLER_281_109 VPWR VGND sg13cmos5l_decap_8
XFILLER_19_84 VPWR VGND sg13cmos5l_decap_8
XANTENNA__1345__GATE Tile_X0Y5_FrameStrobe[2] VPWR VGND sg13cmos5l_antennanp
XFILLER_255_0 VPWR VGND sg13cmos5l_fill_1
XANTENNA__1131__D Tile_X0Y4_FrameData[27] VPWR VGND sg13cmos5l_antennanp
XANTENNA__2281__A3 Tile_X0Y3_W6END[11] VPWR VGND sg13cmos5l_antennanp
XFILLER_187_102 VPWR VGND sg13cmos5l_fill_2
XFILLER_42_163 VPWR VGND sg13cmos5l_decap_8
XANTENNA__0970__D Tile_X0Y3_FrameData[12] VPWR VGND sg13cmos5l_antennanp
XFILLER_187_146 VPWR VGND sg13cmos5l_decap_8
XANTENNA__2569__A1 Tile_X0Y2_W6END[10] VPWR VGND sg13cmos5l_antennanp
XFILLER_128_202 VPWR VGND sg13cmos5l_decap_8
XFILLER_89_9 VPWR VGND sg13cmos5l_decap_8
XANTENNA__1708__X Tile_X0Y0_E6BEG[0] VPWR VGND sg13cmos5l_antennanp
XFILLER_143_216 VPWR VGND sg13cmos5l_fill_2
X_0640_ _0640_/Q Tile_X0Y2_FrameData[6] VGND VPWR Tile_X0Y5_FrameStrobe[2] latch
XFILLER_317_30 VPWR VGND sg13cmos5l_decap_4
X_0571_ _0571_/Q Tile_X0Y2_FrameData[11] VGND VPWR Tile_X0Y5_FrameStrobe[0] latch
XANTENNA__2741__A1 AXIL_S_SOC_ARPROT2 VPWR VGND sg13cmos5l_antennanp
XFILLER_253_18 VPWR VGND sg13cmos5l_fill_1
X_2310_ _2310_/X AXIL_S_SOC_WDATA1 AXIL_S_SOC_WDATA13 _2353_/X _2379_/X _0472_/Q _0471_/Q
+ VPWR VGND sg13cmos5l_mux4_1
XFILLER_300_202 VPWR VGND sg13cmos5l_fill_2
X_2241_ _2241_/X _2250_/X _2249_/X Tile_X0Y0_S2MID[0] Tile_X0Y0_S2END[0] _0094_/Q
+ _0093_/Q VPWR VGND sg13cmos5l_mux4_1
XANTENNA__0210__D Tile_X0Y0_FrameData[20] VPWR VGND sg13cmos5l_antennanp
XANTENNA__1306__D Tile_X0Y5_FrameData[22] VPWR VGND sg13cmos5l_antennanp
XFILLER_111_157 VPWR VGND sg13cmos5l_decap_8
XFILLER_333_62 VPWR VGND sg13cmos5l_decap_4
X_2172_ _2172_/X AXIL_S_SOC_WDATA23 AXIL_S_SOC_WDATA31 _2241_/X _2248_/X _0252_/Q
+ _0251_/Q VPWR VGND sg13cmos5l_mux4_1
XFILLER_265_172 VPWR VGND sg13cmos5l_decap_8
X_1123_ _1123_/Q Tile_X0Y4_FrameData[3] VGND VPWR Tile_X0Y5_FrameStrobe[2] latch
XANTENNA__0554__GATE Tile_X0Y5_FrameStrobe[0] VPWR VGND sg13cmos5l_antennanp
XANTENNA__2257__A0 Tile_X0Y2_W2MID[3] VPWR VGND sg13cmos5l_antennanp
X_1054_ _1054_/Q Tile_X0Y4_FrameData[8] VGND VPWR Tile_X0Y5_FrameStrobe[0] latch
XFILLER_80_203 VPWR VGND sg13cmos5l_fill_1
XFILLER_18_171 VPWR VGND sg13cmos5l_decap_4
XANTENNA__1041__D Tile_X0Y4_FrameData[21] VPWR VGND sg13cmos5l_antennanp
XFILLER_202_99 VPWR VGND sg13cmos5l_decap_8
XANTENNA__0569__GATE Tile_X0Y5_FrameStrobe[0] VPWR VGND sg13cmos5l_antennanp
XANTENNA__0880__D Tile_X0Y3_FrameData[6] VPWR VGND sg13cmos5l_antennanp
XFILLER_178_168 VPWR VGND sg13cmos5l_decap_8
X_1956_ Tile_X0Y1_E2BEG[1] _2294_/X VPWR VGND sg13cmos5l_buf_1
X_0907_ _0907_/Q Tile_X0Y3_FrameData[11] VGND VPWR Tile_X0Y5_FrameStrobe[3] latch
XANTENNA__1618__X Tile_X0Y0_N4BEG[14] VPWR VGND sg13cmos5l_antennanp
X_1887_ Tile_X0Y1_FrameData_O[0] Tile_X0Y1_FrameData[0] VPWR VGND sg13cmos5l_buf_1
XFILLER_335_154 VPWR VGND sg13cmos5l_decap_4
XFILLER_294_69 VPWR VGND sg13cmos5l_fill_2
X_0838_ _0838_/Q Tile_X0Y3_FrameData[16] VGND VPWR Tile_X0Y5_FrameStrobe[1] latch
XFILLER_350_102 VPWR VGND sg13cmos5l_decap_8
X_0769_ _0769_/Q Tile_X0Y2_FrameData[5] VGND VPWR Tile_X0Y5_FrameStrobe[6] latch
XANTENNA__2732__A1 AXIL_S_SOC_ARPROT2 VPWR VGND sg13cmos5l_antennanp
XFILLER_227_85 VPWR VGND sg13cmos5l_decap_4
X_2508_ _2508_/X _2572_/X _2571_/X AXIL_S_SOC_ARADDR1 AXIL_S_SOC_ARADDR4 _0988_/Q
+ _0987_/Q VPWR VGND sg13cmos5l_mux4_1
XFILLER_350_168 VPWR VGND sg13cmos5l_decap_8
XANTENNA__0507__GATE Tile_X0Y5_FrameStrobe[6] VPWR VGND sg13cmos5l_antennanp
XANTENNA__0120__D Tile_X0Y0_FrameData[14] VPWR VGND sg13cmos5l_antennanp
XANTENNA__1216__D Tile_X0Y4_FrameData[6] VPWR VGND sg13cmos5l_antennanp
XFILLER_243_51 VPWR VGND sg13cmos5l_decap_8
X_2439_ _2439_/X AXIL_S_SOC_AWADDR6 _2477_/X _2470_/X _2483_/X _0670_/Q _0669_/Q VPWR
+ VGND sg13cmos5l_mux4_1
XANTENNA__2496__A0 Tile_X0Y4_W2MID[4] VPWR VGND sg13cmos5l_antennanp
XFILLER_243_62 VPWR VGND sg13cmos5l_fill_1
XFILLER_56_38 VPWR VGND sg13cmos5l_decap_8
XFILLER_56_27 VPWR VGND sg13cmos5l_decap_8
XFILLER_56_222 VPWR VGND sg13cmos5l_fill_2
XFILLER_256_183 VPWR VGND sg13cmos5l_fill_1
XANTENNA__2799__A1 Tile_X0Y5_N2END[5] VPWR VGND sg13cmos5l_antennanp
XFILLER_112_77 VPWR VGND sg13cmos5l_fill_1
XFILLER_169_124 VPWR VGND sg13cmos5l_decap_8
XFILLER_72_59 VPWR VGND sg13cmos5l_decap_8
XFILLER_72_26 VPWR VGND sg13cmos5l_decap_4
XFILLER_346_7 VPWR VGND sg13cmos5l_decap_8
XFILLER_188_59 VPWR VGND sg13cmos5l_fill_2
XANTENNA__0790__D Tile_X0Y2_FrameData[16] VPWR VGND sg13cmos5l_antennanp
XANTENNA__2420__A0 AXIL_S_SOC_AWADDR1 VPWR VGND sg13cmos5l_antennanp
XFILLER_268_81 VPWR VGND sg13cmos5l_decap_8
XFILLER_338_29 VPWR VGND sg13cmos5l_decap_8
XANTENNA__1528__X Tile_X0Y3_E6BEG[2] VPWR VGND sg13cmos5l_antennanp
XFILLER_21_63 VPWR VGND sg13cmos5l_fill_1
XFILLER_97_12 VPWR VGND sg13cmos5l_fill_1
XFILLER_341_135 VPWR VGND sg13cmos5l_fill_1
XFILLER_137_85 VPWR VGND sg13cmos5l_decap_4
XFILLER_97_56 VPWR VGND sg13cmos5l_fill_1
XFILLER_97_45 VPWR VGND sg13cmos5l_decap_8
XFILLER_341_168 VPWR VGND sg13cmos5l_fill_2
XANTENNA__1126__D Tile_X0Y4_FrameData[0] VPWR VGND sg13cmos5l_antennanp
XFILLER_47_211 VPWR VGND sg13cmos5l_fill_1
XANTENNA__0965__D Tile_X0Y3_FrameData[17] VPWR VGND sg13cmos5l_antennanp
XFILLER_247_161 VPWR VGND sg13cmos5l_decap_4
XFILLER_303_43 VPWR VGND sg13cmos5l_decap_8
XFILLER_303_32 VPWR VGND sg13cmos5l_fill_1
XANTENNA__1284__GATE Tile_X0Y5_FrameStrobe[0] VPWR VGND sg13cmos5l_antennanp
XFILLER_262_164 VPWR VGND sg13cmos5l_decap_8
XFILLER_262_186 VPWR VGND sg13cmos5l_fill_2
XANTENNA__2094__X Tile_X0Y3_E2BEG[6] VPWR VGND sg13cmos5l_antennanp
XANTENNA__1299__GATE Tile_X0Y5_FrameStrobe[1] VPWR VGND sg13cmos5l_antennanp
XFILLER_175_116 VPWR VGND sg13cmos5l_decap_8
X_1810_ Tile_X0Y4_E6BEG[5] _2654_/X VPWR VGND sg13cmos5l_buf_1
XFILLER_87_6 VPWR VGND sg13cmos5l_decap_8
XANTENNA__2411__A0 AXIL_S_SOC_AWADDR2 VPWR VGND sg13cmos5l_antennanp
XFILLER_175_149 VPWR VGND sg13cmos5l_decap_8
X_2790_ _2790_/X Tile_X0Y5_N1END[1] _2794_/X Tile_X0Y5_W6END[1] _2790_/A3 _1270_/Q
+ _1269_/Q VPWR VGND sg13cmos5l_mux4_1
XFILLER_30_188 VPWR VGND sg13cmos5l_decap_8
XFILLER_30_166 VPWR VGND sg13cmos5l_fill_1
XANTENNA__0205__D Tile_X0Y0_FrameData[25] VPWR VGND sg13cmos5l_antennanp
X_1741_ Tile_X0Y2_FrameData_O[1] Tile_X0Y2_FrameData[1] VPWR VGND sg13cmos5l_buf_1
XFILLER_7_43 VPWR VGND sg13cmos5l_fill_1
XFILLER_7_32 VPWR VGND sg13cmos5l_fill_1
XANTENNA__1222__GATE Tile_X0Y5_FrameStrobe[5] VPWR VGND sg13cmos5l_antennanp
X_1672_ Tile_X0Y0_FrameData_O[12] Tile_X0Y0_FrameData[12] VPWR VGND sg13cmos5l_buf_1
XFILLER_264_39 VPWR VGND sg13cmos5l_decap_8
X_0623_ _0623_/Q Tile_X0Y2_FrameData[23] VGND VPWR Tile_X0Y5_FrameStrobe[2] latch
XANTENNA__2714__A1 Tile_X0Y3_W2END[6] VPWR VGND sg13cmos5l_antennanp
XFILLER_194_91 VPWR VGND sg13cmos5l_decap_8
X_0554_ _0554_/Q Tile_X0Y2_FrameData[28] VGND VPWR Tile_X0Y5_FrameStrobe[0] latch
XFILLER_97_133 VPWR VGND sg13cmos5l_fill_2
XFILLER_97_122 VPWR VGND sg13cmos5l_decap_8
XFILLER_97_111 VPWR VGND sg13cmos5l_fill_1
XFILLER_344_50 VPWR VGND sg13cmos5l_decap_8
XANTENNA__1036__D Tile_X0Y4_FrameData[26] VPWR VGND sg13cmos5l_antennanp
XANTENNA__1237__GATE Tile_X0Y5_FrameStrobe[6] VPWR VGND sg13cmos5l_antennanp
XFILLER_280_16 VPWR VGND sg13cmos5l_decap_4
XFILLER_285_223 VPWR VGND sg13cmos5l_fill_1
X_0485_ _0485_/Q Tile_X0Y1_FrameData[17] VGND VPWR Tile_X0Y5_FrameStrobe[5] latch
XFILLER_280_38 VPWR VGND sg13cmos5l_decap_8
X_2224_ _2224_/X _2704_/X _2693_/X _2692_/X _2709_/X _1237_/Q _1236_/Q VPWR VGND sg13cmos5l_mux4_1
XFILLER_97_177 VPWR VGND sg13cmos5l_decap_8
XANTENNA__0493__GATE Tile_X0Y5_FrameStrobe[5] VPWR VGND sg13cmos5l_antennanp
XANTENNA__0875__D Tile_X0Y3_FrameData[11] VPWR VGND sg13cmos5l_antennanp
XFILLER_16_0 VPWR VGND sg13cmos5l_fill_2
XFILLER_213_21 VPWR VGND sg13cmos5l_decap_8
XFILLER_213_43 VPWR VGND sg13cmos5l_decap_4
X_2155_ _2155_/X Tile_X0Y0_W1END[1] Tile_X0Y0_WW4END[1] Tile_X0Y0_WW4END[5] Tile_X0Y0_W6END[9]
+ _0283_/Q _0282_/Q VPWR VGND sg13cmos5l_mux4_1
XANTENNA__1901__X Tile_X0Y1_FrameData_O[14] VPWR VGND sg13cmos5l_antennanp
X_1106_ _1106_/Q Tile_X0Y4_FrameData[20] VGND VPWR Tile_X0Y5_FrameStrobe[2] latch
XFILLER_360_71 VPWR VGND sg13cmos5l_fill_2
XFILLER_253_153 VPWR VGND sg13cmos5l_decap_8
X_2086_ Tile_X0Y3_E1BEG[2] _2507_/X VPWR VGND sg13cmos5l_buf_1
XANTENNA__2245__A3 Tile_X0Y0_S2END[4] VPWR VGND sg13cmos5l_antennanp
XFILLER_289_58 VPWR VGND sg13cmos5l_decap_8
X_1037_ _1037_/Q Tile_X0Y4_FrameData[25] VGND VPWR Tile_X0Y5_FrameStrobe[0] latch
XANTENNA__2650__A0 Tile_X0Y5_N4END[5] VPWR VGND sg13cmos5l_antennanp
XFILLER_166_116 VPWR VGND sg13cmos5l_decap_8
XANTENNA__0431__GATE Tile_X0Y5_FrameStrobe[3] VPWR VGND sg13cmos5l_antennanp
XANTENNA__0115__D Tile_X0Y0_FrameData[19] VPWR VGND sg13cmos5l_antennanp
XANTENNA__2402__A0 AXIL_S_SOC_AWADDR1 VPWR VGND sg13cmos5l_antennanp
X_1939_ Tile_X0Y1_E6BEG[4] _2329_/X VPWR VGND sg13cmos5l_buf_1
XFILLER_107_216 VPWR VGND sg13cmos5l_fill_2
XFILLER_238_95 VPWR VGND sg13cmos5l_fill_2
XANTENNA__0446__GATE Tile_X0Y5_FrameStrobe[4] VPWR VGND sg13cmos5l_antennanp
XANTENNA__2705__A1 Tile_X0Y5_N4END[5] VPWR VGND sg13cmos5l_antennanp
XFILLER_88_133 VPWR VGND sg13cmos5l_fill_2
XFILLER_107_99 VPWR VGND sg13cmos5l_fill_1
XFILLER_276_223 VPWR VGND sg13cmos5l_fill_1
XFILLER_88_166 VPWR VGND sg13cmos5l_decap_4
XFILLER_88_144 VPWR VGND sg13cmos5l_fill_1
XFILLER_190_27 VPWR VGND sg13cmos5l_decap_4
XFILLER_236_109 VPWR VGND sg13cmos5l_decap_8
XFILLER_291_204 VPWR VGND sg13cmos5l_decap_4
XFILLER_88_199 VPWR VGND sg13cmos5l_decap_4
XANTENNA__0785__D Tile_X0Y2_FrameData[21] VPWR VGND sg13cmos5l_antennanp
XANTENNA__1811__X Tile_X0Y4_E6BEG[6] VPWR VGND sg13cmos5l_antennanp
XFILLER_123_65 VPWR VGND sg13cmos5l_decap_8
XFILLER_244_131 VPWR VGND sg13cmos5l_fill_2
XFILLER_83_58 VPWR VGND sg13cmos5l_decap_8
XANTENNA__2236__A3 Tile_X0Y0_S4END[2] VPWR VGND sg13cmos5l_antennanp
XANTENNA__2641__A0 AXIL_S_SOC_WSTRB2 VPWR VGND sg13cmos5l_antennanp
XFILLER_16_85 VPWR VGND sg13cmos5l_decap_8
XFILLER_12_144 VPWR VGND sg13cmos5l_fill_2
XFILLER_157_149 VPWR VGND sg13cmos5l_decap_4
XFILLER_120_0 VPWR VGND sg13cmos5l_fill_2
XFILLER_172_119 VPWR VGND sg13cmos5l_decap_8
XFILLER_218_0 VPWR VGND sg13cmos5l_fill_2
XFILLER_180_141 VPWR VGND sg13cmos5l_fill_2
XFILLER_314_157 VPWR VGND sg13cmos5l_fill_1
XANTENNA__2089__X Tile_X0Y3_E2BEG[1] VPWR VGND sg13cmos5l_antennanp
XFILLER_267_212 VPWR VGND sg13cmos5l_fill_2
XFILLER_267_223 VPWR VGND sg13cmos5l_fill_1
XFILLER_79_155 VPWR VGND sg13cmos5l_decap_8
XFILLER_322_190 VPWR VGND sg13cmos5l_fill_1
X_0270_ _0270_/Q Tile_X0Y0_FrameData[24] VGND VPWR Tile_X0Y5_FrameStrobe[6] latch
XFILLER_94_114 VPWR VGND sg13cmos5l_decap_8
XANTENNA__0695__D Tile_X0Y2_FrameData[15] VPWR VGND sg13cmos5l_antennanp
XANTENNA__1721__X Tile_X0Y0_E2BEGb[1] VPWR VGND sg13cmos5l_antennanp
XANTENNA__2475__A3 Tile_X0Y0_S4END[11] VPWR VGND sg13cmos5l_antennanp
XFILLER_180_82 VPWR VGND sg13cmos5l_fill_2
XFILLER_235_153 VPWR VGND sg13cmos5l_decap_8
XFILLER_330_41 VPWR VGND sg13cmos5l_fill_1
XANTENNA__2632__A0 AXIL_S_SOC_WSTRB1 VPWR VGND sg13cmos5l_antennanp
XFILLER_250_156 VPWR VGND sg13cmos5l_decap_8
XFILLER_73_80 VPWR VGND sg13cmos5l_decap_8
XANTENNA__1161__GATE Tile_X0Y5_FrameStrobe[4] VPWR VGND sg13cmos5l_antennanp
X_2773_ _2773_/X Tile_X0Y5_W2MID[7] Tile_X0Y5_W2END[7] Tile_X0Y5_W6END[8] _2825_/X
+ _1356_/Q _1355_/Q VPWR VGND sg13cmos5l_mux4_1
X_1724_ Tile_X0Y0_E2BEGb[4] _2177_/X VPWR VGND sg13cmos5l_buf_1
XFILLER_156_193 VPWR VGND sg13cmos5l_decap_8
XFILLER_208_76 VPWR VGND sg13cmos5l_decap_8
X_1655_ Tile_X0Y0_FrameStrobe_O[15] Tile_X0Y5_FrameStrobe[15] VPWR VGND sg13cmos5l_buf_1
XFILLER_355_60 VPWR VGND sg13cmos5l_decap_8
XANTENNA__1176__GATE Tile_X0Y5_FrameStrobe[4] VPWR VGND sg13cmos5l_antennanp
X_1586_ Tile_X0Y3_UserCLKo Tile_X0Y3_UserCLK VPWR VGND sg13cmos5l_buf_1
X_0606_ _0606_/Q Tile_X0Y2_FrameData[8] VGND VPWR Tile_X0Y5_FrameStrobe[1] latch
XFILLER_320_138 VPWR VGND sg13cmos5l_decap_4
XANTENNA__2163__A2 AXIL_S_SOC_WDATA16 VPWR VGND sg13cmos5l_antennanp
XFILLER_291_48 VPWR VGND sg13cmos5l_decap_8
X_0537_ _0537_/Q Tile_X0Y1_FrameData[29] VGND VPWR Tile_X0Y5_FrameStrobe[7] latch
XFILLER_224_42 VPWR VGND sg13cmos5l_decap_8
XFILLER_224_53 VPWR VGND sg13cmos5l_decap_8
XFILLER_224_64 VPWR VGND sg13cmos5l_fill_2
X_2207_ _2207_/X AXIL_S_SOC_WDATA18 _2238_/X _2237_/X _2247_/X _0182_/Q _0181_/Q VPWR
+ VGND sg13cmos5l_mux4_1
X_0468_ _0468_/Q Tile_X0Y1_FrameData[2] VGND VPWR Tile_X0Y5_FrameStrobe[4] latch
XANTENNA__1631__X Tile_X0Y0_N2BEG[3] VPWR VGND sg13cmos5l_antennanp
XANTENNA__2466__A3 Tile_X0Y0_S4END[11] VPWR VGND sg13cmos5l_antennanp
XFILLER_226_131 VPWR VGND sg13cmos5l_fill_1
X_0399_ _0399_/Q Tile_X0Y1_FrameData[7] VGND VPWR Tile_X0Y5_FrameStrobe[2] latch
XFILLER_85_169 VPWR VGND sg13cmos5l_decap_8
XFILLER_226_164 VPWR VGND sg13cmos5l_fill_1
XFILLER_240_30 VPWR VGND sg13cmos5l_decap_4
X_2138_ AXIL_S_SOC_RRESP0 Tile_X0Y5_W2MID[1] Tile_X0Y5_W2END[1] Tile_X0Y5_W6END[1]
+ _2826_/X _1326_/Q _1325_/Q VPWR VGND sg13cmos5l_mux4_1
XFILLER_93_180 VPWR VGND sg13cmos5l_decap_8
XANTENNA__1114__GATE Tile_X0Y5_FrameStrobe[2] VPWR VGND sg13cmos5l_antennanp
X_2069_ Tile_X0Y5_S4BEG[2] _2069_/A VPWR VGND sg13cmos5l_buf_1
XANTENNA__2218__A3 Tile_X0Y0_S4END[3] VPWR VGND sg13cmos5l_antennanp
XANTENNA__2623__A0 AXIL_S_SOC_WSTRB0 VPWR VGND sg13cmos5l_antennanp
XFILLER_156_9 VPWR VGND sg13cmos5l_decap_8
XFILLER_241_167 VPWR VGND sg13cmos5l_decap_8
XANTENNA__0370__GATE Tile_X0Y5_FrameStrobe[1] VPWR VGND sg13cmos5l_antennanp
XFILLER_328_216 VPWR VGND sg13cmos5l_fill_1
XANTENNA__1129__GATE Tile_X0Y5_FrameStrobe[3] VPWR VGND sg13cmos5l_antennanp
XFILLER_139_149 VPWR VGND sg13cmos5l_decap_4
XFILLER_147_171 VPWR VGND sg13cmos5l_decap_8
XANTENNA__0385__GATE Tile_X0Y5_FrameStrobe[2] VPWR VGND sg13cmos5l_antennanp
XANTENNA__1806__X Tile_X0Y4_E6BEG[1] VPWR VGND sg13cmos5l_antennanp
XFILLER_118_65 VPWR VGND sg13cmos5l_decap_8
XFILLER_162_163 VPWR VGND sg13cmos5l_fill_2
XFILLER_78_58 VPWR VGND sg13cmos5l_decap_8
XFILLER_134_20 VPWR VGND sg13cmos5l_decap_8
XFILLER_281_70 VPWR VGND sg13cmos5l_fill_1
XFILLER_281_81 VPWR VGND sg13cmos5l_decap_8
XANTENNA__1404__D Tile_X0Y5_FrameData[20] VPWR VGND sg13cmos5l_antennanp
XANTENNA__1541__X Tile_X0Y3_EE4BEG[3] VPWR VGND sg13cmos5l_antennanp
XFILLER_134_97 VPWR VGND sg13cmos5l_decap_4
XFILLER_91_106 VPWR VGND sg13cmos5l_decap_8
XANTENNA__0323__GATE Tile_X0Y5_FrameStrobe[0] VPWR VGND sg13cmos5l_antennanp
XFILLER_27_51 VPWR VGND sg13cmos5l_fill_2
XFILLER_94_79 VPWR VGND sg13cmos5l_decap_8
XFILLER_84_180 VPWR VGND sg13cmos5l_decap_8
XANTENNA__0953__GATE Tile_X0Y5_FrameStrobe[5] VPWR VGND sg13cmos5l_antennanp
XFILLER_150_74 VPWR VGND sg13cmos5l_fill_2
XFILLER_168_0 VPWR VGND sg13cmos5l_fill_2
XFILLER_217_175 VPWR VGND sg13cmos5l_decap_8
XANTENNA__0338__GATE Tile_X0Y5_FrameStrobe[0] VPWR VGND sg13cmos5l_antennanp
XFILLER_335_0 VPWR VGND sg13cmos5l_fill_1
XANTENNA__0968__GATE Tile_X0Y5_FrameStrobe[5] VPWR VGND sg13cmos5l_antennanp
XFILLER_43_61 VPWR VGND sg13cmos5l_fill_1
XFILLER_300_88 VPWR VGND sg13cmos5l_decap_8
XFILLER_138_171 VPWR VGND sg13cmos5l_fill_1
XANTENNA__2393__A2 Tile_X0Y0_W2END[1] VPWR VGND sg13cmos5l_antennanp
XANTENNA__1716__X Tile_X0Y0_E6BEG[8] VPWR VGND sg13cmos5l_antennanp
XFILLER_175_60 VPWR VGND sg13cmos5l_decap_8
XFILLER_57_7 VPWR VGND sg13cmos5l_fill_1
XFILLER_4_151 VPWR VGND sg13cmos5l_fill_2
XFILLER_153_174 VPWR VGND sg13cmos5l_decap_8
X_1440_ _1440_/Q Tile_X0Y5_FrameData[16] VGND VPWR Tile_X0Y5_FrameStrobe[5] latch
XFILLER_4_11 VPWR VGND sg13cmos5l_fill_2
XANTENNA__2145__A2 Tile_X0Y0_W6END[7] VPWR VGND sg13cmos5l_antennanp
X_1371_ _1371_/Q Tile_X0Y5_FrameData[21] VGND VPWR Tile_X0Y5_FrameStrobe[3] latch
XFILLER_302_149 VPWR VGND sg13cmos5l_decap_8
XANTENNA__0906__GATE Tile_X0Y5_FrameStrobe[3] VPWR VGND sg13cmos5l_antennanp
X_0322_ _0322_/Q Tile_X0Y1_FrameData[20] VGND VPWR Tile_X0Y5_FrameStrobe[0] latch
XFILLER_68_91 VPWR VGND sg13cmos5l_decap_8
XFILLER_67_136 VPWR VGND sg13cmos5l_decap_4
XANTENNA__1314__D Tile_X0Y5_FrameData[14] VPWR VGND sg13cmos5l_antennanp
XFILLER_208_120 VPWR VGND sg13cmos5l_fill_1
X_0253_ _0253_/Q Tile_X0Y0_FrameData[9] VGND VPWR Tile_X0Y5_FrameStrobe[5] latch
XFILLER_82_117 VPWR VGND sg13cmos5l_fill_2
XFILLER_341_40 VPWR VGND sg13cmos5l_decap_8
XFILLER_208_142 VPWR VGND sg13cmos5l_decap_4
X_0184_ _0184_/Q Tile_X0Y0_FrameData[14] VGND VPWR Tile_X0Y5_FrameStrobe[3] latch
XFILLER_223_112 VPWR VGND sg13cmos5l_decap_4
XFILLER_84_90 VPWR VGND sg13cmos5l_decap_8
XFILLER_75_191 VPWR VGND sg13cmos5l_fill_1
XANTENNA__2605__A0 Tile_X0Y2_W1END[0] VPWR VGND sg13cmos5l_antennanp
XFILLER_90_172 VPWR VGND sg13cmos5l_decap_8
XFILLER_210_99 VPWR VGND sg13cmos5l_decap_8
XFILLER_286_15 VPWR VGND sg13cmos5l_decap_8
X_2825_ _2825_/X Tile_X0Y5_N2MID[0] Tile_X0Y5_N2END[0] _2829_/X _2713_/X _1288_/Q
+ _1287_/Q VPWR VGND sg13cmos5l_mux4_1
XFILLER_144_130 VPWR VGND sg13cmos5l_decap_4
XFILLER_219_53 VPWR VGND sg13cmos5l_fill_1
XFILLER_219_75 VPWR VGND sg13cmos5l_decap_8
X_2756_ _2756_/X AXIL_S_SOC_ARPROT0 AXIL_S_SOC_ARVALID _2824_/X _2825_/X _1390_/Q
+ _1389_/Q VPWR VGND sg13cmos5l_mux4_1
XANTENNA__1626__X Tile_X0Y0_N2BEGb[6] VPWR VGND sg13cmos5l_antennanp
XANTENNA__2384__A2 Tile_X0Y3_W6END[6] VPWR VGND sg13cmos5l_antennanp
X_1707_ Tile_X0Y0_EE4BEG[15] _2196_/X VPWR VGND sg13cmos5l_buf_1
X_2687_ _2687_/X _2240_/X _2239_/X _2230_/X _2229_/X _0154_/Q _0153_/Q VPWR VGND sg13cmos5l_mux4_1
XFILLER_144_185 VPWR VGND sg13cmos5l_decap_4
XFILLER_235_30 VPWR VGND sg13cmos5l_fill_1
X_1638_ Tile_X0Y0_N1BEG[2] _2143_/X VPWR VGND sg13cmos5l_buf_1
XANTENNA__2136__A2 Tile_X0Y0_W6END[6] VPWR VGND sg13cmos5l_antennanp
X_1569_ Tile_X0Y3_FrameData_O[15] Tile_X0Y3_FrameData[15] VPWR VGND sg13cmos5l_buf_1
XFILLER_48_28 VPWR VGND sg13cmos5l_fill_1
XFILLER_301_182 VPWR VGND sg13cmos5l_fill_2
XANTENNA__1224__D Tile_X0Y4_FrameData[30] VPWR VGND sg13cmos5l_antennanp
XFILLER_104_34 VPWR VGND sg13cmos5l_fill_1
XFILLER_251_40 VPWR VGND sg13cmos5l_decap_8
XFILLER_104_56 VPWR VGND sg13cmos5l_decap_8
XFILLER_104_78 VPWR VGND sg13cmos5l_fill_1
XFILLER_73_139 VPWR VGND sg13cmos5l_decap_8
XANTENNA__1053__GATE Tile_X0Y5_FrameStrobe[0] VPWR VGND sg13cmos5l_antennanp
XFILLER_214_101 VPWR VGND sg13cmos5l_decap_4
XFILLER_64_49 VPWR VGND sg13cmos5l_decap_4
XFILLER_120_11 VPWR VGND sg13cmos5l_fill_1
XFILLER_214_145 VPWR VGND sg13cmos5l_decap_8
XFILLER_154_6 VPWR VGND sg13cmos5l_decap_8
XANTENNA__1068__GATE Tile_X0Y5_FrameStrobe[1] VPWR VGND sg13cmos5l_antennanp
XFILLER_13_42 VPWR VGND sg13cmos5l_fill_2
XFILLER_129_20 VPWR VGND sg13cmos5l_decap_8
XFILLER_13_53 VPWR VGND sg13cmos5l_fill_1
XANTENNA__1536__X Tile_X0Y3_E6BEG[10] VPWR VGND sg13cmos5l_antennanp
XFILLER_135_163 VPWR VGND sg13cmos5l_decap_8
XANTENNA__0303__D Tile_X0Y0_FrameData[23] VPWR VGND sg13cmos5l_antennanp
XFILLER_89_79 VPWR VGND sg13cmos5l_decap_8
XANTENNA__2127__A2 Tile_X0Y1_W6END[5] VPWR VGND sg13cmos5l_antennanp
XFILLER_150_133 VPWR VGND sg13cmos5l_decap_8
XANTENNA__1006__GATE Tile_X0Y5_FrameStrobe[6] VPWR VGND sg13cmos5l_antennanp
XFILLER_150_177 VPWR VGND sg13cmos5l_fill_1
XFILLER_292_80 VPWR VGND sg13cmos5l_fill_2
XFILLER_150_199 VPWR VGND sg13cmos5l_decap_8
XFILLER_49_125 VPWR VGND sg13cmos5l_decap_8
XANTENNA__0262__GATE Tile_X0Y5_FrameStrobe[5] VPWR VGND sg13cmos5l_antennanp
XANTENNA__1134__D Tile_X0Y4_FrameData[24] VPWR VGND sg13cmos5l_antennanp
XFILLER_285_0 VPWR VGND sg13cmos5l_fill_1
XFILLER_64_106 VPWR VGND sg13cmos5l_decap_8
XFILLER_49_158 VPWR VGND sg13cmos5l_decap_8
XANTENNA__0892__GATE Tile_X0Y5_FrameStrobe[3] VPWR VGND sg13cmos5l_antennanp
XANTENNA__2835__A0 Tile_X0Y4_W1END[2] VPWR VGND sg13cmos5l_antennanp
XANTENNA__0973__D Tile_X0Y3_FrameData[9] VPWR VGND sg13cmos5l_antennanp
XFILLER_161_84 VPWR VGND sg13cmos5l_decap_8
XFILLER_205_112 VPWR VGND sg13cmos5l_decap_8
XFILLER_311_43 VPWR VGND sg13cmos5l_fill_1
XANTENNA__0277__GATE Tile_X0Y5_FrameStrobe[6] VPWR VGND sg13cmos5l_antennanp
XFILLER_205_189 VPWR VGND sg13cmos5l_decap_8
XFILLER_220_126 VPWR VGND sg13cmos5l_decap_4
X_0940_ _0940_/Q Tile_X0Y3_FrameData[10] VGND VPWR Tile_X0Y5_FrameStrobe[4] latch
XFILLER_359_171 VPWR VGND sg13cmos5l_fill_1
XANTENNA__0200__GATE Tile_X0Y5_FrameStrobe[4] VPWR VGND sg13cmos5l_antennanp
XANTENNA__0830__GATE Tile_X0Y5_FrameStrobe[1] VPWR VGND sg13cmos5l_antennanp
X_0871_ _0871_/Q Tile_X0Y3_FrameData[15] VGND VPWR Tile_X0Y5_FrameStrobe[2] latch
XFILLER_70_70 VPWR VGND sg13cmos5l_decap_8
XFILLER_186_70 VPWR VGND sg13cmos5l_decap_8
X_2610_ _2610_/X Tile_X0Y5_W2MID[1] Tile_X0Y5_W2END[1] Tile_X0Y5_W6END[1] _2798_/X
+ _1476_/Q _1475_/Q VPWR VGND sg13cmos5l_mux4_1
XANTENNA__1309__D Tile_X0Y5_FrameData[19] VPWR VGND sg13cmos5l_antennanp
X_2541_ _2541_/X Tile_X0Y5_N4END[8] Tile_X0Y0_S4END[12] _2574_/X _2573_/X _0922_/Q
+ _0921_/Q VPWR VGND sg13cmos5l_mux4_1
XFILLER_336_40 VPWR VGND sg13cmos5l_decap_8
XANTENNA__0213__D Tile_X0Y0_FrameData[17] VPWR VGND sg13cmos5l_antennanp
XANTENNA__0215__GATE Tile_X0Y5_FrameStrobe[4] VPWR VGND sg13cmos5l_antennanp
X_2472_ _2472_/X _2458_/X Tile_X0Y5_N4END[12] _2457_/X Tile_X0Y0_S4END[8] _0590_/Q
+ _0589_/Q VPWR VGND sg13cmos5l_mux4_1
XANTENNA__0845__GATE Tile_X0Y5_FrameStrobe[1] VPWR VGND sg13cmos5l_antennanp
XANTENNA__2118__A2 Tile_X0Y2_W6END[4] VPWR VGND sg13cmos5l_antennanp
XFILLER_141_144 VPWR VGND sg13cmos5l_decap_8
XFILLER_272_17 VPWR VGND sg13cmos5l_decap_8
X_1423_ _1423_/Q Tile_X0Y5_FrameData[1] VGND VPWR Tile_X0Y5_FrameStrobe[4] latch
XFILLER_287_148 VPWR VGND sg13cmos5l_decap_8
X_1354_ _1354_/Q Tile_X0Y5_FrameData[6] VGND VPWR Tile_X0Y5_FrameStrobe[2] latch
XANTENNA__1044__D Tile_X0Y4_FrameData[18] VPWR VGND sg13cmos5l_antennanp
XFILLER_205_77 VPWR VGND sg13cmos5l_decap_8
X_1285_ _1285_/Q Tile_X0Y5_FrameData[11] VGND VPWR Tile_X0Y5_FrameStrobe[0] latch
X_0305_ _0305_/Q Tile_X0Y0_FrameData[21] VGND VPWR Tile_X0Y5_FrameStrobe[7] latch
XFILLER_352_94 VPWR VGND sg13cmos5l_decap_8
XFILLER_352_61 VPWR VGND sg13cmos5l_decap_8
XANTENNA__2826__A0 Tile_X0Y5_N2MID[1] VPWR VGND sg13cmos5l_antennanp
XFILLER_243_207 VPWR VGND sg13cmos5l_fill_2
X_0236_ _0236_/Q Tile_X0Y0_FrameData[26] VGND VPWR Tile_X0Y5_FrameStrobe[5] latch
XFILLER_55_139 VPWR VGND sg13cmos5l_decap_8
XANTENNA__0883__D Tile_X0Y3_FrameData[3] VPWR VGND sg13cmos5l_antennanp
XFILLER_221_32 VPWR VGND sg13cmos5l_decap_4
X_0167_ _0167_/Q Tile_X0Y0_FrameData[31] VGND VPWR Tile_X0Y5_FrameStrobe[3] latch
XFILLER_63_172 VPWR VGND sg13cmos5l_decap_4
X_0098_ _0098_/Q Tile_X0Y0_FrameData[4] VGND VPWR Tile_X0Y5_FrameStrobe[0] latch
XFILLER_297_36 VPWR VGND sg13cmos5l_fill_1
XFILLER_109_119 VPWR VGND sg13cmos5l_decap_8
XFILLER_166_29 VPWR VGND sg13cmos5l_decap_8
X_2808_ _2808_/X _2370_/X _2369_/X _2358_/X _2357_/X _0391_/Q _0390_/Q VPWR VGND sg13cmos5l_mux4_1
XANTENNA__1219__D Tile_X0Y4_FrameData[3] VPWR VGND sg13cmos5l_antennanp
XFILLER_117_130 VPWR VGND sg13cmos5l_decap_8
X_2739_ _2739_/X AXIL_S_SOC_ARPROT1 AXIL_S_SOC_RREADY _2826_/X _2798_/X _1424_/Q _1423_/Q
+ VPWR VGND sg13cmos5l_mux4_1
XANTENNA__0123__D Tile_X0Y0_FrameData[11] VPWR VGND sg13cmos5l_antennanp
XFILLER_117_174 VPWR VGND sg13cmos5l_decap_8
XFILLER_278_104 VPWR VGND sg13cmos5l_fill_2
XANTENNA__2109__A2 Tile_X0Y3_W6END[3] VPWR VGND sg13cmos5l_antennanp
XFILLER_59_38 VPWR VGND sg13cmos5l_decap_4
XFILLER_59_27 VPWR VGND sg13cmos5l_fill_1
XFILLER_286_170 VPWR VGND sg13cmos5l_decap_4
XANTENNA__2817__A0 Tile_X0Y5_N1END[3] VPWR VGND sg13cmos5l_antennanp
XFILLER_262_94 VPWR VGND sg13cmos5l_decap_8
XFILLER_271_6 VPWR VGND sg13cmos5l_decap_4
XFILLER_75_48 VPWR VGND sg13cmos5l_decap_8
XANTENNA__0793__D Tile_X0Y3_FrameData[29] VPWR VGND sg13cmos5l_antennanp
XFILLER_131_10 VPWR VGND sg13cmos5l_fill_1
XANTENNA__2293__A1 AXIL_S_SOC_WDATA8 VPWR VGND sg13cmos5l_antennanp
XFILLER_54_150 VPWR VGND sg13cmos5l_decap_8
XFILLER_131_98 VPWR VGND sg13cmos5l_fill_2
XFILLER_199_177 VPWR VGND sg13cmos5l_decap_4
XFILLER_357_39 VPWR VGND sg13cmos5l_fill_2
XFILLER_356_185 VPWR VGND sg13cmos5l_decap_4
XANTENNA__1129__D Tile_X0Y4_FrameData[29] VPWR VGND sg13cmos5l_antennanp
XFILLER_108_130 VPWR VGND sg13cmos5l_decap_8
XFILLER_123_100 VPWR VGND sg13cmos5l_fill_2
XFILLER_170_217 VPWR VGND sg13cmos5l_fill_1
XFILLER_40_84 VPWR VGND sg13cmos5l_fill_1
XFILLER_40_73 VPWR VGND sg13cmos5l_fill_1
XANTENNA__0968__D Tile_X0Y3_FrameData[14] VPWR VGND sg13cmos5l_antennanp
XFILLER_123_122 VPWR VGND sg13cmos5l_fill_1
XFILLER_312_222 VPWR VGND sg13cmos5l_fill_2
XFILLER_284_118 VPWR VGND sg13cmos5l_decap_8
XANTENNA__2097__X Tile_X0Y3_E2BEGb[1] VPWR VGND sg13cmos5l_antennanp
XFILLER_277_192 VPWR VGND sg13cmos5l_decap_8
XFILLER_292_162 VPWR VGND sg13cmos5l_fill_2
XFILLER_92_223 VPWR VGND sg13cmos5l_fill_1
XFILLER_37_139 VPWR VGND sg13cmos5l_fill_1
XFILLER_37_128 VPWR VGND sg13cmos5l_decap_8
XFILLER_37_117 VPWR VGND sg13cmos5l_decap_4
X_1070_ _1070_/Q Tile_X0Y4_FrameData[24] VGND VPWR Tile_X0Y5_FrameStrobe[1] latch
XFILLER_322_86 VPWR VGND sg13cmos5l_fill_1
XFILLER_322_75 VPWR VGND sg13cmos5l_decap_8
XFILLER_322_64 VPWR VGND sg13cmos5l_decap_4
XFILLER_65_92 VPWR VGND sg13cmos5l_decap_8
XANTENNA__0208__D Tile_X0Y0_FrameData[22] VPWR VGND sg13cmos5l_antennanp
X_1972_ Tile_X0Y5_E2BEG[1] _2726_/X VPWR VGND sg13cmos5l_buf_1
XFILLER_201_170 VPWR VGND sg13cmos5l_decap_8
X_0923_ _0923_/Q Tile_X0Y3_FrameData[27] VGND VPWR Tile_X0Y5_FrameStrobe[4] latch
X_0854_ _0854_/Q Tile_X0Y3_FrameData[0] VGND VPWR Tile_X0Y5_FrameStrobe[1] latch
XANTENNA__0154__GATE Tile_X0Y5_FrameStrobe[2] VPWR VGND sg13cmos5l_antennanp
XANTENNA__2339__A2 Tile_X0Y1_W6END[2] VPWR VGND sg13cmos5l_antennanp
XANTENNA__0784__GATE Tile_X0Y5_FrameStrobe[7] VPWR VGND sg13cmos5l_antennanp
XANTENNA__1039__D Tile_X0Y4_FrameData[23] VPWR VGND sg13cmos5l_antennanp
X_0785_ _0785_/Q Tile_X0Y2_FrameData[21] VGND VPWR Tile_X0Y5_FrameStrobe[7] latch
XANTENNA__0878__D Tile_X0Y3_FrameData[8] VPWR VGND sg13cmos5l_antennanp
X_2524_ _2524_/X AXIL_S_SOC_ARADDR5 AXIL_S_SOC_ARADDR7 _2589_/X _2596_/X _0956_/Q
+ _0955_/Q VPWR VGND sg13cmos5l_mux4_1
XFILLER_46_0 VPWR VGND sg13cmos5l_fill_2
XANTENNA__1904__X Tile_X0Y1_FrameData_O[17] VPWR VGND sg13cmos5l_antennanp
XFILLER_114_155 VPWR VGND sg13cmos5l_decap_8
XFILLER_216_65 VPWR VGND sg13cmos5l_decap_8
X_2455_ _2455_/X _2462_/X _2461_/X Tile_X0Y2_W6END[2] _2455_/A3 _0554_/Q _0553_/Q
+ VPWR VGND sg13cmos5l_mux4_1
XANTENNA__0169__GATE Tile_X0Y5_FrameStrobe[3] VPWR VGND sg13cmos5l_antennanp
X_1406_ _1406_/Q Tile_X0Y5_FrameData[18] VGND VPWR Tile_X0Y5_FrameStrobe[4] latch
X_2386_ _2386_/X Tile_X0Y3_W2MID[5] Tile_X0Y3_W2END[5] Tile_X0Y3_W6END[5] _2591_/X
+ _1018_/Q _1017_/Q VPWR VGND sg13cmos5l_mux4_1
XANTENNA__0799__GATE Tile_X0Y5_FrameStrobe[0] VPWR VGND sg13cmos5l_antennanp
X_1337_ _1337_/Q Tile_X0Y5_FrameData[23] VGND VPWR Tile_X0Y5_FrameStrobe[2] latch
X_1268_ _1268_/Q Tile_X0Y5_FrameData[28] VGND VPWR Tile_X0Y5_FrameStrobe[0] latch
XANTENNA__0722__GATE Tile_X0Y5_FrameStrobe[5] VPWR VGND sg13cmos5l_antennanp
XANTENNA__2275__A1 Tile_X0Y2_WW4END[2] VPWR VGND sg13cmos5l_antennanp
X_1199_ _1199_/Q Tile_X0Y4_FrameData[23] VGND VPWR Tile_X0Y5_FrameStrobe[5] latch
X_0219_ _0219_/Q Tile_X0Y0_FrameData[11] VGND VPWR Tile_X0Y5_FrameStrobe[4] latch
XFILLER_36_150 VPWR VGND sg13cmos5l_fill_1
XFILLER_36_172 VPWR VGND sg13cmos5l_decap_8
XANTENNA__0107__GATE Tile_X0Y5_FrameStrobe[1] VPWR VGND sg13cmos5l_antennanp
XANTENNA__0118__D Tile_X0Y0_FrameData[16] VPWR VGND sg13cmos5l_antennanp
XFILLER_196_103 VPWR VGND sg13cmos5l_decap_8
XANTENNA__0737__GATE Tile_X0Y5_FrameStrobe[5] VPWR VGND sg13cmos5l_antennanp
XFILLER_353_111 VPWR VGND sg13cmos5l_decap_8
XFILLER_257_50 VPWR VGND sg13cmos5l_decap_8
XFILLER_257_72 VPWR VGND sg13cmos5l_decap_4
XFILLER_193_27 VPWR VGND sg13cmos5l_fill_1
XFILLER_257_83 VPWR VGND sg13cmos5l_fill_2
XFILLER_353_188 VPWR VGND sg13cmos5l_decap_8
XFILLER_105_144 VPWR VGND sg13cmos5l_decap_8
XFILLER_10_54 VPWR VGND sg13cmos5l_fill_2
XFILLER_193_38 VPWR VGND sg13cmos5l_decap_8
XANTENNA__0788__D Tile_X0Y2_FrameData[18] VPWR VGND sg13cmos5l_antennanp
XFILLER_10_65 VPWR VGND sg13cmos5l_fill_1
XFILLER_126_43 VPWR VGND sg13cmos5l_decap_8
XANTENNA__1814__X Tile_X0Y4_E6BEG[9] VPWR VGND sg13cmos5l_antennanp
XFILLER_266_107 VPWR VGND sg13cmos5l_decap_4
XFILLER_86_36 VPWR VGND sg13cmos5l_decap_8
XANTENNA__2502__A2 Tile_X0Y4_W6END[1] VPWR VGND sg13cmos5l_antennanp
XFILLER_142_42 VPWR VGND sg13cmos5l_decap_4
XFILLER_274_140 VPWR VGND sg13cmos5l_decap_8
XFILLER_142_53 VPWR VGND sg13cmos5l_decap_8
XFILLER_142_75 VPWR VGND sg13cmos5l_fill_1
XANTENNA__1412__D Tile_X0Y5_FrameData[12] VPWR VGND sg13cmos5l_antennanp
XFILLER_142_97 VPWR VGND sg13cmos5l_decap_8
XFILLER_27_172 VPWR VGND sg13cmos5l_decap_4
XFILLER_298_90 VPWR VGND sg13cmos5l_fill_1
XFILLER_187_169 VPWR VGND sg13cmos5l_fill_1
XFILLER_51_61 VPWR VGND sg13cmos5l_fill_2
XFILLER_329_196 VPWR VGND sg13cmos5l_fill_2
XFILLER_167_50 VPWR VGND sg13cmos5l_fill_2
XFILLER_344_155 VPWR VGND sg13cmos5l_decap_4
XFILLER_167_94 VPWR VGND sg13cmos5l_decap_8
X_0570_ _0570_/Q Tile_X0Y2_FrameData[12] VGND VPWR Tile_X0Y5_FrameStrobe[0] latch
XANTENNA__0698__D Tile_X0Y2_FrameData[12] VPWR VGND sg13cmos5l_antennanp
XANTENNA__1724__X Tile_X0Y0_E2BEGb[4] VPWR VGND sg13cmos5l_antennanp
XFILLER_183_71 VPWR VGND sg13cmos5l_decap_8
X_2240_ _2240_/X _2213_/X _0049_/X Tile_X0Y0_S1END[0] Tile_X0Y0_S4END[0] _0126_/Q
+ _0125_/Q VPWR VGND sg13cmos5l_mux4_1
XFILLER_333_41 VPWR VGND sg13cmos5l_decap_8
X_2171_ _2171_/X AXIL_S_SOC_WDATA22 AXIL_S_SOC_WDATA30 _2242_/X _2247_/X _0254_/Q
+ _0253_/Q VPWR VGND sg13cmos5l_mux4_1
X_1122_ _1122_/Q Tile_X0Y4_FrameData[4] VGND VPWR Tile_X0Y5_FrameStrobe[2] latch
XANTENNA__1322__D Tile_X0Y5_FrameData[6] VPWR VGND sg13cmos5l_antennanp
XANTENNA__2257__A1 Tile_X0Y2_W2END[3] VPWR VGND sg13cmos5l_antennanp
X_1053_ _1053_/Q Tile_X0Y4_FrameData[9] VGND VPWR Tile_X0Y5_FrameStrobe[0] latch
XANTENNA__1452__GATE Tile_X0Y5_FrameStrobe[5] VPWR VGND sg13cmos5l_antennanp
XANTENNA__1900__A Tile_X0Y1_FrameData[13] VPWR VGND sg13cmos5l_antennanp
XFILLER_202_78 VPWR VGND sg13cmos5l_decap_8
XFILLER_92_90 VPWR VGND sg13cmos5l_decap_4
XFILLER_178_147 VPWR VGND sg13cmos5l_decap_8
XANTENNA__1467__GATE Tile_X0Y5_FrameStrobe[6] VPWR VGND sg13cmos5l_antennanp
X_1955_ Tile_X0Y1_E2BEG[0] _2293_/X VPWR VGND sg13cmos5l_buf_1
XANTENNA__0093__GATE Tile_X0Y5_FrameStrobe[0] VPWR VGND sg13cmos5l_antennanp
XFILLER_193_128 VPWR VGND sg13cmos5l_fill_1
X_0906_ _0906_/Q Tile_X0Y3_FrameData[12] VGND VPWR Tile_X0Y5_FrameStrobe[3] latch
XFILLER_294_37 VPWR VGND sg13cmos5l_fill_1
X_1886_ Tile_X0Y1_UserCLKo Tile_X0Y1_UserCLK VPWR VGND sg13cmos5l_buf_1
XFILLER_294_48 VPWR VGND sg13cmos5l_decap_4
XFILLER_294_59 VPWR VGND sg13cmos5l_fill_1
X_0837_ _0837_/Q Tile_X0Y3_FrameData[17] VGND VPWR Tile_X0Y5_FrameStrobe[1] latch
XANTENNA__2193__A0 AXIL_S_SOC_WDATA16 VPWR VGND sg13cmos5l_antennanp
X_0768_ _0768_/Q Tile_X0Y2_FrameData[6] VGND VPWR Tile_X0Y5_FrameStrobe[6] latch
XFILLER_0_208 VPWR VGND sg13cmos5l_fill_1
X_2507_ _2507_/X _2570_/X _2569_/X AXIL_S_SOC_ARADDR0 AXIL_S_SOC_ARADDR5 _0990_/Q
+ _0989_/Q VPWR VGND sg13cmos5l_mux4_1
XFILLER_350_158 VPWR VGND sg13cmos5l_fill_2
XANTENNA__0401__D Tile_X0Y1_FrameData[5] VPWR VGND sg13cmos5l_antennanp
XANTENNA__1634__X Tile_X0Y0_N2BEG[6] VPWR VGND sg13cmos5l_antennanp
X_0699_ _0699_/Q Tile_X0Y2_FrameData[11] VGND VPWR Tile_X0Y5_FrameStrobe[4] latch
XANTENNA__1405__GATE Tile_X0Y5_FrameStrobe[4] VPWR VGND sg13cmos5l_antennanp
X_2438_ _2438_/X AXIL_S_SOC_AWADDR5 _2474_/X _2468_/X _2482_/X _0672_/Q _0671_/Q VPWR
+ VGND sg13cmos5l_mux4_1
XANTENNA__2496__A1 Tile_X0Y4_W2END[4] VPWR VGND sg13cmos5l_antennanp
XFILLER_243_85 VPWR VGND sg13cmos5l_decap_4
X_2369_ _2369_/X _2344_/X _0031_/X _2343_/X Tile_X0Y0_S4END[5] _0356_/Q _0355_/Q VPWR
+ VGND sg13cmos5l_mux4_1
XFILLER_56_201 VPWR VGND sg13cmos5l_fill_2
XANTENNA__0661__GATE Tile_X0Y5_FrameStrobe[3] VPWR VGND sg13cmos5l_antennanp
XANTENNA__1232__D Tile_X0Y4_FrameData[22] VPWR VGND sg13cmos5l_antennanp
XFILLER_112_34 VPWR VGND sg13cmos5l_decap_8
XANTENNA__0676__GATE Tile_X0Y5_FrameStrobe[3] VPWR VGND sg13cmos5l_antennanp
XFILLER_188_16 VPWR VGND sg13cmos5l_fill_1
XFILLER_212_221 VPWR VGND sg13cmos5l_fill_2
XFILLER_271_198 VPWR VGND sg13cmos5l_fill_1
XFILLER_72_38 VPWR VGND sg13cmos5l_decap_8
XFILLER_358_214 VPWR VGND sg13cmos5l_fill_1
XFILLER_358_203 VPWR VGND sg13cmos5l_fill_1
XFILLER_188_27 VPWR VGND sg13cmos5l_fill_1
XFILLER_188_38 VPWR VGND sg13cmos5l_decap_8
XFILLER_241_7 VPWR VGND sg13cmos5l_fill_2
XFILLER_339_7 VPWR VGND sg13cmos5l_decap_8
XFILLER_169_169 VPWR VGND sg13cmos5l_fill_1
XFILLER_184_106 VPWR VGND sg13cmos5l_decap_8
XANTENNA__1809__X Tile_X0Y4_E6BEG[4] VPWR VGND sg13cmos5l_antennanp
XANTENNA__2420__A1 AXIL_S_SOC_AWADDR3 VPWR VGND sg13cmos5l_antennanp
XFILLER_125_206 VPWR VGND sg13cmos5l_decap_8
XANTENNA__2184__A0 AXIL_S_SOC_WDATA19 VPWR VGND sg13cmos5l_antennanp
XFILLER_21_86 VPWR VGND sg13cmos5l_fill_2
XANTENNA__0614__GATE Tile_X0Y5_FrameStrobe[1] VPWR VGND sg13cmos5l_antennanp
XANTENNA__1407__D Tile_X0Y5_FrameData[17] VPWR VGND sg13cmos5l_antennanp
XANTENNA__2723__A2 Tile_X0Y5_WW4END[5] VPWR VGND sg13cmos5l_antennanp
XFILLER_97_24 VPWR VGND sg13cmos5l_decap_8
XANTENNA__0311__D Tile_X0Y0_FrameData[31] VPWR VGND sg13cmos5l_antennanp
XANTENNA__1544__X Tile_X0Y3_EE4BEG[6] VPWR VGND sg13cmos5l_antennanp
XFILLER_239_118 VPWR VGND sg13cmos5l_decap_8
XANTENNA__0629__GATE Tile_X0Y5_FrameStrobe[2] VPWR VGND sg13cmos5l_antennanp
XFILLER_247_140 VPWR VGND sg13cmos5l_decap_8
XFILLER_101_180 VPWR VGND sg13cmos5l_decap_8
XFILLER_247_173 VPWR VGND sg13cmos5l_decap_4
XANTENNA__1142__D Tile_X0Y4_FrameData[16] VPWR VGND sg13cmos5l_antennanp
XFILLER_262_143 VPWR VGND sg13cmos5l_decap_8
XFILLER_46_61 VPWR VGND sg13cmos5l_fill_2
XFILLER_46_94 VPWR VGND sg13cmos5l_decap_8
XANTENNA__0981__D Tile_X0Y3_FrameData[1] VPWR VGND sg13cmos5l_antennanp
XFILLER_349_203 VPWR VGND sg13cmos5l_fill_2
XFILLER_30_123 VPWR VGND sg13cmos5l_decap_4
XANTENNA__1719__X Tile_X0Y0_E6BEG[11] VPWR VGND sg13cmos5l_antennanp
XFILLER_178_60 VPWR VGND sg13cmos5l_decap_8
XANTENNA__2411__A1 AXIL_S_SOC_AWPROT0 VPWR VGND sg13cmos5l_antennanp
X_1740_ Tile_X0Y2_FrameData_O[0] Tile_X0Y2_FrameData[0] VPWR VGND sg13cmos5l_buf_1
XFILLER_116_206 VPWR VGND sg13cmos5l_decap_8
XFILLER_116_217 VPWR VGND sg13cmos5l_fill_1
X_1671_ Tile_X0Y0_FrameData_O[11] Tile_X0Y0_FrameData[11] VPWR VGND sg13cmos5l_buf_1
XANTENNA__2175__A0 AXIL_S_SOC_WDATA18 VPWR VGND sg13cmos5l_antennanp
XFILLER_194_70 VPWR VGND sg13cmos5l_decap_8
XFILLER_264_18 VPWR VGND sg13cmos5l_decap_8
X_0622_ _0622_/Q Tile_X0Y2_FrameData[24] VGND VPWR Tile_X0Y5_FrameStrobe[2] latch
XANTENNA__2714__A2 Tile_X0Y3_W6END[9] VPWR VGND sg13cmos5l_antennanp
X_0553_ _0553_/Q Tile_X0Y2_FrameData[29] VGND VPWR Tile_X0Y5_FrameStrobe[0] latch
XANTENNA__0221__D Tile_X0Y0_FrameData[9] VPWR VGND sg13cmos5l_antennanp
XANTENNA__1317__D Tile_X0Y5_FrameData[11] VPWR VGND sg13cmos5l_antennanp
X_0484_ _0484_/Q Tile_X0Y1_FrameData[18] VGND VPWR Tile_X0Y5_FrameStrobe[5] latch
XANTENNA__2478__A1 Tile_X0Y5_N4END[13] VPWR VGND sg13cmos5l_antennanp
X_2223_ _2223_/X Tile_X0Y4_W1END[1] Tile_X0Y4_WW4END[1] Tile_X0Y4_W6END[9] _2705_/X
+ _1237_/Q _1236_/Q VPWR VGND sg13cmos5l_mux4_1
XFILLER_238_184 VPWR VGND sg13cmos5l_decap_4
X_2154_ _2154_/X _2240_/X _2239_/X _2230_/X _2229_/X _0286_/Q _0285_/Q VPWR VGND sg13cmos5l_mux4_1
XFILLER_38_223 VPWR VGND sg13cmos5l_fill_1
XANTENNA__1052__D Tile_X0Y4_FrameData[10] VPWR VGND sg13cmos5l_antennanp
XANTENNA__1391__GATE Tile_X0Y5_FrameStrobe[3] VPWR VGND sg13cmos5l_antennanp
XFILLER_253_110 VPWR VGND sg13cmos5l_fill_2
X_1105_ _1105_/Q Tile_X0Y4_FrameData[21] VGND VPWR Tile_X0Y5_FrameStrobe[2] latch
X_2085_ Tile_X0Y3_E1BEG[1] _2506_/X VPWR VGND sg13cmos5l_buf_1
XANTENNA__0891__D Tile_X0Y3_FrameData[27] VPWR VGND sg13cmos5l_antennanp
X_1036_ _1036_/Q Tile_X0Y4_FrameData[26] VGND VPWR Tile_X0Y5_FrameStrobe[0] latch
XFILLER_355_206 VPWR VGND sg13cmos5l_decap_4
XANTENNA__1629__X Tile_X0Y0_N2BEG[1] VPWR VGND sg13cmos5l_antennanp
XANTENNA__2402__A1 AXIL_S_SOC_AWADDR9 VPWR VGND sg13cmos5l_antennanp
XFILLER_238_30 VPWR VGND sg13cmos5l_fill_1
X_1938_ Tile_X0Y1_E6BEG[3] _2328_/X VPWR VGND sg13cmos5l_buf_1
XFILLER_238_74 VPWR VGND sg13cmos5l_decap_8
X_1869_ Tile_X0Y2_E2BEGb[3] _2412_/X VPWR VGND sg13cmos5l_buf_1
XANTENNA__2166__A0 AXIL_S_SOC_WDATA17 VPWR VGND sg13cmos5l_antennanp
XANTENNA__0131__D Tile_X0Y0_FrameData[3] VPWR VGND sg13cmos5l_antennanp
XANTENNA__1227__D Tile_X0Y4_FrameData[27] VPWR VGND sg13cmos5l_antennanp
XANTENNA__1344__GATE Tile_X0Y5_FrameStrobe[2] VPWR VGND sg13cmos5l_antennanp
XFILLER_254_51 VPWR VGND sg13cmos5l_decap_8
XFILLER_88_112 VPWR VGND sg13cmos5l_decap_8
XFILLER_254_95 VPWR VGND sg13cmos5l_fill_1
XFILLER_276_213 VPWR VGND sg13cmos5l_fill_1
XFILLER_67_38 VPWR VGND sg13cmos5l_fill_1
XANTENNA__2469__A1 Tile_X0Y5_N4END[13] VPWR VGND sg13cmos5l_antennanp
XFILLER_191_7 VPWR VGND sg13cmos5l_decap_8
XFILLER_88_178 VPWR VGND sg13cmos5l_decap_8
XANTENNA__1359__GATE Tile_X0Y5_FrameStrobe[2] VPWR VGND sg13cmos5l_antennanp
XFILLER_229_173 VPWR VGND sg13cmos5l_decap_8
XFILLER_291_216 VPWR VGND sg13cmos5l_fill_2
XFILLER_29_223 VPWR VGND sg13cmos5l_fill_1
XFILLER_270_50 VPWR VGND sg13cmos5l_fill_2
XFILLER_270_83 VPWR VGND sg13cmos5l_decap_8
XFILLER_189_209 VPWR VGND sg13cmos5l_decap_4
XFILLER_199_15 VPWR VGND sg13cmos5l_decap_4
XFILLER_83_37 VPWR VGND sg13cmos5l_decap_8
XFILLER_244_198 VPWR VGND sg13cmos5l_decap_8
XFILLER_351_6 VPWR VGND sg13cmos5l_fill_2
XANTENNA__2641__A1 AXIL_S_SOC_WVALID VPWR VGND sg13cmos5l_antennanp
XFILLER_16_64 VPWR VGND sg13cmos5l_decap_8
XFILLER_200_202 VPWR VGND sg13cmos5l_decap_8
XANTENNA__0306__D Tile_X0Y0_FrameData[20] VPWR VGND sg13cmos5l_antennanp
XANTENNA__1539__X Tile_X0Y3_EE4BEG[1] VPWR VGND sg13cmos5l_antennanp
XFILLER_12_167 VPWR VGND sg13cmos5l_fill_1
XFILLER_157_128 VPWR VGND sg13cmos5l_decap_8
XFILLER_346_217 VPWR VGND sg13cmos5l_fill_1
XFILLER_32_63 VPWR VGND sg13cmos5l_fill_1
XFILLER_32_85 VPWR VGND sg13cmos5l_decap_4
XFILLER_295_80 VPWR VGND sg13cmos5l_fill_1
XANTENNA__0553__GATE Tile_X0Y5_FrameStrobe[0] VPWR VGND sg13cmos5l_antennanp
XFILLER_113_0 VPWR VGND sg13cmos5l_fill_1
XFILLER_148_85 VPWR VGND sg13cmos5l_decap_8
XANTENNA__2157__A0 Tile_X0Y0_W1END[2] VPWR VGND sg13cmos5l_antennanp
XANTENNA__1137__D Tile_X0Y4_FrameData[21] VPWR VGND sg13cmos5l_antennanp
XFILLER_79_134 VPWR VGND sg13cmos5l_decap_8
XANTENNA__0568__GATE Tile_X0Y5_FrameStrobe[0] VPWR VGND sg13cmos5l_antennanp
XANTENNA__0976__D Tile_X0Y3_FrameData[6] VPWR VGND sg13cmos5l_antennanp
XFILLER_282_216 VPWR VGND sg13cmos5l_fill_2
XFILLER_314_98 VPWR VGND sg13cmos5l_fill_1
XFILLER_330_20 VPWR VGND sg13cmos5l_decap_8
XANTENNA__2632__A1 AXIL_S_SOC_WSTRB3 VPWR VGND sg13cmos5l_antennanp
XFILLER_330_97 VPWR VGND sg13cmos5l_fill_1
XANTENNA__0506__GATE Tile_X0Y5_FrameStrobe[6] VPWR VGND sg13cmos5l_antennanp
XFILLER_148_106 VPWR VGND sg13cmos5l_decap_8
XANTENNA__0216__D Tile_X0Y0_FrameData[14] VPWR VGND sg13cmos5l_antennanp
XFILLER_85_4 VPWR VGND sg13cmos5l_fill_1
XANTENNA__2396__A0 Tile_X0Y3_W2MID[0] VPWR VGND sg13cmos5l_antennanp
X_2772_ _2772_/X Tile_X0Y5_W1END[3] Tile_X0Y5_W6END[11] _2801_/X _2792_/X _1358_/Q
+ _1357_/Q VPWR VGND sg13cmos5l_mux4_1
XFILLER_156_172 VPWR VGND sg13cmos5l_decap_8
XFILLER_275_28 VPWR VGND sg13cmos5l_decap_8
X_1723_ Tile_X0Y0_E2BEGb[3] _2176_/X VPWR VGND sg13cmos5l_buf_1
XFILLER_208_11 VPWR VGND sg13cmos5l_fill_2
XANTENNA__2148__A0 Tile_X0Y0_W2MID[4] VPWR VGND sg13cmos5l_antennanp
XFILLER_208_55 VPWR VGND sg13cmos5l_decap_8
X_1654_ Tile_X0Y0_FrameStrobe_O[14] Tile_X0Y5_FrameStrobe[14] VPWR VGND sg13cmos5l_buf_1
XANTENNA__1047__D Tile_X0Y4_FrameData[15] VPWR VGND sg13cmos5l_antennanp
X_1585_ Tile_X0Y3_FrameData_O[31] Tile_X0Y3_FrameData[31] VPWR VGND sg13cmos5l_buf_1
X_0605_ _0605_/Q Tile_X0Y2_FrameData[9] VGND VPWR Tile_X0Y5_FrameStrobe[1] latch
XANTENNA__2163__A3 AXIL_S_SOC_WDATA21 VPWR VGND sg13cmos5l_antennanp
XFILLER_258_213 VPWR VGND sg13cmos5l_fill_2
X_0536_ _0536_/Q Tile_X0Y1_FrameData[30] VGND VPWR Tile_X0Y5_FrameStrobe[7] latch
XANTENNA__0886__D Tile_X0Y3_FrameData[0] VPWR VGND sg13cmos5l_antennanp
XFILLER_224_21 VPWR VGND sg13cmos5l_decap_8
X_0467_ _0467_/Q Tile_X0Y1_FrameData[3] VGND VPWR Tile_X0Y5_FrameStrobe[4] latch
XANTENNA__1912__X Tile_X0Y1_FrameData_O[25] VPWR VGND sg13cmos5l_antennanp
X_2206_ _2206_/X AXIL_S_SOC_WDATA17 _2236_/X _2234_/X _2246_/X _0184_/Q _0183_/Q VPWR
+ VGND sg13cmos5l_mux4_1
XANTENNA__2320__A0 AXIL_S_SOC_WDATA7 VPWR VGND sg13cmos5l_antennanp
X_0398_ _0398_/Q Tile_X0Y1_FrameData[8] VGND VPWR Tile_X0Y5_FrameStrobe[2] latch
X_2137_ AXIL_S_SOC_RDATA31 Tile_X0Y0_W2MID[7] Tile_X0Y0_W2END[7] Tile_X0Y0_W6END[7]
+ _2248_/X _0128_/Q _0127_/Q VPWR VGND sg13cmos5l_mux4_1
XFILLER_241_124 VPWR VGND sg13cmos5l_decap_8
X_2068_ Tile_X0Y5_S4BEG[1] _2068_/A VPWR VGND sg13cmos5l_buf_1
XANTENNA__2623__A1 AXIL_S_SOC_WSTRB2 VPWR VGND sg13cmos5l_antennanp
X_1019_ _1019_/Q Tile_X0Y3_FrameData[27] VGND VPWR Tile_X0Y5_FrameStrobe[7] latch
XANTENNA__0126__D Tile_X0Y0_FrameData[8] VPWR VGND sg13cmos5l_antennanp
XFILLER_139_128 VPWR VGND sg13cmos5l_decap_8
XFILLER_249_51 VPWR VGND sg13cmos5l_fill_1
XANTENNA__2387__A0 Tile_X0Y0_W2MID[4] VPWR VGND sg13cmos5l_antennanp
XFILLER_147_150 VPWR VGND sg13cmos5l_decap_8
XFILLER_185_17 VPWR VGND sg13cmos5l_fill_1
XFILLER_185_28 VPWR VGND sg13cmos5l_decap_8
XFILLER_211_8 VPWR VGND sg13cmos5l_decap_8
XFILLER_343_209 VPWR VGND sg13cmos5l_fill_2
XFILLER_147_194 VPWR VGND sg13cmos5l_fill_1
XANTENNA__1283__GATE Tile_X0Y5_FrameStrobe[0] VPWR VGND sg13cmos5l_antennanp
XANTENNA__2139__A0 Tile_X0Y5_W2MID[2] VPWR VGND sg13cmos5l_antennanp
XFILLER_78_37 VPWR VGND sg13cmos5l_decap_8
XANTENNA__0796__D Tile_X0Y3_FrameData[26] VPWR VGND sg13cmos5l_antennanp
XANTENNA__1298__GATE Tile_X0Y5_FrameStrobe[1] VPWR VGND sg13cmos5l_antennanp
XANTENNA__1822__X Tile_X0Y4_EE4BEG[5] VPWR VGND sg13cmos5l_antennanp
XFILLER_134_76 VPWR VGND sg13cmos5l_decap_8
XANTENNA__2311__A0 AXIL_S_SOC_WDATA2 VPWR VGND sg13cmos5l_antennanp
XFILLER_217_132 VPWR VGND sg13cmos5l_fill_1
XFILLER_217_143 VPWR VGND sg13cmos5l_decap_4
XANTENNA__1221__GATE Tile_X0Y5_FrameStrobe[5] VPWR VGND sg13cmos5l_antennanp
XANTENNA__1420__D Tile_X0Y5_FrameData[4] VPWR VGND sg13cmos5l_antennanp
XFILLER_232_135 VPWR VGND sg13cmos5l_fill_2
XANTENNA__1236__GATE Tile_X0Y5_FrameStrobe[6] VPWR VGND sg13cmos5l_antennanp
XFILLER_185_212 VPWR VGND sg13cmos5l_fill_2
XFILLER_159_62 VPWR VGND sg13cmos5l_decap_8
XFILLER_328_0 VPWR VGND sg13cmos5l_decap_4
XANTENNA__0492__GATE Tile_X0Y5_FrameStrobe[5] VPWR VGND sg13cmos5l_antennanp
XFILLER_159_95 VPWR VGND sg13cmos5l_decap_8
X_1370_ _1370_/Q Tile_X0Y5_FrameData[22] VGND VPWR Tile_X0Y5_FrameStrobe[3] latch
XFILLER_302_139 VPWR VGND sg13cmos5l_fill_1
XANTENNA__2550__A0 AXIL_S_SOC_ARADDR1 VPWR VGND sg13cmos5l_antennanp
X_0321_ _0321_/Q Tile_X0Y1_FrameData[21] VGND VPWR Tile_X0Y5_FrameStrobe[0] latch
XFILLER_67_115 VPWR VGND sg13cmos5l_decap_8
XFILLER_325_97 VPWR VGND sg13cmos5l_fill_1
XFILLER_325_86 VPWR VGND sg13cmos5l_fill_2
XANTENNA__1732__X Tile_X0Y0_E2BEG[4] VPWR VGND sg13cmos5l_antennanp
XANTENNA__0430__GATE Tile_X0Y5_FrameStrobe[3] VPWR VGND sg13cmos5l_antennanp
XANTENNA__2302__A0 AXIL_S_SOC_WDATA1 VPWR VGND sg13cmos5l_antennanp
X_0252_ _0252_/Q Tile_X0Y0_FrameData[10] VGND VPWR Tile_X0Y5_FrameStrobe[5] latch
XFILLER_82_107 VPWR VGND sg13cmos5l_decap_4
X_0183_ _0183_/Q Tile_X0Y0_FrameData[15] VGND VPWR Tile_X0Y5_FrameStrobe[3] latch
XANTENNA__0445__GATE Tile_X0Y5_FrameStrobe[4] VPWR VGND sg13cmos5l_antennanp
XFILLER_223_157 VPWR VGND sg13cmos5l_fill_1
XFILLER_90_151 VPWR VGND sg13cmos5l_decap_8
XANTENNA__1330__D Tile_X0Y5_FrameData[30] VPWR VGND sg13cmos5l_antennanp
XANTENNA__2605__A1 Tile_X0Y2_W2MID[3] VPWR VGND sg13cmos5l_antennanp
XFILLER_90_2 VPWR VGND sg13cmos5l_fill_1
X_2824_ _2824_/X Tile_X0Y5_N1END[0] Tile_X0Y5_N4END[0] _2793_/X _0032_/X _1320_/Q
+ _1319_/Q VPWR VGND sg13cmos5l_mux4_1
XFILLER_219_10 VPWR VGND sg13cmos5l_fill_1
XANTENNA__1907__X Tile_X0Y1_FrameData_O[20] VPWR VGND sg13cmos5l_antennanp
X_2755_ _2755_/X AXIL_S_SOC_ARPROT2 AXIL_S_SOC_RREADY _2822_/X _2826_/X _1392_/Q _1391_/Q
+ VPWR VGND sg13cmos5l_mux4_1
X_1706_ Tile_X0Y0_EE4BEG[14] _2195_/X VPWR VGND sg13cmos5l_buf_1
X_2686_ _2686_/X Tile_X0Y0_W1END[0] Tile_X0Y0_WW4END[8] Tile_X0Y0_WW4END[12] Tile_X0Y0_W6END[4]
+ _0154_/Q _0153_/Q VPWR VGND sg13cmos5l_mux4_1
XFILLER_144_164 VPWR VGND sg13cmos5l_decap_8
X_1637_ Tile_X0Y0_N1BEG[1] _2142_/X VPWR VGND sg13cmos5l_buf_1
XANTENNA__2541__A0 Tile_X0Y5_N4END[8] VPWR VGND sg13cmos5l_antennanp
XFILLER_100_201 VPWR VGND sg13cmos5l_decap_8
X_1568_ Tile_X0Y3_FrameData_O[14] Tile_X0Y3_FrameData[14] VPWR VGND sg13cmos5l_buf_1
XANTENNA__1642__X Tile_X0Y0_FrameStrobe_O[2] VPWR VGND sg13cmos5l_antennanp
XFILLER_100_223 VPWR VGND sg13cmos5l_fill_1
X_1499_ _2453_/A3 VPWR VGND sg13cmos5l_tielo
X_0519_ _0519_/Q Tile_X0Y1_FrameData[15] VGND VPWR Tile_X0Y5_FrameStrobe[6] latch
XFILLER_58_126 VPWR VGND sg13cmos5l_decap_4
XFILLER_81_140 VPWR VGND sg13cmos5l_fill_2
XANTENNA__1240__D Tile_X0Y4_FrameData[14] VPWR VGND sg13cmos5l_antennanp
XFILLER_81_184 VPWR VGND sg13cmos5l_fill_1
XFILLER_13_21 VPWR VGND sg13cmos5l_fill_1
XFILLER_80_49 VPWR VGND sg13cmos5l_decap_8
XANTENNA__1817__X Tile_X0Y4_EE4BEG[0] VPWR VGND sg13cmos5l_antennanp
XFILLER_135_120 VPWR VGND sg13cmos5l_decap_8
XANTENNA__2375__A3 Tile_X0Y0_S2MID[2] VPWR VGND sg13cmos5l_antennanp
XANTENNA__2780__A0 Tile_X0Y5_W1END[3] VPWR VGND sg13cmos5l_antennanp
XFILLER_135_142 VPWR VGND sg13cmos5l_decap_8
XFILLER_89_58 VPWR VGND sg13cmos5l_decap_8
XFILLER_296_105 VPWR VGND sg13cmos5l_decap_8
XFILLER_145_53 VPWR VGND sg13cmos5l_decap_8
XANTENNA__2532__A0 AXIL_S_SOC_ARADDR1 VPWR VGND sg13cmos5l_antennanp
XFILLER_145_86 VPWR VGND sg13cmos5l_decap_8
XANTENNA__1415__D Tile_X0Y5_FrameData[9] VPWR VGND sg13cmos5l_antennanp
XANTENNA__1552__X Tile_X0Y3_EE4BEG[14] VPWR VGND sg13cmos5l_antennanp
XANTENNA__1160__GATE Tile_X0Y5_FrameStrobe[4] VPWR VGND sg13cmos5l_antennanp
XANTENNA__2835__A1 Tile_X0Y4_W2MID[1] VPWR VGND sg13cmos5l_antennanp
XFILLER_161_63 VPWR VGND sg13cmos5l_decap_8
XFILLER_180_0 VPWR VGND sg13cmos5l_fill_2
XFILLER_57_170 VPWR VGND sg13cmos5l_decap_4
XFILLER_72_140 VPWR VGND sg13cmos5l_fill_1
XFILLER_57_181 VPWR VGND sg13cmos5l_decap_8
XANTENNA__1150__D Tile_X0Y4_FrameData[8] VPWR VGND sg13cmos5l_antennanp
XANTENNA__1175__GATE Tile_X0Y5_FrameStrobe[4] VPWR VGND sg13cmos5l_antennanp
XANTENNA__2599__A0 Tile_X0Y2_W2MID[6] VPWR VGND sg13cmos5l_antennanp
XFILLER_205_168 VPWR VGND sg13cmos5l_decap_8
XFILLER_220_105 VPWR VGND sg13cmos5l_decap_8
XFILLER_54_83 VPWR VGND sg13cmos5l_fill_1
X_0870_ _0870_/Q Tile_X0Y3_FrameData[16] VGND VPWR Tile_X0Y5_FrameStrobe[2] latch
XANTENNA__1727__X Tile_X0Y0_E2BEGb[7] VPWR VGND sg13cmos5l_antennanp
XFILLER_126_120 VPWR VGND sg13cmos5l_fill_2
XANTENNA__2366__A3 Tile_X0Y0_S4END[6] VPWR VGND sg13cmos5l_antennanp
X_2540_ _2540_/X AXIL_S_SOC_ARADDR3 AXIL_S_SOC_ARADDR5 _2588_/X _2589_/X _0924_/Q
+ _0923_/Q VPWR VGND sg13cmos5l_mux4_1
XANTENNA__2771__A0 Tile_X0Y5_W1END[2] VPWR VGND sg13cmos5l_antennanp
X_2471_ _2471_/X _2458_/X Tile_X0Y5_N4END[12] _2457_/X Tile_X0Y0_S4END[8] _0582_/Q
+ _0581_/Q VPWR VGND sg13cmos5l_mux4_1
XANTENNA__1113__GATE Tile_X0Y5_FrameStrobe[2] VPWR VGND sg13cmos5l_antennanp
X_1422_ _1422_/Q Tile_X0Y5_FrameData[2] VGND VPWR Tile_X0Y5_FrameStrobe[4] latch
XFILLER_330_223 VPWR VGND sg13cmos5l_fill_1
XANTENNA__2523__A0 AXIL_S_SOC_ARADDR4 VPWR VGND sg13cmos5l_antennanp
XANTENNA__1325__D Tile_X0Y5_FrameData[3] VPWR VGND sg13cmos5l_antennanp
XANTENNA__1903__A Tile_X0Y1_FrameData[16] VPWR VGND sg13cmos5l_antennanp
XFILLER_228_216 VPWR VGND sg13cmos5l_fill_2
X_1353_ _1353_/Q Tile_X0Y5_FrameData[7] VGND VPWR Tile_X0Y5_FrameStrobe[2] latch
XFILLER_95_221 VPWR VGND sg13cmos5l_fill_2
XANTENNA__1128__GATE Tile_X0Y5_FrameStrobe[3] VPWR VGND sg13cmos5l_antennanp
XFILLER_205_56 VPWR VGND sg13cmos5l_decap_8
X_1284_ _1284_/Q Tile_X0Y5_FrameData[12] VGND VPWR Tile_X0Y5_FrameStrobe[0] latch
X_0304_ _0304_/Q Tile_X0Y0_FrameData[22] VGND VPWR Tile_X0Y5_FrameStrobe[7] latch
XANTENNA__2826__A1 Tile_X0Y5_N2END[1] VPWR VGND sg13cmos5l_antennanp
X_0235_ _0235_/Q Tile_X0Y0_FrameData[27] VGND VPWR Tile_X0Y5_FrameStrobe[5] latch
XFILLER_48_181 VPWR VGND sg13cmos5l_decap_8
XANTENNA__0384__GATE Tile_X0Y5_FrameStrobe[2] VPWR VGND sg13cmos5l_antennanp
XFILLER_221_66 VPWR VGND sg13cmos5l_decap_8
X_0166_ _0166_/Q Tile_X0Y0_FrameData[0] VGND VPWR Tile_X0Y5_FrameStrobe[2] latch
XFILLER_63_151 VPWR VGND sg13cmos5l_decap_8
XANTENNA__1060__D Tile_X0Y4_FrameData[2] VPWR VGND sg13cmos5l_antennanp
X_0097_ _0097_/Q Tile_X0Y0_FrameData[5] VGND VPWR Tile_X0Y5_FrameStrobe[0] latch
XFILLER_297_15 VPWR VGND sg13cmos5l_decap_8
XANTENNA__0399__GATE Tile_X0Y5_FrameStrobe[2] VPWR VGND sg13cmos5l_antennanp
XFILLER_149_223 VPWR VGND sg13cmos5l_fill_1
XANTENNA__0404__D Tile_X0Y1_FrameData[2] VPWR VGND sg13cmos5l_antennanp
XANTENNA__1637__X Tile_X0Y0_N1BEG[1] VPWR VGND sg13cmos5l_antennanp
X_2807_ _2807_/X Tile_X0Y1_W1END[1] Tile_X0Y1_WW4END[9] Tile_X0Y1_WW4END[13] Tile_X0Y1_W6END[5]
+ _0391_/Q _0390_/Q VPWR VGND sg13cmos5l_mux4_1
X_0999_ _0999_/Q Tile_X0Y3_FrameData[15] VGND VPWR Tile_X0Y5_FrameStrobe[6] latch
XANTENNA__0322__GATE Tile_X0Y5_FrameStrobe[0] VPWR VGND sg13cmos5l_antennanp
XANTENNA__2357__A3 Tile_X0Y0_S4END[5] VPWR VGND sg13cmos5l_antennanp
XFILLER_246_30 VPWR VGND sg13cmos5l_fill_1
X_2738_ _2738_/X AXIL_S_SOC_ARPROT0 AXIL_S_SOC_ARVALID _2827_/X _2799_/X _1426_/Q
+ _1425_/Q VPWR VGND sg13cmos5l_mux4_1
XANTENNA__0952__GATE Tile_X0Y5_FrameStrobe[5] VPWR VGND sg13cmos5l_antennanp
XANTENNA__2762__A0 AXIL_S_SOC_ARPROT0 VPWR VGND sg13cmos5l_antennanp
XFILLER_246_41 VPWR VGND sg13cmos5l_decap_4
XFILLER_246_96 VPWR VGND sg13cmos5l_decap_8
X_2669_ _2669_/X _2674_/X _2673_/X Tile_X0Y4_W6END[0] _2669_/A3 _1038_/Q _1037_/Q
+ VPWR VGND sg13cmos5l_mux4_1
XANTENNA__2514__A0 AXIL_S_SOC_ARADDR3 VPWR VGND sg13cmos5l_antennanp
XANTENNA__0337__GATE Tile_X0Y5_FrameStrobe[0] VPWR VGND sg13cmos5l_antennanp
XANTENNA__1235__D Tile_X0Y4_FrameData[19] VPWR VGND sg13cmos5l_antennanp
XANTENNA__0967__GATE Tile_X0Y5_FrameStrobe[5] VPWR VGND sg13cmos5l_antennanp
XFILLER_262_73 VPWR VGND sg13cmos5l_decap_8
XANTENNA__2817__A1 Tile_X0Y5_N4END[3] VPWR VGND sg13cmos5l_antennanp
XFILLER_199_134 VPWR VGND sg13cmos5l_fill_1
XFILLER_24_31 VPWR VGND sg13cmos5l_fill_2
XFILLER_348_109 VPWR VGND sg13cmos5l_decap_8
XANTENNA__0905__GATE Tile_X0Y5_FrameStrobe[3] VPWR VGND sg13cmos5l_antennanp
XFILLER_138_2 VPWR VGND sg13cmos5l_fill_1
XFILLER_24_97 VPWR VGND sg13cmos5l_decap_4
XFILLER_356_142 VPWR VGND sg13cmos5l_decap_4
XANTENNA__1547__X Tile_X0Y3_EE4BEG[9] VPWR VGND sg13cmos5l_antennanp
XFILLER_356_197 VPWR VGND sg13cmos5l_fill_1
XANTENNA__0314__D Tile_X0Y1_FrameData[28] VPWR VGND sg13cmos5l_antennanp
XFILLER_156_30 VPWR VGND sg13cmos5l_fill_2
XANTENNA__2753__A0 AXIL_S_SOC_ARPROT0 VPWR VGND sg13cmos5l_antennanp
XFILLER_123_134 VPWR VGND sg13cmos5l_fill_1
XFILLER_156_74 VPWR VGND sg13cmos5l_fill_2
XANTENNA__1145__D Tile_X0Y4_FrameData[13] VPWR VGND sg13cmos5l_antennanp
XFILLER_306_99 VPWR VGND sg13cmos5l_fill_1
XFILLER_306_77 VPWR VGND sg13cmos5l_fill_1
XFILLER_172_84 VPWR VGND sg13cmos5l_decap_8
XFILLER_277_171 VPWR VGND sg13cmos5l_decap_8
XFILLER_49_83 VPWR VGND sg13cmos5l_fill_1
XANTENNA__0984__D Tile_X0Y3_FrameData[30] VPWR VGND sg13cmos5l_antennanp
XFILLER_292_141 VPWR VGND sg13cmos5l_decap_8
XFILLER_45_195 VPWR VGND sg13cmos5l_decap_8
XFILLER_45_184 VPWR VGND sg13cmos5l_fill_2
X_1971_ Tile_X0Y5_E2BEG[0] _2725_/X VPWR VGND sg13cmos5l_buf_1
XANTENNA__2587__A3 Tile_X0Y0_S4END[12] VPWR VGND sg13cmos5l_antennanp
XFILLER_197_81 VPWR VGND sg13cmos5l_decap_8
X_0922_ _0922_/Q Tile_X0Y3_FrameData[28] VGND VPWR Tile_X0Y5_FrameStrobe[4] latch
XFILLER_81_92 VPWR VGND sg13cmos5l_decap_8
XFILLER_197_92 VPWR VGND sg13cmos5l_fill_1
X_0853_ _0853_/Q Tile_X0Y3_FrameData[1] VGND VPWR Tile_X0Y5_FrameStrobe[1] latch
XFILLER_362_123 VPWR VGND sg13cmos5l_decap_8
XANTENNA__0224__D Tile_X0Y0_FrameData[6] VPWR VGND sg13cmos5l_antennanp
XANTENNA__1052__GATE Tile_X0Y5_FrameStrobe[0] VPWR VGND sg13cmos5l_antennanp
XANTENNA__2744__A0 AXIL_S_SOC_ARPROT0 VPWR VGND sg13cmos5l_antennanp
XFILLER_283_28 VPWR VGND sg13cmos5l_fill_1
X_2523_ _2523_/X AXIL_S_SOC_ARADDR4 AXIL_S_SOC_ARADDR6 _2590_/X _2595_/X _0958_/Q
+ _0957_/Q VPWR VGND sg13cmos5l_mux4_1
X_0784_ _0784_/Q Tile_X0Y2_FrameData[22] VGND VPWR Tile_X0Y5_FrameStrobe[7] latch
XFILLER_347_84 VPWR VGND sg13cmos5l_decap_8
XFILLER_114_134 VPWR VGND sg13cmos5l_decap_8
XFILLER_303_212 VPWR VGND sg13cmos5l_fill_1
X_2454_ _2454_/X _2460_/X _2459_/X Tile_X0Y2_W6END[1] _2454_/A3 _0556_/Q _0555_/Q
+ VPWR VGND sg13cmos5l_mux4_1
XANTENNA__1055__D Tile_X0Y4_FrameData[7] VPWR VGND sg13cmos5l_antennanp
XFILLER_268_160 VPWR VGND sg13cmos5l_fill_1
X_1405_ _1405_/Q Tile_X0Y5_FrameData[19] VGND VPWR Tile_X0Y5_FrameStrobe[4] latch
X_2385_ _2385_/X Tile_X0Y0_W2MID[5] Tile_X0Y0_W2END[5] Tile_X0Y0_W6END[10] _2243_/X
+ _0166_/Q _0165_/Q VPWR VGND sg13cmos5l_mux4_1
XANTENNA__1067__GATE Tile_X0Y5_FrameStrobe[1] VPWR VGND sg13cmos5l_antennanp
X_1336_ _1336_/Q Tile_X0Y5_FrameData[24] VGND VPWR Tile_X0Y5_FrameStrobe[2] latch
XANTENNA__0894__D Tile_X0Y3_FrameData[24] VPWR VGND sg13cmos5l_antennanp
XFILLER_232_43 VPWR VGND sg13cmos5l_decap_4
XANTENNA__1920__X Tile_X0Y1_EE4BEG[1] VPWR VGND sg13cmos5l_antennanp
XFILLER_232_54 VPWR VGND sg13cmos5l_decap_8
XFILLER_283_163 VPWR VGND sg13cmos5l_decap_4
XFILLER_283_174 VPWR VGND sg13cmos5l_decap_8
XFILLER_283_185 VPWR VGND sg13cmos5l_fill_1
X_1267_ _1267_/Q Tile_X0Y5_FrameData[29] VGND VPWR Tile_X0Y5_FrameStrobe[0] latch
XANTENNA__2275__A2 Tile_X0Y2_WW4END[6] VPWR VGND sg13cmos5l_antennanp
XFILLER_283_196 VPWR VGND sg13cmos5l_fill_2
X_1198_ _1198_/Q Tile_X0Y4_FrameData[24] VGND VPWR Tile_X0Y5_FrameStrobe[5] latch
X_0218_ _0218_/Q Tile_X0Y0_FrameData[12] VGND VPWR Tile_X0Y5_FrameStrobe[4] latch
X_0149_ _0149_/Q Tile_X0Y0_FrameData[17] VGND VPWR Tile_X0Y5_FrameStrobe[2] latch
XFILLER_101_36 VPWR VGND sg13cmos5l_decap_8
XFILLER_101_47 VPWR VGND sg13cmos5l_fill_2
XFILLER_51_132 VPWR VGND sg13cmos5l_decap_4
XANTENNA__1005__GATE Tile_X0Y5_FrameStrobe[6] VPWR VGND sg13cmos5l_antennanp
XFILLER_196_159 VPWR VGND sg13cmos5l_decap_8
XFILLER_51_165 VPWR VGND sg13cmos5l_fill_2
XANTENNA__2578__A3 Tile_X0Y0_S4END[13] VPWR VGND sg13cmos5l_antennanp
XANTENNA__0261__GATE Tile_X0Y5_FrameStrobe[5] VPWR VGND sg13cmos5l_antennanp
XFILLER_229_9 VPWR VGND sg13cmos5l_fill_2
XANTENNA__0134__D Tile_X0Y0_FrameData[0] VPWR VGND sg13cmos5l_antennanp
XANTENNA__0891__GATE Tile_X0Y5_FrameStrobe[3] VPWR VGND sg13cmos5l_antennanp
XANTENNA__2735__A0 AXIL_S_SOC_ARPROT0 VPWR VGND sg13cmos5l_antennanp
XFILLER_353_167 VPWR VGND sg13cmos5l_decap_8
XFILLER_10_22 VPWR VGND sg13cmos5l_fill_1
XFILLER_126_22 VPWR VGND sg13cmos5l_decap_8
XANTENNA__0276__GATE Tile_X0Y5_FrameStrobe[6] VPWR VGND sg13cmos5l_antennanp
XFILLER_273_83 VPWR VGND sg13cmos5l_decap_8
XFILLER_19_31 VPWR VGND sg13cmos5l_fill_2
XFILLER_259_193 VPWR VGND sg13cmos5l_decap_4
XFILLER_142_21 VPWR VGND sg13cmos5l_decap_8
XANTENNA__1830__X Tile_X0Y4_EE4BEG[13] VPWR VGND sg13cmos5l_antennanp
XFILLER_274_163 VPWR VGND sg13cmos5l_decap_4
XFILLER_274_174 VPWR VGND sg13cmos5l_decap_8
XANTENNA__0214__GATE Tile_X0Y5_FrameStrobe[4] VPWR VGND sg13cmos5l_antennanp
XANTENNA__0309__D Tile_X0Y0_FrameData[17] VPWR VGND sg13cmos5l_antennanp
XANTENNA__0844__GATE Tile_X0Y5_FrameStrobe[1] VPWR VGND sg13cmos5l_antennanp
XFILLER_143_0 VPWR VGND sg13cmos5l_decap_4
XFILLER_35_96 VPWR VGND sg13cmos5l_decap_8
XANTENNA__0229__GATE Tile_X0Y5_FrameStrobe[4] VPWR VGND sg13cmos5l_antennanp
XFILLER_310_0 VPWR VGND sg13cmos5l_fill_1
XANTENNA__0859__GATE Tile_X0Y5_FrameStrobe[2] VPWR VGND sg13cmos5l_antennanp
XFILLER_167_73 VPWR VGND sg13cmos5l_decap_8
XANTENNA__0979__D Tile_X0Y3_FrameData[3] VPWR VGND sg13cmos5l_antennanp
XANTENNA__2726__A0 AXIL_S_SOC_ARPROT1 VPWR VGND sg13cmos5l_antennanp
XFILLER_317_54 VPWR VGND sg13cmos5l_decap_4
XFILLER_297_222 VPWR VGND sg13cmos5l_fill_2
XFILLER_111_126 VPWR VGND sg13cmos5l_decap_8
XFILLER_111_137 VPWR VGND sg13cmos5l_fill_2
XFILLER_333_20 VPWR VGND sg13cmos5l_decap_8
XFILLER_265_141 VPWR VGND sg13cmos5l_fill_2
X_2170_ _2170_/X AXIL_S_SOC_WDATA21 AXIL_S_SOC_WDATA29 _2243_/X _2246_/X _0256_/Q
+ _0255_/Q VPWR VGND sg13cmos5l_mux4_1
XANTENNA__1740__X Tile_X0Y2_FrameData_O[0] VPWR VGND sg13cmos5l_antennanp
X_1121_ _1121_/Q Tile_X0Y4_FrameData[5] VGND VPWR Tile_X0Y5_FrameStrobe[2] latch
XFILLER_76_81 VPWR VGND sg13cmos5l_decap_4
XANTENNA__2257__A2 Tile_X0Y2_W6END[3] VPWR VGND sg13cmos5l_antennanp
XFILLER_18_140 VPWR VGND sg13cmos5l_fill_2
XFILLER_202_13 VPWR VGND sg13cmos5l_fill_1
X_1052_ _1052_/Q Tile_X0Y4_FrameData[10] VGND VPWR Tile_X0Y5_FrameStrobe[0] latch
XANTENNA__0219__D Tile_X0Y0_FrameData[11] VPWR VGND sg13cmos5l_antennanp
XFILLER_202_57 VPWR VGND sg13cmos5l_decap_8
XFILLER_280_155 VPWR VGND sg13cmos5l_decap_8
XFILLER_33_110 VPWR VGND sg13cmos5l_decap_4
XFILLER_33_154 VPWR VGND sg13cmos5l_decap_8
XFILLER_178_126 VPWR VGND sg13cmos5l_decap_8
XFILLER_33_187 VPWR VGND sg13cmos5l_decap_8
X_1954_ Tile_X0Y1_E2BEGb[7] _2308_/X VPWR VGND sg13cmos5l_buf_1
XFILLER_119_204 VPWR VGND sg13cmos5l_decap_8
X_0905_ _0905_/Q Tile_X0Y3_FrameData[13] VGND VPWR Tile_X0Y5_FrameStrobe[3] latch
X_1885_ Tile_X0Y2_E6BEG[11] _2444_/X VPWR VGND sg13cmos5l_buf_1
XFILLER_335_145 VPWR VGND sg13cmos5l_fill_2
XANTENNA__0889__D Tile_X0Y3_FrameData[29] VPWR VGND sg13cmos5l_antennanp
XANTENNA__2717__A0 Tile_X0Y3_W1END[0] VPWR VGND sg13cmos5l_antennanp
X_0836_ _0836_/Q Tile_X0Y3_FrameData[18] VGND VPWR Tile_X0Y5_FrameStrobe[1] latch
XANTENNA__1915__X Tile_X0Y1_FrameData_O[28] VPWR VGND sg13cmos5l_antennanp
XANTENNA__2193__A1 AXIL_S_SOC_WDATA28 VPWR VGND sg13cmos5l_antennanp
X_0767_ _0767_/Q Tile_X0Y2_FrameData[7] VGND VPWR Tile_X0Y5_FrameStrobe[6] latch
XFILLER_350_137 VPWR VGND sg13cmos5l_decap_8
X_2506_ _2506_/X _2568_/X _2567_/X AXIL_S_SOC_ARADDR3 AXIL_S_SOC_ARADDR6 _0992_/Q
+ _0991_/Q VPWR VGND sg13cmos5l_mux4_1
XFILLER_248_108 VPWR VGND sg13cmos5l_fill_1
X_2437_ _2437_/X AXIL_S_SOC_AWADDR4 _2473_/X _2466_/X _2481_/X _0674_/Q _0673_/Q VPWR
+ VGND sg13cmos5l_mux4_1
X_0698_ _0698_/Q Tile_X0Y2_FrameData[12] VGND VPWR Tile_X0Y5_FrameStrobe[4] latch
XFILLER_243_20 VPWR VGND sg13cmos5l_decap_8
XANTENNA__2496__A2 Tile_X0Y4_W6END[4] VPWR VGND sg13cmos5l_antennanp
XFILLER_243_75 VPWR VGND sg13cmos5l_decap_4
XFILLER_256_130 VPWR VGND sg13cmos5l_fill_2
X_2368_ _2368_/X _2346_/X _0030_/X _2345_/X Tile_X0Y0_S4END[6] _0362_/Q _0361_/Q VPWR
+ VGND sg13cmos5l_mux4_1
XANTENNA__1650__X Tile_X0Y0_FrameStrobe_O[10] VPWR VGND sg13cmos5l_antennanp
X_1319_ _1319_/Q Tile_X0Y5_FrameData[9] VGND VPWR Tile_X0Y5_FrameStrobe[1] latch
X_2299_ _2299_/X AXIL_S_SOC_WDATA6 AXIL_S_SOC_WDATA14 _2374_/X _2379_/X _0494_/Q _0493_/Q
+ VPWR VGND sg13cmos5l_mux4_1
XANTENNA__2248__A2 Tile_X0Y0_S2MID[7] VPWR VGND sg13cmos5l_antennanp
XANTENNA__0129__D Tile_X0Y0_FrameData[5] VPWR VGND sg13cmos5l_antennanp
XFILLER_24_110 VPWR VGND sg13cmos5l_fill_2
XFILLER_212_200 VPWR VGND sg13cmos5l_decap_8
XFILLER_21_21 VPWR VGND sg13cmos5l_fill_1
XANTENNA__0799__D Tile_X0Y3_FrameData[23] VPWR VGND sg13cmos5l_antennanp
XFILLER_137_21 VPWR VGND sg13cmos5l_decap_8
XFILLER_21_54 VPWR VGND sg13cmos5l_fill_2
XANTENNA__1825__X Tile_X0Y4_EE4BEG[8] VPWR VGND sg13cmos5l_antennanp
XFILLER_137_32 VPWR VGND sg13cmos5l_fill_2
XFILLER_341_115 VPWR VGND sg13cmos5l_decap_4
XANTENNA__2184__A1 AXIL_S_SOC_WDATA31 VPWR VGND sg13cmos5l_antennanp
XANTENNA__2723__A3 AXIL_S_SOC_ARPROT0 VPWR VGND sg13cmos5l_antennanp
XFILLER_284_71 VPWR VGND sg13cmos5l_fill_2
XFILLER_153_42 VPWR VGND sg13cmos5l_decap_8
XANTENNA__1423__D Tile_X0Y5_FrameData[1] VPWR VGND sg13cmos5l_antennanp
XANTENNA__1560__X Tile_X0Y3_FrameData_O[6] VPWR VGND sg13cmos5l_antennanp
XFILLER_153_97 VPWR VGND sg13cmos5l_decap_8
XFILLER_303_23 VPWR VGND sg13cmos5l_decap_8
XFILLER_303_67 VPWR VGND sg13cmos5l_decap_4
XANTENNA__0153__GATE Tile_X0Y5_FrameStrobe[2] VPWR VGND sg13cmos5l_antennanp
XANTENNA__2239__A2 Tile_X0Y0_S1END[0] VPWR VGND sg13cmos5l_antennanp
XFILLER_260_0 VPWR VGND sg13cmos5l_fill_2
XANTENNA__0783__GATE Tile_X0Y5_FrameStrobe[7] VPWR VGND sg13cmos5l_antennanp
XANTENNA__0168__GATE Tile_X0Y5_FrameStrobe[3] VPWR VGND sg13cmos5l_antennanp
XFILLER_62_72 VPWR VGND sg13cmos5l_fill_1
XANTENNA__0798__GATE Tile_X0Y5_FrameStrobe[0] VPWR VGND sg13cmos5l_antennanp
XFILLER_30_157 VPWR VGND sg13cmos5l_decap_8
XFILLER_317_134 VPWR VGND sg13cmos5l_decap_8
XFILLER_317_112 VPWR VGND sg13cmos5l_decap_8
X_1670_ Tile_X0Y0_FrameData_O[10] Tile_X0Y0_FrameData[10] VPWR VGND sg13cmos5l_buf_1
XFILLER_328_53 VPWR VGND sg13cmos5l_decap_8
XFILLER_317_156 VPWR VGND sg13cmos5l_fill_1
XANTENNA__0721__GATE Tile_X0Y5_FrameStrobe[5] VPWR VGND sg13cmos5l_antennanp
X_0621_ _0621_/Q Tile_X0Y2_FrameData[25] VGND VPWR Tile_X0Y5_FrameStrobe[2] latch
XANTENNA__0502__D Tile_X0Y1_FrameData[0] VPWR VGND sg13cmos5l_antennanp
XANTENNA__1735__X Tile_X0Y0_E2BEG[7] VPWR VGND sg13cmos5l_antennanp
XANTENNA__2175__A1 AXIL_S_SOC_WDATA26 VPWR VGND sg13cmos5l_antennanp
X_0552_ _0552_/Q Tile_X0Y2_FrameData[30] VGND VPWR Tile_X0Y5_FrameStrobe[0] latch
XANTENNA__0106__GATE Tile_X0Y5_FrameStrobe[1] VPWR VGND sg13cmos5l_antennanp
X_0483_ _0483_/Q Tile_X0Y1_FrameData[19] VGND VPWR Tile_X0Y5_FrameStrobe[5] latch
XANTENNA__0736__GATE Tile_X0Y5_FrameStrobe[5] VPWR VGND sg13cmos5l_antennanp
X_2222_ _2222_/X _2215_/X _0064_/X Tile_X0Y0_S1END[2] Tile_X0Y0_S4END[2] _0106_/Q
+ _0105_/Q VPWR VGND sg13cmos5l_mux4_1
XFILLER_87_80 VPWR VGND sg13cmos5l_decap_8
XANTENNA__1333__D Tile_X0Y5_FrameData[27] VPWR VGND sg13cmos5l_antennanp
X_2153_ _2153_/X Tile_X0Y0_W1END[0] Tile_X0Y0_WW4END[0] Tile_X0Y0_WW4END[4] Tile_X0Y0_W6END[8]
+ _0286_/Q _0285_/Q VPWR VGND sg13cmos5l_mux4_1
XFILLER_360_40 VPWR VGND sg13cmos5l_fill_2
XANTENNA__1911__A Tile_X0Y1_FrameData[24] VPWR VGND sg13cmos5l_antennanp
X_1104_ _1104_/Q Tile_X0Y4_FrameData[22] VGND VPWR Tile_X0Y5_FrameStrobe[2] latch
XFILLER_360_73 VPWR VGND sg13cmos5l_fill_1
XFILLER_213_89 VPWR VGND sg13cmos5l_decap_8
X_2084_ Tile_X0Y3_E1BEG[0] _2505_/X VPWR VGND sg13cmos5l_buf_1
XFILLER_360_95 VPWR VGND sg13cmos5l_decap_8
X_1035_ _1035_/Q Tile_X0Y4_FrameData[27] VGND VPWR Tile_X0Y5_FrameStrobe[0] latch
XFILLER_21_113 VPWR VGND sg13cmos5l_fill_1
XFILLER_21_135 VPWR VGND sg13cmos5l_decap_8
XFILLER_308_101 VPWR VGND sg13cmos5l_fill_1
X_1937_ Tile_X0Y1_E6BEG[2] _2327_/X VPWR VGND sg13cmos5l_buf_1
X_1868_ Tile_X0Y2_E2BEGb[2] _2411_/X VPWR VGND sg13cmos5l_buf_1
XFILLER_238_97 VPWR VGND sg13cmos5l_fill_1
X_0819_ _0819_/Q Tile_X0Y3_FrameData[3] VGND VPWR Tile_X0Y5_FrameStrobe[0] latch
XANTENNA__0412__D Tile_X0Y1_FrameData[26] VPWR VGND sg13cmos5l_antennanp
XANTENNA__1645__X Tile_X0Y0_FrameStrobe_O[5] VPWR VGND sg13cmos5l_antennanp
XANTENNA__2166__A1 AXIL_S_SOC_WDATA25 VPWR VGND sg13cmos5l_antennanp
XFILLER_107_13 VPWR VGND sg13cmos5l_fill_1
X_1799_ Tile_X0Y4_E2BEGb[2] _2627_/X VPWR VGND sg13cmos5l_buf_1
XFILLER_323_148 VPWR VGND sg13cmos5l_decap_8
XFILLER_107_46 VPWR VGND sg13cmos5l_decap_8
XFILLER_130_221 VPWR VGND sg13cmos5l_fill_2
XFILLER_67_17 VPWR VGND sg13cmos5l_decap_8
XANTENNA__1243__D Tile_X0Y4_FrameData[11] VPWR VGND sg13cmos5l_antennanp
XFILLER_229_152 VPWR VGND sg13cmos5l_decap_8
XFILLER_96_190 VPWR VGND sg13cmos5l_decap_8
XFILLER_270_62 VPWR VGND sg13cmos5l_decap_8
XFILLER_83_27 VPWR VGND sg13cmos5l_fill_2
XFILLER_16_32 VPWR VGND sg13cmos5l_fill_2
XFILLER_344_6 VPWR VGND sg13cmos5l_decap_8
XFILLER_12_135 VPWR VGND sg13cmos5l_fill_2
XFILLER_120_2 VPWR VGND sg13cmos5l_fill_1
XFILLER_148_64 VPWR VGND sg13cmos5l_decap_8
XANTENNA__1418__D Tile_X0Y5_FrameData[6] VPWR VGND sg13cmos5l_antennanp
XFILLER_180_110 VPWR VGND sg13cmos5l_decap_8
XFILLER_180_132 VPWR VGND sg13cmos5l_fill_2
XANTENNA__0322__D Tile_X0Y1_FrameData[20] VPWR VGND sg13cmos5l_antennanp
XANTENNA__1451__GATE Tile_X0Y5_FrameStrobe[5] VPWR VGND sg13cmos5l_antennanp
XANTENNA__1555__X Tile_X0Y3_FrameData_O[1] VPWR VGND sg13cmos5l_antennanp
XANTENNA__2157__A1 Tile_X0Y0_WW4END[2] VPWR VGND sg13cmos5l_antennanp
XFILLER_180_143 VPWR VGND sg13cmos5l_fill_1
XFILLER_79_113 VPWR VGND sg13cmos5l_decap_8
XFILLER_164_74 VPWR VGND sg13cmos5l_decap_8
XFILLER_164_85 VPWR VGND sg13cmos5l_fill_1
XFILLER_267_214 VPWR VGND sg13cmos5l_fill_1
XFILLER_322_170 VPWR VGND sg13cmos5l_decap_8
XFILLER_314_33 VPWR VGND sg13cmos5l_decap_4
XANTENNA__1153__D Tile_X0Y4_FrameData[5] VPWR VGND sg13cmos5l_antennanp
XANTENNA__1466__GATE Tile_X0Y5_FrameStrobe[6] VPWR VGND sg13cmos5l_antennanp
XFILLER_314_77 VPWR VGND sg13cmos5l_decap_8
XANTENNA__0092__GATE Tile_X0Y5_FrameStrobe[0] VPWR VGND sg13cmos5l_antennanp
XFILLER_235_122 VPWR VGND sg13cmos5l_fill_2
XANTENNA__0992__D Tile_X0Y3_FrameData[22] VPWR VGND sg13cmos5l_antennanp
XFILLER_180_84 VPWR VGND sg13cmos5l_fill_1
XFILLER_180_95 VPWR VGND sg13cmos5l_decap_8
XFILLER_235_188 VPWR VGND sg13cmos5l_decap_8
XFILLER_92_6 VPWR VGND sg13cmos5l_decap_8
XANTENNA__1404__GATE Tile_X0Y5_FrameStrobe[4] VPWR VGND sg13cmos5l_antennanp
XFILLER_148_129 VPWR VGND sg13cmos5l_decap_8
XANTENNA__2396__A1 Tile_X0Y3_W2END[0] VPWR VGND sg13cmos5l_antennanp
X_2771_ _2771_/X Tile_X0Y5_W1END[2] Tile_X0Y5_W6END[10] _2805_/X _2791_/X _1360_/Q
+ _1359_/Q VPWR VGND sg13cmos5l_mux4_1
XFILLER_339_74 VPWR VGND sg13cmos5l_decap_8
XANTENNA__0660__GATE Tile_X0Y5_FrameStrobe[3] VPWR VGND sg13cmos5l_antennanp
XFILLER_156_162 VPWR VGND sg13cmos5l_fill_2
X_1722_ Tile_X0Y0_E2BEGb[2] _2175_/X VPWR VGND sg13cmos5l_buf_1
XFILLER_339_96 VPWR VGND sg13cmos5l_fill_1
XANTENNA__1328__D Tile_X0Y5_FrameData[0] VPWR VGND sg13cmos5l_antennanp
X_1653_ Tile_X0Y0_FrameStrobe_O[13] Tile_X0Y5_FrameStrobe[13] VPWR VGND sg13cmos5l_buf_1
XANTENNA__0232__D Tile_X0Y0_FrameData[30] VPWR VGND sg13cmos5l_antennanp
XANTENNA__1419__GATE Tile_X0Y5_FrameStrobe[4] VPWR VGND sg13cmos5l_antennanp
XANTENNA__1906__A Tile_X0Y1_FrameData[19] VPWR VGND sg13cmos5l_antennanp
XANTENNA__2148__A1 Tile_X0Y0_W2END[4] VPWR VGND sg13cmos5l_antennanp
X_0604_ _0604_/Q Tile_X0Y2_FrameData[10] VGND VPWR Tile_X0Y5_FrameStrobe[1] latch
XFILLER_355_40 VPWR VGND sg13cmos5l_decap_8
XFILLER_112_210 VPWR VGND sg13cmos5l_fill_1
X_1584_ Tile_X0Y3_FrameData_O[30] Tile_X0Y3_FrameData[30] VPWR VGND sg13cmos5l_buf_1
XANTENNA__0675__GATE Tile_X0Y5_FrameStrobe[3] VPWR VGND sg13cmos5l_antennanp
XFILLER_291_28 VPWR VGND sg13cmos5l_decap_8
X_0535_ _0535_/Q Tile_X0Y1_FrameData[31] VGND VPWR Tile_X0Y5_FrameStrobe[7] latch
XFILLER_21_0 VPWR VGND sg13cmos5l_fill_2
X_0466_ _0466_/Q Tile_X0Y1_FrameData[4] VGND VPWR Tile_X0Y5_FrameStrobe[4] latch
XANTENNA__1063__D Tile_X0Y4_FrameData[31] VPWR VGND sg13cmos5l_antennanp
XFILLER_273_206 VPWR VGND sg13cmos5l_decap_8
XFILLER_273_217 VPWR VGND sg13cmos5l_fill_1
X_2205_ _2205_/X AXIL_S_SOC_WDATA16 _2235_/X _2233_/X _2245_/X _0186_/Q _0185_/Q VPWR
+ VGND sg13cmos5l_mux4_1
XANTENNA__1641__A Tile_X0Y5_FrameStrobe[1] VPWR VGND sg13cmos5l_antennanp
XANTENNA__2320__A1 AXIL_S_SOC_WDATA11 VPWR VGND sg13cmos5l_antennanp
XFILLER_226_100 VPWR VGND sg13cmos5l_fill_1
XFILLER_226_122 VPWR VGND sg13cmos5l_decap_8
X_0397_ _0397_/Q Tile_X0Y1_FrameData[9] VGND VPWR Tile_X0Y5_FrameStrobe[2] latch
X_2136_ AXIL_S_SOC_RDATA30 Tile_X0Y0_W2MID[6] Tile_X0Y0_W2END[6] Tile_X0Y0_W6END[6]
+ _2247_/X _0130_/Q _0129_/Q VPWR VGND sg13cmos5l_mux4_1
X_2067_ Tile_X0Y5_S4BEG[0] _2067_/A VPWR VGND sg13cmos5l_buf_1
XANTENNA__0613__GATE Tile_X0Y5_FrameStrobe[1] VPWR VGND sg13cmos5l_antennanp
XFILLER_241_147 VPWR VGND sg13cmos5l_decap_8
XFILLER_241_158 VPWR VGND sg13cmos5l_fill_2
X_1018_ _1018_/Q Tile_X0Y3_FrameData[28] VGND VPWR Tile_X0Y5_FrameStrobe[7] latch
XANTENNA__0407__D Tile_X0Y1_FrameData[31] VPWR VGND sg13cmos5l_antennanp
XFILLER_139_107 VPWR VGND sg13cmos5l_decap_8
XANTENNA__0628__GATE Tile_X0Y5_FrameStrobe[2] VPWR VGND sg13cmos5l_antennanp
XANTENNA__2387__A1 Tile_X0Y0_W2END[4] VPWR VGND sg13cmos5l_antennanp
XFILLER_118_12 VPWR VGND sg13cmos5l_decap_4
XFILLER_309_9 VPWR VGND sg13cmos5l_fill_2
XANTENNA__0142__D Tile_X0Y0_FrameData[24] VPWR VGND sg13cmos5l_antennanp
XANTENNA__1238__D Tile_X0Y4_FrameData[16] VPWR VGND sg13cmos5l_antennanp
XANTENNA__2139__A1 Tile_X0Y5_W2END[2] VPWR VGND sg13cmos5l_antennanp
XFILLER_162_165 VPWR VGND sg13cmos5l_fill_1
XFILLER_162_187 VPWR VGND sg13cmos5l_decap_8
XANTENNA__2311__A1 AXIL_S_SOC_WDATA14 VPWR VGND sg13cmos5l_antennanp
XFILLER_217_111 VPWR VGND sg13cmos5l_decap_8
XFILLER_17_216 VPWR VGND sg13cmos5l_fill_2
XFILLER_150_32 VPWR VGND sg13cmos5l_decap_8
XFILLER_232_103 VPWR VGND sg13cmos5l_decap_8
XFILLER_232_158 VPWR VGND sg13cmos5l_decap_4
XANTENNA__0317__D Tile_X0Y1_FrameData[25] VPWR VGND sg13cmos5l_antennanp
XANTENNA__2614__A2 AXIL_S_SOC_WSTRB0 VPWR VGND sg13cmos5l_antennanp
XFILLER_43_74 VPWR VGND sg13cmos5l_decap_8
XFILLER_300_68 VPWR VGND sg13cmos5l_decap_4
XFILLER_138_162 VPWR VGND sg13cmos5l_decap_8
XANTENNA__1390__GATE Tile_X0Y5_FrameStrobe[3] VPWR VGND sg13cmos5l_antennanp
XFILLER_309_44 VPWR VGND sg13cmos5l_decap_8
XANTENNA__1148__D Tile_X0Y4_FrameData[10] VPWR VGND sg13cmos5l_antennanp
XFILLER_153_132 VPWR VGND sg13cmos5l_decap_8
XFILLER_99_208 VPWR VGND sg13cmos5l_decap_4
XFILLER_299_136 VPWR VGND sg13cmos5l_fill_2
XFILLER_175_95 VPWR VGND sg13cmos5l_decap_8
XFILLER_325_10 VPWR VGND sg13cmos5l_decap_4
XFILLER_302_107 VPWR VGND sg13cmos5l_decap_8
XFILLER_299_169 VPWR VGND sg13cmos5l_decap_8
XANTENNA__0987__D Tile_X0Y3_FrameData[27] VPWR VGND sg13cmos5l_antennanp
XFILLER_325_32 VPWR VGND sg13cmos5l_decap_4
X_0320_ _0320_/Q Tile_X0Y1_FrameData[22] VGND VPWR Tile_X0Y5_FrameStrobe[0] latch
XFILLER_68_82 VPWR VGND sg13cmos5l_fill_2
XFILLER_67_149 VPWR VGND sg13cmos5l_decap_4
XANTENNA__2302__A1 AXIL_S_SOC_WDATA9 VPWR VGND sg13cmos5l_antennanp
X_0251_ _0251_/Q Tile_X0Y0_FrameData[11] VGND VPWR Tile_X0Y5_FrameStrobe[5] latch
X_0182_ _0182_/Q Tile_X0Y0_FrameData[16] VGND VPWR Tile_X0Y5_FrameStrobe[3] latch
XFILLER_82_119 VPWR VGND sg13cmos5l_fill_1
XFILLER_341_75 VPWR VGND sg13cmos5l_decap_4
XFILLER_90_130 VPWR VGND sg13cmos5l_decap_8
XANTENNA__0227__D Tile_X0Y0_FrameData[3] VPWR VGND sg13cmos5l_antennanp
XANTENNA__1343__GATE Tile_X0Y5_FrameStrobe[2] VPWR VGND sg13cmos5l_antennanp
XANTENNA__2605__A2 Tile_X0Y2_W2END[3] VPWR VGND sg13cmos5l_antennanp
XFILLER_176_202 VPWR VGND sg13cmos5l_fill_1
X_2823_ _2823_/X Tile_X0Y5_N1END[0] Tile_X0Y5_N4END[0] _2793_/X _0032_/X _1312_/Q
+ _1311_/Q VPWR VGND sg13cmos5l_mux4_1
X_2754_ _2754_/X AXIL_S_SOC_ARPROT1 AXIL_S_SOC_ARVALID _2820_/X _2827_/X _1394_/Q
+ _1393_/Q VPWR VGND sg13cmos5l_mux4_1
XANTENNA__1358__GATE Tile_X0Y5_FrameStrobe[2] VPWR VGND sg13cmos5l_antennanp
X_1705_ Tile_X0Y0_EE4BEG[13] _2194_/X VPWR VGND sg13cmos5l_buf_1
XANTENNA__1058__D Tile_X0Y4_FrameData[4] VPWR VGND sg13cmos5l_antennanp
XFILLER_144_143 VPWR VGND sg13cmos5l_decap_8
X_2685_ _2685_/X _2680_/X Tile_X0Y5_N4END[7] _2679_/X _0025_/X _1064_/Q _1063_/Q VPWR
+ VGND sg13cmos5l_mux4_1
XFILLER_235_21 VPWR VGND sg13cmos5l_decap_8
X_1636_ Tile_X0Y0_N1BEG[0] _2141_/X VPWR VGND sg13cmos5l_buf_1
XANTENNA__0897__D Tile_X0Y3_FrameData[21] VPWR VGND sg13cmos5l_antennanp
XFILLER_144_198 VPWR VGND sg13cmos5l_decap_8
X_1567_ Tile_X0Y3_FrameData_O[13] Tile_X0Y3_FrameData[13] VPWR VGND sg13cmos5l_buf_1
XANTENNA__1923__X Tile_X0Y1_EE4BEG[4] VPWR VGND sg13cmos5l_antennanp
XANTENNA__2541__A1 Tile_X0Y0_S4END[12] VPWR VGND sg13cmos5l_antennanp
X_0518_ _0518_/Q Tile_X0Y1_FrameData[16] VGND VPWR Tile_X0Y5_FrameStrobe[6] latch
XFILLER_235_98 VPWR VGND sg13cmos5l_decap_8
X_1498_ _2564_/A3 VPWR VGND sg13cmos5l_tielo
XFILLER_301_173 VPWR VGND sg13cmos5l_fill_1
X_0449_ _0449_/Q Tile_X0Y1_FrameData[21] VGND VPWR Tile_X0Y5_FrameStrobe[4] latch
XFILLER_251_64 VPWR VGND sg13cmos5l_fill_2
XFILLER_214_114 VPWR VGND sg13cmos5l_decap_8
XFILLER_251_97 VPWR VGND sg13cmos5l_fill_1
X_2119_ AXIL_S_SOC_RDATA13 Tile_X0Y2_W2MID[5] Tile_X0Y2_W2END[5] Tile_X0Y2_W6END[5]
+ _2486_/X _0612_/Q _0611_/Q VPWR VGND sg13cmos5l_mux4_1
XANTENNA__0552__GATE Tile_X0Y5_FrameStrobe[0] VPWR VGND sg13cmos5l_antennanp
XFILLER_81_163 VPWR VGND sg13cmos5l_decap_8
XANTENNA__0137__D Tile_X0Y0_FrameData[29] VPWR VGND sg13cmos5l_antennanp
XFILLER_120_24 VPWR VGND sg13cmos5l_decap_4
XFILLER_120_68 VPWR VGND sg13cmos5l_fill_1
XFILLER_147_7 VPWR VGND sg13cmos5l_decap_8
XFILLER_167_202 VPWR VGND sg13cmos5l_decap_8
XFILLER_222_180 VPWR VGND sg13cmos5l_decap_8
XANTENNA__0567__GATE Tile_X0Y5_FrameStrobe[0] VPWR VGND sg13cmos5l_antennanp
XFILLER_13_11 VPWR VGND sg13cmos5l_fill_2
XFILLER_196_17 VPWR VGND sg13cmos5l_decap_4
XFILLER_13_66 VPWR VGND sg13cmos5l_fill_1
XFILLER_13_77 VPWR VGND sg13cmos5l_decap_8
XFILLER_89_37 VPWR VGND sg13cmos5l_decap_8
XANTENNA__2780__A1 Tile_X0Y5_W2MID[0] VPWR VGND sg13cmos5l_antennanp
XFILLER_150_124 VPWR VGND sg13cmos5l_fill_2
XFILLER_1_101 VPWR VGND sg13cmos5l_fill_1
XFILLER_296_128 VPWR VGND sg13cmos5l_decap_8
XANTENNA__0600__D Tile_X0Y2_FrameData[14] VPWR VGND sg13cmos5l_antennanp
XANTENNA__1833__X Tile_X0Y4_FrameData_O[0] VPWR VGND sg13cmos5l_antennanp
XANTENNA__2532__A1 AXIL_S_SOC_ARADDR7 VPWR VGND sg13cmos5l_antennanp
XFILLER_150_168 VPWR VGND sg13cmos5l_decap_8
XFILLER_292_82 VPWR VGND sg13cmos5l_fill_1
XANTENNA__0505__GATE Tile_X0Y5_FrameStrobe[6] VPWR VGND sg13cmos5l_antennanp
XFILLER_237_206 VPWR VGND sg13cmos5l_fill_2
XFILLER_38_30 VPWR VGND sg13cmos5l_fill_2
XANTENNA__2296__A0 AXIL_S_SOC_WDATA3 VPWR VGND sg13cmos5l_antennanp
XFILLER_161_42 VPWR VGND sg13cmos5l_decap_8
XANTENNA__1431__D Tile_X0Y5_FrameData[25] VPWR VGND sg13cmos5l_antennanp
XANTENNA__2835__A2 Tile_X0Y4_W2END[1] VPWR VGND sg13cmos5l_antennanp
XFILLER_173_0 VPWR VGND sg13cmos5l_fill_1
XFILLER_311_34 VPWR VGND sg13cmos5l_fill_1
XANTENNA__2599__A1 Tile_X0Y2_W2END[6] VPWR VGND sg13cmos5l_antennanp
XFILLER_54_62 VPWR VGND sg13cmos5l_fill_1
XFILLER_340_0 VPWR VGND sg13cmos5l_decap_8
XFILLER_311_78 VPWR VGND sg13cmos5l_decap_4
XFILLER_220_139 VPWR VGND sg13cmos5l_decap_8
XFILLER_359_162 VPWR VGND sg13cmos5l_decap_8
XFILLER_9_223 VPWR VGND sg13cmos5l_fill_1
XANTENNA__2771__A1 Tile_X0Y5_W6END[10] VPWR VGND sg13cmos5l_antennanp
X_2470_ _2470_/X _2460_/X Tile_X0Y5_N4END[13] _2459_/X Tile_X0Y0_S4END[9] _0588_/Q
+ _0587_/Q VPWR VGND sg13cmos5l_mux4_1
X_1421_ _1421_/Q Tile_X0Y5_FrameData[3] VGND VPWR Tile_X0Y5_FrameStrobe[4] latch
XANTENNA__0510__D Tile_X0Y1_FrameData[24] VPWR VGND sg13cmos5l_antennanp
XANTENNA__1743__X Tile_X0Y2_FrameData_O[3] VPWR VGND sg13cmos5l_antennanp
XANTENNA__2523__A1 AXIL_S_SOC_ARADDR6 VPWR VGND sg13cmos5l_antennanp
XFILLER_205_35 VPWR VGND sg13cmos5l_decap_8
X_1352_ _1352_/Q Tile_X0Y5_FrameData[8] VGND VPWR Tile_X0Y5_FrameStrobe[2] latch
X_1283_ _1283_/Q Tile_X0Y5_FrameData[13] VGND VPWR Tile_X0Y5_FrameStrobe[0] latch
X_0303_ _0303_/Q Tile_X0Y0_FrameData[23] VGND VPWR Tile_X0Y5_FrameStrobe[7] latch
XANTENNA__2287__A0 Tile_X0Y3_W1END[0] VPWR VGND sg13cmos5l_antennanp
X_0234_ _0234_/Q Tile_X0Y0_FrameData[28] VGND VPWR Tile_X0Y5_FrameStrobe[5] latch
XFILLER_95_80 VPWR VGND sg13cmos5l_decap_8
XFILLER_48_171 VPWR VGND sg13cmos5l_decap_4
XANTENNA__1341__D Tile_X0Y5_FrameData[19] VPWR VGND sg13cmos5l_antennanp
X_0165_ _0165_/Q Tile_X0Y0_FrameData[1] VGND VPWR Tile_X0Y5_FrameStrobe[2] latch
XANTENNA__1282__GATE Tile_X0Y5_FrameStrobe[0] VPWR VGND sg13cmos5l_antennanp
X_0096_ _0096_/Q Tile_X0Y0_FrameData[6] VGND VPWR Tile_X0Y5_FrameStrobe[0] latch
XFILLER_297_27 VPWR VGND sg13cmos5l_decap_8
XANTENNA__1297__GATE Tile_X0Y5_FrameStrobe[1] VPWR VGND sg13cmos5l_antennanp
XANTENNA__1918__X Tile_X0Y1_FrameData_O[31] VPWR VGND sg13cmos5l_antennanp
XFILLER_117_110 VPWR VGND sg13cmos5l_decap_8
X_2806_ _2806_/X Tile_X0Y5_N1END[2] Tile_X0Y5_N4END[2] _2795_/X _0058_/X _1300_/Q
+ _1299_/Q VPWR VGND sg13cmos5l_mux4_1
X_0998_ _0998_/Q Tile_X0Y3_FrameData[16] VGND VPWR Tile_X0Y5_FrameStrobe[6] latch
XFILLER_117_121 VPWR VGND sg13cmos5l_fill_2
X_2737_ _2737_/X AXIL_S_SOC_ARPROT2 AXIL_S_SOC_RREADY _2828_/X _2800_/X _1428_/Q _1427_/Q
+ VPWR VGND sg13cmos5l_mux4_1
XANTENNA__1220__GATE Tile_X0Y5_FrameStrobe[5] VPWR VGND sg13cmos5l_antennanp
X_2668_ _2668_/X _2700_/X _2685_/X _2684_/X _2681_/X _1099_/Q _1098_/Q VPWR VGND sg13cmos5l_mux4_1
XFILLER_246_75 VPWR VGND sg13cmos5l_decap_8
XFILLER_278_106 VPWR VGND sg13cmos5l_fill_1
XFILLER_278_128 VPWR VGND sg13cmos5l_decap_8
X_1619_ Tile_X0Y0_N4BEG[15] _1619_/A VPWR VGND sg13cmos5l_buf_1
XFILLER_59_18 VPWR VGND sg13cmos5l_fill_1
XANTENNA__0420__D Tile_X0Y1_FrameData[18] VPWR VGND sg13cmos5l_antennanp
XANTENNA__1653__X Tile_X0Y0_FrameStrobe_O[13] VPWR VGND sg13cmos5l_antennanp
XANTENNA__2514__A1 AXIL_S_SOC_ARADDR5 VPWR VGND sg13cmos5l_antennanp
X_2599_ _2599_/X Tile_X0Y2_W2MID[6] Tile_X0Y2_W2END[6] Tile_X0Y2_W6END[9] _2482_/X
+ _0648_/Q _0647_/Q VPWR VGND sg13cmos5l_mux4_1
XFILLER_219_206 VPWR VGND sg13cmos5l_decap_8
XANTENNA__1235__GATE Tile_X0Y5_FrameStrobe[6] VPWR VGND sg13cmos5l_antennanp
XFILLER_115_79 VPWR VGND sg13cmos5l_decap_8
XFILLER_262_52 VPWR VGND sg13cmos5l_decap_8
XFILLER_286_183 VPWR VGND sg13cmos5l_decap_8
XANTENNA__0491__GATE Tile_X0Y5_FrameStrobe[5] VPWR VGND sg13cmos5l_antennanp
XFILLER_39_171 VPWR VGND sg13cmos5l_decap_8
XANTENNA__1251__D Tile_X0Y4_FrameData[3] VPWR VGND sg13cmos5l_antennanp
XFILLER_199_113 VPWR VGND sg13cmos5l_decap_8
XFILLER_264_7 VPWR VGND sg13cmos5l_fill_2
XFILLER_202_106 VPWR VGND sg13cmos5l_decap_8
XFILLER_91_49 VPWR VGND sg13cmos5l_fill_1
XFILLER_54_196 VPWR VGND sg13cmos5l_decap_4
XFILLER_24_10 VPWR VGND sg13cmos5l_fill_1
XFILLER_24_76 VPWR VGND sg13cmos5l_decap_8
XFILLER_356_121 VPWR VGND sg13cmos5l_decap_8
XANTENNA__1828__X Tile_X0Y4_EE4BEG[11] VPWR VGND sg13cmos5l_antennanp
XANTENNA__2202__A0 AXIL_S_SOC_WDATA21 VPWR VGND sg13cmos5l_antennanp
XANTENNA__2753__A1 AXIL_S_SOC_ARPROT2 VPWR VGND sg13cmos5l_antennanp
XFILLER_108_176 VPWR VGND sg13cmos5l_decap_8
XFILLER_156_53 VPWR VGND sg13cmos5l_decap_8
XFILLER_108_187 VPWR VGND sg13cmos5l_fill_1
XFILLER_123_113 VPWR VGND sg13cmos5l_decap_8
XFILLER_306_23 VPWR VGND sg13cmos5l_decap_8
XANTENNA__0330__D Tile_X0Y1_FrameData[12] VPWR VGND sg13cmos5l_antennanp
XANTENNA__0444__GATE Tile_X0Y5_FrameStrobe[4] VPWR VGND sg13cmos5l_antennanp
XANTENNA__1426__D Tile_X0Y5_FrameData[30] VPWR VGND sg13cmos5l_antennanp
XANTENNA__1563__X Tile_X0Y3_FrameData_O[9] VPWR VGND sg13cmos5l_antennanp
XFILLER_123_146 VPWR VGND sg13cmos5l_decap_8
XFILLER_306_34 VPWR VGND sg13cmos5l_fill_2
XFILLER_290_0 VPWR VGND sg13cmos5l_fill_1
XFILLER_77_222 VPWR VGND sg13cmos5l_fill_2
XFILLER_172_63 VPWR VGND sg13cmos5l_decap_8
XANTENNA__2269__A0 Tile_X0Y1_W1END[1] VPWR VGND sg13cmos5l_antennanp
XFILLER_92_214 VPWR VGND sg13cmos5l_fill_1
XFILLER_37_108 VPWR VGND sg13cmos5l_decap_4
XFILLER_322_33 VPWR VGND sg13cmos5l_fill_2
XANTENNA__0459__GATE Tile_X0Y5_FrameStrobe[4] VPWR VGND sg13cmos5l_antennanp
XFILLER_225_209 VPWR VGND sg13cmos5l_fill_2
XFILLER_292_164 VPWR VGND sg13cmos5l_fill_1
XANTENNA__1161__D Tile_X0Y4_FrameData[29] VPWR VGND sg13cmos5l_antennanp
XFILLER_60_111 VPWR VGND sg13cmos5l_decap_8
X_1970_ Tile_X0Y5_E1BEG[3] _2724_/X VPWR VGND sg13cmos5l_buf_1
XFILLER_60_144 VPWR VGND sg13cmos5l_decap_8
XFILLER_60_133 VPWR VGND sg13cmos5l_decap_4
XANTENNA__2441__A0 AXIL_S_SOC_AWADDR0 VPWR VGND sg13cmos5l_antennanp
X_0921_ _0921_/Q Tile_X0Y3_FrameData[29] VGND VPWR Tile_X0Y5_FrameStrobe[4] latch
XFILLER_81_71 VPWR VGND sg13cmos5l_decap_8
XFILLER_60_188 VPWR VGND sg13cmos5l_fill_2
XANTENNA__0505__D Tile_X0Y1_FrameData[29] VPWR VGND sg13cmos5l_antennanp
XANTENNA__1738__X Tile_X0Y0_E1BEG[2] VPWR VGND sg13cmos5l_antennanp
XFILLER_197_60 VPWR VGND sg13cmos5l_decap_8
XFILLER_146_205 VPWR VGND sg13cmos5l_decap_4
X_0852_ _0852_/Q Tile_X0Y3_FrameData[2] VGND VPWR Tile_X0Y5_FrameStrobe[1] latch
XFILLER_362_102 VPWR VGND sg13cmos5l_decap_8
X_0783_ _0783_/Q Tile_X0Y2_FrameData[23] VGND VPWR Tile_X0Y5_FrameStrobe[7] latch
XFILLER_347_63 VPWR VGND sg13cmos5l_decap_8
XANTENNA__2744__A1 AXIL_S_SOC_ARVALID VPWR VGND sg13cmos5l_antennanp
X_2522_ _2522_/X AXIL_S_SOC_ARADDR3 AXIL_S_SOC_ARADDR5 _2591_/X _2594_/X _0960_/Q
+ _0959_/Q VPWR VGND sg13cmos5l_mux4_1
XFILLER_362_168 VPWR VGND sg13cmos5l_fill_2
XFILLER_362_157 VPWR VGND sg13cmos5l_fill_1
XFILLER_114_113 VPWR VGND sg13cmos5l_decap_8
XANTENNA__0240__D Tile_X0Y0_FrameData[22] VPWR VGND sg13cmos5l_antennanp
XANTENNA__1336__D Tile_X0Y5_FrameData[24] VPWR VGND sg13cmos5l_antennanp
XANTENNA__1914__A Tile_X0Y1_FrameData[27] VPWR VGND sg13cmos5l_antennanp
X_2453_ _2453_/X _2458_/X _2457_/X Tile_X0Y2_W6END[0] _2453_/A3 _0558_/Q _0557_/Q
+ VPWR VGND sg13cmos5l_mux4_1
X_1404_ _1404_/Q Tile_X0Y5_FrameData[20] VGND VPWR Tile_X0Y5_FrameStrobe[4] latch
X_2384_ _2384_/X Tile_X0Y3_W2MID[6] Tile_X0Y3_W2END[6] Tile_X0Y3_W6END[6] _2590_/X
+ _1020_/Q _1019_/Q VPWR VGND sg13cmos5l_mux4_1
X_1335_ _1335_/Q Tile_X0Y5_FrameData[25] VGND VPWR Tile_X0Y5_FrameStrobe[2] latch
XFILLER_268_194 VPWR VGND sg13cmos5l_fill_2
X_1266_ _1266_/Q Tile_X0Y5_FrameData[30] VGND VPWR Tile_X0Y5_FrameStrobe[0] latch
XANTENNA__1071__D Tile_X0Y4_FrameData[23] VPWR VGND sg13cmos5l_antennanp
XANTENNA__2275__A3 Tile_X0Y2_W6END[10] VPWR VGND sg13cmos5l_antennanp
X_1197_ _1197_/Q Tile_X0Y4_FrameData[25] VGND VPWR Tile_X0Y5_FrameStrobe[5] latch
X_0217_ _0217_/Q Tile_X0Y0_FrameData[13] VGND VPWR Tile_X0Y5_FrameStrobe[4] latch
XANTENNA__2680__A0 Tile_X0Y5_W1END[3] VPWR VGND sg13cmos5l_antennanp
XFILLER_101_15 VPWR VGND sg13cmos5l_fill_1
X_0148_ _0148_/Q Tile_X0Y0_FrameData[18] VGND VPWR Tile_X0Y5_FrameStrobe[2] latch
XFILLER_51_144 VPWR VGND sg13cmos5l_decap_8
XANTENNA__2432__A0 AXIL_S_SOC_AWADDR1 VPWR VGND sg13cmos5l_antennanp
XFILLER_196_138 VPWR VGND sg13cmos5l_decap_8
X_0079_ _0079_/Q Tile_X0Y0_FrameData[23] VGND VPWR Tile_X0Y5_FrameStrobe[0] latch
XFILLER_51_188 VPWR VGND sg13cmos5l_decap_4
XANTENNA__0415__D Tile_X0Y1_FrameData[23] VPWR VGND sg13cmos5l_antennanp
XANTENNA__1648__X Tile_X0Y0_FrameStrobe_O[8] VPWR VGND sg13cmos5l_antennanp
XFILLER_338_132 VPWR VGND sg13cmos5l_fill_2
XFILLER_137_205 VPWR VGND sg13cmos5l_decap_8
XFILLER_137_216 VPWR VGND sg13cmos5l_fill_2
XFILLER_338_187 VPWR VGND sg13cmos5l_fill_2
XFILLER_353_146 VPWR VGND sg13cmos5l_decap_8
XANTENNA__2735__A1 AXIL_S_SOC_ARPROT2 VPWR VGND sg13cmos5l_antennanp
XFILLER_126_12 VPWR VGND sg13cmos5l_fill_1
XANTENNA__0150__D Tile_X0Y0_FrameData[16] VPWR VGND sg13cmos5l_antennanp
XANTENNA__1246__D Tile_X0Y4_FrameData[8] VPWR VGND sg13cmos5l_antennanp
XANTENNA__1174__GATE Tile_X0Y5_FrameStrobe[4] VPWR VGND sg13cmos5l_antennanp
XANTENNA__2499__A0 Tile_X0Y1_W1END[1] VPWR VGND sg13cmos5l_antennanp
XFILLER_105_179 VPWR VGND sg13cmos5l_decap_8
XFILLER_126_67 VPWR VGND sg13cmos5l_fill_2
XFILLER_273_73 VPWR VGND sg13cmos5l_fill_2
XFILLER_59_222 VPWR VGND sg13cmos5l_fill_2
XFILLER_59_211 VPWR VGND sg13cmos5l_fill_1
XFILLER_113_190 VPWR VGND sg13cmos5l_decap_8
XFILLER_120_138 VPWR VGND sg13cmos5l_decap_8
XFILLER_19_119 VPWR VGND sg13cmos5l_fill_1
XFILLER_19_98 VPWR VGND sg13cmos5l_decap_8
XANTENNA__1189__GATE Tile_X0Y5_FrameStrobe[4] VPWR VGND sg13cmos5l_antennanp
XFILLER_35_42 VPWR VGND sg13cmos5l_fill_2
XANTENNA__1112__GATE Tile_X0Y5_FrameStrobe[2] VPWR VGND sg13cmos5l_antennanp
XFILLER_42_144 VPWR VGND sg13cmos5l_fill_2
XFILLER_35_75 VPWR VGND sg13cmos5l_decap_8
XANTENNA__2423__A0 AXIL_S_SOC_AWADDR6 VPWR VGND sg13cmos5l_antennanp
XFILLER_42_177 VPWR VGND sg13cmos5l_decap_4
XFILLER_298_70 VPWR VGND sg13cmos5l_decap_8
XANTENNA__0325__D Tile_X0Y1_FrameData[17] VPWR VGND sg13cmos5l_antennanp
XANTENNA__1558__X Tile_X0Y3_FrameData_O[4] VPWR VGND sg13cmos5l_antennanp
XFILLER_136_0 VPWR VGND sg13cmos5l_decap_8
XFILLER_51_63 VPWR VGND sg13cmos5l_fill_1
XANTENNA__1127__GATE Tile_X0Y5_FrameStrobe[3] VPWR VGND sg13cmos5l_antennanp
XFILLER_51_74 VPWR VGND sg13cmos5l_decap_4
XANTENNA__2726__A1 AXIL_S_SOC_RREADY VPWR VGND sg13cmos5l_antennanp
XFILLER_143_208 VPWR VGND sg13cmos5l_fill_1
XFILLER_344_179 VPWR VGND sg13cmos5l_fill_2
XFILLER_344_168 VPWR VGND sg13cmos5l_decap_8
XFILLER_303_0 VPWR VGND sg13cmos5l_decap_8
XANTENNA__0383__GATE Tile_X0Y5_FrameStrobe[2] VPWR VGND sg13cmos5l_antennanp
XANTENNA__1156__D Tile_X0Y4_FrameData[2] VPWR VGND sg13cmos5l_antennanp
XFILLER_111_105 VPWR VGND sg13cmos5l_decap_8
XFILLER_257_109 VPWR VGND sg13cmos5l_decap_4
XANTENNA__0995__D Tile_X0Y3_FrameData[19] VPWR VGND sg13cmos5l_antennanp
XANTENNA__0398__GATE Tile_X0Y5_FrameStrobe[2] VPWR VGND sg13cmos5l_antennanp
XFILLER_265_120 VPWR VGND sg13cmos5l_decap_8
X_1120_ _1120_/Q Tile_X0Y4_FrameData[6] VGND VPWR Tile_X0Y5_FrameStrobe[2] latch
XFILLER_265_186 VPWR VGND sg13cmos5l_fill_2
XFILLER_280_112 VPWR VGND sg13cmos5l_fill_1
XFILLER_280_134 VPWR VGND sg13cmos5l_decap_8
X_1051_ _1051_/Q Tile_X0Y4_FrameData[11] VGND VPWR Tile_X0Y5_FrameStrobe[0] latch
XANTENNA__0321__GATE Tile_X0Y5_FrameStrobe[0] VPWR VGND sg13cmos5l_antennanp
XFILLER_202_36 VPWR VGND sg13cmos5l_decap_8
XFILLER_280_178 VPWR VGND sg13cmos5l_decap_8
XANTENNA__0951__GATE Tile_X0Y5_FrameStrobe[5] VPWR VGND sg13cmos5l_antennanp
XFILLER_178_105 VPWR VGND sg13cmos5l_decap_8
XFILLER_18_196 VPWR VGND sg13cmos5l_fill_2
XANTENNA__0336__GATE Tile_X0Y5_FrameStrobe[0] VPWR VGND sg13cmos5l_antennanp
XANTENNA__2414__A0 AXIL_S_SOC_AWADDR5 VPWR VGND sg13cmos5l_antennanp
X_1953_ Tile_X0Y1_E2BEGb[6] _2307_/X VPWR VGND sg13cmos5l_buf_1
XFILLER_358_40 VPWR VGND sg13cmos5l_decap_8
XANTENNA__0235__D Tile_X0Y0_FrameData[27] VPWR VGND sg13cmos5l_antennanp
XANTENNA__0966__GATE Tile_X0Y5_FrameStrobe[5] VPWR VGND sg13cmos5l_antennanp
XANTENNA__1909__A Tile_X0Y1_FrameData[22] VPWR VGND sg13cmos5l_antennanp
X_1884_ Tile_X0Y2_E6BEG[10] _2443_/X VPWR VGND sg13cmos5l_buf_1
X_0904_ _0904_/Q Tile_X0Y3_FrameData[14] VGND VPWR Tile_X0Y5_FrameStrobe[3] latch
XFILLER_186_193 VPWR VGND sg13cmos5l_fill_2
X_0835_ _0835_/Q Tile_X0Y3_FrameData[19] VGND VPWR Tile_X0Y5_FrameStrobe[1] latch
XANTENNA__2717__A1 Tile_X0Y3_W2MID[3] VPWR VGND sg13cmos5l_antennanp
XFILLER_134_219 VPWR VGND sg13cmos5l_decap_4
XFILLER_227_55 VPWR VGND sg13cmos5l_fill_2
X_0766_ _0766_/Q Tile_X0Y2_FrameData[8] VGND VPWR Tile_X0Y5_FrameStrobe[6] latch
XFILLER_51_0 VPWR VGND sg13cmos5l_fill_1
XFILLER_350_116 VPWR VGND sg13cmos5l_decap_8
XANTENNA__1066__D Tile_X0Y4_FrameData[28] VPWR VGND sg13cmos5l_antennanp
XFILLER_288_223 VPWR VGND sg13cmos5l_fill_1
X_2505_ _2505_/X _2566_/X _2565_/X AXIL_S_SOC_ARADDR2 AXIL_S_SOC_ARADDR7 _0994_/Q
+ _0993_/Q VPWR VGND sg13cmos5l_mux4_1
X_0697_ _0697_/Q Tile_X0Y2_FrameData[13] VGND VPWR Tile_X0Y5_FrameStrobe[4] latch
XANTENNA__1644__A Tile_X0Y5_FrameStrobe[4] VPWR VGND sg13cmos5l_antennanp
X_2436_ _2436_/X Tile_X0Y5_N4END[15] Tile_X0Y0_S4END[11] _2472_/X _2471_/X _0676_/Q
+ _0675_/Q VPWR VGND sg13cmos5l_mux4_1
XFILLER_102_138 VPWR VGND sg13cmos5l_decap_8
XANTENNA__0904__GATE Tile_X0Y5_FrameStrobe[3] VPWR VGND sg13cmos5l_antennanp
XANTENNA__1931__X Tile_X0Y1_EE4BEG[12] VPWR VGND sg13cmos5l_antennanp
X_2367_ _2367_/X _2348_/X _0029_/X _2347_/X Tile_X0Y0_S4END[7] _0360_/Q _0359_/Q VPWR
+ VGND sg13cmos5l_mux4_1
X_1318_ _1318_/Q Tile_X0Y5_FrameData[10] VGND VPWR Tile_X0Y5_FrameStrobe[1] latch
X_2298_ _2298_/X AXIL_S_SOC_WDATA5 AXIL_S_SOC_WDATA13 _2375_/X _2378_/X _0496_/Q _0495_/Q
+ VPWR VGND sg13cmos5l_mux4_1
XFILLER_112_25 VPWR VGND sg13cmos5l_fill_1
X_1249_ _1249_/Q Tile_X0Y4_FrameData[5] VGND VPWR Tile_X0Y5_FrameStrobe[6] latch
XFILLER_2_90 VPWR VGND sg13cmos5l_fill_2
XANTENNA__0919__GATE Tile_X0Y5_FrameStrobe[4] VPWR VGND sg13cmos5l_antennanp
XANTENNA__2248__A3 Tile_X0Y0_S2END[7] VPWR VGND sg13cmos5l_antennanp
XANTENNA__2653__A0 AXIL_S_SOC_WVALID VPWR VGND sg13cmos5l_antennanp
XFILLER_169_138 VPWR VGND sg13cmos5l_fill_2
XFILLER_212_223 VPWR VGND sg13cmos5l_fill_1
XANTENNA__2405__A0 AXIL_S_SOC_AWADDR4 VPWR VGND sg13cmos5l_antennanp
XANTENNA__0145__D Tile_X0Y0_FrameData[21] VPWR VGND sg13cmos5l_antennanp
XFILLER_177_171 VPWR VGND sg13cmos5l_fill_2
XFILLER_326_102 VPWR VGND sg13cmos5l_fill_1
XFILLER_122_6 VPWR VGND sg13cmos5l_fill_2
XFILLER_268_95 VPWR VGND sg13cmos5l_decap_8
XFILLER_326_124 VPWR VGND sg13cmos5l_decap_8
XANTENNA__2708__A1 Tile_X0Y5_N2MID[0] VPWR VGND sg13cmos5l_antennanp
XFILLER_137_55 VPWR VGND sg13cmos5l_decap_8
XFILLER_192_185 VPWR VGND sg13cmos5l_decap_8
XFILLER_279_201 VPWR VGND sg13cmos5l_decap_8
XFILLER_284_83 VPWR VGND sg13cmos5l_decap_8
XFILLER_334_190 VPWR VGND sg13cmos5l_fill_1
XANTENNA__1554__A Tile_X0Y3_FrameData[0] VPWR VGND sg13cmos5l_antennanp
XANTENNA__2002__X Tile_X0Y5_EE4BEG[3] VPWR VGND sg13cmos5l_antennanp
XFILLER_153_21 VPWR VGND sg13cmos5l_decap_8
XANTENNA__1841__X Tile_X0Y4_FrameData_O[8] VPWR VGND sg13cmos5l_antennanp
XFILLER_262_101 VPWR VGND sg13cmos5l_decap_8
XFILLER_262_112 VPWR VGND sg13cmos5l_fill_2
XANTENNA__2239__A3 Tile_X0Y0_S4END[0] VPWR VGND sg13cmos5l_antennanp
XANTENNA__2644__A0 AXIL_S_SOC_WSTRB1 VPWR VGND sg13cmos5l_antennanp
XFILLER_303_79 VPWR VGND sg13cmos5l_decap_8
XANTENNA__1051__GATE Tile_X0Y5_FrameStrobe[0] VPWR VGND sg13cmos5l_antennanp
XFILLER_253_0 VPWR VGND sg13cmos5l_decap_4
XFILLER_262_178 VPWR VGND sg13cmos5l_fill_1
XFILLER_349_216 VPWR VGND sg13cmos5l_fill_2
XFILLER_62_62 VPWR VGND sg13cmos5l_fill_1
XFILLER_62_40 VPWR VGND sg13cmos5l_decap_4
XANTENNA__1066__GATE Tile_X0Y5_FrameStrobe[1] VPWR VGND sg13cmos5l_antennanp
XFILLER_168_182 VPWR VGND sg13cmos5l_decap_8
XFILLER_178_84 VPWR VGND sg13cmos5l_decap_8
XFILLER_7_24 VPWR VGND sg13cmos5l_fill_2
XFILLER_328_32 VPWR VGND sg13cmos5l_decap_8
XFILLER_7_68 VPWR VGND sg13cmos5l_fill_2
XFILLER_317_168 VPWR VGND sg13cmos5l_decap_8
XFILLER_183_174 VPWR VGND sg13cmos5l_fill_2
X_0620_ _0620_/Q Tile_X0Y2_FrameData[26] VGND VPWR Tile_X0Y5_FrameStrobe[2] latch
X_0551_ _0551_/Q Tile_X0Y1_FrameData[31] VGND VPWR Tile_X0Y5_FrameStrobe[0] latch
XFILLER_332_149 VPWR VGND sg13cmos5l_decap_8
X_2221_ _2221_/X _2215_/X _0064_/X Tile_X0Y0_S1END[2] Tile_X0Y0_S4END[2] _0098_/Q
+ _0097_/Q VPWR VGND sg13cmos5l_mux4_1
X_0482_ _0482_/Q Tile_X0Y1_FrameData[20] VGND VPWR Tile_X0Y5_FrameStrobe[5] latch
XFILLER_344_64 VPWR VGND sg13cmos5l_decap_8
XANTENNA__1004__GATE Tile_X0Y5_FrameStrobe[6] VPWR VGND sg13cmos5l_antennanp
XANTENNA__1751__X Tile_X0Y2_FrameData_O[11] VPWR VGND sg13cmos5l_antennanp
XANTENNA__2478__A3 Tile_X0Y0_S4END[9] VPWR VGND sg13cmos5l_antennanp
XFILLER_344_97 VPWR VGND sg13cmos5l_decap_8
X_2152_ _2152_/X Tile_X0Y0_W2MID[0] Tile_X0Y0_W2END[0] Tile_X0Y0_W6END[0] _2248_/X
+ _0288_/Q _0287_/Q VPWR VGND sg13cmos5l_mux4_1
XANTENNA__0260__GATE Tile_X0Y5_FrameStrobe[5] VPWR VGND sg13cmos5l_antennanp
X_2083_ Tile_X0Y5_UserCLKo Tile_X0Y5_UserCLK VPWR VGND sg13cmos5l_buf_1
X_1103_ _1103_/Q Tile_X0Y4_FrameData[23] VGND VPWR Tile_X0Y5_FrameStrobe[2] latch
XANTENNA__0890__GATE Tile_X0Y5_FrameStrobe[3] VPWR VGND sg13cmos5l_antennanp
XANTENNA__1019__GATE Tile_X0Y5_FrameStrobe[7] VPWR VGND sg13cmos5l_antennanp
XANTENNA__2635__A0 Tile_X0Y4_WW4END[6] VPWR VGND sg13cmos5l_antennanp
XFILLER_253_167 VPWR VGND sg13cmos5l_decap_4
XFILLER_289_17 VPWR VGND sg13cmos5l_decap_8
X_1034_ _1034_/Q Tile_X0Y4_FrameData[28] VGND VPWR Tile_X0Y5_FrameStrobe[0] latch
XFILLER_53_206 VPWR VGND sg13cmos5l_decap_4
XANTENNA__0275__GATE Tile_X0Y5_FrameStrobe[6] VPWR VGND sg13cmos5l_antennanp
XFILLER_159_193 VPWR VGND sg13cmos5l_decap_8
X_1936_ Tile_X0Y1_E6BEG[1] _2326_/X VPWR VGND sg13cmos5l_buf_1
XANTENNA__1926__X Tile_X0Y1_EE4BEG[7] VPWR VGND sg13cmos5l_antennanp
X_1867_ Tile_X0Y2_E2BEGb[1] _2410_/X VPWR VGND sg13cmos5l_buf_1
X_1798_ Tile_X0Y4_E2BEGb[1] _2626_/X VPWR VGND sg13cmos5l_buf_1
X_0818_ _0818_/Q Tile_X0Y3_FrameData[4] VGND VPWR Tile_X0Y5_FrameStrobe[0] latch
XANTENNA__0213__GATE Tile_X0Y5_FrameStrobe[4] VPWR VGND sg13cmos5l_antennanp
XFILLER_254_31 VPWR VGND sg13cmos5l_fill_2
X_0749_ _0749_/Q Tile_X0Y2_FrameData[25] VGND VPWR Tile_X0Y5_FrameStrobe[6] latch
XANTENNA__0843__GATE Tile_X0Y5_FrameStrobe[1] VPWR VGND sg13cmos5l_antennanp
XFILLER_254_75 VPWR VGND sg13cmos5l_decap_4
XFILLER_254_86 VPWR VGND sg13cmos5l_decap_8
XANTENNA__1661__X Tile_X0Y0_FrameData_O[1] VPWR VGND sg13cmos5l_antennanp
XANTENNA__2469__A3 Tile_X0Y0_S4END[9] VPWR VGND sg13cmos5l_antennanp
XFILLER_229_131 VPWR VGND sg13cmos5l_decap_8
X_2419_ _2419_/X AXIL_S_SOC_AWADDR0 AXIL_S_SOC_AWADDR2 _2469_/X _2486_/X _0710_/Q
+ _0709_/Q VPWR VGND sg13cmos5l_mux4_1
XFILLER_123_24 VPWR VGND sg13cmos5l_fill_1
XANTENNA__0228__GATE Tile_X0Y5_FrameStrobe[4] VPWR VGND sg13cmos5l_antennanp
XANTENNA__0858__GATE Tile_X0Y5_FrameStrobe[2] VPWR VGND sg13cmos5l_antennanp
XANTENNA__2626__A0 AXIL_S_SOC_WSTRB1 VPWR VGND sg13cmos5l_antennanp
XFILLER_197_211 VPWR VGND sg13cmos5l_fill_1
XFILLER_197_222 VPWR VGND sg13cmos5l_fill_2
XFILLER_16_99 VPWR VGND sg13cmos5l_decap_8
XFILLER_279_61 VPWR VGND sg13cmos5l_fill_1
XFILLER_279_83 VPWR VGND sg13cmos5l_decap_8
XFILLER_32_10 VPWR VGND sg13cmos5l_fill_2
XFILLER_32_54 VPWR VGND sg13cmos5l_fill_2
XANTENNA__1836__X Tile_X0Y4_FrameData_O[3] VPWR VGND sg13cmos5l_antennanp
XFILLER_148_43 VPWR VGND sg13cmos5l_decap_8
XFILLER_165_163 VPWR VGND sg13cmos5l_decap_4
XANTENNA__0603__D Tile_X0Y2_FrameData[11] VPWR VGND sg13cmos5l_antennanp
XFILLER_165_174 VPWR VGND sg13cmos5l_decap_4
XFILLER_165_196 VPWR VGND sg13cmos5l_fill_2
XFILLER_314_127 VPWR VGND sg13cmos5l_fill_1
XANTENNA__2157__A2 Tile_X0Y0_WW4END[6] VPWR VGND sg13cmos5l_antennanp
XFILLER_180_177 VPWR VGND sg13cmos5l_fill_2
XFILLER_180_188 VPWR VGND sg13cmos5l_decap_8
XFILLER_164_53 VPWR VGND sg13cmos5l_decap_8
XANTENNA__1434__D Tile_X0Y5_FrameData[22] VPWR VGND sg13cmos5l_antennanp
XANTENNA__1571__X Tile_X0Y3_FrameData_O[17] VPWR VGND sg13cmos5l_antennanp
XFILLER_79_169 VPWR VGND sg13cmos5l_decap_8
XFILLER_314_45 VPWR VGND sg13cmos5l_fill_1
XFILLER_94_128 VPWR VGND sg13cmos5l_decap_8
XFILLER_180_41 VPWR VGND sg13cmos5l_fill_2
XFILLER_57_95 VPWR VGND sg13cmos5l_fill_2
XFILLER_180_74 VPWR VGND sg13cmos5l_decap_4
XANTENNA__2617__A0 AXIL_S_SOC_WSTRB0 VPWR VGND sg13cmos5l_antennanp
XFILLER_189_72 VPWR VGND sg13cmos5l_fill_1
X_2770_ _2770_/X Tile_X0Y5_W1END[1] Tile_X0Y5_W6END[9] _2809_/X _2790_/X _1362_/Q
+ _1361_/Q VPWR VGND sg13cmos5l_mux4_1
XFILLER_339_53 VPWR VGND sg13cmos5l_fill_1
XANTENNA__1746__X Tile_X0Y2_FrameData_O[6] VPWR VGND sg13cmos5l_antennanp
XANTENNA__2396__A2 Tile_X0Y3_W6END[0] VPWR VGND sg13cmos5l_antennanp
X_1721_ Tile_X0Y0_E2BEGb[1] _2174_/X VPWR VGND sg13cmos5l_buf_1
XANTENNA__0513__D Tile_X0Y1_FrameData[21] VPWR VGND sg13cmos5l_antennanp
X_1652_ Tile_X0Y0_FrameStrobe_O[12] Tile_X0Y5_FrameStrobe[12] VPWR VGND sg13cmos5l_buf_1
XANTENNA__2148__A2 Tile_X0Y0_W6END[4] VPWR VGND sg13cmos5l_antennanp
XFILLER_171_144 VPWR VGND sg13cmos5l_decap_8
X_0603_ _0603_/Q Tile_X0Y2_FrameData[11] VGND VPWR Tile_X0Y5_FrameStrobe[1] latch
XFILLER_112_200 VPWR VGND sg13cmos5l_decap_4
X_1583_ Tile_X0Y3_FrameData_O[29] Tile_X0Y3_FrameData[29] VPWR VGND sg13cmos5l_buf_1
XFILLER_355_74 VPWR VGND sg13cmos5l_decap_8
X_0534_ _0534_/Q Tile_X0Y1_FrameData[0] VGND VPWR Tile_X0Y5_FrameStrobe[6] latch
XANTENNA__1344__D Tile_X0Y5_FrameData[16] VPWR VGND sg13cmos5l_antennanp
X_0465_ _0465_/Q Tile_X0Y1_FrameData[5] VGND VPWR Tile_X0Y5_FrameStrobe[4] latch
X_2204_ _2204_/X AXIL_S_SOC_WDATA23 _2239_/X _2230_/X _2244_/X _0188_/Q _0187_/Q VPWR
+ VGND sg13cmos5l_mux4_1
XFILLER_14_0 VPWR VGND sg13cmos5l_fill_2
X_2135_ AXIL_S_SOC_RDATA29 Tile_X0Y0_W2MID[5] Tile_X0Y0_W2END[5] Tile_X0Y0_W6END[5]
+ _2246_/X _0132_/Q _0131_/Q VPWR VGND sg13cmos5l_mux4_1
X_0396_ _0396_/Q Tile_X0Y1_FrameData[10] VGND VPWR Tile_X0Y5_FrameStrobe[2] latch
XFILLER_26_206 VPWR VGND sg13cmos5l_fill_2
XANTENNA__2608__A0 Tile_X0Y5_W2MID[2] VPWR VGND sg13cmos5l_antennanp
XFILLER_240_44 VPWR VGND sg13cmos5l_fill_1
XFILLER_241_104 VPWR VGND sg13cmos5l_decap_8
XFILLER_241_115 VPWR VGND sg13cmos5l_fill_2
X_2066_ Tile_X0Y5_S2BEGb[7] _2836_/X VPWR VGND sg13cmos5l_buf_1
XFILLER_93_194 VPWR VGND sg13cmos5l_decap_8
XFILLER_179_211 VPWR VGND sg13cmos5l_fill_1
X_1017_ _1017_/Q Tile_X0Y3_FrameData[29] VGND VPWR Tile_X0Y5_FrameStrobe[7] latch
XANTENNA__2387__A2 Tile_X0Y0_W6END[11] VPWR VGND sg13cmos5l_antennanp
X_1919_ Tile_X0Y1_EE4BEG[0] _2309_/X VPWR VGND sg13cmos5l_buf_1
XANTENNA__0423__D Tile_X0Y1_FrameData[15] VPWR VGND sg13cmos5l_antennanp
XANTENNA__1656__X Tile_X0Y0_FrameStrobe_O[16] VPWR VGND sg13cmos5l_antennanp
XFILLER_147_185 VPWR VGND sg13cmos5l_decap_8
XFILLER_162_111 VPWR VGND sg13cmos5l_decap_8
XANTENNA__0152__GATE Tile_X0Y5_FrameStrobe[2] VPWR VGND sg13cmos5l_antennanp
XANTENNA__2139__A2 Tile_X0Y5_W6END[2] VPWR VGND sg13cmos5l_antennanp
XANTENNA__0782__GATE Tile_X0Y5_FrameStrobe[7] VPWR VGND sg13cmos5l_antennanp
XFILLER_103_200 VPWR VGND sg13cmos5l_decap_8
XFILLER_118_79 VPWR VGND sg13cmos5l_decap_8
XFILLER_265_85 VPWR VGND sg13cmos5l_decap_8
XFILLER_78_28 VPWR VGND sg13cmos5l_fill_2
XFILLER_78_17 VPWR VGND sg13cmos5l_decap_8
XFILLER_249_204 VPWR VGND sg13cmos5l_decap_8
XANTENNA__1254__D Tile_X0Y4_FrameData[0] VPWR VGND sg13cmos5l_antennanp
XFILLER_281_40 VPWR VGND sg13cmos5l_decap_8
XANTENNA__0167__GATE Tile_X0Y5_FrameStrobe[3] VPWR VGND sg13cmos5l_antennanp
XFILLER_94_27 VPWR VGND sg13cmos5l_decap_8
XANTENNA__0797__GATE Tile_X0Y5_FrameStrobe[0] VPWR VGND sg13cmos5l_antennanp
XFILLER_27_32 VPWR VGND sg13cmos5l_fill_1
XFILLER_217_189 VPWR VGND sg13cmos5l_decap_8
XFILLER_84_194 VPWR VGND sg13cmos5l_decap_8
XANTENNA__0720__GATE Tile_X0Y5_FrameStrobe[5] VPWR VGND sg13cmos5l_antennanp
XANTENNA__2614__A3 AXIL_S_SOC_WSTRB3 VPWR VGND sg13cmos5l_antennanp
XANTENNA__0105__GATE Tile_X0Y5_FrameStrobe[1] VPWR VGND sg13cmos5l_antennanp
XANTENNA__0735__GATE Tile_X0Y5_FrameStrobe[5] VPWR VGND sg13cmos5l_antennanp
XANTENNA__1429__D Tile_X0Y5_FrameData[27] VPWR VGND sg13cmos5l_antennanp
XFILLER_309_23 VPWR VGND sg13cmos5l_decap_8
XANTENNA__0333__D Tile_X0Y1_FrameData[9] VPWR VGND sg13cmos5l_antennanp
XANTENNA__1566__X Tile_X0Y3_FrameData_O[12] VPWR VGND sg13cmos5l_antennanp
XFILLER_153_111 VPWR VGND sg13cmos5l_decap_8
XFILLER_216_0 VPWR VGND sg13cmos5l_fill_1
XFILLER_4_132 VPWR VGND sg13cmos5l_fill_2
XFILLER_299_126 VPWR VGND sg13cmos5l_fill_1
XFILLER_299_115 VPWR VGND sg13cmos5l_fill_1
XFILLER_153_188 VPWR VGND sg13cmos5l_decap_8
XFILLER_175_74 VPWR VGND sg13cmos5l_decap_8
XFILLER_325_44 VPWR VGND sg13cmos5l_decap_8
XANTENNA__1164__D Tile_X0Y4_FrameData[26] VPWR VGND sg13cmos5l_antennanp
XANTENNA__1742__A Tile_X0Y2_FrameData[2] VPWR VGND sg13cmos5l_antennanp
XFILLER_191_73 VPWR VGND sg13cmos5l_decap_4
X_0250_ _0250_/Q Tile_X0Y0_FrameData[12] VGND VPWR Tile_X0Y5_FrameStrobe[5] latch
XFILLER_208_101 VPWR VGND sg13cmos5l_fill_1
XFILLER_341_21 VPWR VGND sg13cmos5l_decap_4
X_0181_ _0181_/Q Tile_X0Y0_FrameData[17] VGND VPWR Tile_X0Y5_FrameStrobe[3] latch
XFILLER_341_54 VPWR VGND sg13cmos5l_decap_8
XFILLER_208_189 VPWR VGND sg13cmos5l_decap_8
XANTENNA__0508__D Tile_X0Y1_FrameData[26] VPWR VGND sg13cmos5l_antennanp
XFILLER_90_186 VPWR VGND sg13cmos5l_decap_4
XFILLER_176_214 VPWR VGND sg13cmos5l_fill_1
X_2822_ _2822_/X Tile_X0Y5_N1END[1] Tile_X0Y5_N4END[1] _2794_/X _0059_/X _1318_/Q
+ _1317_/Q VPWR VGND sg13cmos5l_mux4_1
XANTENNA__1339__D Tile_X0Y5_FrameData[21] VPWR VGND sg13cmos5l_antennanp
XFILLER_129_141 VPWR VGND sg13cmos5l_fill_1
X_2753_ _2753_/X AXIL_S_SOC_ARPROT0 AXIL_S_SOC_ARPROT2 _2819_/X _2828_/X _1396_/Q
+ _1395_/Q VPWR VGND sg13cmos5l_mux4_1
XANTENNA__0243__D Tile_X0Y0_FrameData[19] VPWR VGND sg13cmos5l_antennanp
XANTENNA__1917__A Tile_X0Y1_FrameData[30] VPWR VGND sg13cmos5l_antennanp
XFILLER_129_163 VPWR VGND sg13cmos5l_fill_1
XFILLER_129_185 VPWR VGND sg13cmos5l_decap_8
X_1704_ Tile_X0Y0_EE4BEG[12] _2193_/X VPWR VGND sg13cmos5l_buf_1
XFILLER_219_89 VPWR VGND sg13cmos5l_decap_8
X_2684_ _2684_/X _2680_/X Tile_X0Y5_N4END[7] _2679_/X _0025_/X _1056_/Q _1055_/Q VPWR
+ VGND sg13cmos5l_mux4_1
X_1635_ Tile_X0Y0_N2BEG[7] _2152_/X VPWR VGND sg13cmos5l_buf_1
X_1566_ Tile_X0Y3_FrameData_O[12] Tile_X0Y3_FrameData[12] VPWR VGND sg13cmos5l_buf_1
XANTENNA__1074__D Tile_X0Y4_FrameData[20] VPWR VGND sg13cmos5l_antennanp
X_0517_ _0517_/Q Tile_X0Y1_FrameData[17] VGND VPWR Tile_X0Y5_FrameStrobe[6] latch
XFILLER_301_141 VPWR VGND sg13cmos5l_fill_1
XFILLER_298_181 VPWR VGND sg13cmos5l_decap_8
XANTENNA__1652__A Tile_X0Y5_FrameStrobe[12] VPWR VGND sg13cmos5l_antennanp
XANTENNA__2100__X AXIL_S_SOC_AWREADY VPWR VGND sg13cmos5l_antennanp
XANTENNA__2829__A0 Tile_X0Y4_W2MID[7] VPWR VGND sg13cmos5l_antennanp
X_1497_ _1497_/Q Tile_X0Y5_FrameData[31] VGND VPWR Tile_X0Y5_FrameStrobe[0] latch
XFILLER_301_152 VPWR VGND sg13cmos5l_fill_1
X_0448_ _0448_/Q Tile_X0Y1_FrameData[22] VGND VPWR Tile_X0Y5_FrameStrobe[4] latch
X_0379_ _0379_/Q Tile_X0Y1_FrameData[27] VGND VPWR Tile_X0Y5_FrameStrobe[2] latch
X_2118_ AXIL_S_SOC_RDATA12 Tile_X0Y2_W2MID[4] Tile_X0Y2_W2END[4] Tile_X0Y2_W6END[4]
+ _2485_/X _0614_/Q _0613_/Q VPWR VGND sg13cmos5l_mux4_1
XANTENNA__0418__D Tile_X0Y1_FrameData[20] VPWR VGND sg13cmos5l_antennanp
XFILLER_14_209 VPWR VGND sg13cmos5l_fill_2
X_2049_ Tile_X0Y5_S1BEG[2] _2771_/X VPWR VGND sg13cmos5l_buf_1
XANTENNA__1450__GATE Tile_X0Y5_FrameStrobe[5] VPWR VGND sg13cmos5l_antennanp
XFILLER_196_29 VPWR VGND sg13cmos5l_decap_8
XFILLER_321_9 VPWR VGND sg13cmos5l_fill_2
XANTENNA__1249__D Tile_X0Y4_FrameData[5] VPWR VGND sg13cmos5l_antennanp
XANTENNA__1465__GATE Tile_X0Y5_FrameStrobe[6] VPWR VGND sg13cmos5l_antennanp
XFILLER_13_34 VPWR VGND sg13cmos5l_fill_2
XANTENNA__0153__D Tile_X0Y0_FrameData[13] VPWR VGND sg13cmos5l_antennanp
XFILLER_129_34 VPWR VGND sg13cmos5l_decap_4
XFILLER_129_67 VPWR VGND sg13cmos5l_decap_4
XFILLER_89_16 VPWR VGND sg13cmos5l_decap_8
XANTENNA__0091__GATE Tile_X0Y5_FrameStrobe[0] VPWR VGND sg13cmos5l_antennanp
XFILLER_276_84 VPWR VGND sg13cmos5l_decap_8
XFILLER_324_222 VPWR VGND sg13cmos5l_fill_2
XANTENNA__2780__A2 Tile_X0Y5_W2END[0] VPWR VGND sg13cmos5l_antennanp
XFILLER_135_177 VPWR VGND sg13cmos5l_decap_8
XFILLER_150_103 VPWR VGND sg13cmos5l_decap_8
XFILLER_150_147 VPWR VGND sg13cmos5l_decap_8
XFILLER_292_61 VPWR VGND sg13cmos5l_decap_8
XFILLER_292_72 VPWR VGND sg13cmos5l_fill_2
XANTENNA__1562__A Tile_X0Y3_FrameData[8] VPWR VGND sg13cmos5l_antennanp
XANTENNA__2010__X Tile_X0Y5_EE4BEG[11] VPWR VGND sg13cmos5l_antennanp
XFILLER_49_139 VPWR VGND sg13cmos5l_decap_8
XANTENNA__1403__GATE Tile_X0Y5_FrameStrobe[4] VPWR VGND sg13cmos5l_antennanp
XANTENNA__2296__A1 AXIL_S_SOC_WDATA11 VPWR VGND sg13cmos5l_antennanp
XFILLER_161_98 VPWR VGND sg13cmos5l_decap_8
XANTENNA__0328__D Tile_X0Y1_FrameData[14] VPWR VGND sg13cmos5l_antennanp
XANTENNA__1418__GATE Tile_X0Y5_FrameStrobe[4] VPWR VGND sg13cmos5l_antennanp
XFILLER_166_0 VPWR VGND sg13cmos5l_fill_2
XANTENNA__2599__A2 Tile_X0Y2_W6END[9] VPWR VGND sg13cmos5l_antennanp
XFILLER_359_141 VPWR VGND sg13cmos5l_decap_8
XFILLER_333_0 VPWR VGND sg13cmos5l_fill_1
XANTENNA__0674__GATE Tile_X0Y5_FrameStrobe[3] VPWR VGND sg13cmos5l_antennanp
XFILLER_213_192 VPWR VGND sg13cmos5l_decap_4
XFILLER_173_206 VPWR VGND sg13cmos5l_fill_2
XANTENNA__1159__D Tile_X0Y4_FrameData[31] VPWR VGND sg13cmos5l_antennanp
XFILLER_186_51 VPWR VGND sg13cmos5l_fill_2
XFILLER_70_95 VPWR VGND sg13cmos5l_fill_2
XFILLER_70_84 VPWR VGND sg13cmos5l_decap_8
XANTENNA__0689__GATE Tile_X0Y5_FrameStrobe[4] VPWR VGND sg13cmos5l_antennanp
XFILLER_126_122 VPWR VGND sg13cmos5l_fill_1
XFILLER_186_84 VPWR VGND sg13cmos5l_decap_8
XANTENNA__0998__D Tile_X0Y3_FrameData[16] VPWR VGND sg13cmos5l_antennanp
XFILLER_141_103 VPWR VGND sg13cmos5l_fill_1
XFILLER_336_54 VPWR VGND sg13cmos5l_decap_8
XFILLER_287_107 VPWR VGND sg13cmos5l_decap_8
X_1420_ _1420_/Q Tile_X0Y5_FrameData[4] VGND VPWR Tile_X0Y5_FrameStrobe[4] latch
XANTENNA__0612__GATE Tile_X0Y5_FrameStrobe[1] VPWR VGND sg13cmos5l_antennanp
XFILLER_141_158 VPWR VGND sg13cmos5l_decap_8
X_1351_ _1351_/Q Tile_X0Y5_FrameData[9] VGND VPWR Tile_X0Y5_FrameStrobe[2] latch
XFILLER_79_82 VPWR VGND sg13cmos5l_decap_8
X_0302_ _0302_/Q Tile_X0Y0_FrameData[24] VGND VPWR Tile_X0Y5_FrameStrobe[7] latch
XFILLER_95_223 VPWR VGND sg13cmos5l_fill_1
XFILLER_352_31 VPWR VGND sg13cmos5l_decap_8
X_1282_ _1282_/Q Tile_X0Y5_FrameData[14] VGND VPWR Tile_X0Y5_FrameStrobe[0] latch
XFILLER_352_75 VPWR VGND sg13cmos5l_fill_2
XANTENNA__2287__A1 Tile_X0Y3_WW4END[0] VPWR VGND sg13cmos5l_antennanp
X_0233_ _0233_/Q Tile_X0Y0_FrameData[29] VGND VPWR Tile_X0Y5_FrameStrobe[5] latch
XFILLER_48_161 VPWR VGND sg13cmos5l_fill_1
XANTENNA__0627__GATE Tile_X0Y5_FrameStrobe[2] VPWR VGND sg13cmos5l_antennanp
X_0164_ _0164_/Q Tile_X0Y0_FrameData[2] VGND VPWR Tile_X0Y5_FrameStrobe[2] latch
XANTENNA__0238__D Tile_X0Y0_FrameData[24] VPWR VGND sg13cmos5l_antennanp
XFILLER_251_210 VPWR VGND sg13cmos5l_fill_1
X_0095_ _0095_/Q Tile_X0Y0_FrameData[7] VGND VPWR Tile_X0Y5_FrameStrobe[0] latch
XFILLER_204_181 VPWR VGND sg13cmos5l_fill_1
X_2805_ _2805_/X Tile_X0Y5_N1END[2] Tile_X0Y5_N4END[2] _2795_/X _0058_/X _1292_/Q
+ _1291_/Q VPWR VGND sg13cmos5l_mux4_1
XFILLER_81_0 VPWR VGND sg13cmos5l_fill_2
XANTENNA__1069__D Tile_X0Y4_FrameData[25] VPWR VGND sg13cmos5l_antennanp
XANTENNA__1647__A Tile_X0Y5_FrameStrobe[7] VPWR VGND sg13cmos5l_antennanp
X_0997_ _0997_/Q Tile_X0Y3_FrameData[17] VGND VPWR Tile_X0Y5_FrameStrobe[6] latch
XANTENNA__2211__A1 Tile_X0Y0_S1END[2] VPWR VGND sg13cmos5l_antennanp
XFILLER_117_144 VPWR VGND sg13cmos5l_decap_8
X_2736_ _2736_/X AXIL_S_SOC_ARPROT1 AXIL_S_SOC_ARVALID _2828_/X _2800_/X _1430_/Q
+ _1429_/Q VPWR VGND sg13cmos5l_mux4_1
XFILLER_117_155 VPWR VGND sg13cmos5l_fill_1
XFILLER_117_166 VPWR VGND sg13cmos5l_decap_4
X_2667_ _2667_/X Tile_X0Y4_W1END[3] Tile_X0Y4_WW4END[15] Tile_X0Y4_W6END[7] _2702_/X
+ _1099_/Q _1098_/Q VPWR VGND sg13cmos5l_mux4_1
XANTENNA__0701__D Tile_X0Y2_FrameData[9] VPWR VGND sg13cmos5l_antennanp
XANTENNA__1934__X Tile_X0Y1_EE4BEG[15] VPWR VGND sg13cmos5l_antennanp
XFILLER_117_188 VPWR VGND sg13cmos5l_fill_2
XFILLER_132_136 VPWR VGND sg13cmos5l_decap_4
X_1618_ Tile_X0Y0_N4BEG[14] _1618_/A VPWR VGND sg13cmos5l_buf_1
X_2598_ _2598_/X Tile_X0Y5_W2MID[7] Tile_X0Y5_W2END[7] Tile_X0Y5_W6END[7] _2825_/X
+ _1488_/Q _1487_/Q VPWR VGND sg13cmos5l_mux4_1
X_1549_ Tile_X0Y3_EE4BEG[11] _2536_/X VPWR VGND sg13cmos5l_buf_1
XFILLER_86_223 VPWR VGND sg13cmos5l_fill_1
XFILLER_115_58 VPWR VGND sg13cmos5l_decap_8
XFILLER_140_180 VPWR VGND sg13cmos5l_decap_4
XFILLER_39_150 VPWR VGND sg13cmos5l_decap_8
XANTENNA__0148__D Tile_X0Y0_FrameData[18] VPWR VGND sg13cmos5l_antennanp
XFILLER_199_103 VPWR VGND sg13cmos5l_decap_4
XFILLER_131_68 VPWR VGND sg13cmos5l_fill_2
XFILLER_54_175 VPWR VGND sg13cmos5l_decap_8
XFILLER_54_164 VPWR VGND sg13cmos5l_decap_4
XFILLER_202_129 VPWR VGND sg13cmos5l_fill_1
XFILLER_356_100 VPWR VGND sg13cmos5l_decap_8
XFILLER_10_223 VPWR VGND sg13cmos5l_fill_1
XFILLER_287_61 VPWR VGND sg13cmos5l_decap_8
XANTENNA__1557__A Tile_X0Y3_FrameData[3] VPWR VGND sg13cmos5l_antennanp
XFILLER_210_184 VPWR VGND sg13cmos5l_decap_8
XANTENNA__2005__X Tile_X0Y5_EE4BEG[6] VPWR VGND sg13cmos5l_antennanp
XFILLER_108_144 VPWR VGND sg13cmos5l_decap_4
XFILLER_108_155 VPWR VGND sg13cmos5l_decap_8
XFILLER_40_65 VPWR VGND sg13cmos5l_fill_1
XANTENNA__0611__D Tile_X0Y2_FrameData[3] VPWR VGND sg13cmos5l_antennanp
XANTENNA__1844__X Tile_X0Y4_FrameData_O[11] VPWR VGND sg13cmos5l_antennanp
XFILLER_156_76 VPWR VGND sg13cmos5l_fill_1
XANTENNA__2505__A2 AXIL_S_SOC_ARADDR2 VPWR VGND sg13cmos5l_antennanp
XFILLER_123_169 VPWR VGND sg13cmos5l_decap_8
XFILLER_156_98 VPWR VGND sg13cmos5l_decap_8
XANTENNA__1342__GATE Tile_X0Y5_FrameStrobe[2] VPWR VGND sg13cmos5l_antennanp
XFILLER_172_31 VPWR VGND sg13cmos5l_decap_8
XFILLER_131_180 VPWR VGND sg13cmos5l_decap_8
XFILLER_172_53 VPWR VGND sg13cmos5l_fill_2
XFILLER_292_110 VPWR VGND sg13cmos5l_decap_8
XANTENNA__1442__D Tile_X0Y5_FrameData[14] VPWR VGND sg13cmos5l_antennanp
XANTENNA__2269__A1 Tile_X0Y1_WW4END[1] VPWR VGND sg13cmos5l_antennanp
XANTENNA__1357__GATE Tile_X0Y5_FrameStrobe[2] VPWR VGND sg13cmos5l_antennanp
XFILLER_233_210 VPWR VGND sg13cmos5l_fill_2
XFILLER_65_84 VPWR VGND sg13cmos5l_fill_1
XFILLER_65_73 VPWR VGND sg13cmos5l_decap_8
XFILLER_45_153 VPWR VGND sg13cmos5l_decap_8
XFILLER_45_131 VPWR VGND sg13cmos5l_decap_8
X_0920_ _0920_/Q Tile_X0Y3_FrameData[30] VGND VPWR Tile_X0Y5_FrameStrobe[4] latch
XFILLER_347_133 VPWR VGND sg13cmos5l_decap_8
X_0851_ _0851_/Q Tile_X0Y3_FrameData[3] VGND VPWR Tile_X0Y5_FrameStrobe[1] latch
X_0782_ _0782_/Q Tile_X0Y2_FrameData[24] VGND VPWR Tile_X0Y5_FrameStrobe[7] latch
XFILLER_347_42 VPWR VGND sg13cmos5l_decap_8
XFILLER_283_19 VPWR VGND sg13cmos5l_fill_2
X_2521_ _2521_/X AXIL_S_SOC_ARADDR2 AXIL_S_SOC_ARADDR4 _2592_/X _2593_/X _0962_/Q
+ _0961_/Q VPWR VGND sg13cmos5l_mux4_1
XANTENNA__0521__D Tile_X0Y1_FrameData[13] VPWR VGND sg13cmos5l_antennanp
XANTENNA__0551__GATE Tile_X0Y5_FrameStrobe[0] VPWR VGND sg13cmos5l_antennanp
XANTENNA__1754__X Tile_X0Y2_FrameData_O[14] VPWR VGND sg13cmos5l_antennanp
X_2452_ _2452_/X _2475_/X _2473_/X _2466_/X _2465_/X _0625_/Q _0624_/Q VPWR VGND sg13cmos5l_mux4_1
XFILLER_268_151 VPWR VGND sg13cmos5l_decap_8
X_1403_ _1403_/Q Tile_X0Y5_FrameData[21] VGND VPWR Tile_X0Y5_FrameStrobe[4] latch
X_2383_ _2383_/X Tile_X0Y0_W2MID[6] Tile_X0Y0_W2END[6] Tile_X0Y0_W6END[9] _2242_/X
+ _0168_/Q _0167_/Q VPWR VGND sg13cmos5l_mux4_1
X_1334_ _1334_/Q Tile_X0Y5_FrameData[26] VGND VPWR Tile_X0Y5_FrameStrobe[2] latch
XANTENNA__0566__GATE Tile_X0Y5_FrameStrobe[0] VPWR VGND sg13cmos5l_antennanp
XANTENNA__1352__D Tile_X0Y5_FrameData[8] VPWR VGND sg13cmos5l_antennanp
XFILLER_28_109 VPWR VGND sg13cmos5l_decap_8
X_1265_ _1265_/Q Tile_X0Y4_FrameData[31] VGND VPWR Tile_X0Y5_FrameStrobe[0] latch
XFILLER_36_120 VPWR VGND sg13cmos5l_fill_2
XFILLER_283_198 VPWR VGND sg13cmos5l_fill_1
X_1196_ _1196_/Q Tile_X0Y4_FrameData[26] VGND VPWR Tile_X0Y5_FrameStrobe[5] latch
X_0216_ _0216_/Q Tile_X0Y0_FrameData[14] VGND VPWR Tile_X0Y5_FrameStrobe[4] latch
XANTENNA__2680__A1 Tile_X0Y5_W6END[7] VPWR VGND sg13cmos5l_antennanp
X_0147_ _0147_/Q Tile_X0Y0_FrameData[19] VGND VPWR Tile_X0Y5_FrameStrobe[2] latch
XFILLER_36_186 VPWR VGND sg13cmos5l_decap_8
X_0078_ _0078_/Q Tile_X0Y0_FrameData[24] VGND VPWR Tile_X0Y5_FrameStrobe[0] latch
XFILLER_36_197 VPWR VGND sg13cmos5l_fill_1
XANTENNA__1929__X Tile_X0Y1_EE4BEG[10] VPWR VGND sg13cmos5l_antennanp
XFILLER_51_167 VPWR VGND sg13cmos5l_fill_1
XANTENNA__0504__GATE Tile_X0Y5_FrameStrobe[6] VPWR VGND sg13cmos5l_antennanp
XANTENNA__2432__A1 AXIL_S_SOC_AWADDR3 VPWR VGND sg13cmos5l_antennanp
XFILLER_338_155 VPWR VGND sg13cmos5l_decap_8
XANTENNA__2196__A0 AXIL_S_SOC_WDATA19 VPWR VGND sg13cmos5l_antennanp
XFILLER_257_64 VPWR VGND sg13cmos5l_fill_1
XFILLER_353_125 VPWR VGND sg13cmos5l_decap_8
X_2719_ _2719_/X Tile_X0Y3_W1END[2] Tile_X0Y3_W2MID[1] Tile_X0Y3_W2END[1] _2595_/X
+ _0878_/Q _0877_/Q VPWR VGND sg13cmos5l_mux4_1
XANTENNA__0431__D Tile_X0Y1_FrameData[7] VPWR VGND sg13cmos5l_antennanp
XANTENNA__0519__GATE Tile_X0Y5_FrameStrobe[6] VPWR VGND sg13cmos5l_antennanp
XANTENNA__1664__X Tile_X0Y0_FrameData_O[4] VPWR VGND sg13cmos5l_antennanp
XFILLER_105_103 VPWR VGND sg13cmos5l_decap_8
XFILLER_105_158 VPWR VGND sg13cmos5l_decap_8
XANTENNA__2499__A1 Tile_X0Y1_W2MID[2] VPWR VGND sg13cmos5l_antennanp
XFILLER_259_151 VPWR VGND sg13cmos5l_fill_2
XANTENNA__1262__D Tile_X0Y4_FrameData[24] VPWR VGND sg13cmos5l_antennanp
XFILLER_274_110 VPWR VGND sg13cmos5l_fill_2
XANTENNA__1840__A Tile_X0Y4_FrameData[7] VPWR VGND sg13cmos5l_antennanp
XANTENNA__2120__A0 Tile_X0Y2_W2MID[6] VPWR VGND sg13cmos5l_antennanp
XANTENNA__0606__D Tile_X0Y2_FrameData[8] VPWR VGND sg13cmos5l_antennanp
XANTENNA__1839__X Tile_X0Y4_FrameData_O[6] VPWR VGND sg13cmos5l_antennanp
XFILLER_187_139 VPWR VGND sg13cmos5l_decap_8
XFILLER_42_156 VPWR VGND sg13cmos5l_decap_8
XFILLER_329_111 VPWR VGND sg13cmos5l_decap_4
XANTENNA__2423__A1 AXIL_S_SOC_AWPROT0 VPWR VGND sg13cmos5l_antennanp
XFILLER_329_122 VPWR VGND sg13cmos5l_fill_2
XFILLER_128_217 VPWR VGND sg13cmos5l_fill_1
XFILLER_195_194 VPWR VGND sg13cmos5l_decap_4
XANTENNA__2187__A0 AXIL_S_SOC_WDATA22 VPWR VGND sg13cmos5l_antennanp
XFILLER_317_23 VPWR VGND sg13cmos5l_decap_8
XANTENNA__0341__D Tile_X0Y1_FrameData[1] VPWR VGND sg13cmos5l_antennanp
XANTENNA__1437__D Tile_X0Y5_FrameData[19] VPWR VGND sg13cmos5l_antennanp
XANTENNA__1574__X Tile_X0Y3_FrameData_O[20] VPWR VGND sg13cmos5l_antennanp
XFILLER_317_34 VPWR VGND sg13cmos5l_fill_1
XFILLER_297_202 VPWR VGND sg13cmos5l_decap_4
XANTENNA__1281__GATE Tile_X0Y5_FrameStrobe[0] VPWR VGND sg13cmos5l_antennanp
XFILLER_183_63 VPWR VGND sg13cmos5l_fill_1
XFILLER_183_85 VPWR VGND sg13cmos5l_fill_1
XFILLER_265_143 VPWR VGND sg13cmos5l_fill_1
XFILLER_333_66 VPWR VGND sg13cmos5l_fill_1
XFILLER_333_55 VPWR VGND sg13cmos5l_decap_8
XANTENNA__1172__D Tile_X0Y4_FrameData[18] VPWR VGND sg13cmos5l_antennanp
XANTENNA__1296__GATE Tile_X0Y5_FrameStrobe[0] VPWR VGND sg13cmos5l_antennanp
XANTENNA__1750__A Tile_X0Y2_FrameData[10] VPWR VGND sg13cmos5l_antennanp
XFILLER_76_94 VPWR VGND sg13cmos5l_decap_8
XFILLER_333_99 VPWR VGND sg13cmos5l_decap_8
XANTENNA__2111__A0 Tile_X0Y3_W2MID[5] VPWR VGND sg13cmos5l_antennanp
XFILLER_18_131 VPWR VGND sg13cmos5l_fill_2
XFILLER_18_142 VPWR VGND sg13cmos5l_fill_1
XFILLER_206_221 VPWR VGND sg13cmos5l_fill_2
X_1050_ _1050_/Q Tile_X0Y4_FrameData[12] VGND VPWR Tile_X0Y5_FrameStrobe[0] latch
XFILLER_221_213 VPWR VGND sg13cmos5l_fill_2
XANTENNA__0516__D Tile_X0Y1_FrameData[18] VPWR VGND sg13cmos5l_antennanp
XANTENNA__1749__X Tile_X0Y2_FrameData_O[9] VPWR VGND sg13cmos5l_antennanp
XANTENNA__2414__A1 AXIL_S_SOC_AWVALID VPWR VGND sg13cmos5l_antennanp
X_1952_ Tile_X0Y1_E2BEGb[5] _2306_/X VPWR VGND sg13cmos5l_buf_1
XANTENNA__1234__GATE Tile_X0Y5_FrameStrobe[6] VPWR VGND sg13cmos5l_antennanp
X_1883_ Tile_X0Y2_E6BEG[9] _2442_/X VPWR VGND sg13cmos5l_buf_1
X_0903_ _0903_/Q Tile_X0Y3_FrameData[15] VGND VPWR Tile_X0Y5_FrameStrobe[3] latch
XFILLER_358_74 VPWR VGND sg13cmos5l_decap_4
XFILLER_186_183 VPWR VGND sg13cmos5l_fill_2
X_0834_ _0834_/Q Tile_X0Y3_FrameData[20] VGND VPWR Tile_X0Y5_FrameStrobe[1] latch
XFILLER_358_85 VPWR VGND sg13cmos5l_fill_1
XANTENNA__0490__GATE Tile_X0Y5_FrameStrobe[5] VPWR VGND sg13cmos5l_antennanp
XANTENNA__2178__A0 AXIL_S_SOC_WDATA21 VPWR VGND sg13cmos5l_antennanp
XANTENNA__2717__A2 Tile_X0Y3_W2END[3] VPWR VGND sg13cmos5l_antennanp
XFILLER_335_158 VPWR VGND sg13cmos5l_fill_2
XANTENNA__0251__D Tile_X0Y0_FrameData[11] VPWR VGND sg13cmos5l_antennanp
XANTENNA__1347__D Tile_X0Y5_FrameData[13] VPWR VGND sg13cmos5l_antennanp
X_0765_ _0765_/Q Tile_X0Y2_FrameData[9] VGND VPWR Tile_X0Y5_FrameStrobe[6] latch
XANTENNA__1249__GATE Tile_X0Y5_FrameStrobe[6] VPWR VGND sg13cmos5l_antennanp
XFILLER_227_89 VPWR VGND sg13cmos5l_fill_1
X_2504_ _2504_/X Tile_X0Y4_W2MID[0] Tile_X0Y4_W2END[0] Tile_X0Y4_W6END[0] _2681_/X
+ _1242_/Q _1241_/Q VPWR VGND sg13cmos5l_mux4_1
X_0696_ _0696_/Q Tile_X0Y2_FrameData[14] VGND VPWR Tile_X0Y5_FrameStrobe[4] latch
XFILLER_44_0 VPWR VGND sg13cmos5l_fill_1
X_2435_ _2435_/X Tile_X0Y5_N4END[14] Tile_X0Y0_S4END[10] _2470_/X _2469_/X _0678_/Q
+ _0677_/Q VPWR VGND sg13cmos5l_mux4_1
XFILLER_243_44 VPWR VGND sg13cmos5l_decap_8
XFILLER_243_66 VPWR VGND sg13cmos5l_decap_4
X_2366_ _2366_/X _2346_/X _0030_/X _2345_/X Tile_X0Y0_S4END[6] _0354_/Q _0353_/Q VPWR
+ VGND sg13cmos5l_mux4_1
XANTENNA__1082__D Tile_X0Y4_FrameData[12] VPWR VGND sg13cmos5l_antennanp
XANTENNA__1660__A Tile_X0Y0_FrameData[0] VPWR VGND sg13cmos5l_antennanp
XFILLER_256_143 VPWR VGND sg13cmos5l_fill_1
X_1317_ _1317_/Q Tile_X0Y5_FrameData[11] VGND VPWR Tile_X0Y5_FrameStrobe[1] latch
X_2297_ _2297_/X AXIL_S_SOC_WDATA4 AXIL_S_SOC_WDATA12 _2376_/X _2377_/X _0498_/Q _0497_/Q
+ VPWR VGND sg13cmos5l_mux4_1
XANTENNA__2102__A0 Tile_X0Y4_W2MID[2] VPWR VGND sg13cmos5l_antennanp
XFILLER_110_194 VPWR VGND sg13cmos5l_decap_8
X_1248_ _1248_/Q Tile_X0Y4_FrameData[6] VGND VPWR Tile_X0Y5_FrameStrobe[6] latch
XFILLER_24_101 VPWR VGND sg13cmos5l_fill_2
XFILLER_24_112 VPWR VGND sg13cmos5l_fill_1
X_1179_ _1179_/Q Tile_X0Y4_FrameData[11] VGND VPWR Tile_X0Y5_FrameStrobe[4] latch
XFILLER_72_19 VPWR VGND sg13cmos5l_decap_8
XANTENNA__0426__D Tile_X0Y1_FrameData[12] VPWR VGND sg13cmos5l_antennanp
XANTENNA__1659__X Tile_X0Y0_FrameStrobe_O[19] VPWR VGND sg13cmos5l_antennanp
XFILLER_169_117 VPWR VGND sg13cmos5l_decap_8
XFILLER_24_178 VPWR VGND sg13cmos5l_decap_4
XANTENNA__0443__GATE Tile_X0Y5_FrameStrobe[4] VPWR VGND sg13cmos5l_antennanp
XANTENNA__2405__A1 AXIL_S_SOC_AWPROT2 VPWR VGND sg13cmos5l_antennanp
XANTENNA__0458__GATE Tile_X0Y5_FrameStrobe[4] VPWR VGND sg13cmos5l_antennanp
XANTENNA__2169__A0 AXIL_S_SOC_WDATA20 VPWR VGND sg13cmos5l_antennanp
XANTENNA__0161__D Tile_X0Y0_FrameData[5] VPWR VGND sg13cmos5l_antennanp
XANTENNA__1257__D Tile_X0Y4_FrameData[29] VPWR VGND sg13cmos5l_antennanp
XANTENNA__1835__A Tile_X0Y4_FrameData[2] VPWR VGND sg13cmos5l_antennanp
XFILLER_21_67 VPWR VGND sg13cmos5l_fill_2
XFILLER_341_128 VPWR VGND sg13cmos5l_decap_8
XFILLER_137_78 VPWR VGND sg13cmos5l_decap_8
XFILLER_137_89 VPWR VGND sg13cmos5l_fill_2
XFILLER_97_38 VPWR VGND sg13cmos5l_decap_8
XFILLER_97_16 VPWR VGND sg13cmos5l_fill_2
XANTENNA__2341__A0 Tile_X0Y0_W1END[0] VPWR VGND sg13cmos5l_antennanp
XFILLER_247_132 VPWR VGND sg13cmos5l_fill_1
XANTENNA__1570__A Tile_X0Y3_FrameData[16] VPWR VGND sg13cmos5l_antennanp
XFILLER_247_154 VPWR VGND sg13cmos5l_decap_8
XFILLER_247_165 VPWR VGND sg13cmos5l_fill_1
XFILLER_303_36 VPWR VGND sg13cmos5l_decap_8
XANTENNA__2644__A1 AXIL_S_SOC_BREADY VPWR VGND sg13cmos5l_antennanp
XFILLER_260_2 VPWR VGND sg13cmos5l_fill_1
XFILLER_262_157 VPWR VGND sg13cmos5l_decap_8
XANTENNA__0336__D Tile_X0Y1_FrameData[6] VPWR VGND sg13cmos5l_antennanp
XANTENNA__1569__X Tile_X0Y3_FrameData_O[15] VPWR VGND sg13cmos5l_antennanp
XFILLER_246_0 VPWR VGND sg13cmos5l_fill_2
XFILLER_168_161 VPWR VGND sg13cmos5l_decap_8
XFILLER_175_109 VPWR VGND sg13cmos5l_decap_8
XFILLER_178_74 VPWR VGND sg13cmos5l_decap_8
XANTENNA__1167__D Tile_X0Y4_FrameData[23] VPWR VGND sg13cmos5l_antennanp
XANTENNA__1745__A Tile_X0Y2_FrameData[5] VPWR VGND sg13cmos5l_antennanp
XFILLER_194_84 VPWR VGND sg13cmos5l_decap_8
X_0550_ _0550_/Q Tile_X0Y1_FrameData[16] VGND VPWR Tile_X0Y5_FrameStrobe[7] latch
XFILLER_97_115 VPWR VGND sg13cmos5l_decap_8
XFILLER_97_104 VPWR VGND sg13cmos5l_decap_8
XFILLER_344_43 VPWR VGND sg13cmos5l_decap_8
X_2220_ _2220_/X _2706_/X _2697_/X _2696_/X _2708_/X _1240_/Q _1239_/Q VPWR VGND sg13cmos5l_mux4_1
X_0481_ _0481_/Q Tile_X0Y1_FrameData[21] VGND VPWR Tile_X0Y5_FrameStrobe[5] latch
XANTENNA__2332__A0 AXIL_S_SOC_WDATA7 VPWR VGND sg13cmos5l_antennanp
XFILLER_213_14 VPWR VGND sg13cmos5l_decap_8
X_2151_ _2151_/X Tile_X0Y0_W2MID[1] Tile_X0Y0_W2END[1] Tile_X0Y0_W6END[1] _2247_/X
+ _0290_/Q _0289_/Q VPWR VGND sg13cmos5l_mux4_1
XFILLER_213_36 VPWR VGND sg13cmos5l_decap_8
X_2082_ Tile_X0Y5_S4BEG[15] _2082_/A VPWR VGND sg13cmos5l_buf_1
X_1102_ _1102_/Q Tile_X0Y4_FrameData[24] VGND VPWR Tile_X0Y5_FrameStrobe[2] latch
XFILLER_360_53 VPWR VGND sg13cmos5l_fill_2
X_1033_ _1033_/Q Tile_X0Y4_FrameData[29] VGND VPWR Tile_X0Y5_FrameStrobe[0] latch
XANTENNA__2635__A1 AXIL_S_SOC_WSTRB2 VPWR VGND sg13cmos5l_antennanp
XFILLER_253_179 VPWR VGND sg13cmos5l_decap_4
XANTENNA__0246__D Tile_X0Y0_FrameData[16] VPWR VGND sg13cmos5l_antennanp
XANTENNA__1173__GATE Tile_X0Y5_FrameStrobe[4] VPWR VGND sg13cmos5l_antennanp
XFILLER_166_109 VPWR VGND sg13cmos5l_decap_8
X_1935_ Tile_X0Y1_E6BEG[0] _2325_/X VPWR VGND sg13cmos5l_buf_1
XFILLER_159_172 VPWR VGND sg13cmos5l_decap_8
XFILLER_174_120 VPWR VGND sg13cmos5l_decap_8
X_1866_ Tile_X0Y2_E2BEGb[0] _2409_/X VPWR VGND sg13cmos5l_buf_1
XANTENNA__1077__D Tile_X0Y4_FrameData[17] VPWR VGND sg13cmos5l_antennanp
XANTENNA__1188__GATE Tile_X0Y5_FrameStrobe[4] VPWR VGND sg13cmos5l_antennanp
XANTENNA__1655__A Tile_X0Y5_FrameStrobe[15] VPWR VGND sg13cmos5l_antennanp
XFILLER_238_88 VPWR VGND sg13cmos5l_decap_8
X_1797_ Tile_X0Y4_E2BEGb[0] _2625_/X VPWR VGND sg13cmos5l_buf_1
X_0817_ _0817_/Q Tile_X0Y3_FrameData[5] VGND VPWR Tile_X0Y5_FrameStrobe[0] latch
XANTENNA__2103__X AXIL_S_SOC_BRESP1 VPWR VGND sg13cmos5l_antennanp
XFILLER_254_10 VPWR VGND sg13cmos5l_fill_2
X_0748_ _0748_/Q Tile_X0Y2_FrameData[26] VGND VPWR Tile_X0Y5_FrameStrobe[6] latch
XANTENNA__2571__A0 Tile_X0Y2_W1END[3] VPWR VGND sg13cmos5l_antennanp
XFILLER_254_43 VPWR VGND sg13cmos5l_decap_4
XFILLER_331_150 VPWR VGND sg13cmos5l_fill_1
XANTENNA__1111__GATE Tile_X0Y5_FrameStrobe[2] VPWR VGND sg13cmos5l_antennanp
XANTENNA__1942__X Tile_X0Y1_E6BEG[7] VPWR VGND sg13cmos5l_antennanp
XFILLER_130_223 VPWR VGND sg13cmos5l_fill_1
X_0679_ _0679_/Q Tile_X0Y2_FrameData[31] VGND VPWR Tile_X0Y5_FrameStrobe[4] latch
XFILLER_88_126 VPWR VGND sg13cmos5l_decap_8
XANTENNA__2323__A0 AXIL_S_SOC_WDATA2 VPWR VGND sg13cmos5l_antennanp
XFILLER_229_110 VPWR VGND sg13cmos5l_decap_8
X_2418_ _2418_/X AXIL_S_SOC_AWADDR1 AXIL_S_SOC_AWVALID _2467_/X _2487_/X _0712_/Q
+ _0711_/Q VPWR VGND sg13cmos5l_mux4_1
XFILLER_88_159 VPWR VGND sg13cmos5l_decap_8
X_2349_ _2349_/X _2348_/X _0029_/X _2347_/X Tile_X0Y0_S4END[7] _0336_/Q _0335_/Q VPWR
+ VGND sg13cmos5l_mux4_1
XANTENNA__1126__GATE Tile_X0Y5_FrameStrobe[2] VPWR VGND sg13cmos5l_antennanp
XFILLER_177_8 VPWR VGND sg13cmos5l_fill_2
XFILLER_270_97 VPWR VGND sg13cmos5l_decap_8
XFILLER_83_29 VPWR VGND sg13cmos5l_fill_1
XFILLER_44_207 VPWR VGND sg13cmos5l_fill_2
XANTENNA__2626__A1 AXIL_S_SOC_WSTRB3 VPWR VGND sg13cmos5l_antennanp
XFILLER_203_80 VPWR VGND sg13cmos5l_decap_4
XANTENNA__0382__GATE Tile_X0Y5_FrameStrobe[2] VPWR VGND sg13cmos5l_antennanp
XFILLER_16_78 VPWR VGND sg13cmos5l_decap_8
XANTENNA__0156__D Tile_X0Y0_FrameData[10] VPWR VGND sg13cmos5l_antennanp
XFILLER_337_7 VPWR VGND sg13cmos5l_decap_8
XFILLER_232_6 VPWR VGND sg13cmos5l_fill_2
XANTENNA__0397__GATE Tile_X0Y5_FrameStrobe[2] VPWR VGND sg13cmos5l_antennanp
XFILLER_165_120 VPWR VGND sg13cmos5l_decap_4
XFILLER_165_153 VPWR VGND sg13cmos5l_decap_4
XFILLER_148_99 VPWR VGND sg13cmos5l_decap_8
XANTENNA__0320__GATE Tile_X0Y5_FrameStrobe[0] VPWR VGND sg13cmos5l_antennanp
XANTENNA__1565__A Tile_X0Y3_FrameData[11] VPWR VGND sg13cmos5l_antennanp
XANTENNA__2013__X Tile_X0Y5_EE4BEG[14] VPWR VGND sg13cmos5l_antennanp
XANTENNA__2157__A3 Tile_X0Y0_W6END[10] VPWR VGND sg13cmos5l_antennanp
XFILLER_164_10 VPWR VGND sg13cmos5l_decap_8
XANTENNA__0950__GATE Tile_X0Y5_FrameStrobe[4] VPWR VGND sg13cmos5l_antennanp
XANTENNA__1852__X Tile_X0Y4_FrameData_O[19] VPWR VGND sg13cmos5l_antennanp
XFILLER_267_205 VPWR VGND sg13cmos5l_decap_8
XFILLER_79_148 VPWR VGND sg13cmos5l_decap_8
XANTENNA__2314__A0 AXIL_S_SOC_WDATA5 VPWR VGND sg13cmos5l_antennanp
XFILLER_94_107 VPWR VGND sg13cmos5l_decap_8
XANTENNA__0335__GATE Tile_X0Y5_FrameStrobe[0] VPWR VGND sg13cmos5l_antennanp
XFILLER_196_0 VPWR VGND sg13cmos5l_decap_8
XANTENNA__0965__GATE Tile_X0Y5_FrameStrobe[5] VPWR VGND sg13cmos5l_antennanp
XFILLER_235_124 VPWR VGND sg13cmos5l_fill_1
XANTENNA__1450__D Tile_X0Y5_FrameData[6] VPWR VGND sg13cmos5l_antennanp
XANTENNA__2617__A1 AXIL_S_SOC_WSTRB2 VPWR VGND sg13cmos5l_antennanp
XFILLER_113_91 VPWR VGND sg13cmos5l_decap_8
XFILLER_330_34 VPWR VGND sg13cmos5l_decap_8
XFILLER_250_127 VPWR VGND sg13cmos5l_fill_1
XFILLER_250_149 VPWR VGND sg13cmos5l_fill_2
XFILLER_73_73 VPWR VGND sg13cmos5l_decap_8
XFILLER_339_32 VPWR VGND sg13cmos5l_decap_8
XFILLER_339_21 VPWR VGND sg13cmos5l_fill_1
XANTENNA__0903__GATE Tile_X0Y5_FrameStrobe[3] VPWR VGND sg13cmos5l_antennanp
XFILLER_156_142 VPWR VGND sg13cmos5l_decap_4
X_1720_ Tile_X0Y0_E2BEGb[0] _2173_/X VPWR VGND sg13cmos5l_buf_1
XFILLER_156_164 VPWR VGND sg13cmos5l_fill_1
XFILLER_156_186 VPWR VGND sg13cmos5l_decap_8
XFILLER_171_101 VPWR VGND sg13cmos5l_decap_8
X_1651_ Tile_X0Y0_FrameStrobe_O[11] Tile_X0Y5_FrameStrobe[11] VPWR VGND sg13cmos5l_buf_1
X_0602_ _0602_/Q Tile_X0Y2_FrameData[12] VGND VPWR Tile_X0Y5_FrameStrobe[1] latch
XANTENNA__0918__GATE Tile_X0Y5_FrameStrobe[3] VPWR VGND sg13cmos5l_antennanp
XANTENNA__2553__A0 Tile_X0Y3_W1END[0] VPWR VGND sg13cmos5l_antennanp
XFILLER_171_167 VPWR VGND sg13cmos5l_decap_8
XFILLER_208_69 VPWR VGND sg13cmos5l_decap_8
X_1582_ Tile_X0Y3_FrameData_O[28] Tile_X0Y3_FrameData[28] VPWR VGND sg13cmos5l_buf_1
XANTENNA__1762__X Tile_X0Y2_FrameData_O[22] VPWR VGND sg13cmos5l_antennanp
XFILLER_291_19 VPWR VGND sg13cmos5l_decap_4
X_0533_ _0533_/Q Tile_X0Y1_FrameData[1] VGND VPWR Tile_X0Y5_FrameStrobe[6] latch
XANTENNA__2305__A0 AXIL_S_SOC_WDATA4 VPWR VGND sg13cmos5l_antennanp
XFILLER_224_35 VPWR VGND sg13cmos5l_decap_8
X_0464_ _0464_/Q Tile_X0Y1_FrameData[6] VGND VPWR Tile_X0Y5_FrameStrobe[4] latch
XFILLER_85_107 VPWR VGND sg13cmos5l_fill_1
X_2203_ _2203_/X AXIL_S_SOC_WDATA22 _2237_/X _2226_/X _2243_/X _0190_/Q _0189_/Q VPWR
+ VGND sg13cmos5l_mux4_1
XFILLER_85_129 VPWR VGND sg13cmos5l_decap_4
X_2134_ AXIL_S_SOC_RDATA28 Tile_X0Y0_W2MID[4] Tile_X0Y0_W2END[4] Tile_X0Y0_W6END[4]
+ _2245_/X _0134_/Q _0133_/Q VPWR VGND sg13cmos5l_mux4_1
X_0395_ _0395_/Q Tile_X0Y1_FrameData[11] VGND VPWR Tile_X0Y5_FrameStrobe[2] latch
XFILLER_304_90 VPWR VGND sg13cmos5l_fill_1
XANTENNA__1360__D Tile_X0Y5_FrameData[0] VPWR VGND sg13cmos5l_antennanp
XANTENNA__2608__A1 Tile_X0Y5_W2END[2] VPWR VGND sg13cmos5l_antennanp
X_2065_ Tile_X0Y5_S2BEGb[6] _2835_/X VPWR VGND sg13cmos5l_buf_1
XFILLER_241_138 VPWR VGND sg13cmos5l_fill_2
X_1016_ _1016_/Q Tile_X0Y3_FrameData[30] VGND VPWR Tile_X0Y5_FrameStrobe[7] latch
XFILLER_249_21 VPWR VGND sg13cmos5l_fill_1
XANTENNA__0704__D Tile_X0Y2_FrameData[6] VPWR VGND sg13cmos5l_antennanp
XANTENNA__1937__X Tile_X0Y1_E6BEG[2] VPWR VGND sg13cmos5l_antennanp
XANTENNA__2792__A0 Tile_X0Y5_N1END[3] VPWR VGND sg13cmos5l_antennanp
XFILLER_249_87 VPWR VGND sg13cmos5l_fill_2
X_1918_ Tile_X0Y1_FrameData_O[31] Tile_X0Y1_FrameData[31] VPWR VGND sg13cmos5l_buf_1
XFILLER_147_164 VPWR VGND sg13cmos5l_decap_8
X_1849_ Tile_X0Y4_FrameData_O[16] Tile_X0Y4_FrameData[16] VPWR VGND sg13cmos5l_buf_1
XFILLER_8_90 VPWR VGND sg13cmos5l_fill_2
XANTENNA__1050__GATE Tile_X0Y5_FrameStrobe[0] VPWR VGND sg13cmos5l_antennanp
XANTENNA__2544__A0 Tile_X0Y5_N4END[11] VPWR VGND sg13cmos5l_antennanp
XFILLER_118_58 VPWR VGND sg13cmos5l_decap_8
XANTENNA__1672__X Tile_X0Y0_FrameData_O[12] VPWR VGND sg13cmos5l_antennanp
XFILLER_134_13 VPWR VGND sg13cmos5l_decap_8
XFILLER_281_63 VPWR VGND sg13cmos5l_decap_8
XFILLER_281_74 VPWR VGND sg13cmos5l_decap_8
XANTENNA__1065__GATE Tile_X0Y5_FrameStrobe[1] VPWR VGND sg13cmos5l_antennanp
XFILLER_150_12 VPWR VGND sg13cmos5l_decap_8
XFILLER_84_173 VPWR VGND sg13cmos5l_decap_8
XANTENNA__1270__D Tile_X0Y5_FrameData[26] VPWR VGND sg13cmos5l_antennanp
XFILLER_150_23 VPWR VGND sg13cmos5l_fill_2
XFILLER_150_67 VPWR VGND sg13cmos5l_decap_8
XANTENNA__2008__X Tile_X0Y5_EE4BEG[9] VPWR VGND sg13cmos5l_antennanp
XFILLER_300_37 VPWR VGND sg13cmos5l_fill_2
XFILLER_159_10 VPWR VGND sg13cmos5l_fill_2
XFILLER_240_160 VPWR VGND sg13cmos5l_decap_8
XFILLER_240_182 VPWR VGND sg13cmos5l_decap_4
XFILLER_43_54 VPWR VGND sg13cmos5l_fill_2
XFILLER_300_59 VPWR VGND sg13cmos5l_decap_4
XANTENNA__0614__D Tile_X0Y2_FrameData[0] VPWR VGND sg13cmos5l_antennanp
XANTENNA__1003__GATE Tile_X0Y5_FrameStrobe[6] VPWR VGND sg13cmos5l_antennanp
XANTENNA__1847__X Tile_X0Y4_FrameData_O[14] VPWR VGND sg13cmos5l_antennanp
XANTENNA__2378__A3 Tile_X0Y0_S2MID[5] VPWR VGND sg13cmos5l_antennanp
XFILLER_159_76 VPWR VGND sg13cmos5l_fill_2
XANTENNA__2783__A0 Tile_X0Y5_W1END[1] VPWR VGND sg13cmos5l_antennanp
XFILLER_175_53 VPWR VGND sg13cmos5l_decap_8
XFILLER_4_100 VPWR VGND sg13cmos5l_fill_1
XANTENNA__1018__GATE Tile_X0Y5_FrameStrobe[7] VPWR VGND sg13cmos5l_antennanp
XANTENNA__2535__A0 AXIL_S_SOC_ARADDR0 VPWR VGND sg13cmos5l_antennanp
XFILLER_153_167 VPWR VGND sg13cmos5l_decap_8
XFILLER_299_138 VPWR VGND sg13cmos5l_fill_1
XANTENNA__1445__D Tile_X0Y5_FrameData[11] VPWR VGND sg13cmos5l_antennanp
XANTENNA__1582__X Tile_X0Y3_FrameData_O[28] VPWR VGND sg13cmos5l_antennanp
XANTENNA__0274__GATE Tile_X0Y5_FrameStrobe[6] VPWR VGND sg13cmos5l_antennanp
XFILLER_68_51 VPWR VGND sg13cmos5l_decap_8
XFILLER_191_41 VPWR VGND sg13cmos5l_decap_8
XFILLER_255_208 VPWR VGND sg13cmos5l_fill_1
XFILLER_67_129 VPWR VGND sg13cmos5l_decap_8
XFILLER_341_33 VPWR VGND sg13cmos5l_decap_8
XFILLER_208_135 VPWR VGND sg13cmos5l_decap_8
X_0180_ _0180_/Q Tile_X0Y0_FrameData[18] VGND VPWR Tile_X0Y5_FrameStrobe[3] latch
XANTENNA__0289__GATE Tile_X0Y5_FrameStrobe[6] VPWR VGND sg13cmos5l_antennanp
XANTENNA__1180__D Tile_X0Y4_FrameData[10] VPWR VGND sg13cmos5l_antennanp
XFILLER_223_105 VPWR VGND sg13cmos5l_decap_8
XFILLER_84_83 VPWR VGND sg13cmos5l_decap_8
XFILLER_223_116 VPWR VGND sg13cmos5l_fill_2
XFILLER_90_165 VPWR VGND sg13cmos5l_decap_8
XANTENNA__0212__GATE Tile_X0Y5_FrameStrobe[4] VPWR VGND sg13cmos5l_antennanp
XFILLER_231_171 VPWR VGND sg13cmos5l_decap_8
XANTENNA__0842__GATE Tile_X0Y5_FrameStrobe[1] VPWR VGND sg13cmos5l_antennanp
XANTENNA__1757__X Tile_X0Y2_FrameData_O[17] VPWR VGND sg13cmos5l_antennanp
X_2821_ _2821_/X Tile_X0Y5_N1END[1] Tile_X0Y5_N4END[1] _2794_/X _0059_/X _1310_/Q
+ _1309_/Q VPWR VGND sg13cmos5l_mux4_1
XANTENNA__0524__D Tile_X0Y1_FrameData[10] VPWR VGND sg13cmos5l_antennanp
XANTENNA__2369__A3 Tile_X0Y0_S4END[5] VPWR VGND sg13cmos5l_antennanp
X_2752_ _2752_/X AXIL_S_SOC_ARPROT1 AXIL_S_SOC_ARPROT2 _2823_/X _2800_/X _1398_/Q
+ _1397_/Q VPWR VGND sg13cmos5l_mux4_1
XANTENNA__0227__GATE Tile_X0Y5_FrameStrobe[4] VPWR VGND sg13cmos5l_antennanp
XANTENNA__2774__A0 Tile_X0Y5_W2MID[6] VPWR VGND sg13cmos5l_antennanp
XFILLER_144_101 VPWR VGND sg13cmos5l_fill_1
XFILLER_219_46 VPWR VGND sg13cmos5l_decap_8
X_1703_ Tile_X0Y0_EE4BEG[11] _2192_/X VPWR VGND sg13cmos5l_buf_1
XANTENNA__0857__GATE Tile_X0Y5_FrameStrobe[2] VPWR VGND sg13cmos5l_antennanp
XFILLER_144_134 VPWR VGND sg13cmos5l_fill_2
XFILLER_219_68 VPWR VGND sg13cmos5l_decap_8
X_2683_ _2683_/X _2608_/X Tile_X0Y5_N2MID[5] _2718_/X _2607_/X _1044_/Q _1043_/Q VPWR
+ VGND sg13cmos5l_mux4_1
XFILLER_333_223 VPWR VGND sg13cmos5l_fill_1
XANTENNA__2526__A0 AXIL_S_SOC_ARADDR1 VPWR VGND sg13cmos5l_antennanp
XFILLER_144_178 VPWR VGND sg13cmos5l_decap_8
X_1634_ Tile_X0Y0_N2BEG[6] _2151_/X VPWR VGND sg13cmos5l_buf_1
XANTENNA__1355__D Tile_X0Y5_FrameData[5] VPWR VGND sg13cmos5l_antennanp
XFILLER_144_189 VPWR VGND sg13cmos5l_fill_2
X_1565_ Tile_X0Y3_FrameData_O[11] Tile_X0Y3_FrameData[11] VPWR VGND sg13cmos5l_buf_1
XFILLER_98_221 VPWR VGND sg13cmos5l_fill_2
X_0516_ _0516_/Q Tile_X0Y1_FrameData[18] VGND VPWR Tile_X0Y5_FrameStrobe[6] latch
X_1496_ _1496_/Q Tile_X0Y5_FrameData[24] VGND VPWR Tile_X0Y5_FrameStrobe[7] latch
XANTENNA__2829__A1 Tile_X0Y4_W2END[7] VPWR VGND sg13cmos5l_antennanp
X_0447_ _0447_/Q Tile_X0Y1_FrameData[23] VGND VPWR Tile_X0Y5_FrameStrobe[4] latch
XFILLER_251_33 VPWR VGND sg13cmos5l_decap_8
X_0378_ _0378_/Q Tile_X0Y1_FrameData[28] VGND VPWR Tile_X0Y5_FrameStrobe[2] latch
XANTENNA__1090__D Tile_X0Y4_FrameData[4] VPWR VGND sg13cmos5l_antennanp
XFILLER_214_105 VPWR VGND sg13cmos5l_fill_2
X_2117_ AXIL_S_SOC_RDATA11 Tile_X0Y2_W2MID[3] Tile_X0Y2_W2END[3] Tile_X0Y2_W6END[3]
+ _2484_/X _0616_/Q _0615_/Q VPWR VGND sg13cmos5l_mux4_1
XFILLER_81_110 VPWR VGND sg13cmos5l_fill_1
XFILLER_214_138 VPWR VGND sg13cmos5l_decap_8
X_2048_ Tile_X0Y5_S1BEG[1] _2770_/X VPWR VGND sg13cmos5l_buf_1
XANTENNA__1667__X Tile_X0Y0_FrameData_O[7] VPWR VGND sg13cmos5l_antennanp
XANTENNA__0434__D Tile_X0Y1_FrameData[4] VPWR VGND sg13cmos5l_antennanp
XFILLER_200_81 VPWR VGND sg13cmos5l_decap_4
XFILLER_200_92 VPWR VGND sg13cmos5l_decap_4
XANTENNA__2765__A0 AXIL_S_SOC_ARPROT0 VPWR VGND sg13cmos5l_antennanp
XFILLER_276_52 VPWR VGND sg13cmos5l_decap_4
XFILLER_314_9 VPWR VGND sg13cmos5l_fill_1
XFILLER_135_134 VPWR VGND sg13cmos5l_decap_4
XANTENNA__2517__A0 AXIL_S_SOC_ARADDR0 VPWR VGND sg13cmos5l_antennanp
XFILLER_135_156 VPWR VGND sg13cmos5l_decap_8
XANTENNA__1265__D Tile_X0Y4_FrameData[31] VPWR VGND sg13cmos5l_antennanp
XFILLER_145_23 VPWR VGND sg13cmos5l_fill_2
XFILLER_296_119 VPWR VGND sg13cmos5l_fill_2
XANTENNA__1843__A Tile_X0Y4_FrameData[10] VPWR VGND sg13cmos5l_antennanp
XFILLER_145_67 VPWR VGND sg13cmos5l_decap_4
XFILLER_289_193 VPWR VGND sg13cmos5l_fill_2
XFILLER_49_118 VPWR VGND sg13cmos5l_decap_8
XANTENNA__0609__D Tile_X0Y2_FrameData[5] VPWR VGND sg13cmos5l_antennanp
XFILLER_161_77 VPWR VGND sg13cmos5l_decap_8
XFILLER_205_105 VPWR VGND sg13cmos5l_decap_8
XFILLER_205_127 VPWR VGND sg13cmos5l_decap_4
XFILLER_260_222 VPWR VGND sg13cmos5l_fill_2
XFILLER_311_47 VPWR VGND sg13cmos5l_fill_2
XFILLER_220_119 VPWR VGND sg13cmos5l_decap_8
XFILLER_359_197 VPWR VGND sg13cmos5l_decap_8
XFILLER_359_175 VPWR VGND sg13cmos5l_fill_1
XANTENNA__0344__D Tile_X0Y1_FrameData[30] VPWR VGND sg13cmos5l_antennanp
XANTENNA__1577__X Tile_X0Y3_FrameData_O[23] VPWR VGND sg13cmos5l_antennanp
XFILLER_326_0 VPWR VGND sg13cmos5l_decap_8
XANTENNA__2756__A0 AXIL_S_SOC_ARPROT0 VPWR VGND sg13cmos5l_antennanp
XFILLER_186_30 VPWR VGND sg13cmos5l_decap_8
XFILLER_70_63 VPWR VGND sg13cmos5l_decap_8
XFILLER_315_223 VPWR VGND sg13cmos5l_fill_1
XFILLER_336_33 VPWR VGND sg13cmos5l_decap_8
XANTENNA__1175__D Tile_X0Y4_FrameData[15] VPWR VGND sg13cmos5l_antennanp
XFILLER_141_137 VPWR VGND sg13cmos5l_decap_8
XANTENNA__1753__A Tile_X0Y2_FrameData[13] VPWR VGND sg13cmos5l_antennanp
X_1350_ _1350_/Q Tile_X0Y5_FrameData[10] VGND VPWR Tile_X0Y5_FrameStrobe[2] latch
X_0301_ _0301_/Q Tile_X0Y0_FrameData[25] VGND VPWR Tile_X0Y5_FrameStrobe[7] latch
XFILLER_95_213 VPWR VGND sg13cmos5l_fill_2
XFILLER_0_180 VPWR VGND sg13cmos5l_fill_2
X_1281_ _1281_/Q Tile_X0Y5_FrameData[15] VGND VPWR Tile_X0Y5_FrameStrobe[0] latch
XFILLER_352_54 VPWR VGND sg13cmos5l_decap_8
XANTENNA__2287__A2 Tile_X0Y3_WW4END[4] VPWR VGND sg13cmos5l_antennanp
X_0232_ _0232_/Q Tile_X0Y0_FrameData[30] VGND VPWR Tile_X0Y5_FrameStrobe[5] latch
XFILLER_352_87 VPWR VGND sg13cmos5l_decap_8
XANTENNA__0519__D Tile_X0Y1_FrameData[15] VPWR VGND sg13cmos5l_antennanp
X_0163_ _0163_/Q Tile_X0Y0_FrameData[3] VGND VPWR Tile_X0Y5_FrameStrobe[2] latch
XFILLER_48_195 VPWR VGND sg13cmos5l_fill_1
XFILLER_221_25 VPWR VGND sg13cmos5l_decap_8
XFILLER_221_36 VPWR VGND sg13cmos5l_fill_2
XANTENNA__0151__GATE Tile_X0Y5_FrameStrobe[2] VPWR VGND sg13cmos5l_antennanp
X_0094_ _0094_/Q Tile_X0Y0_FrameData[8] VGND VPWR Tile_X0Y5_FrameStrobe[0] latch
XFILLER_63_176 VPWR VGND sg13cmos5l_fill_1
XFILLER_63_165 VPWR VGND sg13cmos5l_decap_8
XANTENNA__0781__GATE Tile_X0Y5_FrameStrobe[7] VPWR VGND sg13cmos5l_antennanp
XFILLER_211_108 VPWR VGND sg13cmos5l_decap_8
XANTENNA__0166__GATE Tile_X0Y5_FrameStrobe[2] VPWR VGND sg13cmos5l_antennanp
XANTENNA__0254__D Tile_X0Y0_FrameData[8] VPWR VGND sg13cmos5l_antennanp
X_2804_ _2804_/X _2372_/X _2371_/X _2362_/X _2361_/X _0394_/Q _0393_/Q VPWR VGND sg13cmos5l_mux4_1
XANTENNA__0796__GATE Tile_X0Y5_FrameStrobe[0] VPWR VGND sg13cmos5l_antennanp
XANTENNA__2747__A0 AXIL_S_SOC_ARPROT0 VPWR VGND sg13cmos5l_antennanp
XFILLER_164_207 VPWR VGND sg13cmos5l_decap_8
XFILLER_164_218 VPWR VGND sg13cmos5l_decap_4
X_0996_ _0996_/Q Tile_X0Y3_FrameData[18] VGND VPWR Tile_X0Y5_FrameStrobe[6] latch
XANTENNA__2211__A2 Tile_X0Y0_W6END[2] VPWR VGND sg13cmos5l_antennanp
X_2735_ _2735_/X AXIL_S_SOC_ARPROT0 AXIL_S_SOC_ARPROT2 _2827_/X _2799_/X _1432_/Q
+ _1431_/Q VPWR VGND sg13cmos5l_mux4_1
X_2666_ _2666_/X _2701_/X _2689_/X _2688_/X _2682_/X _1102_/Q _1101_/Q VPWR VGND sg13cmos5l_mux4_1
XANTENNA__1085__D Tile_X0Y4_FrameData[9] VPWR VGND sg13cmos5l_antennanp
XFILLER_132_104 VPWR VGND sg13cmos5l_decap_4
X_1617_ Tile_X0Y0_N4BEG[13] _1617_/A VPWR VGND sg13cmos5l_buf_1
XANTENNA__1663__A Tile_X0Y0_FrameData[3] VPWR VGND sg13cmos5l_antennanp
XANTENNA__2111__X AXIL_S_SOC_RDATA5 VPWR VGND sg13cmos5l_antennanp
XFILLER_132_148 VPWR VGND sg13cmos5l_decap_4
X_2597_ _2597_/X Tile_X0Y2_W2MID[7] Tile_X0Y2_W2END[7] Tile_X0Y2_W6END[8] _2481_/X
+ _0650_/Q _0649_/Q VPWR VGND sg13cmos5l_mux4_1
XFILLER_262_21 VPWR VGND sg13cmos5l_decap_8
X_1548_ Tile_X0Y3_EE4BEG[10] _2535_/X VPWR VGND sg13cmos5l_buf_1
XANTENNA__0104__GATE Tile_X0Y5_FrameStrobe[1] VPWR VGND sg13cmos5l_antennanp
XANTENNA__1950__X Tile_X0Y1_E2BEGb[3] VPWR VGND sg13cmos5l_antennanp
XFILLER_286_163 VPWR VGND sg13cmos5l_decap_8
XFILLER_286_174 VPWR VGND sg13cmos5l_fill_2
X_1479_ _1479_/Q Tile_X0Y5_FrameData[9] VGND VPWR Tile_X0Y5_FrameStrobe[6] latch
XANTENNA__0734__GATE Tile_X0Y5_FrameStrobe[5] VPWR VGND sg13cmos5l_antennanp
XFILLER_262_87 VPWR VGND sg13cmos5l_decap_8
XANTENNA__0429__D Tile_X0Y1_FrameData[9] VPWR VGND sg13cmos5l_antennanp
XFILLER_264_9 VPWR VGND sg13cmos5l_fill_1
XFILLER_54_143 VPWR VGND sg13cmos5l_decap_8
XANTENNA__0119__GATE Tile_X0Y5_FrameStrobe[1] VPWR VGND sg13cmos5l_antennanp
XANTENNA__0749__GATE Tile_X0Y5_FrameStrobe[6] VPWR VGND sg13cmos5l_antennanp
XFILLER_24_23 VPWR VGND sg13cmos5l_fill_2
XFILLER_24_45 VPWR VGND sg13cmos5l_fill_2
XANTENNA__0164__D Tile_X0Y0_FrameData[2] VPWR VGND sg13cmos5l_antennanp
XANTENNA__1838__A Tile_X0Y4_FrameData[5] VPWR VGND sg13cmos5l_antennanp
XFILLER_210_141 VPWR VGND sg13cmos5l_decap_8
XANTENNA__2738__A0 AXIL_S_SOC_ARPROT0 VPWR VGND sg13cmos5l_antennanp
XFILLER_356_178 VPWR VGND sg13cmos5l_decap_8
XFILLER_356_167 VPWR VGND sg13cmos5l_fill_1
XFILLER_108_123 VPWR VGND sg13cmos5l_decap_8
XFILLER_356_189 VPWR VGND sg13cmos5l_fill_2
XFILLER_40_77 VPWR VGND sg13cmos5l_decap_8
XFILLER_40_55 VPWR VGND sg13cmos5l_decap_4
XANTENNA__1573__A Tile_X0Y3_FrameData[19] VPWR VGND sg13cmos5l_antennanp
XANTENNA__2021__X Tile_X0Y5_FrameData_O[6] VPWR VGND sg13cmos5l_antennanp
XANTENNA__2505__A3 AXIL_S_SOC_ARADDR7 VPWR VGND sg13cmos5l_antennanp
XFILLER_306_69 VPWR VGND sg13cmos5l_fill_2
XANTENNA__1860__X Tile_X0Y4_FrameData_O[27] VPWR VGND sg13cmos5l_antennanp
XFILLER_277_185 VPWR VGND sg13cmos5l_decap_8
XANTENNA__2269__A2 Tile_X0Y1_WW4END[5] VPWR VGND sg13cmos5l_antennanp
XFILLER_172_98 VPWR VGND sg13cmos5l_decap_8
XANTENNA__0339__D Tile_X0Y1_FrameData[3] VPWR VGND sg13cmos5l_antennanp
XFILLER_276_0 VPWR VGND sg13cmos5l_decap_8
XFILLER_322_35 VPWR VGND sg13cmos5l_fill_1
XFILLER_65_52 VPWR VGND sg13cmos5l_decap_8
XFILLER_45_176 VPWR VGND sg13cmos5l_fill_1
XFILLER_121_91 VPWR VGND sg13cmos5l_decap_8
XFILLER_347_112 VPWR VGND sg13cmos5l_decap_8
XANTENNA__0074__D Tile_X0Y0_FrameData[28] VPWR VGND sg13cmos5l_antennanp
XANTENNA__1748__A Tile_X0Y2_FrameData[8] VPWR VGND sg13cmos5l_antennanp
XANTENNA__2729__A0 AXIL_S_SOC_ARPROT2 VPWR VGND sg13cmos5l_antennanp
X_0850_ _0850_/Q Tile_X0Y3_FrameData[4] VGND VPWR Tile_X0Y5_FrameStrobe[1] latch
XFILLER_347_21 VPWR VGND sg13cmos5l_decap_8
X_0781_ _0781_/Q Tile_X0Y2_FrameData[25] VGND VPWR Tile_X0Y5_FrameStrobe[7] latch
XFILLER_347_189 VPWR VGND sg13cmos5l_fill_1
XANTENNA__0802__D Tile_X0Y3_FrameData[20] VPWR VGND sg13cmos5l_antennanp
X_2520_ _2520_/X AXIL_S_SOC_ARADDR1 AXIL_S_SOC_ARADDR3 _2592_/X _2593_/X _0964_/Q
+ _0963_/Q VPWR VGND sg13cmos5l_mux4_1
XFILLER_347_98 VPWR VGND sg13cmos5l_decap_8
X_2451_ _2451_/X Tile_X0Y2_W1END[3] Tile_X0Y2_WW4END[11] Tile_X0Y2_WW4END[15] Tile_X0Y2_W6END[7]
+ _0625_/Q _0624_/Q VPWR VGND sg13cmos5l_mux4_1
XFILLER_114_148 VPWR VGND sg13cmos5l_decap_8
X_1402_ _1402_/Q Tile_X0Y5_FrameData[22] VGND VPWR Tile_X0Y5_FrameStrobe[4] latch
XFILLER_216_58 VPWR VGND sg13cmos5l_decap_8
X_2382_ _2382_/X Tile_X0Y3_W2MID[7] Tile_X0Y3_W2END[7] Tile_X0Y3_W6END[7] _2589_/X
+ _1022_/Q _1021_/Q VPWR VGND sg13cmos5l_mux4_1
XANTENNA__1770__X Tile_X0Y2_FrameData_O[30] VPWR VGND sg13cmos5l_antennanp
X_1333_ _1333_/Q Tile_X0Y5_FrameData[27] VGND VPWR Tile_X0Y5_FrameStrobe[2] latch
X_1264_ _1264_/Q Tile_X0Y4_FrameData[22] VGND VPWR Tile_X0Y5_FrameStrobe[7] latch
XANTENNA__0249__D Tile_X0Y0_FrameData[13] VPWR VGND sg13cmos5l_antennanp
XANTENNA__1464__GATE Tile_X0Y5_FrameStrobe[6] VPWR VGND sg13cmos5l_antennanp
X_0215_ _0215_/Q Tile_X0Y0_FrameData[15] VGND VPWR Tile_X0Y5_FrameStrobe[4] latch
XANTENNA__0090__GATE Tile_X0Y5_FrameStrobe[0] VPWR VGND sg13cmos5l_antennanp
XFILLER_224_211 VPWR VGND sg13cmos5l_fill_1
X_1195_ _1195_/Q Tile_X0Y4_FrameData[27] VGND VPWR Tile_X0Y5_FrameStrobe[5] latch
XFILLER_36_132 VPWR VGND sg13cmos5l_decap_8
X_0146_ _0146_/Q Tile_X0Y0_FrameData[20] VGND VPWR Tile_X0Y5_FrameStrobe[2] latch
XANTENNA__1479__GATE Tile_X0Y5_FrameStrobe[6] VPWR VGND sg13cmos5l_antennanp
X_0077_ _0077_/Q Tile_X0Y0_FrameData[25] VGND VPWR Tile_X0Y5_FrameStrobe[0] latch
XANTENNA__1658__A Tile_X0Y5_FrameStrobe[18] VPWR VGND sg13cmos5l_antennanp
XANTENNA__1402__GATE Tile_X0Y5_FrameStrobe[4] VPWR VGND sg13cmos5l_antennanp
XANTENNA__2106__X AXIL_S_SOC_RDATA0 VPWR VGND sg13cmos5l_antennanp
XFILLER_257_10 VPWR VGND sg13cmos5l_decap_4
XFILLER_353_104 VPWR VGND sg13cmos5l_decap_8
XANTENNA__1945__X Tile_X0Y1_E6BEG[10] VPWR VGND sg13cmos5l_antennanp
XFILLER_257_43 VPWR VGND sg13cmos5l_decap_8
X_0979_ _0979_/Q Tile_X0Y3_FrameData[3] VGND VPWR Tile_X0Y5_FrameStrobe[5] latch
XANTENNA__0712__D Tile_X0Y2_FrameData[30] VPWR VGND sg13cmos5l_antennanp
XANTENNA__2196__A1 AXIL_S_SOC_WDATA31 VPWR VGND sg13cmos5l_antennanp
X_2718_ _2718_/X Tile_X0Y3_W1END[1] Tile_X0Y3_W2MID[2] Tile_X0Y3_W2END[2] _2594_/X
+ _0880_/Q _0879_/Q VPWR VGND sg13cmos5l_mux4_1
XFILLER_160_210 VPWR VGND sg13cmos5l_fill_2
XANTENNA__1417__GATE Tile_X0Y5_FrameStrobe[4] VPWR VGND sg13cmos5l_antennanp
XFILLER_10_69 VPWR VGND sg13cmos5l_fill_1
XFILLER_126_36 VPWR VGND sg13cmos5l_decap_8
X_2649_ _2649_/X Tile_X0Y5_N4END[4] _0039_/X _2685_/X _2684_/X _1156_/Q _1155_/Q VPWR
+ VGND sg13cmos5l_mux4_1
XANTENNA__2499__A2 Tile_X0Y1_W2END[2] VPWR VGND sg13cmos5l_antennanp
XFILLER_126_69 VPWR VGND sg13cmos5l_fill_1
XFILLER_273_75 VPWR VGND sg13cmos5l_fill_1
XFILLER_86_29 VPWR VGND sg13cmos5l_decap_8
XFILLER_86_18 VPWR VGND sg13cmos5l_fill_1
XANTENNA__0673__GATE Tile_X0Y5_FrameStrobe[3] VPWR VGND sg13cmos5l_antennanp
XANTENNA__1680__X Tile_X0Y0_FrameData_O[20] VPWR VGND sg13cmos5l_antennanp
XFILLER_259_174 VPWR VGND sg13cmos5l_decap_4
XFILLER_273_97 VPWR VGND sg13cmos5l_decap_8
XFILLER_19_23 VPWR VGND sg13cmos5l_fill_2
XFILLER_19_45 VPWR VGND sg13cmos5l_fill_2
XFILLER_206_80 VPWR VGND sg13cmos5l_decap_8
XFILLER_206_91 VPWR VGND sg13cmos5l_fill_2
XFILLER_259_185 VPWR VGND sg13cmos5l_fill_1
XFILLER_274_133 VPWR VGND sg13cmos5l_decap_8
XANTENNA__0159__D Tile_X0Y0_FrameData[7] VPWR VGND sg13cmos5l_antennanp
XFILLER_142_35 VPWR VGND sg13cmos5l_decap_8
XANTENNA__2120__A1 Tile_X0Y2_W2END[6] VPWR VGND sg13cmos5l_antennanp
XFILLER_142_68 VPWR VGND sg13cmos5l_decap_8
XANTENNA__0688__GATE Tile_X0Y5_FrameStrobe[4] VPWR VGND sg13cmos5l_antennanp
XANTENNA__2671__A2 Tile_X0Y4_W6END[2] VPWR VGND sg13cmos5l_antennanp
XFILLER_222_90 VPWR VGND sg13cmos5l_decap_8
XFILLER_27_165 VPWR VGND sg13cmos5l_decap_8
XFILLER_42_102 VPWR VGND sg13cmos5l_decap_8
XFILLER_27_187 VPWR VGND sg13cmos5l_decap_8
XFILLER_42_146 VPWR VGND sg13cmos5l_fill_1
XANTENNA__0611__GATE Tile_X0Y5_FrameStrobe[1] VPWR VGND sg13cmos5l_antennanp
XANTENNA__1568__A Tile_X0Y3_FrameData[14] VPWR VGND sg13cmos5l_antennanp
XFILLER_51_10 VPWR VGND sg13cmos5l_fill_2
XFILLER_298_94 VPWR VGND sg13cmos5l_decap_8
XANTENNA__2016__X Tile_X0Y5_FrameData_O[1] VPWR VGND sg13cmos5l_antennanp
XFILLER_344_104 VPWR VGND sg13cmos5l_fill_2
XANTENNA__0622__D Tile_X0Y2_FrameData[24] VPWR VGND sg13cmos5l_antennanp
XANTENNA__0626__GATE Tile_X0Y5_FrameStrobe[2] VPWR VGND sg13cmos5l_antennanp
XANTENNA__1855__X Tile_X0Y4_FrameData_O[22] VPWR VGND sg13cmos5l_antennanp
XANTENNA__2187__A1 AXIL_S_SOC_WDATA26 VPWR VGND sg13cmos5l_antennanp
XFILLER_167_87 VPWR VGND sg13cmos5l_decap_8
XFILLER_344_159 VPWR VGND sg13cmos5l_fill_2
XFILLER_317_46 VPWR VGND sg13cmos5l_decap_4
XFILLER_151_221 VPWR VGND sg13cmos5l_fill_2
XFILLER_183_31 VPWR VGND sg13cmos5l_fill_1
XFILLER_183_42 VPWR VGND sg13cmos5l_decap_8
XFILLER_4_0 VPWR VGND sg13cmos5l_fill_2
XFILLER_300_207 VPWR VGND sg13cmos5l_fill_2
XANTENNA__1453__D Tile_X0Y5_FrameData[3] VPWR VGND sg13cmos5l_antennanp
XANTENNA__1590__X Tile_X0Y2_EE4BEG[3] VPWR VGND sg13cmos5l_antennanp
XFILLER_183_97 VPWR VGND sg13cmos5l_decap_8
XFILLER_333_34 VPWR VGND sg13cmos5l_decap_8
XFILLER_116_91 VPWR VGND sg13cmos5l_decap_8
XANTENNA__2111__A1 Tile_X0Y3_W2END[5] VPWR VGND sg13cmos5l_antennanp
XFILLER_92_83 VPWR VGND sg13cmos5l_decap_8
X_1951_ Tile_X0Y1_E2BEGb[4] _2305_/X VPWR VGND sg13cmos5l_buf_1
XFILLER_186_151 VPWR VGND sg13cmos5l_fill_1
XFILLER_186_173 VPWR VGND sg13cmos5l_fill_2
X_1882_ Tile_X0Y2_E6BEG[8] _2441_/X VPWR VGND sg13cmos5l_buf_1
X_0902_ _0902_/Q Tile_X0Y3_FrameData[16] VGND VPWR Tile_X0Y5_FrameStrobe[3] latch
XFILLER_358_64 VPWR VGND sg13cmos5l_decap_8
XFILLER_186_195 VPWR VGND sg13cmos5l_fill_1
XFILLER_294_19 VPWR VGND sg13cmos5l_fill_2
X_0833_ _0833_/Q Tile_X0Y3_FrameData[21] VGND VPWR Tile_X0Y5_FrameStrobe[1] latch
XANTENNA__0532__D Tile_X0Y1_FrameData[2] VPWR VGND sg13cmos5l_antennanp
XANTENNA__1765__X Tile_X0Y2_FrameData_O[25] VPWR VGND sg13cmos5l_antennanp
XANTENNA__2178__A1 AXIL_S_SOC_WDATA29 VPWR VGND sg13cmos5l_antennanp
XFILLER_227_13 VPWR VGND sg13cmos5l_fill_2
X_2503_ _2503_/X Tile_X0Y1_W1END[3] Tile_X0Y1_W2MID[0] Tile_X0Y1_W2END[0] _2380_/X
+ _0396_/Q _0395_/Q VPWR VGND sg13cmos5l_mux4_1
X_0764_ _0764_/Q Tile_X0Y2_FrameData[10] VGND VPWR Tile_X0Y5_FrameStrobe[6] latch
X_0695_ _0695_/Q Tile_X0Y2_FrameData[15] VGND VPWR Tile_X0Y5_FrameStrobe[4] latch
X_2434_ _2434_/X Tile_X0Y5_N4END[13] Tile_X0Y0_S4END[9] _2468_/X _2467_/X _0680_/Q
+ _0679_/Q VPWR VGND sg13cmos5l_mux4_1
XANTENNA__1363__D Tile_X0Y5_FrameData[29] VPWR VGND sg13cmos5l_antennanp
X_2365_ _2365_/X _2348_/X _0029_/X _2347_/X Tile_X0Y0_S4END[7] _0352_/Q _0351_/Q VPWR
+ VGND sg13cmos5l_mux4_1
XFILLER_37_0 VPWR VGND sg13cmos5l_fill_2
X_1316_ _1316_/Q Tile_X0Y5_FrameData[12] VGND VPWR Tile_X0Y5_FrameStrobe[1] latch
XFILLER_243_89 VPWR VGND sg13cmos5l_fill_1
X_2296_ _2296_/X AXIL_S_SOC_WDATA3 AXIL_S_SOC_WDATA11 _2376_/X _2377_/X _0500_/Q _0499_/Q
+ VPWR VGND sg13cmos5l_mux4_1
XFILLER_2_70 VPWR VGND sg13cmos5l_fill_2
XANTENNA__2102__A1 Tile_X0Y4_W2END[2] VPWR VGND sg13cmos5l_antennanp
X_1247_ _1247_/Q Tile_X0Y4_FrameData[7] VGND VPWR Tile_X0Y5_FrameStrobe[6] latch
X_1178_ _1178_/Q Tile_X0Y4_FrameData[12] VGND VPWR Tile_X0Y5_FrameStrobe[4] latch
XANTENNA__0707__D Tile_X0Y2_FrameData[3] VPWR VGND sg13cmos5l_antennanp
XFILLER_24_124 VPWR VGND sg13cmos5l_decap_4
X_0129_ _0129_/Q Tile_X0Y0_FrameData[5] VGND VPWR Tile_X0Y5_FrameStrobe[1] latch
XFILLER_212_214 VPWR VGND sg13cmos5l_decap_4
XFILLER_358_207 VPWR VGND sg13cmos5l_decap_8
XANTENNA__1341__GATE Tile_X0Y5_FrameStrobe[2] VPWR VGND sg13cmos5l_antennanp
XFILLER_268_42 VPWR VGND sg13cmos5l_decap_8
XFILLER_177_173 VPWR VGND sg13cmos5l_fill_1
XFILLER_177_195 VPWR VGND sg13cmos5l_decap_8
XFILLER_227_9 VPWR VGND sg13cmos5l_fill_1
XANTENNA__0442__D Tile_X0Y1_FrameData[28] VPWR VGND sg13cmos5l_antennanp
XANTENNA__1675__X Tile_X0Y0_FrameData_O[15] VPWR VGND sg13cmos5l_antennanp
XANTENNA__2169__A1 AXIL_S_SOC_WDATA28 VPWR VGND sg13cmos5l_antennanp
XFILLER_326_148 VPWR VGND sg13cmos5l_decap_4
XANTENNA__1356__GATE Tile_X0Y5_FrameStrobe[2] VPWR VGND sg13cmos5l_antennanp
XFILLER_21_79 VPWR VGND sg13cmos5l_decap_8
XANTENNA__1273__D Tile_X0Y5_FrameData[23] VPWR VGND sg13cmos5l_antennanp
XFILLER_217_90 VPWR VGND sg13cmos5l_decap_8
XANTENNA__1851__A Tile_X0Y4_FrameData[18] VPWR VGND sg13cmos5l_antennanp
XANTENNA__2341__A1 Tile_X0Y0_W6END[8] VPWR VGND sg13cmos5l_antennanp
XFILLER_153_56 VPWR VGND sg13cmos5l_decap_4
XFILLER_247_111 VPWR VGND sg13cmos5l_decap_8
XFILLER_101_173 VPWR VGND sg13cmos5l_decap_8
XFILLER_47_216 VPWR VGND sg13cmos5l_fill_2
XFILLER_247_177 VPWR VGND sg13cmos5l_fill_2
XFILLER_262_114 VPWR VGND sg13cmos5l_fill_1
XANTENNA__0617__D Tile_X0Y2_FrameData[29] VPWR VGND sg13cmos5l_antennanp
XANTENNA__0550__GATE Tile_X0Y5_FrameStrobe[7] VPWR VGND sg13cmos5l_antennanp
XFILLER_102_82 VPWR VGND sg13cmos5l_decap_8
XANTENNA__1309__GATE Tile_X0Y5_FrameStrobe[1] VPWR VGND sg13cmos5l_antennanp
XFILLER_141_0 VPWR VGND sg13cmos5l_decap_8
XFILLER_30_127 VPWR VGND sg13cmos5l_fill_2
XFILLER_30_116 VPWR VGND sg13cmos5l_decap_8
XFILLER_30_105 VPWR VGND sg13cmos5l_decap_4
XFILLER_178_53 VPWR VGND sg13cmos5l_decap_8
XFILLER_239_0 VPWR VGND sg13cmos5l_fill_1
XANTENNA__0565__GATE Tile_X0Y5_FrameStrobe[0] VPWR VGND sg13cmos5l_antennanp
XFILLER_183_110 VPWR VGND sg13cmos5l_decap_8
XFILLER_317_126 VPWR VGND sg13cmos5l_fill_1
XANTENNA__0352__D Tile_X0Y1_FrameData[22] VPWR VGND sg13cmos5l_antennanp
XANTENNA__1448__D Tile_X0Y5_FrameData[8] VPWR VGND sg13cmos5l_antennanp
XANTENNA__1585__X Tile_X0Y3_FrameData_O[31] VPWR VGND sg13cmos5l_antennanp
XFILLER_194_63 VPWR VGND sg13cmos5l_decap_8
XANTENNA__2580__A1 Tile_X0Y5_N4END[8] VPWR VGND sg13cmos5l_antennanp
X_0480_ _0480_/Q Tile_X0Y1_FrameData[22] VGND VPWR Tile_X0Y5_FrameStrobe[5] latch
XANTENNA__1183__D Tile_X0Y4_FrameData[7] VPWR VGND sg13cmos5l_antennanp
XFILLER_87_50 VPWR VGND sg13cmos5l_decap_8
XANTENNA__1761__A Tile_X0Y2_FrameData[21] VPWR VGND sg13cmos5l_antennanp
XANTENNA__0503__GATE Tile_X0Y5_FrameStrobe[6] VPWR VGND sg13cmos5l_antennanp
XFILLER_238_144 VPWR VGND sg13cmos5l_decap_4
X_2150_ _2150_/X Tile_X0Y0_W2MID[2] Tile_X0Y0_W2END[2] Tile_X0Y0_W6END[2] _2246_/X
+ _0292_/Q _0291_/Q VPWR VGND sg13cmos5l_mux4_1
XFILLER_238_177 VPWR VGND sg13cmos5l_decap_8
XFILLER_238_188 VPWR VGND sg13cmos5l_fill_1
X_2081_ Tile_X0Y5_S4BEG[14] _2081_/A VPWR VGND sg13cmos5l_buf_1
X_1101_ _1101_/Q Tile_X0Y4_FrameData[25] VGND VPWR Tile_X0Y5_FrameStrobe[2] latch
XFILLER_253_147 VPWR VGND sg13cmos5l_fill_2
X_1032_ _1032_/Q Tile_X0Y4_FrameData[30] VGND VPWR Tile_X0Y5_FrameStrobe[0] latch
XANTENNA__0527__D Tile_X0Y1_FrameData[7] VPWR VGND sg13cmos5l_antennanp
XANTENNA__0518__GATE Tile_X0Y5_FrameStrobe[6] VPWR VGND sg13cmos5l_antennanp
XFILLER_261_191 VPWR VGND sg13cmos5l_fill_1
X_1934_ Tile_X0Y1_EE4BEG[15] _2324_/X VPWR VGND sg13cmos5l_buf_1
XFILLER_238_23 VPWR VGND sg13cmos5l_fill_1
XANTENNA__0262__D Tile_X0Y0_FrameData[0] VPWR VGND sg13cmos5l_antennanp
XANTENNA__1358__D Tile_X0Y5_FrameData[2] VPWR VGND sg13cmos5l_antennanp
X_1865_ Tile_X0Y4_UserCLKo Tile_X0Y4_UserCLK VPWR VGND sg13cmos5l_buf_1
XFILLER_308_137 VPWR VGND sg13cmos5l_decap_4
X_1796_ Tile_X0Y4_E2BEG[7] _2624_/X VPWR VGND sg13cmos5l_buf_1
X_0816_ _0816_/Q Tile_X0Y3_FrameData[6] VGND VPWR Tile_X0Y5_FrameStrobe[0] latch
XFILLER_174_198 VPWR VGND sg13cmos5l_decap_4
X_0747_ _0747_/Q Tile_X0Y2_FrameData[27] VGND VPWR Tile_X0Y5_FrameStrobe[6] latch
XFILLER_323_129 VPWR VGND sg13cmos5l_decap_4
XANTENNA__2571__A1 Tile_X0Y2_W6END[11] VPWR VGND sg13cmos5l_antennanp
XFILLER_88_105 VPWR VGND sg13cmos5l_decap_8
X_2417_ _2417_/X AXIL_S_SOC_AWADDR0 AXIL_S_SOC_AWPROT2 _2465_/X _2488_/X _0714_/Q
+ _0713_/Q VPWR VGND sg13cmos5l_mux4_1
X_0678_ _0678_/Q Tile_X0Y2_FrameData[0] VGND VPWR Tile_X0Y5_FrameStrobe[3] latch
XANTENNA__1093__D Tile_X0Y4_FrameData[1] VPWR VGND sg13cmos5l_antennanp
XANTENNA__1671__A Tile_X0Y0_FrameData[11] VPWR VGND sg13cmos5l_antennanp
XANTENNA__2323__A1 AXIL_S_SOC_WDATA14 VPWR VGND sg13cmos5l_antennanp
XFILLER_270_21 VPWR VGND sg13cmos5l_fill_1
X_2348_ _2348_/X Tile_X0Y2_W1END[3] Tile_X0Y2_W6END[7] _2465_/X _2456_/X _0784_/Q
+ _0783_/Q VPWR VGND sg13cmos5l_mux4_1
XFILLER_29_205 VPWR VGND sg13cmos5l_decap_8
XFILLER_229_166 VPWR VGND sg13cmos5l_decap_8
XFILLER_270_32 VPWR VGND sg13cmos5l_decap_8
X_2279_ _2279_/X Tile_X0Y2_W1END[0] Tile_X0Y2_WW4END[0] Tile_X0Y2_WW4END[4] Tile_X0Y2_W6END[8]
+ _0766_/Q _0765_/Q VPWR VGND sg13cmos5l_mux4_1
XFILLER_244_147 VPWR VGND sg13cmos5l_fill_2
XFILLER_270_76 VPWR VGND sg13cmos5l_decap_8
XANTENNA__0437__D Tile_X0Y1_FrameData[1] VPWR VGND sg13cmos5l_antennanp
XFILLER_16_24 VPWR VGND sg13cmos5l_fill_2
XFILLER_199_19 VPWR VGND sg13cmos5l_fill_2
XFILLER_279_30 VPWR VGND sg13cmos5l_decap_8
XANTENNA__1280__GATE Tile_X0Y5_FrameStrobe[0] VPWR VGND sg13cmos5l_antennanp
XFILLER_200_217 VPWR VGND sg13cmos5l_fill_1
XFILLER_148_12 VPWR VGND sg13cmos5l_fill_2
XANTENNA__0172__D Tile_X0Y0_FrameData[26] VPWR VGND sg13cmos5l_antennanp
XANTENNA__1268__D Tile_X0Y5_FrameData[28] VPWR VGND sg13cmos5l_antennanp
XANTENNA__1295__GATE Tile_X0Y5_FrameStrobe[0] VPWR VGND sg13cmos5l_antennanp
XANTENNA__1846__A Tile_X0Y4_FrameData[13] VPWR VGND sg13cmos5l_antennanp
XFILLER_165_132 VPWR VGND sg13cmos5l_decap_8
XFILLER_32_89 VPWR VGND sg13cmos5l_fill_1
XFILLER_148_78 VPWR VGND sg13cmos5l_decap_8
XFILLER_180_102 VPWR VGND sg13cmos5l_fill_1
XANTENNA__0900__D Tile_X0Y3_FrameData[18] VPWR VGND sg13cmos5l_antennanp
XFILLER_79_127 VPWR VGND sg13cmos5l_decap_8
XFILLER_322_162 VPWR VGND sg13cmos5l_fill_1
XANTENNA__1581__A Tile_X0Y3_FrameData[27] VPWR VGND sg13cmos5l_antennanp
XANTENNA__2314__A1 AXIL_S_SOC_WDATA9 VPWR VGND sg13cmos5l_antennanp
XFILLER_314_25 VPWR VGND sg13cmos5l_fill_2
XFILLER_180_21 VPWR VGND sg13cmos5l_fill_1
XFILLER_87_171 VPWR VGND sg13cmos5l_decap_8
XANTENNA__1233__GATE Tile_X0Y5_FrameStrobe[6] VPWR VGND sg13cmos5l_antennanp
XFILLER_180_43 VPWR VGND sg13cmos5l_fill_1
XFILLER_189_0 VPWR VGND sg13cmos5l_fill_1
XFILLER_35_208 VPWR VGND sg13cmos5l_decap_4
XANTENNA__0347__D Tile_X0Y1_FrameData[27] VPWR VGND sg13cmos5l_antennanp
XFILLER_113_70 VPWR VGND sg13cmos5l_decap_8
XFILLER_356_0 VPWR VGND sg13cmos5l_fill_1
XANTENNA__1248__GATE Tile_X0Y5_FrameStrobe[6] VPWR VGND sg13cmos5l_antennanp
XFILLER_73_52 VPWR VGND sg13cmos5l_decap_8
XANTENNA__2250__A0 Tile_X0Y1_W2MID[7] VPWR VGND sg13cmos5l_antennanp
XANTENNA__0082__D Tile_X0Y0_FrameData[20] VPWR VGND sg13cmos5l_antennanp
XANTENNA__1178__D Tile_X0Y4_FrameData[12] VPWR VGND sg13cmos5l_antennanp
XANTENNA__1756__A Tile_X0Y2_FrameData[16] VPWR VGND sg13cmos5l_antennanp
X_1650_ Tile_X0Y0_FrameStrobe_O[10] Tile_X0Y5_FrameStrobe[10] VPWR VGND sg13cmos5l_buf_1
XFILLER_360_202 VPWR VGND sg13cmos5l_decap_4
XFILLER_208_48 VPWR VGND sg13cmos5l_decap_8
X_1581_ Tile_X0Y3_FrameData_O[27] Tile_X0Y3_FrameData[27] VPWR VGND sg13cmos5l_buf_1
X_0601_ _0601_/Q Tile_X0Y2_FrameData[13] VGND VPWR Tile_X0Y5_FrameStrobe[1] latch
XFILLER_355_54 VPWR VGND sg13cmos5l_fill_2
XANTENNA__0810__D Tile_X0Y3_FrameData[12] VPWR VGND sg13cmos5l_antennanp
XANTENNA__2553__A1 Tile_X0Y3_WW4END[8] VPWR VGND sg13cmos5l_antennanp
X_0532_ _0532_/Q Tile_X0Y1_FrameData[2] VGND VPWR Tile_X0Y5_FrameStrobe[6] latch
XFILLER_355_98 VPWR VGND sg13cmos5l_decap_8
XANTENNA__0442__GATE Tile_X0Y5_FrameStrobe[4] VPWR VGND sg13cmos5l_antennanp
XANTENNA__2305__A1 AXIL_S_SOC_WDATA12 VPWR VGND sg13cmos5l_antennanp
XFILLER_224_14 VPWR VGND sg13cmos5l_decap_8
X_0463_ _0463_/Q Tile_X0Y1_FrameData[7] VGND VPWR Tile_X0Y5_FrameStrobe[4] latch
X_2202_ _2202_/X AXIL_S_SOC_WDATA21 _2234_/X _2222_/X _2242_/X _0192_/Q _0191_/Q VPWR
+ VGND sg13cmos5l_mux4_1
X_0394_ _0394_/Q Tile_X0Y1_FrameData[12] VGND VPWR Tile_X0Y5_FrameStrobe[2] latch
X_2133_ AXIL_S_SOC_RDATA27 Tile_X0Y0_W2MID[3] Tile_X0Y0_W2END[3] Tile_X0Y0_W6END[3]
+ _2244_/X _0136_/Q _0135_/Q VPWR VGND sg13cmos5l_mux4_1
XFILLER_78_193 VPWR VGND sg13cmos5l_decap_8
XFILLER_26_208 VPWR VGND sg13cmos5l_fill_1
XANTENNA__0257__D Tile_X0Y0_FrameData[5] VPWR VGND sg13cmos5l_antennanp
XANTENNA__0457__GATE Tile_X0Y5_FrameStrobe[4] VPWR VGND sg13cmos5l_antennanp
XANTENNA__2608__A2 Tile_X0Y5_W6END[2] VPWR VGND sg13cmos5l_antennanp
X_2064_ Tile_X0Y5_S2BEGb[5] _2834_/X VPWR VGND sg13cmos5l_buf_1
XFILLER_240_79 VPWR VGND sg13cmos5l_decap_4
X_1015_ _1015_/Q Tile_X0Y3_FrameData[31] VGND VPWR Tile_X0Y5_FrameStrobe[7] latch
XFILLER_249_44 VPWR VGND sg13cmos5l_decap_8
XANTENNA__1088__D Tile_X0Y4_FrameData[6] VPWR VGND sg13cmos5l_antennanp
XANTENNA__1666__A Tile_X0Y0_FrameData[6] VPWR VGND sg13cmos5l_antennanp
XFILLER_147_143 VPWR VGND sg13cmos5l_decap_8
X_1917_ Tile_X0Y1_FrameData_O[30] Tile_X0Y1_FrameData[30] VPWR VGND sg13cmos5l_buf_1
XANTENNA__2114__X AXIL_S_SOC_RDATA8 VPWR VGND sg13cmos5l_antennanp
X_1848_ Tile_X0Y4_FrameData_O[15] Tile_X0Y4_FrameData[15] VPWR VGND sg13cmos5l_buf_1
XFILLER_162_124 VPWR VGND sg13cmos5l_decap_4
XFILLER_265_32 VPWR VGND sg13cmos5l_decap_8
XANTENNA__0720__D Tile_X0Y2_FrameData[22] VPWR VGND sg13cmos5l_antennanp
XANTENNA__1953__X Tile_X0Y1_E2BEGb[6] VPWR VGND sg13cmos5l_antennanp
XANTENNA__2544__A1 Tile_X0Y0_S4END[15] VPWR VGND sg13cmos5l_antennanp
X_1779_ Tile_X0Y2_E2BEG[2] _2403_/X VPWR VGND sg13cmos5l_buf_1
XFILLER_281_20 VPWR VGND sg13cmos5l_fill_2
XFILLER_304_195 VPWR VGND sg13cmos5l_fill_1
XFILLER_134_69 VPWR VGND sg13cmos5l_decap_8
XFILLER_76_108 VPWR VGND sg13cmos5l_decap_8
XFILLER_217_125 VPWR VGND sg13cmos5l_decap_8
XFILLER_84_152 VPWR VGND sg13cmos5l_decap_8
XANTENNA__0167__D Tile_X0Y0_FrameData[31] VPWR VGND sg13cmos5l_antennanp
XFILLER_232_117 VPWR VGND sg13cmos5l_decap_8
XFILLER_300_49 VPWR VGND sg13cmos5l_decap_8
XFILLER_159_22 VPWR VGND sg13cmos5l_decap_4
XFILLER_40_222 VPWR VGND sg13cmos5l_fill_2
XFILLER_159_55 VPWR VGND sg13cmos5l_decap_8
XFILLER_43_88 VPWR VGND sg13cmos5l_decap_4
XANTENNA__1576__A Tile_X0Y3_FrameData[22] VPWR VGND sg13cmos5l_antennanp
XFILLER_138_121 VPWR VGND sg13cmos5l_decap_4
XFILLER_159_88 VPWR VGND sg13cmos5l_decap_8
XANTENNA__2024__X Tile_X0Y5_FrameData_O[9] VPWR VGND sg13cmos5l_antennanp
XANTENNA__2783__A1 Tile_X0Y5_WW4END[11] VPWR VGND sg13cmos5l_antennanp
XFILLER_175_10 VPWR VGND sg13cmos5l_fill_1
XFILLER_309_58 VPWR VGND sg13cmos5l_decap_4
XFILLER_175_32 VPWR VGND sg13cmos5l_fill_1
XFILLER_309_69 VPWR VGND sg13cmos5l_fill_2
XANTENNA__0630__D Tile_X0Y2_FrameData[16] VPWR VGND sg13cmos5l_antennanp
XANTENNA__1863__X Tile_X0Y4_FrameData_O[30] VPWR VGND sg13cmos5l_antennanp
XANTENNA__2535__A1 AXIL_S_SOC_ARADDR6 VPWR VGND sg13cmos5l_antennanp
XFILLER_104_0 VPWR VGND sg13cmos5l_fill_1
XFILLER_4_49 VPWR VGND sg13cmos5l_fill_2
XFILLER_108_81 VPWR VGND sg13cmos5l_decap_8
XFILLER_191_20 VPWR VGND sg13cmos5l_decap_8
XFILLER_325_68 VPWR VGND sg13cmos5l_decap_4
XANTENNA__1172__GATE Tile_X0Y5_FrameStrobe[4] VPWR VGND sg13cmos5l_antennanp
XANTENNA__2299__A0 AXIL_S_SOC_WDATA6 VPWR VGND sg13cmos5l_antennanp
XANTENNA__1461__D Tile_X0Y5_FrameData[27] VPWR VGND sg13cmos5l_antennanp
XFILLER_84_62 VPWR VGND sg13cmos5l_decap_8
XANTENNA__0077__D Tile_X0Y0_FrameData[25] VPWR VGND sg13cmos5l_antennanp
XANTENNA__1187__GATE Tile_X0Y5_FrameStrobe[4] VPWR VGND sg13cmos5l_antennanp
XFILLER_223_139 VPWR VGND sg13cmos5l_decap_8
XFILLER_90_144 VPWR VGND sg13cmos5l_decap_8
XANTENNA__0805__D Tile_X0Y3_FrameData[17] VPWR VGND sg13cmos5l_antennanp
XFILLER_90_6 VPWR VGND sg13cmos5l_decap_8
XANTENNA__1110__GATE Tile_X0Y5_FrameStrobe[2] VPWR VGND sg13cmos5l_antennanp
X_2820_ _2820_/X Tile_X0Y5_N1END[2] Tile_X0Y5_N4END[2] _2795_/X _0058_/X _1316_/Q
+ _1315_/Q VPWR VGND sg13cmos5l_mux4_1
XANTENNA__2223__A0 Tile_X0Y4_W1END[1] VPWR VGND sg13cmos5l_antennanp
XFILLER_129_121 VPWR VGND sg13cmos5l_fill_2
X_2751_ _2751_/X AXIL_S_SOC_ARPROT0 AXIL_S_SOC_ARPROT1 _2821_/X _2799_/X _1400_/Q
+ _1399_/Q VPWR VGND sg13cmos5l_mux4_1
XANTENNA__2774__A1 Tile_X0Y5_W2END[6] VPWR VGND sg13cmos5l_antennanp
X_1702_ Tile_X0Y0_EE4BEG[10] _2191_/X VPWR VGND sg13cmos5l_buf_1
X_2682_ _2682_/X _2610_/X Tile_X0Y5_N2MID[6] _2719_/X _2609_/X _1042_/Q _1041_/Q VPWR
+ VGND sg13cmos5l_mux4_1
XANTENNA__1125__GATE Tile_X0Y5_FrameStrobe[2] VPWR VGND sg13cmos5l_antennanp
X_1633_ Tile_X0Y0_N2BEG[5] _2150_/X VPWR VGND sg13cmos5l_buf_1
XANTENNA__0540__D Tile_X0Y1_FrameData[26] VPWR VGND sg13cmos5l_antennanp
XANTENNA__1773__X Tile_X0Y2_E1BEG[0] VPWR VGND sg13cmos5l_antennanp
XANTENNA__2526__A1 AXIL_S_SOC_ARADDR3 VPWR VGND sg13cmos5l_antennanp
XFILLER_144_157 VPWR VGND sg13cmos5l_decap_8
XANTENNA__0381__GATE Tile_X0Y5_FrameStrobe[2] VPWR VGND sg13cmos5l_antennanp
X_1564_ Tile_X0Y3_FrameData_O[10] Tile_X0Y3_FrameData[10] VPWR VGND sg13cmos5l_buf_1
X_1495_ _1495_/Q Tile_X0Y5_FrameData[25] VGND VPWR Tile_X0Y5_FrameStrobe[7] latch
X_0515_ _0515_/Q Tile_X0Y1_FrameData[19] VGND VPWR Tile_X0Y5_FrameStrobe[6] latch
XFILLER_301_121 VPWR VGND sg13cmos5l_fill_2
X_0446_ _0446_/Q Tile_X0Y1_FrameData[24] VGND VPWR Tile_X0Y5_FrameStrobe[4] latch
XANTENNA__2829__A2 Tile_X0Y4_W6END[8] VPWR VGND sg13cmos5l_antennanp
XFILLER_301_198 VPWR VGND sg13cmos5l_decap_4
XANTENNA__0396__GATE Tile_X0Y5_FrameStrobe[2] VPWR VGND sg13cmos5l_antennanp
XANTENNA__1371__D Tile_X0Y5_FrameData[21] VPWR VGND sg13cmos5l_antennanp
X_0377_ _0377_/Q Tile_X0Y1_FrameData[29] VGND VPWR Tile_X0Y5_FrameStrobe[2] latch
XFILLER_66_152 VPWR VGND sg13cmos5l_decap_8
X_2116_ AXIL_S_SOC_RDATA10 Tile_X0Y2_W2MID[2] Tile_X0Y2_W2END[2] Tile_X0Y2_W6END[2]
+ _2483_/X _0618_/Q _0617_/Q VPWR VGND sg13cmos5l_mux4_1
XFILLER_81_122 VPWR VGND sg13cmos5l_decap_8
XANTENNA__2109__X AXIL_S_SOC_RDATA3 VPWR VGND sg13cmos5l_antennanp
X_2047_ Tile_X0Y5_S1BEG[0] _2769_/X VPWR VGND sg13cmos5l_buf_1
XANTENNA__2462__A0 Tile_X0Y3_W1END[2] VPWR VGND sg13cmos5l_antennanp
XFILLER_120_38 VPWR VGND sg13cmos5l_fill_2
XFILLER_81_177 VPWR VGND sg13cmos5l_decap_8
XANTENNA__0715__D Tile_X0Y2_FrameData[27] VPWR VGND sg13cmos5l_antennanp
XANTENNA__1948__X Tile_X0Y1_E2BEGb[1] VPWR VGND sg13cmos5l_antennanp
XFILLER_167_216 VPWR VGND sg13cmos5l_fill_2
XFILLER_200_60 VPWR VGND sg13cmos5l_decap_8
XFILLER_222_194 VPWR VGND sg13cmos5l_decap_8
XANTENNA__0334__GATE Tile_X0Y5_FrameStrobe[0] VPWR VGND sg13cmos5l_antennanp
XANTENNA__2214__A0 Tile_X0Y1_W1END[1] VPWR VGND sg13cmos5l_antennanp
XANTENNA__0964__GATE Tile_X0Y5_FrameStrobe[5] VPWR VGND sg13cmos5l_antennanp
XFILLER_135_113 VPWR VGND sg13cmos5l_decap_8
XFILLER_276_64 VPWR VGND sg13cmos5l_decap_4
XANTENNA__0450__D Tile_X0Y1_FrameData[20] VPWR VGND sg13cmos5l_antennanp
XANTENNA__1683__X Tile_X0Y0_FrameData_O[23] VPWR VGND sg13cmos5l_antennanp
XANTENNA__2517__A1 AXIL_S_SOC_ARADDR8 VPWR VGND sg13cmos5l_antennanp
XANTENNA__0349__GATE Tile_X0Y5_FrameStrobe[1] VPWR VGND sg13cmos5l_antennanp
XANTENNA__0979__GATE Tile_X0Y5_FrameStrobe[5] VPWR VGND sg13cmos5l_antennanp
XANTENNA__2020__A Tile_X0Y5_FrameData[5] VPWR VGND sg13cmos5l_antennanp
XFILLER_145_79 VPWR VGND sg13cmos5l_decap_8
XANTENNA__0902__GATE Tile_X0Y5_FrameStrobe[3] VPWR VGND sg13cmos5l_antennanp
XANTENNA__1281__D Tile_X0Y5_FrameData[15] VPWR VGND sg13cmos5l_antennanp
XFILLER_161_56 VPWR VGND sg13cmos5l_decap_8
XFILLER_38_77 VPWR VGND sg13cmos5l_decap_4
XFILLER_72_122 VPWR VGND sg13cmos5l_decap_8
XFILLER_57_163 VPWR VGND sg13cmos5l_decap_8
XANTENNA__2019__X Tile_X0Y5_FrameData_O[4] VPWR VGND sg13cmos5l_antennanp
XANTENNA__0917__GATE Tile_X0Y5_FrameStrobe[3] VPWR VGND sg13cmos5l_antennanp
XANTENNA__0625__D Tile_X0Y2_FrameData[21] VPWR VGND sg13cmos5l_antennanp
XANTENNA__1858__X Tile_X0Y4_FrameData_O[25] VPWR VGND sg13cmos5l_antennanp
XANTENNA__2205__A0 AXIL_S_SOC_WDATA16 VPWR VGND sg13cmos5l_antennanp
XFILLER_110_82 VPWR VGND sg13cmos5l_decap_8
XFILLER_70_42 VPWR VGND sg13cmos5l_decap_8
XANTENNA__2756__A1 AXIL_S_SOC_ARVALID VPWR VGND sg13cmos5l_antennanp
XFILLER_319_0 VPWR VGND sg13cmos5l_fill_1
XANTENNA__0360__D Tile_X0Y1_FrameData[14] VPWR VGND sg13cmos5l_antennanp
XANTENNA__1456__D Tile_X0Y5_FrameData[0] VPWR VGND sg13cmos5l_antennanp
XANTENNA__1593__X Tile_X0Y2_EE4BEG[6] VPWR VGND sg13cmos5l_antennanp
X_0300_ _0300_/Q Tile_X0Y0_FrameData[26] VGND VPWR Tile_X0Y5_FrameStrobe[7] latch
XFILLER_352_11 VPWR VGND sg13cmos5l_decap_8
XFILLER_295_131 VPWR VGND sg13cmos5l_decap_8
XFILLER_205_49 VPWR VGND sg13cmos5l_decap_8
X_1280_ _1280_/Q Tile_X0Y5_FrameData[16] VGND VPWR Tile_X0Y5_FrameStrobe[0] latch
XANTENNA__1191__D Tile_X0Y4_FrameData[31] VPWR VGND sg13cmos5l_antennanp
XANTENNA__2287__A3 Tile_X0Y3_W6END[8] VPWR VGND sg13cmos5l_antennanp
XFILLER_0_192 VPWR VGND sg13cmos5l_fill_1
X_0231_ _0231_/Q Tile_X0Y0_FrameData[31] VGND VPWR Tile_X0Y5_FrameStrobe[5] latch
X_0162_ _0162_/Q Tile_X0Y0_FrameData[4] VGND VPWR Tile_X0Y5_FrameStrobe[2] latch
XFILLER_95_94 VPWR VGND sg13cmos5l_fill_2
XANTENNA__2444__A0 AXIL_S_SOC_AWADDR3 VPWR VGND sg13cmos5l_antennanp
X_0093_ _0093_/Q Tile_X0Y0_FrameData[9] VGND VPWR Tile_X0Y5_FrameStrobe[0] latch
XANTENNA__0535__D Tile_X0Y1_FrameData[31] VPWR VGND sg13cmos5l_antennanp
XANTENNA__1768__X Tile_X0Y2_FrameData_O[28] VPWR VGND sg13cmos5l_antennanp
XFILLER_301_81 VPWR VGND sg13cmos5l_fill_2
XFILLER_149_205 VPWR VGND sg13cmos5l_fill_2
X_2803_ _2803_/X Tile_X0Y1_W1END[0] Tile_X0Y1_WW4END[8] Tile_X0Y1_WW4END[12] Tile_X0Y1_W6END[4]
+ _0394_/Q _0393_/Q VPWR VGND sg13cmos5l_mux4_1
XFILLER_81_2 VPWR VGND sg13cmos5l_fill_1
XANTENNA__1064__GATE Tile_X0Y5_FrameStrobe[1] VPWR VGND sg13cmos5l_antennanp
XANTENNA__2747__A1 AXIL_S_SOC_ARPROT1 VPWR VGND sg13cmos5l_antennanp
X_0995_ _0995_/Q Tile_X0Y3_FrameData[19] VGND VPWR Tile_X0Y5_FrameStrobe[6] latch
X_2734_ _2734_/X AXIL_S_SOC_ARPROT1 AXIL_S_SOC_RREADY _2826_/X _2798_/X _1434_/Q _1433_/Q
+ VPWR VGND sg13cmos5l_mux4_1
XANTENNA__0270__D Tile_X0Y0_FrameData[24] VPWR VGND sg13cmos5l_antennanp
XANTENNA__1366__D Tile_X0Y5_FrameData[26] VPWR VGND sg13cmos5l_antennanp
XFILLER_246_23 VPWR VGND sg13cmos5l_decap_8
XFILLER_246_34 VPWR VGND sg13cmos5l_decap_8
XFILLER_246_45 VPWR VGND sg13cmos5l_fill_2
X_2665_ _2665_/X Tile_X0Y4_W1END[2] Tile_X0Y4_WW4END[14] Tile_X0Y4_W6END[6] _2703_/X
+ _1102_/Q _1101_/Q VPWR VGND sg13cmos5l_mux4_1
X_1616_ Tile_X0Y0_N4BEG[12] _1616_/A VPWR VGND sg13cmos5l_buf_1
X_2596_ _2596_/X _2504_/X _2612_/X _2611_/X _2503_/X _0800_/Q _0799_/Q VPWR VGND sg13cmos5l_mux4_1
XANTENNA__1079__GATE Tile_X0Y5_FrameStrobe[1] VPWR VGND sg13cmos5l_antennanp
XFILLER_246_89 VPWR VGND sg13cmos5l_decap_8
XFILLER_5_81 VPWR VGND sg13cmos5l_fill_1
XFILLER_286_142 VPWR VGND sg13cmos5l_decap_8
X_1547_ Tile_X0Y3_EE4BEG[9] _2534_/X VPWR VGND sg13cmos5l_buf_1
XFILLER_262_66 VPWR VGND sg13cmos5l_decap_8
X_1478_ _1478_/Q Tile_X0Y5_FrameData[10] VGND VPWR Tile_X0Y5_FrameStrobe[6] latch
XANTENNA__1002__GATE Tile_X0Y5_FrameStrobe[6] VPWR VGND sg13cmos5l_antennanp
XFILLER_286_197 VPWR VGND sg13cmos5l_fill_2
X_0429_ _0429_/Q Tile_X0Y1_FrameData[9] VGND VPWR Tile_X0Y5_FrameStrobe[3] latch
XFILLER_242_212 VPWR VGND sg13cmos5l_fill_2
XFILLER_242_223 VPWR VGND sg13cmos5l_fill_1
XFILLER_199_127 VPWR VGND sg13cmos5l_decap_8
XFILLER_199_149 VPWR VGND sg13cmos5l_decap_8
XANTENNA__1017__GATE Tile_X0Y5_FrameStrobe[7] VPWR VGND sg13cmos5l_antennanp
XANTENNA__1678__X Tile_X0Y0_FrameData_O[18] VPWR VGND sg13cmos5l_antennanp
XANTENNA__2435__A0 Tile_X0Y5_N4END[14] VPWR VGND sg13cmos5l_antennanp
XANTENNA__0445__D Tile_X0Y1_FrameData[25] VPWR VGND sg13cmos5l_antennanp
XFILLER_145_7 VPWR VGND sg13cmos5l_fill_2
XFILLER_210_120 VPWR VGND sg13cmos5l_decap_8
XANTENNA__0273__GATE Tile_X0Y5_FrameStrobe[6] VPWR VGND sg13cmos5l_antennanp
XFILLER_138_6 VPWR VGND sg13cmos5l_fill_1
XFILLER_356_146 VPWR VGND sg13cmos5l_fill_2
XFILLER_356_135 VPWR VGND sg13cmos5l_decap_8
XANTENNA__2738__A1 AXIL_S_SOC_ARVALID VPWR VGND sg13cmos5l_antennanp
XFILLER_210_164 VPWR VGND sg13cmos5l_decap_4
XANTENNA__2015__A Tile_X0Y5_FrameData[0] VPWR VGND sg13cmos5l_antennanp
XFILLER_108_102 VPWR VGND sg13cmos5l_decap_8
XFILLER_40_45 VPWR VGND sg13cmos5l_fill_1
XANTENNA__0180__D Tile_X0Y0_FrameData[18] VPWR VGND sg13cmos5l_antennanp
XANTENNA__0288__GATE Tile_X0Y5_FrameStrobe[6] VPWR VGND sg13cmos5l_antennanp
XANTENNA__1276__D Tile_X0Y5_FrameData[20] VPWR VGND sg13cmos5l_antennanp
XFILLER_156_23 VPWR VGND sg13cmos5l_decap_8
XFILLER_305_6 VPWR VGND sg13cmos5l_fill_2
XANTENNA__1854__A Tile_X0Y4_FrameData[21] VPWR VGND sg13cmos5l_antennanp
XFILLER_156_67 VPWR VGND sg13cmos5l_decap_8
XANTENNA__0211__GATE Tile_X0Y5_FrameStrobe[4] VPWR VGND sg13cmos5l_antennanp
XFILLER_306_59 VPWR VGND sg13cmos5l_decap_8
XANTENNA__0841__GATE Tile_X0Y5_FrameStrobe[1] VPWR VGND sg13cmos5l_antennanp
XFILLER_172_55 VPWR VGND sg13cmos5l_fill_1
XFILLER_292_101 VPWR VGND sg13cmos5l_fill_2
XFILLER_172_77 VPWR VGND sg13cmos5l_decap_8
XFILLER_292_134 VPWR VGND sg13cmos5l_decap_8
XANTENNA__2269__A3 Tile_X0Y1_W6END[9] VPWR VGND sg13cmos5l_antennanp
XANTENNA__2674__A0 Tile_X0Y5_W1END[0] VPWR VGND sg13cmos5l_antennanp
XFILLER_105_82 VPWR VGND sg13cmos5l_decap_8
XFILLER_65_31 VPWR VGND sg13cmos5l_decap_8
XANTENNA__0226__GATE Tile_X0Y5_FrameStrobe[4] VPWR VGND sg13cmos5l_antennanp
XFILLER_171_0 VPWR VGND sg13cmos5l_fill_2
XANTENNA__0856__GATE Tile_X0Y5_FrameStrobe[2] VPWR VGND sg13cmos5l_antennanp
XANTENNA__1588__X Tile_X0Y2_EE4BEG[1] VPWR VGND sg13cmos5l_antennanp
XANTENNA__2426__A0 AXIL_S_SOC_AWADDR5 VPWR VGND sg13cmos5l_antennanp
XFILLER_121_70 VPWR VGND sg13cmos5l_decap_8
XFILLER_60_125 VPWR VGND sg13cmos5l_fill_1
XANTENNA__0355__D Tile_X0Y1_FrameData[19] VPWR VGND sg13cmos5l_antennanp
XFILLER_81_41 VPWR VGND sg13cmos5l_decap_8
XFILLER_197_30 VPWR VGND sg13cmos5l_fill_2
XFILLER_198_182 VPWR VGND sg13cmos5l_decap_8
XFILLER_81_85 VPWR VGND sg13cmos5l_decap_8
XANTENNA__2729__A1 AXIL_S_SOC_RREADY VPWR VGND sg13cmos5l_antennanp
XFILLER_14_90 VPWR VGND sg13cmos5l_fill_2
XFILLER_197_74 VPWR VGND sg13cmos5l_decap_8
X_0780_ _0780_/Q Tile_X0Y2_FrameData[26] VGND VPWR Tile_X0Y5_FrameStrobe[7] latch
XFILLER_362_116 VPWR VGND sg13cmos5l_decap_8
XANTENNA__1186__D Tile_X0Y4_FrameData[4] VPWR VGND sg13cmos5l_antennanp
XFILLER_347_77 VPWR VGND sg13cmos5l_decap_8
XANTENNA__0090__D Tile_X0Y0_FrameData[12] VPWR VGND sg13cmos5l_antennanp
XANTENNA__1764__A Tile_X0Y2_FrameData[24] VPWR VGND sg13cmos5l_antennanp
XFILLER_114_127 VPWR VGND sg13cmos5l_decap_8
X_2450_ _2450_/X _2476_/X _2474_/X _2468_/X _2467_/X _0628_/Q _0627_/Q VPWR VGND sg13cmos5l_mux4_1
X_1401_ _1401_/Q Tile_X0Y5_FrameData[23] VGND VPWR Tile_X0Y5_FrameStrobe[4] latch
X_2381_ _2381_/X Tile_X0Y0_W2MID[7] Tile_X0Y0_W2END[7] Tile_X0Y0_W6END[8] _2241_/X
+ _0170_/Q _0169_/Q VPWR VGND sg13cmos5l_mux4_1
XANTENNA__0809__GATE Tile_X0Y5_FrameStrobe[0] VPWR VGND sg13cmos5l_antennanp
XFILLER_122_171 VPWR VGND sg13cmos5l_fill_2
XFILLER_122_193 VPWR VGND sg13cmos5l_decap_8
XFILLER_268_175 VPWR VGND sg13cmos5l_decap_4
XFILLER_283_101 VPWR VGND sg13cmos5l_decap_8
X_1332_ _1332_/Q Tile_X0Y5_FrameData[28] VGND VPWR Tile_X0Y5_FrameStrobe[2] latch
X_1263_ _1263_/Q Tile_X0Y4_FrameData[23] VGND VPWR Tile_X0Y5_FrameStrobe[7] latch
XFILLER_83_206 VPWR VGND sg13cmos5l_decap_4
XANTENNA__2665__A0 Tile_X0Y4_W1END[2] VPWR VGND sg13cmos5l_antennanp
XFILLER_232_36 VPWR VGND sg13cmos5l_decap_8
XFILLER_283_156 VPWR VGND sg13cmos5l_decap_8
X_0214_ _0214_/Q Tile_X0Y0_FrameData[16] VGND VPWR Tile_X0Y5_FrameStrobe[4] latch
XFILLER_283_189 VPWR VGND sg13cmos5l_decap_8
X_1194_ _1194_/Q Tile_X0Y4_FrameData[28] VGND VPWR Tile_X0Y5_FrameStrobe[5] latch
X_0145_ _0145_/Q Tile_X0Y0_FrameData[21] VGND VPWR Tile_X0Y5_FrameStrobe[2] latch
XANTENNA__2417__A0 AXIL_S_SOC_AWADDR0 VPWR VGND sg13cmos5l_antennanp
XFILLER_101_29 VPWR VGND sg13cmos5l_decap_8
X_0076_ _0076_/Q Tile_X0Y0_FrameData[26] VGND VPWR Tile_X0Y5_FrameStrobe[0] latch
XFILLER_51_136 VPWR VGND sg13cmos5l_fill_1
XFILLER_51_125 VPWR VGND sg13cmos5l_decap_8
XANTENNA__0265__D Tile_X0Y0_FrameData[29] VPWR VGND sg13cmos5l_antennanp
XFILLER_189_160 VPWR VGND sg13cmos5l_decap_8
XFILLER_51_158 VPWR VGND sg13cmos5l_decap_8
X_0978_ _0978_/Q Tile_X0Y3_FrameData[4] VGND VPWR Tile_X0Y5_FrameStrobe[5] latch
XANTENNA__1096__D Tile_X0Y4_FrameData[30] VPWR VGND sg13cmos5l_antennanp
X_2717_ _2717_/X Tile_X0Y3_W1END[0] Tile_X0Y3_W2MID[3] Tile_X0Y3_W2END[3] _2593_/X
+ _0882_/Q _0881_/Q VPWR VGND sg13cmos5l_mux4_1
XANTENNA__1674__A Tile_X0Y0_FrameData[14] VPWR VGND sg13cmos5l_antennanp
XANTENNA__2122__X AXIL_S_SOC_RDATA16 VPWR VGND sg13cmos5l_antennanp
XFILLER_257_99 VPWR VGND sg13cmos5l_decap_4
XFILLER_273_10 VPWR VGND sg13cmos5l_fill_2
XFILLER_273_32 VPWR VGND sg13cmos5l_decap_8
X_2648_ _2648_/X Tile_X0Y4_WW4END[11] AXIL_S_SOC_WSTRB3 _2707_/X _2708_/X _1158_/Q
+ _1157_/Q VPWR VGND sg13cmos5l_mux4_1
XANTENNA__1961__X Tile_X0Y1_E2BEG[6] VPWR VGND sg13cmos5l_antennanp
XFILLER_273_54 VPWR VGND sg13cmos5l_decap_4
X_2579_ _2579_/X _2566_/X Tile_X0Y5_N4END[8] _2565_/X Tile_X0Y0_S4END[12] _0822_/Q
+ _0821_/Q VPWR VGND sg13cmos5l_mux4_1
XFILLER_142_14 VPWR VGND sg13cmos5l_decap_8
XFILLER_274_112 VPWR VGND sg13cmos5l_fill_1
XANTENNA__2656__A0 AXIL_S_SOC_WSTRB1 VPWR VGND sg13cmos5l_antennanp
XFILLER_19_57 VPWR VGND sg13cmos5l_fill_2
XFILLER_274_156 VPWR VGND sg13cmos5l_decap_8
XANTENNA__2120__A2 Tile_X0Y2_W6END[6] VPWR VGND sg13cmos5l_antennanp
XFILLER_27_122 VPWR VGND sg13cmos5l_decap_4
XFILLER_262_7 VPWR VGND sg13cmos5l_decap_8
XFILLER_35_34 VPWR VGND sg13cmos5l_fill_2
XANTENNA__2408__A0 AXIL_S_SOC_AWADDR1 VPWR VGND sg13cmos5l_antennanp
XFILLER_298_40 VPWR VGND sg13cmos5l_decap_4
XANTENNA__0175__D Tile_X0Y0_FrameData[23] VPWR VGND sg13cmos5l_antennanp
XANTENNA__1849__A Tile_X0Y4_FrameData[16] VPWR VGND sg13cmos5l_antennanp
XFILLER_35_89 VPWR VGND sg13cmos5l_decap_8
XFILLER_143_4 VPWR VGND sg13cmos5l_fill_2
XFILLER_195_130 VPWR VGND sg13cmos5l_fill_2
XFILLER_329_124 VPWR VGND sg13cmos5l_fill_1
XFILLER_298_84 VPWR VGND sg13cmos5l_fill_2
XANTENNA__0903__D Tile_X0Y3_FrameData[15] VPWR VGND sg13cmos5l_antennanp
XFILLER_50_191 VPWR VGND sg13cmos5l_fill_1
XFILLER_167_66 VPWR VGND sg13cmos5l_decap_8
XFILLER_337_190 VPWR VGND sg13cmos5l_decap_8
XANTENNA__1584__A Tile_X0Y3_FrameData[30] VPWR VGND sg13cmos5l_antennanp
XANTENNA__2032__X Tile_X0Y5_FrameData_O[17] VPWR VGND sg13cmos5l_antennanp
XANTENNA__0150__GATE Tile_X0Y5_FrameStrobe[2] VPWR VGND sg13cmos5l_antennanp
XFILLER_352_182 VPWR VGND sg13cmos5l_decap_8
XFILLER_352_171 VPWR VGND sg13cmos5l_decap_8
XFILLER_317_58 VPWR VGND sg13cmos5l_fill_2
XANTENNA__0780__GATE Tile_X0Y5_FrameStrobe[7] VPWR VGND sg13cmos5l_antennanp
XANTENNA__1871__X Tile_X0Y2_E2BEGb[5] VPWR VGND sg13cmos5l_antennanp
XFILLER_104_171 VPWR VGND sg13cmos5l_fill_2
XFILLER_333_13 VPWR VGND sg13cmos5l_decap_8
XFILLER_265_134 VPWR VGND sg13cmos5l_decap_8
XANTENNA__0165__GATE Tile_X0Y5_FrameStrobe[2] VPWR VGND sg13cmos5l_antennanp
XANTENNA__2647__A0 Tile_X0Y4_WW4END[10] VPWR VGND sg13cmos5l_antennanp
XFILLER_18_100 VPWR VGND sg13cmos5l_decap_4
XFILLER_76_85 VPWR VGND sg13cmos5l_fill_2
XFILLER_76_74 VPWR VGND sg13cmos5l_decap_8
XANTENNA__0795__GATE Tile_X0Y5_FrameStrobe[0] VPWR VGND sg13cmos5l_antennanp
XANTENNA__2111__A2 Tile_X0Y3_W6END[5] VPWR VGND sg13cmos5l_antennanp
XFILLER_206_201 VPWR VGND sg13cmos5l_decap_8
XFILLER_132_80 VPWR VGND sg13cmos5l_decap_8
XFILLER_206_223 VPWR VGND sg13cmos5l_fill_1
XFILLER_280_148 VPWR VGND sg13cmos5l_decap_8
XFILLER_92_62 VPWR VGND sg13cmos5l_decap_8
XFILLER_33_136 VPWR VGND sg13cmos5l_decap_4
XFILLER_33_114 VPWR VGND sg13cmos5l_fill_1
XFILLER_33_103 VPWR VGND sg13cmos5l_decap_8
XANTENNA__0085__D Tile_X0Y0_FrameData[17] VPWR VGND sg13cmos5l_antennanp
XANTENNA__1759__A Tile_X0Y2_FrameData[19] VPWR VGND sg13cmos5l_antennanp
XFILLER_178_119 VPWR VGND sg13cmos5l_decap_8
XFILLER_33_147 VPWR VGND sg13cmos5l_decap_8
X_1950_ Tile_X0Y1_E2BEGb[3] _2304_/X VPWR VGND sg13cmos5l_buf_1
XANTENNA__0813__D Tile_X0Y3_FrameData[9] VPWR VGND sg13cmos5l_antennanp
X_1881_ Tile_X0Y2_E6BEG[7] _2440_/X VPWR VGND sg13cmos5l_buf_1
X_0901_ _0901_/Q Tile_X0Y3_FrameData[17] VGND VPWR Tile_X0Y5_FrameStrobe[3] latch
XFILLER_41_180 VPWR VGND sg13cmos5l_decap_8
XANTENNA__0103__GATE Tile_X0Y5_FrameStrobe[1] VPWR VGND sg13cmos5l_antennanp
XANTENNA__0733__GATE Tile_X0Y5_FrameStrobe[5] VPWR VGND sg13cmos5l_antennanp
XFILLER_186_185 VPWR VGND sg13cmos5l_fill_1
X_0832_ _0832_/Q Tile_X0Y3_FrameData[22] VGND VPWR Tile_X0Y5_FrameStrobe[1] latch
XFILLER_358_98 VPWR VGND sg13cmos5l_decap_8
X_2502_ _2502_/X Tile_X0Y4_W2MID[1] Tile_X0Y4_W2END[1] Tile_X0Y4_W6END[1] _2682_/X
+ _1244_/Q _1243_/Q VPWR VGND sg13cmos5l_mux4_1
X_0763_ _0763_/Q Tile_X0Y2_FrameData[11] VGND VPWR Tile_X0Y5_FrameStrobe[6] latch
XANTENNA__0118__GATE Tile_X0Y5_FrameStrobe[1] VPWR VGND sg13cmos5l_antennanp
XFILLER_142_211 VPWR VGND sg13cmos5l_decap_4
X_0694_ _0694_/Q Tile_X0Y2_FrameData[16] VGND VPWR Tile_X0Y5_FrameStrobe[4] latch
XANTENNA__0748__GATE Tile_X0Y5_FrameStrobe[6] VPWR VGND sg13cmos5l_antennanp
XANTENNA__1781__X Tile_X0Y2_E2BEG[4] VPWR VGND sg13cmos5l_antennanp
X_2433_ _2433_/X Tile_X0Y5_N4END[12] Tile_X0Y0_S4END[8] _2466_/X _2465_/X _0682_/Q
+ _0681_/Q VPWR VGND sg13cmos5l_mux4_1
XFILLER_243_13 VPWR VGND sg13cmos5l_decap_8
X_2364_ _2364_/X _2819_/X _2817_/X _2802_/X _2801_/X _1463_/Q _1462_/Q VPWR VGND sg13cmos5l_mux4_1
XFILLER_256_112 VPWR VGND sg13cmos5l_decap_8
X_1315_ _1315_/Q Tile_X0Y5_FrameData[13] VGND VPWR Tile_X0Y5_FrameStrobe[1] latch
XFILLER_110_152 VPWR VGND sg13cmos5l_decap_8
X_2295_ _2295_/X AXIL_S_SOC_WDATA2 AXIL_S_SOC_WDATA10 _2375_/X _2378_/X _0502_/Q _0501_/Q
+ VPWR VGND sg13cmos5l_mux4_1
XANTENNA__2638__A0 AXIL_S_SOC_WSTRB3 VPWR VGND sg13cmos5l_antennanp
X_1246_ _1246_/Q Tile_X0Y4_FrameData[8] VGND VPWR Tile_X0Y5_FrameStrobe[6] latch
XANTENNA__2102__A2 Tile_X0Y4_W6END[2] VPWR VGND sg13cmos5l_antennanp
X_1177_ _1177_/Q Tile_X0Y4_FrameData[13] VGND VPWR Tile_X0Y5_FrameStrobe[4] latch
X_0128_ _0128_/Q Tile_X0Y0_FrameData[6] VGND VPWR Tile_X0Y5_FrameStrobe[1] latch
XANTENNA__1669__A Tile_X0Y0_FrameData[9] VPWR VGND sg13cmos5l_antennanp
XANTENNA__2117__X AXIL_S_SOC_RDATA11 VPWR VGND sg13cmos5l_antennanp
X_0059_ _0059_/X _2807_/X _2808_/X _0389_/Q VPWR VGND sg13cmos5l_mux2_1
XANTENNA__1956__X Tile_X0Y1_E2BEG[1] VPWR VGND sg13cmos5l_antennanp
XANTENNA__2810__A0 Tile_X0Y5_N1END[1] VPWR VGND sg13cmos5l_antennanp
XFILLER_177_141 VPWR VGND sg13cmos5l_fill_2
XANTENNA__0723__D Tile_X0Y2_FrameData[19] VPWR VGND sg13cmos5l_antennanp
XFILLER_192_122 VPWR VGND sg13cmos5l_decap_8
XFILLER_21_25 VPWR VGND sg13cmos5l_fill_1
XFILLER_326_138 VPWR VGND sg13cmos5l_fill_2
XFILLER_133_200 VPWR VGND sg13cmos5l_decap_8
XFILLER_137_14 VPWR VGND sg13cmos5l_decap_8
XFILLER_341_119 VPWR VGND sg13cmos5l_fill_2
XFILLER_341_108 VPWR VGND sg13cmos5l_decap_8
XFILLER_192_199 VPWR VGND sg13cmos5l_decap_8
XFILLER_284_64 VPWR VGND sg13cmos5l_decap_8
XANTENNA__1691__X Tile_X0Y0_FrameData_O[31] VPWR VGND sg13cmos5l_antennanp
XFILLER_284_97 VPWR VGND sg13cmos5l_decap_8
XFILLER_294_207 VPWR VGND sg13cmos5l_fill_1
XFILLER_99_180 VPWR VGND sg13cmos5l_decap_8
XFILLER_153_35 VPWR VGND sg13cmos5l_decap_8
XFILLER_101_152 VPWR VGND sg13cmos5l_decap_8
XANTENNA__2629__A0 AXIL_S_SOC_WSTRB0 VPWR VGND sg13cmos5l_antennanp
XANTENNA__1579__A Tile_X0Y3_FrameData[25] VPWR VGND sg13cmos5l_antennanp
XFILLER_102_61 VPWR VGND sg13cmos5l_decap_8
XANTENNA__2027__X Tile_X0Y5_FrameData_O[12] VPWR VGND sg13cmos5l_antennanp
XFILLER_270_192 VPWR VGND sg13cmos5l_decap_8
XANTENNA__1866__X Tile_X0Y2_E2BEGb[0] VPWR VGND sg13cmos5l_antennanp
XANTENNA__2801__A0 Tile_X0Y5_N1END[3] VPWR VGND sg13cmos5l_antennanp
XFILLER_168_152 VPWR VGND sg13cmos5l_fill_2
XANTENNA__0633__D Tile_X0Y2_FrameData[13] VPWR VGND sg13cmos5l_antennanp
XFILLER_178_98 VPWR VGND sg13cmos5l_decap_8
XFILLER_328_24 VPWR VGND sg13cmos5l_decap_4
XANTENNA__1463__GATE Tile_X0Y5_FrameStrobe[6] VPWR VGND sg13cmos5l_antennanp
XFILLER_328_46 VPWR VGND sg13cmos5l_decap_8
XANTENNA__1464__D Tile_X0Y5_FrameData[24] VPWR VGND sg13cmos5l_antennanp
XFILLER_344_34 VPWR VGND sg13cmos5l_decap_4
XANTENNA__1478__GATE Tile_X0Y5_FrameStrobe[6] VPWR VGND sg13cmos5l_antennanp
XFILLER_285_207 VPWR VGND sg13cmos5l_fill_1
XFILLER_344_78 VPWR VGND sg13cmos5l_decap_4
XFILLER_340_174 VPWR VGND sg13cmos5l_fill_1
XFILLER_87_73 VPWR VGND sg13cmos5l_decap_8
X_1100_ _1100_/Q Tile_X0Y4_FrameData[26] VGND VPWR Tile_X0Y5_FrameStrobe[2] latch
XFILLER_360_11 VPWR VGND sg13cmos5l_fill_1
XANTENNA__1401__GATE Tile_X0Y5_FrameStrobe[4] VPWR VGND sg13cmos5l_antennanp
X_2080_ Tile_X0Y5_S4BEG[13] _2080_/A VPWR VGND sg13cmos5l_buf_1
XFILLER_360_55 VPWR VGND sg13cmos5l_fill_1
XANTENNA__0808__D Tile_X0Y3_FrameData[14] VPWR VGND sg13cmos5l_antennanp
X_1031_ _1031_/Q Tile_X0Y3_FrameData[31] VGND VPWR Tile_X0Y5_FrameStrobe[0] latch
XFILLER_360_77 VPWR VGND sg13cmos5l_fill_2
XFILLER_360_66 VPWR VGND sg13cmos5l_fill_2
XANTENNA__1416__GATE Tile_X0Y5_FrameStrobe[4] VPWR VGND sg13cmos5l_antennanp
XANTENNA__2399__A2 AXIL_S_SOC_AWADDR0 VPWR VGND sg13cmos5l_antennanp
XFILLER_21_128 VPWR VGND sg13cmos5l_decap_8
X_1933_ Tile_X0Y1_EE4BEG[14] _2323_/X VPWR VGND sg13cmos5l_buf_1
XANTENNA__0543__D Tile_X0Y1_FrameData[23] VPWR VGND sg13cmos5l_antennanp
XANTENNA__0672__GATE Tile_X0Y5_FrameStrobe[3] VPWR VGND sg13cmos5l_antennanp
XANTENNA__1776__X Tile_X0Y2_E1BEG[3] VPWR VGND sg13cmos5l_antennanp
X_1864_ Tile_X0Y4_FrameData_O[31] Tile_X0Y4_FrameData[31] VPWR VGND sg13cmos5l_buf_1
XFILLER_115_200 VPWR VGND sg13cmos5l_fill_1
X_1795_ Tile_X0Y4_E2BEG[6] _2623_/X VPWR VGND sg13cmos5l_buf_1
X_0815_ _0815_/Q Tile_X0Y3_FrameData[7] VGND VPWR Tile_X0Y5_FrameStrobe[0] latch
XANTENNA__0687__GATE Tile_X0Y5_FrameStrobe[4] VPWR VGND sg13cmos5l_antennanp
X_0746_ _0746_/Q Tile_X0Y2_FrameData[28] VGND VPWR Tile_X0Y5_FrameStrobe[6] latch
XANTENNA__1374__D Tile_X0Y5_FrameData[18] VPWR VGND sg13cmos5l_antennanp
XFILLER_331_141 VPWR VGND sg13cmos5l_fill_1
XFILLER_331_130 VPWR VGND sg13cmos5l_decap_8
XFILLER_254_67 VPWR VGND sg13cmos5l_fill_1
X_2416_ _2416_/X AXIL_S_SOC_AWADDR1 AXIL_S_SOC_AWADDR7 _2481_/X _2488_/X _0716_/Q
+ _0715_/Q VPWR VGND sg13cmos5l_mux4_1
X_0677_ _0677_/Q Tile_X0Y2_FrameData[1] VGND VPWR Tile_X0Y5_FrameStrobe[3] latch
XANTENNA__0610__GATE Tile_X0Y5_FrameStrobe[1] VPWR VGND sg13cmos5l_antennanp
XFILLER_229_145 VPWR VGND sg13cmos5l_decap_8
X_2347_ _2347_/X Tile_X0Y0_W1END[3] Tile_X0Y0_W6END[11] _2217_/X _2212_/X _0172_/Q
+ _0171_/Q VPWR VGND sg13cmos5l_mux4_1
XFILLER_270_55 VPWR VGND sg13cmos5l_decap_8
X_2278_ _2278_/X _2478_/X _2477_/X _2470_/X _2469_/X _0763_/Q _0762_/Q VPWR VGND sg13cmos5l_mux4_1
XFILLER_96_183 VPWR VGND sg13cmos5l_decap_8
XANTENNA__0718__D Tile_X0Y2_FrameData[24] VPWR VGND sg13cmos5l_antennanp
X_1229_ _1229_/Q Tile_X0Y4_FrameData[25] VGND VPWR Tile_X0Y5_FrameStrobe[6] latch
XFILLER_44_209 VPWR VGND sg13cmos5l_fill_1
XANTENNA__0625__GATE Tile_X0Y5_FrameStrobe[2] VPWR VGND sg13cmos5l_antennanp
XFILLER_203_93 VPWR VGND sg13cmos5l_decap_4
XFILLER_279_20 VPWR VGND sg13cmos5l_decap_8
XFILLER_12_128 VPWR VGND sg13cmos5l_decap_8
XFILLER_279_97 VPWR VGND sg13cmos5l_fill_1
XANTENNA__0453__D Tile_X0Y1_FrameData[17] VPWR VGND sg13cmos5l_antennanp
XANTENNA__1686__X Tile_X0Y0_FrameData_O[26] VPWR VGND sg13cmos5l_antennanp
XFILLER_148_57 VPWR VGND sg13cmos5l_decap_8
XANTENNA__2023__A Tile_X0Y5_FrameData[8] VPWR VGND sg13cmos5l_antennanp
XFILLER_106_222 VPWR VGND sg13cmos5l_fill_2
XFILLER_180_125 VPWR VGND sg13cmos5l_decap_8
XANTENNA__1284__D Tile_X0Y5_FrameData[12] VPWR VGND sg13cmos5l_antennanp
XANTENNA__2562__A2 Tile_X0Y3_W6END[1] VPWR VGND sg13cmos5l_antennanp
XFILLER_79_106 VPWR VGND sg13cmos5l_decap_8
XANTENNA__1862__A Tile_X0Y4_FrameData[29] VPWR VGND sg13cmos5l_antennanp
XFILLER_164_67 VPWR VGND sg13cmos5l_decap_8
XFILLER_87_150 VPWR VGND sg13cmos5l_decap_8
XFILLER_314_37 VPWR VGND sg13cmos5l_fill_2
XFILLER_235_115 VPWR VGND sg13cmos5l_decap_8
XFILLER_57_87 VPWR VGND sg13cmos5l_fill_2
XANTENNA__0628__D Tile_X0Y2_FrameData[18] VPWR VGND sg13cmos5l_antennanp
XFILLER_73_31 VPWR VGND sg13cmos5l_decap_8
XFILLER_73_20 VPWR VGND sg13cmos5l_fill_1
XFILLER_250_118 VPWR VGND sg13cmos5l_fill_2
XFILLER_251_0 VPWR VGND sg13cmos5l_fill_1
XFILLER_189_42 VPWR VGND sg13cmos5l_fill_2
XFILLER_349_0 VPWR VGND sg13cmos5l_fill_1
XANTENNA__1459__D Tile_X0Y5_FrameData[29] VPWR VGND sg13cmos5l_antennanp
XANTENNA__0363__D Tile_X0Y1_FrameData[11] VPWR VGND sg13cmos5l_antennanp
XANTENNA__1596__X Tile_X0Y2_EE4BEG[9] VPWR VGND sg13cmos5l_antennanp
XFILLER_339_67 VPWR VGND sg13cmos5l_decap_8
XANTENNA__2250__A1 Tile_X0Y1_W2END[7] VPWR VGND sg13cmos5l_antennanp
XFILLER_345_222 VPWR VGND sg13cmos5l_fill_2
XFILLER_156_155 VPWR VGND sg13cmos5l_decap_8
X_1580_ Tile_X0Y3_FrameData_O[26] Tile_X0Y3_FrameData[26] VPWR VGND sg13cmos5l_buf_1
X_0600_ _0600_/Q Tile_X0Y2_FrameData[14] VGND VPWR Tile_X0Y5_FrameStrobe[1] latch
XFILLER_355_33 VPWR VGND sg13cmos5l_decap_8
XANTENNA__1194__D Tile_X0Y4_FrameData[28] VPWR VGND sg13cmos5l_antennanp
XANTENNA__2553__A2 Tile_X0Y3_WW4END[12] VPWR VGND sg13cmos5l_antennanp
X_0531_ _0531_/Q Tile_X0Y1_FrameData[3] VGND VPWR Tile_X0Y5_FrameStrobe[6] latch
XANTENNA__1772__A Tile_X0Y2_UserCLK VPWR VGND sg13cmos5l_antennanp
XFILLER_98_83 VPWR VGND sg13cmos5l_decap_8
X_0462_ _0462_/Q Tile_X0Y1_FrameData[8] VGND VPWR Tile_X0Y5_FrameStrobe[4] latch
XANTENNA__1340__GATE Tile_X0Y5_FrameStrobe[2] VPWR VGND sg13cmos5l_antennanp
X_2201_ _2201_/X AXIL_S_SOC_WDATA20 _2233_/X _2218_/X _2241_/X _0194_/Q _0193_/Q VPWR
+ VGND sg13cmos5l_mux4_1
X_0393_ _0393_/Q Tile_X0Y1_FrameData[13] VGND VPWR Tile_X0Y5_FrameStrobe[2] latch
X_2132_ AXIL_S_SOC_RDATA26 Tile_X0Y0_W2MID[2] Tile_X0Y0_W2END[2] Tile_X0Y0_W6END[2]
+ _2243_/X _0138_/Q _0137_/Q VPWR VGND sg13cmos5l_mux4_1
XFILLER_78_172 VPWR VGND sg13cmos5l_decap_8
XANTENNA__0538__D Tile_X0Y1_FrameData[28] VPWR VGND sg13cmos5l_antennanp
XFILLER_93_164 VPWR VGND sg13cmos5l_decap_4
X_2063_ Tile_X0Y5_S2BEGb[4] _2833_/X VPWR VGND sg13cmos5l_buf_1
XANTENNA__1355__GATE Tile_X0Y5_FrameStrobe[2] VPWR VGND sg13cmos5l_antennanp
XFILLER_240_69 VPWR VGND sg13cmos5l_fill_1
X_1014_ _1014_/Q Tile_X0Y3_FrameData[0] VGND VPWR Tile_X0Y5_FrameStrobe[6] latch
XFILLER_234_181 VPWR VGND sg13cmos5l_decap_8
XANTENNA__0273__D Tile_X0Y0_FrameData[21] VPWR VGND sg13cmos5l_antennanp
XANTENNA__1369__D Tile_X0Y5_FrameData[23] VPWR VGND sg13cmos5l_antennanp
XFILLER_249_89 VPWR VGND sg13cmos5l_fill_1
X_1916_ Tile_X0Y1_FrameData_O[29] Tile_X0Y1_FrameData[29] VPWR VGND sg13cmos5l_buf_1
XANTENNA__2792__A2 Tile_X0Y5_W6END[3] VPWR VGND sg13cmos5l_antennanp
X_1847_ Tile_X0Y4_FrameData_O[14] Tile_X0Y4_FrameData[14] VPWR VGND sg13cmos5l_buf_1
XFILLER_8_81 VPWR VGND sg13cmos5l_fill_1
XFILLER_351_203 VPWR VGND sg13cmos5l_fill_2
X_1778_ Tile_X0Y2_E2BEG[1] _2402_/X VPWR VGND sg13cmos5l_buf_1
XANTENNA__1682__A Tile_X0Y0_FrameData[22] VPWR VGND sg13cmos5l_antennanp
XANTENNA__2130__X AXIL_S_SOC_RDATA24 VPWR VGND sg13cmos5l_antennanp
XFILLER_265_99 VPWR VGND sg13cmos5l_decap_8
X_0729_ _0729_/Q Tile_X0Y2_FrameData[13] VGND VPWR Tile_X0Y5_FrameStrobe[5] latch
XFILLER_170_191 VPWR VGND sg13cmos5l_decap_8
XANTENNA__1308__GATE Tile_X0Y5_FrameStrobe[1] VPWR VGND sg13cmos5l_antennanp
XFILLER_69_150 VPWR VGND sg13cmos5l_fill_1
XFILLER_217_104 VPWR VGND sg13cmos5l_decap_8
XFILLER_69_183 VPWR VGND sg13cmos5l_decap_4
XANTENNA__0448__D Tile_X0Y1_FrameData[22] VPWR VGND sg13cmos5l_antennanp
XANTENNA__0564__GATE Tile_X0Y5_FrameStrobe[0] VPWR VGND sg13cmos5l_antennanp
XFILLER_214_70 VPWR VGND sg13cmos5l_decap_8
XFILLER_225_170 VPWR VGND sg13cmos5l_decap_8
XANTENNA__2018__A Tile_X0Y5_FrameData[3] VPWR VGND sg13cmos5l_antennanp
XANTENNA__2480__A1 Tile_X0Y5_N4END[12] VPWR VGND sg13cmos5l_antennanp
XFILLER_342_7 VPWR VGND sg13cmos5l_decap_8
XANTENNA__0579__GATE Tile_X0Y5_FrameStrobe[0] VPWR VGND sg13cmos5l_antennanp
XFILLER_230_80 VPWR VGND sg13cmos5l_fill_2
XANTENNA__0183__D Tile_X0Y0_FrameData[15] VPWR VGND sg13cmos5l_antennanp
XANTENNA__1279__D Tile_X0Y5_FrameData[17] VPWR VGND sg13cmos5l_antennanp
XANTENNA__1857__A Tile_X0Y4_FrameData[24] VPWR VGND sg13cmos5l_antennanp
XANTENNA__0502__GATE Tile_X0Y5_FrameStrobe[5] VPWR VGND sg13cmos5l_antennanp
XANTENNA__2783__A2 Tile_X0Y5_WW4END[13] VPWR VGND sg13cmos5l_antennanp
XFILLER_138_155 VPWR VGND sg13cmos5l_decap_8
XFILLER_309_37 VPWR VGND sg13cmos5l_decap_8
XANTENNA__0911__D Tile_X0Y3_FrameData[7] VPWR VGND sg13cmos5l_antennanp
XFILLER_153_125 VPWR VGND sg13cmos5l_decap_8
XFILLER_4_124 VPWR VGND sg13cmos5l_fill_1
XANTENNA__0517__GATE Tile_X0Y5_FrameStrobe[6] VPWR VGND sg13cmos5l_antennanp
XFILLER_108_60 VPWR VGND sg13cmos5l_decap_8
XFILLER_175_88 VPWR VGND sg13cmos5l_decap_8
XFILLER_325_36 VPWR VGND sg13cmos5l_fill_2
XFILLER_325_25 VPWR VGND sg13cmos5l_decap_8
XFILLER_325_14 VPWR VGND sg13cmos5l_fill_2
XANTENNA__2040__X Tile_X0Y5_FrameData_O[25] VPWR VGND sg13cmos5l_antennanp
XFILLER_325_58 VPWR VGND sg13cmos5l_fill_2
XANTENNA__2299__A1 AXIL_S_SOC_WDATA14 VPWR VGND sg13cmos5l_antennanp
XFILLER_67_109 VPWR VGND sg13cmos5l_fill_2
XANTENNA__0358__D Tile_X0Y1_FrameData[16] VPWR VGND sg13cmos5l_antennanp
XFILLER_263_210 VPWR VGND sg13cmos5l_fill_1
XFILLER_84_41 VPWR VGND sg13cmos5l_decap_8
XFILLER_75_142 VPWR VGND sg13cmos5l_decap_8
XFILLER_90_123 VPWR VGND sg13cmos5l_decap_8
XFILLER_341_68 VPWR VGND sg13cmos5l_decap_8
XANTENNA__2471__A1 Tile_X0Y5_N4END[12] VPWR VGND sg13cmos5l_antennanp
XFILLER_216_181 VPWR VGND sg13cmos5l_decap_8
XANTENNA__0093__D Tile_X0Y0_FrameData[9] VPWR VGND sg13cmos5l_antennanp
XANTENNA__1189__D Tile_X0Y4_FrameData[1] VPWR VGND sg13cmos5l_antennanp
XANTENNA__1767__A Tile_X0Y2_FrameData[27] VPWR VGND sg13cmos5l_antennanp
XANTENNA__2223__A1 Tile_X0Y4_WW4END[1] VPWR VGND sg13cmos5l_antennanp
X_2750_ _2750_/X AXIL_S_SOC_ARPROT0 AXIL_S_SOC_RREADY _2818_/X _2798_/X _1402_/Q _1401_/Q
+ VPWR VGND sg13cmos5l_mux4_1
XFILLER_83_6 VPWR VGND sg13cmos5l_fill_1
XANTENNA__2774__A2 Tile_X0Y5_W6END[9] VPWR VGND sg13cmos5l_antennanp
X_1701_ Tile_X0Y0_EE4BEG[9] _2190_/X VPWR VGND sg13cmos5l_buf_1
X_2681_ _2681_/X _2612_/X Tile_X0Y5_N2MID[7] _2720_/X _2611_/X _1040_/Q _1039_/Q VPWR
+ VGND sg13cmos5l_mux4_1
XANTENNA__0821__D Tile_X0Y3_FrameData[1] VPWR VGND sg13cmos5l_antennanp
X_1632_ Tile_X0Y0_N2BEG[4] _2149_/X VPWR VGND sg13cmos5l_buf_1
XFILLER_235_14 VPWR VGND sg13cmos5l_decap_8
X_1563_ Tile_X0Y3_FrameData_O[9] Tile_X0Y3_FrameData[9] VPWR VGND sg13cmos5l_buf_1
XFILLER_98_223 VPWR VGND sg13cmos5l_fill_1
XFILLER_235_47 VPWR VGND sg13cmos5l_decap_8
XFILLER_235_69 VPWR VGND sg13cmos5l_fill_1
X_1494_ _1494_/Q Tile_X0Y5_FrameData[26] VGND VPWR Tile_X0Y5_FrameStrobe[7] latch
X_0514_ _0514_/Q Tile_X0Y1_FrameData[20] VGND VPWR Tile_X0Y5_FrameStrobe[6] latch
XFILLER_301_100 VPWR VGND sg13cmos5l_decap_8
X_0445_ _0445_/Q Tile_X0Y1_FrameData[25] VGND VPWR Tile_X0Y5_FrameStrobe[4] latch
XFILLER_301_166 VPWR VGND sg13cmos5l_decap_8
XFILLER_298_195 VPWR VGND sg13cmos5l_fill_2
XFILLER_251_13 VPWR VGND sg13cmos5l_fill_1
XANTENNA__0268__D Tile_X0Y0_FrameData[26] VPWR VGND sg13cmos5l_antennanp
XFILLER_12_0 VPWR VGND sg13cmos5l_fill_1
XFILLER_251_57 VPWR VGND sg13cmos5l_decap_8
XFILLER_254_210 VPWR VGND sg13cmos5l_fill_1
X_0376_ _0376_/Q Tile_X0Y1_FrameData[30] VGND VPWR Tile_X0Y5_FrameStrobe[2] latch
XANTENNA__1294__GATE Tile_X0Y5_FrameStrobe[0] VPWR VGND sg13cmos5l_antennanp
XFILLER_251_79 VPWR VGND sg13cmos5l_decap_4
X_2115_ AXIL_S_SOC_RDATA9 Tile_X0Y2_W2MID[1] Tile_X0Y2_W2END[1] Tile_X0Y2_W6END[1]
+ _2482_/X _0620_/Q _0619_/Q VPWR VGND sg13cmos5l_mux4_1
X_2046_ Tile_X0Y5_FrameData_O[31] Tile_X0Y5_FrameData[31] VPWR VGND sg13cmos5l_buf_1
XANTENNA__2462__A1 Tile_X0Y3_W6END[6] VPWR VGND sg13cmos5l_antennanp
XFILLER_22_223 VPWR VGND sg13cmos5l_fill_1
XANTENNA__1099__D Tile_X0Y4_FrameData[27] VPWR VGND sg13cmos5l_antennanp
XANTENNA__1677__A Tile_X0Y0_FrameData[17] VPWR VGND sg13cmos5l_antennanp
XFILLER_222_173 VPWR VGND sg13cmos5l_decap_8
XANTENNA__2125__X AXIL_S_SOC_RDATA19 VPWR VGND sg13cmos5l_antennanp
XANTENNA__2214__A1 Tile_X0Y1_W6END[5] VPWR VGND sg13cmos5l_antennanp
XFILLER_129_15 VPWR VGND sg13cmos5l_fill_2
XANTENNA__1232__GATE Tile_X0Y5_FrameStrobe[6] VPWR VGND sg13cmos5l_antennanp
XFILLER_276_21 VPWR VGND sg13cmos5l_fill_2
XANTENNA__0731__D Tile_X0Y2_FrameData[11] VPWR VGND sg13cmos5l_antennanp
XANTENNA__1964__X Tile_X0Y1_E1BEG[1] VPWR VGND sg13cmos5l_antennanp
XFILLER_202_9 VPWR VGND sg13cmos5l_decap_4
XFILLER_276_98 VPWR VGND sg13cmos5l_decap_4
XFILLER_150_117 VPWR VGND sg13cmos5l_decap_8
XFILLER_292_20 VPWR VGND sg13cmos5l_fill_2
XANTENNA__1247__GATE Tile_X0Y5_FrameStrobe[6] VPWR VGND sg13cmos5l_antennanp
XFILLER_289_184 VPWR VGND sg13cmos5l_decap_4
XFILLER_289_195 VPWR VGND sg13cmos5l_fill_1
XFILLER_292_97 VPWR VGND sg13cmos5l_decap_4
XFILLER_49_109 VPWR VGND sg13cmos5l_decap_4
XANTENNA__0178__D Tile_X0Y0_FrameData[20] VPWR VGND sg13cmos5l_antennanp
XANTENNA__2150__A0 Tile_X0Y0_W2MID[2] VPWR VGND sg13cmos5l_antennanp
XFILLER_161_35 VPWR VGND sg13cmos5l_decap_8
XFILLER_72_101 VPWR VGND sg13cmos5l_fill_2
XFILLER_311_49 VPWR VGND sg13cmos5l_fill_1
XANTENNA__0906__D Tile_X0Y3_FrameData[12] VPWR VGND sg13cmos5l_antennanp
XFILLER_241_90 VPWR VGND sg13cmos5l_decap_8
XFILLER_54_66 VPWR VGND sg13cmos5l_decap_4
XFILLER_359_122 VPWR VGND sg13cmos5l_decap_8
XFILLER_158_206 VPWR VGND sg13cmos5l_decap_4
XFILLER_359_155 VPWR VGND sg13cmos5l_decap_8
XANTENNA__0441__GATE Tile_X0Y5_FrameStrobe[4] VPWR VGND sg13cmos5l_antennanp
XANTENNA__2035__X Tile_X0Y5_FrameData_O[20] VPWR VGND sg13cmos5l_antennanp
XFILLER_70_21 VPWR VGND sg13cmos5l_decap_8
XANTENNA__0641__D Tile_X0Y2_FrameData[5] VPWR VGND sg13cmos5l_antennanp
XANTENNA__1874__X Tile_X0Y2_E6BEG[0] VPWR VGND sg13cmos5l_antennanp
XFILLER_186_65 VPWR VGND sg13cmos5l_fill_1
XFILLER_214_0 VPWR VGND sg13cmos5l_fill_1
XANTENNA__0456__GATE Tile_X0Y5_FrameStrobe[4] VPWR VGND sg13cmos5l_antennanp
XFILLER_126_147 VPWR VGND sg13cmos5l_decap_4
XFILLER_186_98 VPWR VGND sg13cmos5l_decap_8
XANTENNA__2508__A2 AXIL_S_SOC_ARADDR1 VPWR VGND sg13cmos5l_antennanp
XFILLER_79_41 VPWR VGND sg13cmos5l_decap_4
XFILLER_79_96 VPWR VGND sg13cmos5l_fill_2
XFILLER_295_110 VPWR VGND sg13cmos5l_decap_8
XANTENNA__1472__D Tile_X0Y5_FrameData[16] VPWR VGND sg13cmos5l_antennanp
XFILLER_352_45 VPWR VGND sg13cmos5l_fill_1
XANTENNA__0088__D Tile_X0Y0_FrameData[14] VPWR VGND sg13cmos5l_antennanp
XANTENNA__2141__A0 Tile_X0Y0_W1END[0] VPWR VGND sg13cmos5l_antennanp
X_0230_ _0230_/Q Tile_X0Y0_FrameData[0] VGND VPWR Tile_X0Y5_FrameStrobe[4] latch
XFILLER_95_73 VPWR VGND sg13cmos5l_decap_8
XANTENNA__2692__A1 Tile_X0Y5_N4END[5] VPWR VGND sg13cmos5l_antennanp
X_0161_ _0161_/Q Tile_X0Y0_FrameData[5] VGND VPWR Tile_X0Y5_FrameStrobe[2] latch
XFILLER_48_175 VPWR VGND sg13cmos5l_fill_2
X_0092_ _0092_/Q Tile_X0Y0_FrameData[10] VGND VPWR Tile_X0Y5_FrameStrobe[0] latch
XANTENNA__0816__D Tile_X0Y3_FrameData[6] VPWR VGND sg13cmos5l_antennanp
XANTENNA__0409__GATE Tile_X0Y5_FrameStrobe[3] VPWR VGND sg13cmos5l_antennanp
XFILLER_301_93 VPWR VGND sg13cmos5l_decap_8
X_2802_ _2802_/X Tile_X0Y5_N1END[3] Tile_X0Y5_N4END[3] _2796_/X _0057_/X _1298_/Q
+ _1297_/Q VPWR VGND sg13cmos5l_mux4_1
X_2733_ _2733_/X AXIL_S_SOC_ARPROT0 AXIL_S_SOC_ARVALID _2825_/X _2797_/X _1436_/Q
+ _1435_/Q VPWR VGND sg13cmos5l_mux4_1
X_0994_ _0994_/Q Tile_X0Y3_FrameData[20] VGND VPWR Tile_X0Y5_FrameStrobe[6] latch
XANTENNA__0551__D Tile_X0Y1_FrameData[31] VPWR VGND sg13cmos5l_antennanp
XANTENNA__1784__X Tile_X0Y2_E2BEG[7] VPWR VGND sg13cmos5l_antennanp
X_2664_ _2664_/X _2704_/X _2693_/X _2692_/X _2683_/X _1105_/Q _1104_/Q VPWR VGND sg13cmos5l_mux4_1
XFILLER_246_68 VPWR VGND sg13cmos5l_fill_1
X_1615_ Tile_X0Y0_N4BEG[11] _1615_/A VPWR VGND sg13cmos5l_buf_1
X_2595_ _2595_/X _2502_/X _2610_/X _2609_/X _2501_/X _0802_/Q _0801_/Q VPWR VGND sg13cmos5l_mux4_1
X_1546_ Tile_X0Y3_EE4BEG[8] _2533_/X VPWR VGND sg13cmos5l_buf_1
XFILLER_5_71 VPWR VGND sg13cmos5l_fill_1
XFILLER_286_121 VPWR VGND sg13cmos5l_decap_8
XANTENNA__1382__D Tile_X0Y5_FrameData[10] VPWR VGND sg13cmos5l_antennanp
XFILLER_262_45 VPWR VGND sg13cmos5l_decap_8
X_1477_ _1477_/Q Tile_X0Y5_FrameData[11] VGND VPWR Tile_X0Y5_FrameStrobe[6] latch
XANTENNA__2132__A0 Tile_X0Y0_W2MID[2] VPWR VGND sg13cmos5l_antennanp
X_0428_ _0428_/Q Tile_X0Y1_FrameData[10] VGND VPWR Tile_X0Y5_FrameStrobe[3] latch
XFILLER_39_142 VPWR VGND sg13cmos5l_fill_1
XFILLER_39_131 VPWR VGND sg13cmos5l_decap_8
XANTENNA__2683__A1 Tile_X0Y5_N2MID[5] VPWR VGND sg13cmos5l_antennanp
X_0359_ _0359_/Q Tile_X0Y1_FrameData[15] VGND VPWR Tile_X0Y5_FrameStrobe[1] latch
XFILLER_39_164 VPWR VGND sg13cmos5l_decap_8
XFILLER_54_112 VPWR VGND sg13cmos5l_decap_8
XANTENNA__0726__D Tile_X0Y2_FrameData[16] VPWR VGND sg13cmos5l_antennanp
XANTENNA__1959__X Tile_X0Y1_E2BEG[4] VPWR VGND sg13cmos5l_antennanp
XANTENNA__2435__A1 Tile_X0Y0_S4END[10] VPWR VGND sg13cmos5l_antennanp
X_2029_ Tile_X0Y5_FrameData_O[14] Tile_X0Y5_FrameData[14] VPWR VGND sg13cmos5l_buf_1
XFILLER_54_189 VPWR VGND sg13cmos5l_decap_8
XFILLER_24_47 VPWR VGND sg13cmos5l_fill_1
XFILLER_287_20 VPWR VGND sg13cmos5l_decap_4
XFILLER_24_69 VPWR VGND sg13cmos5l_decap_4
XFILLER_287_31 VPWR VGND sg13cmos5l_fill_2
XFILLER_287_53 VPWR VGND sg13cmos5l_fill_1
XFILLER_356_114 VPWR VGND sg13cmos5l_decap_8
XANTENNA__1171__GATE Tile_X0Y5_FrameStrobe[4] VPWR VGND sg13cmos5l_antennanp
XFILLER_155_209 VPWR VGND sg13cmos5l_decap_4
XFILLER_287_75 VPWR VGND sg13cmos5l_decap_4
XANTENNA__0461__D Tile_X0Y1_FrameData[9] VPWR VGND sg13cmos5l_antennanp
XANTENNA__1694__X Tile_X0Y0_EE4BEG[2] VPWR VGND sg13cmos5l_antennanp
XFILLER_210_198 VPWR VGND sg13cmos5l_fill_2
XANTENNA__1186__GATE Tile_X0Y5_FrameStrobe[4] VPWR VGND sg13cmos5l_antennanp
XFILLER_108_169 VPWR VGND sg13cmos5l_decap_8
XFILLER_123_106 VPWR VGND sg13cmos5l_decap_8
XFILLER_156_46 VPWR VGND sg13cmos5l_decap_8
XANTENNA__2031__A Tile_X0Y5_FrameData[16] VPWR VGND sg13cmos5l_antennanp
XFILLER_123_139 VPWR VGND sg13cmos5l_decap_8
XFILLER_306_16 VPWR VGND sg13cmos5l_fill_1
XFILLER_131_150 VPWR VGND sg13cmos5l_fill_2
XFILLER_172_23 VPWR VGND sg13cmos5l_fill_2
XFILLER_306_49 VPWR VGND sg13cmos5l_fill_1
XANTENNA__1292__D Tile_X0Y5_FrameData[4] VPWR VGND sg13cmos5l_antennanp
XANTENNA__2123__A0 Tile_X0Y1_W2MID[1] VPWR VGND sg13cmos5l_antennanp
XFILLER_131_194 VPWR VGND sg13cmos5l_decap_4
XFILLER_218_221 VPWR VGND sg13cmos5l_fill_2
XANTENNA__2674__A1 Tile_X0Y5_W6END[4] VPWR VGND sg13cmos5l_antennanp
XFILLER_105_61 VPWR VGND sg13cmos5l_decap_8
XFILLER_322_26 VPWR VGND sg13cmos5l_decap_8
XFILLER_45_145 VPWR VGND sg13cmos5l_fill_1
XANTENNA__0636__D Tile_X0Y2_FrameData[10] VPWR VGND sg13cmos5l_antennanp
XANTENNA__1124__GATE Tile_X0Y5_FrameStrobe[2] VPWR VGND sg13cmos5l_antennanp
XANTENNA__1869__X Tile_X0Y2_E2BEGb[3] VPWR VGND sg13cmos5l_antennanp
XFILLER_164_0 VPWR VGND sg13cmos5l_fill_1
XFILLER_60_104 VPWR VGND sg13cmos5l_decap_8
XFILLER_45_167 VPWR VGND sg13cmos5l_decap_4
XANTENNA__2426__A1 AXIL_S_SOC_AWADDR9 VPWR VGND sg13cmos5l_antennanp
XFILLER_81_20 VPWR VGND sg13cmos5l_decap_8
XANTENNA__0380__GATE Tile_X0Y5_FrameStrobe[2] VPWR VGND sg13cmos5l_antennanp
XFILLER_197_20 VPWR VGND sg13cmos5l_fill_2
XFILLER_198_150 VPWR VGND sg13cmos5l_decap_8
XANTENNA__1139__GATE Tile_X0Y5_FrameStrobe[3] VPWR VGND sg13cmos5l_antennanp
XFILLER_201_132 VPWR VGND sg13cmos5l_fill_1
XFILLER_146_209 VPWR VGND sg13cmos5l_fill_2
XFILLER_347_147 VPWR VGND sg13cmos5l_fill_2
XANTENNA__0371__D Tile_X0Y1_FrameData[3] VPWR VGND sg13cmos5l_antennanp
XANTENNA__1467__D Tile_X0Y5_FrameData[21] VPWR VGND sg13cmos5l_antennanp
XFILLER_347_56 VPWR VGND sg13cmos5l_decap_8
XANTENNA__0395__GATE Tile_X0Y5_FrameStrobe[2] VPWR VGND sg13cmos5l_antennanp
X_1400_ _1400_/Q Tile_X0Y5_FrameData[24] VGND VPWR Tile_X0Y5_FrameStrobe[4] latch
XFILLER_30_90 VPWR VGND sg13cmos5l_decap_8
XFILLER_146_90 VPWR VGND sg13cmos5l_decap_8
X_2380_ _2380_/X _2263_/X _2396_/X _2395_/X Tile_X0Y0_S2MID[7] _0320_/Q _0319_/Q VPWR
+ VGND sg13cmos5l_mux4_1
X_1331_ _1331_/Q Tile_X0Y5_FrameData[29] VGND VPWR Tile_X0Y5_FrameStrobe[2] latch
XANTENNA__2114__A0 Tile_X0Y2_W2MID[0] VPWR VGND sg13cmos5l_antennanp
XFILLER_268_187 VPWR VGND sg13cmos5l_decap_8
X_1262_ _1262_/Q Tile_X0Y4_FrameData[24] VGND VPWR Tile_X0Y5_FrameStrobe[7] latch
XANTENNA__0333__GATE Tile_X0Y5_FrameStrobe[0] VPWR VGND sg13cmos5l_antennanp
XANTENNA__2665__A1 Tile_X0Y4_WW4END[14] VPWR VGND sg13cmos5l_antennanp
X_0213_ _0213_/Q Tile_X0Y0_FrameData[17] VGND VPWR Tile_X0Y5_FrameStrobe[4] latch
XANTENNA__0963__GATE Tile_X0Y5_FrameStrobe[5] VPWR VGND sg13cmos5l_antennanp
X_1193_ _1193_/Q Tile_X0Y4_FrameData[29] VGND VPWR Tile_X0Y5_FrameStrobe[5] latch
XANTENNA__0546__D Tile_X0Y1_FrameData[20] VPWR VGND sg13cmos5l_antennanp
XANTENNA__1779__X Tile_X0Y2_E2BEG[2] VPWR VGND sg13cmos5l_antennanp
XFILLER_291_190 VPWR VGND sg13cmos5l_decap_8
X_0144_ _0144_/Q Tile_X0Y0_FrameData[22] VGND VPWR Tile_X0Y5_FrameStrobe[2] latch
XANTENNA__2417__A1 AXIL_S_SOC_AWPROT2 VPWR VGND sg13cmos5l_antennanp
X_0075_ _0075_/Q Tile_X0Y0_FrameData[27] VGND VPWR Tile_X0Y5_FrameStrobe[0] latch
XANTENNA__0348__GATE Tile_X0Y5_FrameStrobe[1] VPWR VGND sg13cmos5l_antennanp
XANTENNA__0978__GATE Tile_X0Y5_FrameStrobe[5] VPWR VGND sg13cmos5l_antennanp
XANTENNA__0281__D Tile_X0Y0_FrameData[13] VPWR VGND sg13cmos5l_antennanp
XANTENNA__0901__GATE Tile_X0Y5_FrameStrobe[3] VPWR VGND sg13cmos5l_antennanp
XANTENNA__1377__D Tile_X0Y5_FrameData[15] VPWR VGND sg13cmos5l_antennanp
X_0977_ _0977_/Q Tile_X0Y3_FrameData[5] VGND VPWR Tile_X0Y5_FrameStrobe[5] latch
X_2716_ _2716_/X Tile_X0Y3_W2MID[4] Tile_X0Y3_W2END[4] Tile_X0Y3_W6END[11] _2592_/X
+ _0884_/Q _0883_/Q VPWR VGND sg13cmos5l_mux4_1
XFILLER_353_139 VPWR VGND sg13cmos5l_decap_8
X_2647_ _2647_/X Tile_X0Y4_WW4END[10] AXIL_S_SOC_WSTRB2 _2705_/X _2709_/X _1160_/Q
+ _1159_/Q VPWR VGND sg13cmos5l_mux4_1
XANTENNA__0916__GATE Tile_X0Y5_FrameStrobe[3] VPWR VGND sg13cmos5l_antennanp
XFILLER_120_109 VPWR VGND sg13cmos5l_fill_1
XFILLER_273_66 VPWR VGND sg13cmos5l_decap_8
X_2578_ _2578_/X _2568_/X Tile_X0Y5_N4END[9] _2567_/X Tile_X0Y0_S4END[13] _0828_/Q
+ _0827_/Q VPWR VGND sg13cmos5l_mux4_1
XANTENNA__1690__A Tile_X0Y0_FrameData[30] VPWR VGND sg13cmos5l_antennanp
XFILLER_113_183 VPWR VGND sg13cmos5l_decap_8
X_1529_ Tile_X0Y3_E6BEG[3] _2544_/X VPWR VGND sg13cmos5l_buf_1
XANTENNA__2105__A0 Tile_X0Y5_W2MID[0] VPWR VGND sg13cmos5l_antennanp
XFILLER_27_101 VPWR VGND sg13cmos5l_decap_8
XANTENNA__0456__D Tile_X0Y1_FrameData[14] VPWR VGND sg13cmos5l_antennanp
XANTENNA__1689__X Tile_X0Y0_FrameData_O[29] VPWR VGND sg13cmos5l_antennanp
XFILLER_27_156 VPWR VGND sg13cmos5l_fill_2
XANTENNA__2408__A1 AXIL_S_SOC_AWADDR7 VPWR VGND sg13cmos5l_antennanp
XFILLER_35_68 VPWR VGND sg13cmos5l_decap_8
XFILLER_298_63 VPWR VGND sg13cmos5l_decap_4
XANTENNA__2026__A Tile_X0Y5_FrameData[11] VPWR VGND sg13cmos5l_antennanp
XANTENNA__0191__D Tile_X0Y0_FrameData[7] VPWR VGND sg13cmos5l_antennanp
XANTENNA__1287__D Tile_X0Y5_FrameData[9] VPWR VGND sg13cmos5l_antennanp
XANTENNA__1865__A Tile_X0Y4_UserCLK VPWR VGND sg13cmos5l_antennanp
XFILLER_195_175 VPWR VGND sg13cmos5l_decap_4
XFILLER_51_78 VPWR VGND sg13cmos5l_fill_1
XFILLER_151_223 VPWR VGND sg13cmos5l_fill_1
XFILLER_183_22 VPWR VGND sg13cmos5l_decap_8
XANTENNA__2344__A0 Tile_X0Y2_W1END[1] VPWR VGND sg13cmos5l_antennanp
XFILLER_104_150 VPWR VGND sg13cmos5l_decap_8
XFILLER_104_183 VPWR VGND sg13cmos5l_decap_4
XFILLER_116_71 VPWR VGND sg13cmos5l_decap_4
XFILLER_265_113 VPWR VGND sg13cmos5l_decap_8
XFILLER_281_0 VPWR VGND sg13cmos5l_fill_2
XANTENNA__1063__GATE Tile_X0Y5_FrameStrobe[1] VPWR VGND sg13cmos5l_antennanp
XANTENNA__2647__A1 AXIL_S_SOC_WSTRB2 VPWR VGND sg13cmos5l_antennanp
XFILLER_265_179 VPWR VGND sg13cmos5l_decap_8
XANTENNA__0366__D Tile_X0Y1_FrameData[8] VPWR VGND sg13cmos5l_antennanp
XANTENNA__1599__X Tile_X0Y2_EE4BEG[12] VPWR VGND sg13cmos5l_antennanp
XFILLER_202_29 VPWR VGND sg13cmos5l_decap_4
XFILLER_92_41 VPWR VGND sg13cmos5l_decap_8
XANTENNA__1078__GATE Tile_X0Y5_FrameStrobe[1] VPWR VGND sg13cmos5l_antennanp
X_0900_ _0900_/Q Tile_X0Y3_FrameData[18] VGND VPWR Tile_X0Y5_FrameStrobe[3] latch
X_1880_ Tile_X0Y2_E6BEG[6] _2439_/X VPWR VGND sg13cmos5l_buf_1
XFILLER_358_33 VPWR VGND sg13cmos5l_fill_1
XANTENNA__1197__D Tile_X0Y4_FrameData[25] VPWR VGND sg13cmos5l_antennanp
XFILLER_186_175 VPWR VGND sg13cmos5l_fill_1
X_0831_ _0831_/Q Tile_X0Y3_FrameData[23] VGND VPWR Tile_X0Y5_FrameStrobe[1] latch
XANTENNA__1001__GATE Tile_X0Y5_FrameStrobe[6] VPWR VGND sg13cmos5l_antennanp
X_0762_ _0762_/Q Tile_X0Y2_FrameData[12] VGND VPWR Tile_X0Y5_FrameStrobe[6] latch
XFILLER_227_15 VPWR VGND sg13cmos5l_fill_1
XFILLER_227_26 VPWR VGND sg13cmos5l_decap_4
X_2501_ _2501_/X Tile_X0Y1_W1END[2] Tile_X0Y1_W2MID[1] Tile_X0Y1_W2END[1] _2379_/X
+ _0398_/Q _0397_/Q VPWR VGND sg13cmos5l_mux4_1
XFILLER_350_109 VPWR VGND sg13cmos5l_decap_8
X_0693_ _0693_/Q Tile_X0Y2_FrameData[17] VGND VPWR Tile_X0Y5_FrameStrobe[4] latch
XANTENNA__1016__GATE Tile_X0Y5_FrameStrobe[7] VPWR VGND sg13cmos5l_antennanp
XANTENNA__2335__A0 AXIL_S_SOC_WDATA2 VPWR VGND sg13cmos5l_antennanp
X_2432_ _2432_/X AXIL_S_SOC_AWADDR1 AXIL_S_SOC_AWADDR3 _2480_/X _2481_/X _0684_/Q
+ _0683_/Q VPWR VGND sg13cmos5l_mux4_1
XFILLER_307_70 VPWR VGND sg13cmos5l_fill_1
X_2363_ _2363_/X Tile_X0Y5_W1END[3] Tile_X0Y5_WW4END[3] Tile_X0Y5_WW4END[9] Tile_X0Y5_W6END[11]
+ _1463_/Q _1462_/Q VPWR VGND sg13cmos5l_mux4_1
XANTENNA__0272__GATE Tile_X0Y5_FrameStrobe[6] VPWR VGND sg13cmos5l_antennanp
XANTENNA__2350__A3 Tile_X0Y0_S4END[7] VPWR VGND sg13cmos5l_antennanp
XFILLER_110_131 VPWR VGND sg13cmos5l_decap_8
XFILLER_243_58 VPWR VGND sg13cmos5l_decap_4
X_1314_ _1314_/Q Tile_X0Y5_FrameData[14] VGND VPWR Tile_X0Y5_FrameStrobe[1] latch
X_2294_ _2294_/X AXIL_S_SOC_WDATA1 AXIL_S_SOC_WDATA9 _2374_/X _2379_/X _0504_/Q _0503_/Q
+ VPWR VGND sg13cmos5l_mux4_1
XANTENNA__2638__A1 AXIL_S_SOC_BREADY VPWR VGND sg13cmos5l_antennanp
XFILLER_256_179 VPWR VGND sg13cmos5l_decap_4
X_1245_ _1245_/Q Tile_X0Y4_FrameData[9] VGND VPWR Tile_X0Y5_FrameStrobe[6] latch
XFILLER_112_29 VPWR VGND sg13cmos5l_fill_2
X_1176_ _1176_/Q Tile_X0Y4_FrameData[14] VGND VPWR Tile_X0Y5_FrameStrobe[4] latch
XANTENNA__0276__D Tile_X0Y0_FrameData[18] VPWR VGND sg13cmos5l_antennanp
XANTENNA__0287__GATE Tile_X0Y5_FrameStrobe[6] VPWR VGND sg13cmos5l_antennanp
X_0127_ _0127_/Q Tile_X0Y0_FrameData[7] VGND VPWR Tile_X0Y5_FrameStrobe[1] latch
XFILLER_268_11 VPWR VGND sg13cmos5l_fill_2
X_0058_ _0058_/X _2811_/X _2812_/X _0386_/Q VPWR VGND sg13cmos5l_mux2_1
XANTENNA__0210__GATE Tile_X0Y5_FrameStrobe[4] VPWR VGND sg13cmos5l_antennanp
XANTENNA__2810__A1 Tile_X0Y5_N4END[1] VPWR VGND sg13cmos5l_antennanp
XANTENNA__0840__GATE Tile_X0Y5_FrameStrobe[1] VPWR VGND sg13cmos5l_antennanp
XFILLER_268_88 VPWR VGND sg13cmos5l_decap_8
XANTENNA__1685__A Tile_X0Y0_FrameData[25] VPWR VGND sg13cmos5l_antennanp
XANTENNA__2133__X AXIL_S_SOC_RDATA27 VPWR VGND sg13cmos5l_antennanp
XANTENNA__0225__GATE Tile_X0Y5_FrameStrobe[4] VPWR VGND sg13cmos5l_antennanp
XFILLER_21_59 VPWR VGND sg13cmos5l_decap_4
XFILLER_284_43 VPWR VGND sg13cmos5l_decap_8
XANTENNA__0855__GATE Tile_X0Y5_FrameStrobe[2] VPWR VGND sg13cmos5l_antennanp
XANTENNA__1972__X Tile_X0Y5_E2BEG[1] VPWR VGND sg13cmos5l_antennanp
XFILLER_284_76 VPWR VGND sg13cmos5l_decap_8
XFILLER_334_183 VPWR VGND sg13cmos5l_decap_8
XFILLER_153_14 VPWR VGND sg13cmos5l_decap_8
XFILLER_101_131 VPWR VGND sg13cmos5l_decap_8
XFILLER_198_6 VPWR VGND sg13cmos5l_decap_4
XFILLER_47_207 VPWR VGND sg13cmos5l_decap_4
XANTENNA__2629__A1 AXIL_S_SOC_WVALID VPWR VGND sg13cmos5l_antennanp
XANTENNA__0186__D Tile_X0Y0_FrameData[12] VPWR VGND sg13cmos5l_antennanp
XFILLER_270_171 VPWR VGND sg13cmos5l_decap_8
XANTENNA__0914__D Tile_X0Y3_FrameData[4] VPWR VGND sg13cmos5l_antennanp
XFILLER_62_55 VPWR VGND sg13cmos5l_decap_4
XFILLER_62_44 VPWR VGND sg13cmos5l_fill_2
XANTENNA__0808__GATE Tile_X0Y5_FrameStrobe[0] VPWR VGND sg13cmos5l_antennanp
XANTENNA__2801__A1 Tile_X0Y5_N4END[3] VPWR VGND sg13cmos5l_antennanp
XFILLER_168_175 VPWR VGND sg13cmos5l_decap_8
XANTENNA__2043__X Tile_X0Y5_FrameData_O[28] VPWR VGND sg13cmos5l_antennanp
XANTENNA__2565__A0 Tile_X0Y2_W1END[0] VPWR VGND sg13cmos5l_antennanp
XFILLER_183_156 VPWR VGND sg13cmos5l_fill_2
XFILLER_194_21 VPWR VGND sg13cmos5l_decap_4
XFILLER_194_32 VPWR VGND sg13cmos5l_decap_4
XANTENNA__1882__X Tile_X0Y2_E6BEG[8] VPWR VGND sg13cmos5l_antennanp
XFILLER_325_161 VPWR VGND sg13cmos5l_fill_2
XANTENNA__2317__A0 AXIL_S_SOC_WDATA4 VPWR VGND sg13cmos5l_antennanp
XANTENNA__2580__A3 Tile_X0Y0_S4END[12] VPWR VGND sg13cmos5l_antennanp
XFILLER_194_98 VPWR VGND sg13cmos5l_fill_2
XFILLER_344_13 VPWR VGND sg13cmos5l_fill_2
XFILLER_97_129 VPWR VGND sg13cmos5l_decap_4
XFILLER_344_57 VPWR VGND sg13cmos5l_decap_8
XFILLER_340_186 VPWR VGND sg13cmos5l_fill_2
XANTENNA__1480__D Tile_X0Y5_FrameData[8] VPWR VGND sg13cmos5l_antennanp
XFILLER_213_28 VPWR VGND sg13cmos5l_fill_1
X_1030_ _1030_/Q Tile_X0Y3_FrameData[16] VGND VPWR Tile_X0Y5_FrameStrobe[7] latch
XANTENNA__0096__D Tile_X0Y0_FrameData[6] VPWR VGND sg13cmos5l_antennanp
XFILLER_261_182 VPWR VGND sg13cmos5l_decap_8
XANTENNA__0824__D Tile_X0Y3_FrameData[30] VPWR VGND sg13cmos5l_antennanp
XANTENNA__2399__A3 AXIL_S_SOC_AWADDR5 VPWR VGND sg13cmos5l_antennanp
XFILLER_14_170 VPWR VGND sg13cmos5l_fill_1
X_1932_ Tile_X0Y1_EE4BEG[13] _2322_/X VPWR VGND sg13cmos5l_buf_1
XFILLER_159_164 VPWR VGND sg13cmos5l_fill_1
XFILLER_159_186 VPWR VGND sg13cmos5l_decap_8
X_1863_ Tile_X0Y4_FrameData_O[30] Tile_X0Y4_FrameData[30] VPWR VGND sg13cmos5l_buf_1
XFILLER_174_134 VPWR VGND sg13cmos5l_decap_4
X_0814_ _0814_/Q Tile_X0Y3_FrameData[8] VGND VPWR Tile_X0Y5_FrameStrobe[0] latch
XFILLER_174_167 VPWR VGND sg13cmos5l_fill_2
X_1794_ Tile_X0Y4_E2BEG[5] _2622_/X VPWR VGND sg13cmos5l_buf_1
XANTENNA__1792__X Tile_X0Y4_E2BEG[3] VPWR VGND sg13cmos5l_antennanp
X_0745_ _0745_/Q Tile_X0Y2_FrameData[29] VGND VPWR Tile_X0Y5_FrameStrobe[6] latch
XANTENNA__2308__A0 AXIL_S_SOC_WDATA7 VPWR VGND sg13cmos5l_antennanp
X_0676_ _0676_/Q Tile_X0Y2_FrameData[2] VGND VPWR Tile_X0Y5_FrameStrobe[3] latch
XFILLER_42_0 VPWR VGND sg13cmos5l_fill_2
X_2415_ _2415_/X AXIL_S_SOC_AWADDR0 AXIL_S_SOC_AWADDR6 _2482_/X _2487_/X _0718_/Q
+ _0717_/Q VPWR VGND sg13cmos5l_mux4_1
XFILLER_229_124 VPWR VGND sg13cmos5l_decap_8
X_2346_ _2346_/X Tile_X0Y2_W1END[2] Tile_X0Y2_W6END[6] _2467_/X _2455_/X _0786_/Q
+ _0785_/Q VPWR VGND sg13cmos5l_mux4_1
XFILLER_96_162 VPWR VGND sg13cmos5l_decap_8
XANTENNA__1390__D Tile_X0Y5_FrameData[2] VPWR VGND sg13cmos5l_antennanp
X_2277_ _2277_/X Tile_X0Y2_W1END[1] Tile_X0Y2_WW4END[1] Tile_X0Y2_WW4END[5] Tile_X0Y2_W6END[9]
+ _0763_/Q _0762_/Q VPWR VGND sg13cmos5l_mux4_1
XFILLER_244_149 VPWR VGND sg13cmos5l_fill_1
X_1228_ _1228_/Q Tile_X0Y4_FrameData[26] VGND VPWR Tile_X0Y5_FrameStrobe[6] latch
XANTENNA__2128__X AXIL_S_SOC_RDATA22 VPWR VGND sg13cmos5l_antennanp
XFILLER_203_50 VPWR VGND sg13cmos5l_decap_4
XFILLER_203_61 VPWR VGND sg13cmos5l_decap_8
XFILLER_203_72 VPWR VGND sg13cmos5l_fill_1
XFILLER_237_190 VPWR VGND sg13cmos5l_fill_1
XFILLER_16_59 VPWR VGND sg13cmos5l_fill_2
X_1159_ _1159_/Q Tile_X0Y4_FrameData[31] VGND VPWR Tile_X0Y5_FrameStrobe[4] latch
XANTENNA__0734__D Tile_X0Y2_FrameData[8] VPWR VGND sg13cmos5l_antennanp
XANTENNA__1967__X Tile_X0Y5_E1BEG[0] VPWR VGND sg13cmos5l_antennanp
XFILLER_279_54 VPWR VGND sg13cmos5l_decap_8
XFILLER_279_76 VPWR VGND sg13cmos5l_decap_8
XANTENNA__2795__A0 Tile_X0Y4_W1END[2] VPWR VGND sg13cmos5l_antennanp
XFILLER_148_14 VPWR VGND sg13cmos5l_fill_1
XFILLER_148_36 VPWR VGND sg13cmos5l_decap_8
XFILLER_295_42 VPWR VGND sg13cmos5l_fill_2
XANTENNA__0164__GATE Tile_X0Y5_FrameStrobe[2] VPWR VGND sg13cmos5l_antennanp
XANTENNA__0794__GATE Tile_X0Y5_FrameStrobe[0] VPWR VGND sg13cmos5l_antennanp
XANTENNA__2547__A0 AXIL_S_SOC_ARADDR6 VPWR VGND sg13cmos5l_antennanp
XFILLER_165_178 VPWR VGND sg13cmos5l_fill_2
XFILLER_295_64 VPWR VGND sg13cmos5l_fill_2
XFILLER_228_80 VPWR VGND sg13cmos5l_decap_8
XFILLER_164_24 VPWR VGND sg13cmos5l_fill_1
XANTENNA__0179__GATE Tile_X0Y5_FrameStrobe[3] VPWR VGND sg13cmos5l_antennanp
XFILLER_164_46 VPWR VGND sg13cmos5l_decap_8
XFILLER_322_186 VPWR VGND sg13cmos5l_decap_4
XANTENNA__0102__GATE Tile_X0Y5_FrameStrobe[0] VPWR VGND sg13cmos5l_antennanp
XANTENNA__0909__D Tile_X0Y3_FrameData[9] VPWR VGND sg13cmos5l_antennanp
XANTENNA__0732__GATE Tile_X0Y5_FrameStrobe[5] VPWR VGND sg13cmos5l_antennanp
XFILLER_180_78 VPWR VGND sg13cmos5l_fill_1
XFILLER_290_211 VPWR VGND sg13cmos5l_fill_1
XANTENNA__2038__X Tile_X0Y5_FrameData_O[23] VPWR VGND sg13cmos5l_antennanp
XFILLER_250_108 VPWR VGND sg13cmos5l_fill_2
XFILLER_189_21 VPWR VGND sg13cmos5l_decap_8
XANTENNA__0117__GATE Tile_X0Y5_FrameStrobe[1] VPWR VGND sg13cmos5l_antennanp
XANTENNA__1877__X Tile_X0Y2_E6BEG[3] VPWR VGND sg13cmos5l_antennanp
XFILLER_73_87 VPWR VGND sg13cmos5l_fill_1
XANTENNA__0644__D Tile_X0Y2_FrameData[2] VPWR VGND sg13cmos5l_antennanp
XANTENNA__0747__GATE Tile_X0Y5_FrameStrobe[6] VPWR VGND sg13cmos5l_antennanp
XFILLER_244_0 VPWR VGND sg13cmos5l_fill_2
XFILLER_339_57 VPWR VGND sg13cmos5l_decap_8
XFILLER_339_46 VPWR VGND sg13cmos5l_decap_8
XANTENNA__2250__A2 Tile_X0Y1_W6END[7] VPWR VGND sg13cmos5l_antennanp
XFILLER_156_112 VPWR VGND sg13cmos5l_decap_8
XFILLER_78_9 VPWR VGND sg13cmos5l_decap_4
XANTENNA__2538__A0 AXIL_S_SOC_ARADDR1 VPWR VGND sg13cmos5l_antennanp
XANTENNA__1475__D Tile_X0Y5_FrameData[13] VPWR VGND sg13cmos5l_antennanp
XFILLER_171_137 VPWR VGND sg13cmos5l_decap_8
XANTENNA__2553__A3 Tile_X0Y3_W6END[4] VPWR VGND sg13cmos5l_antennanp
X_0530_ _0530_/Q Tile_X0Y1_FrameData[4] VGND VPWR Tile_X0Y5_FrameStrobe[6] latch
XFILLER_355_67 VPWR VGND sg13cmos5l_decap_8
XFILLER_355_56 VPWR VGND sg13cmos5l_fill_1
XFILLER_313_131 VPWR VGND sg13cmos5l_fill_1
XFILLER_112_204 VPWR VGND sg13cmos5l_fill_1
X_2200_ _2200_/X _0065_/X Tile_X0Y0_S4END[3] _2230_/X _2229_/X _0196_/Q _0195_/Q VPWR
+ VGND sg13cmos5l_mux4_1
X_0461_ _0461_/Q Tile_X0Y1_FrameData[9] VGND VPWR Tile_X0Y5_FrameStrobe[4] latch
XFILLER_224_49 VPWR VGND sg13cmos5l_fill_1
X_0392_ _0392_/Q Tile_X0Y1_FrameData[14] VGND VPWR Tile_X0Y5_FrameStrobe[2] latch
XANTENNA__0819__D Tile_X0Y3_FrameData[3] VPWR VGND sg13cmos5l_antennanp
X_2131_ AXIL_S_SOC_RDATA25 Tile_X0Y0_W2MID[1] Tile_X0Y0_W2END[1] Tile_X0Y0_W6END[1]
+ _2242_/X _0140_/Q _0139_/Q VPWR VGND sg13cmos5l_mux4_1
X_2062_ Tile_X0Y5_S2BEGb[3] _2832_/X VPWR VGND sg13cmos5l_buf_1
X_1013_ _1013_/Q Tile_X0Y3_FrameData[1] VGND VPWR Tile_X0Y5_FrameStrobe[6] latch
XFILLER_93_187 VPWR VGND sg13cmos5l_decap_8
XFILLER_234_160 VPWR VGND sg13cmos5l_decap_8
XANTENNA__1787__X Tile_X0Y4_E1BEG[2] VPWR VGND sg13cmos5l_antennanp
XANTENNA__0554__D Tile_X0Y2_FrameData[28] VPWR VGND sg13cmos5l_antennanp
XANTENNA__2777__A0 Tile_X0Y5_W1END[0] VPWR VGND sg13cmos5l_antennanp
XFILLER_249_35 VPWR VGND sg13cmos5l_decap_4
X_1915_ Tile_X0Y1_FrameData_O[28] Tile_X0Y1_FrameData[28] VPWR VGND sg13cmos5l_buf_1
XANTENNA__2241__A2 Tile_X0Y0_S2MID[0] VPWR VGND sg13cmos5l_antennanp
XANTENNA__2529__A0 AXIL_S_SOC_ARADDR4 VPWR VGND sg13cmos5l_antennanp
XFILLER_147_178 VPWR VGND sg13cmos5l_decap_8
XFILLER_162_104 VPWR VGND sg13cmos5l_decap_8
X_1846_ Tile_X0Y4_FrameData_O[13] Tile_X0Y4_FrameData[13] VPWR VGND sg13cmos5l_buf_1
XANTENNA__1385__D Tile_X0Y5_FrameData[7] VPWR VGND sg13cmos5l_antennanp
X_1777_ Tile_X0Y2_E2BEG[0] _2401_/X VPWR VGND sg13cmos5l_buf_1
XFILLER_265_78 VPWR VGND sg13cmos5l_decap_8
X_0728_ _0728_/Q Tile_X0Y2_FrameData[14] VGND VPWR Tile_X0Y5_FrameStrobe[5] latch
XFILLER_170_170 VPWR VGND sg13cmos5l_decap_8
X_0659_ _0659_/Q Tile_X0Y2_FrameData[19] VGND VPWR Tile_X0Y5_FrameStrobe[3] latch
XFILLER_304_186 VPWR VGND sg13cmos5l_fill_2
XFILLER_134_27 VPWR VGND sg13cmos5l_decap_8
XFILLER_281_33 VPWR VGND sg13cmos5l_fill_1
XANTENNA__0729__D Tile_X0Y2_FrameData[13] VPWR VGND sg13cmos5l_antennanp
XFILLER_281_88 VPWR VGND sg13cmos5l_fill_1
XFILLER_281_99 VPWR VGND sg13cmos5l_decap_4
X_2329_ _2329_/X AXIL_S_SOC_WDATA4 _2365_/X _2350_/X _2373_/X _0434_/Q _0433_/Q VPWR
+ VGND sg13cmos5l_mux4_1
XFILLER_27_14 VPWR VGND sg13cmos5l_fill_1
XFILLER_84_143 VPWR VGND sg13cmos5l_fill_2
XANTENNA__1462__GATE Tile_X0Y5_FrameStrobe[6] VPWR VGND sg13cmos5l_antennanp
XFILLER_84_187 VPWR VGND sg13cmos5l_decap_8
XFILLER_240_130 VPWR VGND sg13cmos5l_fill_2
XFILLER_43_13 VPWR VGND sg13cmos5l_fill_2
XANTENNA__0464__D Tile_X0Y1_FrameData[6] VPWR VGND sg13cmos5l_antennanp
XANTENNA__1697__X Tile_X0Y0_EE4BEG[5] VPWR VGND sg13cmos5l_antennanp
XFILLER_335_7 VPWR VGND sg13cmos5l_decap_8
XANTENNA__1477__GATE Tile_X0Y5_FrameStrobe[6] VPWR VGND sg13cmos5l_antennanp
XANTENNA__2768__A0 AXIL_S_SOC_ARVALID VPWR VGND sg13cmos5l_antennanp
XFILLER_230_6 VPWR VGND sg13cmos5l_fill_2
XFILLER_240_174 VPWR VGND sg13cmos5l_decap_4
XFILLER_327_223 VPWR VGND sg13cmos5l_fill_1
XFILLER_327_212 VPWR VGND sg13cmos5l_fill_2
XANTENNA__1400__GATE Tile_X0Y5_FrameStrobe[4] VPWR VGND sg13cmos5l_antennanp
XANTENNA__2034__A Tile_X0Y5_FrameData[19] VPWR VGND sg13cmos5l_antennanp
XANTENNA__2783__A3 Tile_X0Y5_W6END[5] VPWR VGND sg13cmos5l_antennanp
XANTENNA__1295__D Tile_X0Y5_FrameData[1] VPWR VGND sg13cmos5l_antennanp
XFILLER_239_90 VPWR VGND sg13cmos5l_decap_8
XFILLER_299_119 VPWR VGND sg13cmos5l_decap_8
XFILLER_299_108 VPWR VGND sg13cmos5l_decap_8
XFILLER_175_67 VPWR VGND sg13cmos5l_decap_8
XANTENNA__1415__GATE Tile_X0Y5_FrameStrobe[4] VPWR VGND sg13cmos5l_antennanp
XFILLER_68_65 VPWR VGND sg13cmos5l_decap_4
XANTENNA__0639__D Tile_X0Y2_FrameData[7] VPWR VGND sg13cmos5l_antennanp
XANTENNA__0671__GATE Tile_X0Y5_FrameStrobe[3] VPWR VGND sg13cmos5l_antennanp
XFILLER_191_66 VPWR VGND sg13cmos5l_decap_8
XFILLER_191_77 VPWR VGND sg13cmos5l_fill_1
XFILLER_194_0 VPWR VGND sg13cmos5l_decap_8
XFILLER_68_98 VPWR VGND sg13cmos5l_fill_2
XFILLER_341_14 VPWR VGND sg13cmos5l_decap_8
XFILLER_124_82 VPWR VGND sg13cmos5l_decap_8
XFILLER_191_99 VPWR VGND sg13cmos5l_fill_2
XFILLER_208_116 VPWR VGND sg13cmos5l_decap_4
XFILLER_263_200 VPWR VGND sg13cmos5l_fill_1
XFILLER_84_20 VPWR VGND sg13cmos5l_decap_8
XFILLER_75_132 VPWR VGND sg13cmos5l_fill_2
XFILLER_341_47 VPWR VGND sg13cmos5l_decap_8
XFILLER_341_25 VPWR VGND sg13cmos5l_fill_2
XFILLER_90_102 VPWR VGND sg13cmos5l_decap_8
XFILLER_361_0 VPWR VGND sg13cmos5l_fill_1
XFILLER_84_97 VPWR VGND sg13cmos5l_decap_8
XANTENNA__0686__GATE Tile_X0Y5_FrameStrobe[4] VPWR VGND sg13cmos5l_antennanp
XFILLER_90_179 VPWR VGND sg13cmos5l_decap_8
XANTENNA__0374__D Tile_X0Y1_FrameData[0] VPWR VGND sg13cmos5l_antennanp
XFILLER_140_81 VPWR VGND sg13cmos5l_decap_8
XFILLER_140_92 VPWR VGND sg13cmos5l_fill_1
XANTENNA__2759__A0 Tile_X0Y5_N4END[2] VPWR VGND sg13cmos5l_antennanp
XFILLER_129_101 VPWR VGND sg13cmos5l_fill_2
XFILLER_176_207 VPWR VGND sg13cmos5l_fill_2
XANTENNA__2223__A2 Tile_X0Y4_W6END[9] VPWR VGND sg13cmos5l_antennanp
XFILLER_318_223 VPWR VGND sg13cmos5l_fill_1
XFILLER_129_156 VPWR VGND sg13cmos5l_decap_8
X_1700_ Tile_X0Y0_EE4BEG[8] _2189_/X VPWR VGND sg13cmos5l_buf_1
X_2680_ _2680_/X Tile_X0Y5_W1END[3] Tile_X0Y5_W6END[7] _2801_/X _2792_/X _1490_/Q
+ _1489_/Q VPWR VGND sg13cmos5l_mux4_1
XFILLER_76_6 VPWR VGND sg13cmos5l_decap_4
XFILLER_149_90 VPWR VGND sg13cmos5l_fill_1
X_1631_ Tile_X0Y0_N2BEG[3] _2148_/X VPWR VGND sg13cmos5l_buf_1
XANTENNA__0624__GATE Tile_X0Y5_FrameStrobe[2] VPWR VGND sg13cmos5l_antennanp
X_1562_ Tile_X0Y3_FrameData_O[8] Tile_X0Y3_FrameData[8] VPWR VGND sg13cmos5l_buf_1
XFILLER_298_130 VPWR VGND sg13cmos5l_fill_2
XFILLER_152_181 VPWR VGND sg13cmos5l_decap_8
XFILLER_235_37 VPWR VGND sg13cmos5l_decap_8
X_1493_ _1493_/Q Tile_X0Y5_FrameData[27] VGND VPWR Tile_X0Y5_FrameStrobe[7] latch
X_0513_ _0513_/Q Tile_X0Y1_FrameData[21] VGND VPWR Tile_X0Y5_FrameStrobe[6] latch
XFILLER_301_123 VPWR VGND sg13cmos5l_fill_1
XFILLER_298_174 VPWR VGND sg13cmos5l_decap_8
X_0444_ _0444_/Q Tile_X0Y1_FrameData[26] VGND VPWR Tile_X0Y5_FrameStrobe[4] latch
XFILLER_301_134 VPWR VGND sg13cmos5l_decap_8
XANTENNA__0549__D Tile_X0Y1_FrameData[17] VPWR VGND sg13cmos5l_antennanp
XANTENNA__0639__GATE Tile_X0Y5_FrameStrobe[2] VPWR VGND sg13cmos5l_antennanp
XFILLER_66_110 VPWR VGND sg13cmos5l_decap_8
XFILLER_301_178 VPWR VGND sg13cmos5l_decap_4
XFILLER_104_19 VPWR VGND sg13cmos5l_fill_1
XFILLER_254_222 VPWR VGND sg13cmos5l_fill_2
X_2114_ AXIL_S_SOC_RDATA8 Tile_X0Y2_W2MID[0] Tile_X0Y2_W2END[0] Tile_X0Y2_W6END[0]
+ _2481_/X _0622_/Q _0621_/Q VPWR VGND sg13cmos5l_mux4_1
X_0375_ _0375_/Q Tile_X0Y1_FrameData[31] VGND VPWR Tile_X0Y5_FrameStrobe[2] latch
XFILLER_251_69 VPWR VGND sg13cmos5l_fill_2
XFILLER_207_160 VPWR VGND sg13cmos5l_decap_8
X_2045_ Tile_X0Y5_FrameData_O[30] Tile_X0Y5_FrameData[30] VPWR VGND sg13cmos5l_buf_1
XANTENNA__0284__D Tile_X0Y0_FrameData[10] VPWR VGND sg13cmos5l_antennanp
XFILLER_222_141 VPWR VGND sg13cmos5l_decap_8
XFILLER_222_152 VPWR VGND sg13cmos5l_decap_8
XFILLER_13_16 VPWR VGND sg13cmos5l_fill_2
XFILLER_129_38 VPWR VGND sg13cmos5l_fill_1
XFILLER_190_221 VPWR VGND sg13cmos5l_fill_2
XFILLER_276_77 VPWR VGND sg13cmos5l_decap_8
X_1829_ Tile_X0Y4_EE4BEG[12] _2645_/X VPWR VGND sg13cmos5l_buf_1
XFILLER_89_213 VPWR VGND sg13cmos5l_fill_1
XANTENNA__1980__X Tile_X0Y5_E2BEGb[1] VPWR VGND sg13cmos5l_antennanp
XFILLER_143_170 VPWR VGND sg13cmos5l_fill_1
XFILLER_292_43 VPWR VGND sg13cmos5l_fill_2
XFILLER_292_54 VPWR VGND sg13cmos5l_decap_8
XFILLER_8_9 VPWR VGND sg13cmos5l_fill_2
XANTENNA__0459__D Tile_X0Y1_FrameData[11] VPWR VGND sg13cmos5l_antennanp
XFILLER_292_8 VPWR VGND sg13cmos5l_fill_2
XANTENNA__2150__A1 Tile_X0Y0_W2END[2] VPWR VGND sg13cmos5l_antennanp
XFILLER_245_222 VPWR VGND sg13cmos5l_fill_2
XFILLER_278_6 VPWR VGND sg13cmos5l_fill_2
XANTENNA__2029__A Tile_X0Y5_FrameData[14] VPWR VGND sg13cmos5l_antennanp
XFILLER_205_119 VPWR VGND sg13cmos5l_fill_1
XFILLER_54_45 VPWR VGND sg13cmos5l_fill_1
XFILLER_359_101 VPWR VGND sg13cmos5l_decap_8
XANTENNA__0194__D Tile_X0Y0_FrameData[4] VPWR VGND sg13cmos5l_antennanp
XANTENNA__2453__A2 Tile_X0Y2_W6END[0] VPWR VGND sg13cmos5l_antennanp
XFILLER_213_130 VPWR VGND sg13cmos5l_decap_4
XFILLER_213_185 VPWR VGND sg13cmos5l_decap_8
XANTENNA__0922__D Tile_X0Y3_FrameData[28] VPWR VGND sg13cmos5l_antennanp
XFILLER_186_22 VPWR VGND sg13cmos5l_fill_2
XFILLER_186_44 VPWR VGND sg13cmos5l_decap_8
XFILLER_70_77 VPWR VGND sg13cmos5l_decap_8
XFILLER_181_210 VPWR VGND sg13cmos5l_decap_8
XFILLER_186_77 VPWR VGND sg13cmos5l_decap_8
XANTENNA__2051__X Tile_X0Y5_S2BEG[0] VPWR VGND sg13cmos5l_antennanp
XFILLER_181_221 VPWR VGND sg13cmos5l_fill_2
XFILLER_207_0 VPWR VGND sg13cmos5l_fill_1
XFILLER_79_20 VPWR VGND sg13cmos5l_decap_8
XFILLER_336_14 VPWR VGND sg13cmos5l_fill_2
XANTENNA__1354__GATE Tile_X0Y5_FrameStrobe[2] VPWR VGND sg13cmos5l_antennanp
XANTENNA__2508__A3 AXIL_S_SOC_ARADDR4 VPWR VGND sg13cmos5l_antennanp
XFILLER_119_93 VPWR VGND sg13cmos5l_decap_8
XFILLER_336_47 VPWR VGND sg13cmos5l_decap_8
XANTENNA__1890__X Tile_X0Y1_FrameData_O[3] VPWR VGND sg13cmos5l_antennanp
XFILLER_134_192 VPWR VGND sg13cmos5l_decap_4
XFILLER_79_75 VPWR VGND sg13cmos5l_decap_8
XFILLER_352_24 VPWR VGND sg13cmos5l_decap_8
XANTENNA__0369__D Tile_X0Y1_FrameData[5] VPWR VGND sg13cmos5l_antennanp
XFILLER_135_92 VPWR VGND sg13cmos5l_decap_8
XFILLER_295_166 VPWR VGND sg13cmos5l_decap_8
XFILLER_295_155 VPWR VGND sg13cmos5l_fill_1
XANTENNA__1369__GATE Tile_X0Y5_FrameStrobe[3] VPWR VGND sg13cmos5l_antennanp
XANTENNA__2141__A1 Tile_X0Y0_W6END[4] VPWR VGND sg13cmos5l_antennanp
XFILLER_95_52 VPWR VGND sg13cmos5l_decap_8
XFILLER_352_68 VPWR VGND sg13cmos5l_decap_8
X_0160_ _0160_/Q Tile_X0Y0_FrameData[6] VGND VPWR Tile_X0Y5_FrameStrobe[2] latch
XFILLER_251_203 VPWR VGND sg13cmos5l_decap_8
XFILLER_28_90 VPWR VGND sg13cmos5l_decap_4
X_0091_ _0091_/Q Tile_X0Y0_FrameData[11] VGND VPWR Tile_X0Y5_FrameStrobe[0] latch
XFILLER_63_124 VPWR VGND sg13cmos5l_decap_4
XFILLER_204_141 VPWR VGND sg13cmos5l_decap_8
XFILLER_149_207 VPWR VGND sg13cmos5l_fill_1
XFILLER_71_190 VPWR VGND sg13cmos5l_decap_4
XANTENNA__1307__GATE Tile_X0Y5_FrameStrobe[1] VPWR VGND sg13cmos5l_antennanp
X_2801_ _2801_/X Tile_X0Y5_N1END[3] Tile_X0Y5_N4END[3] _2796_/X _0057_/X _1290_/Q
+ _1289_/Q VPWR VGND sg13cmos5l_mux4_1
X_0993_ _0993_/Q Tile_X0Y3_FrameData[21] VGND VPWR Tile_X0Y5_FrameStrobe[6] latch
XANTENNA__0832__D Tile_X0Y3_FrameData[22] VPWR VGND sg13cmos5l_antennanp
X_2732_ _2732_/X AXIL_S_SOC_ARPROT0 AXIL_S_SOC_ARPROT2 _2825_/X _2797_/X _1438_/Q
+ _1437_/Q VPWR VGND sg13cmos5l_mux4_1
XANTENNA__0563__GATE Tile_X0Y5_FrameStrobe[0] VPWR VGND sg13cmos5l_antennanp
XFILLER_117_137 VPWR VGND sg13cmos5l_decap_8
XFILLER_246_14 VPWR VGND sg13cmos5l_fill_1
X_2663_ _2663_/X Tile_X0Y4_W1END[1] Tile_X0Y4_WW4END[13] Tile_X0Y4_W6END[5] _2705_/X
+ _1105_/Q _1104_/Q VPWR VGND sg13cmos5l_mux4_1
X_1614_ Tile_X0Y0_N4BEG[10] _1614_/A VPWR VGND sg13cmos5l_buf_1
X_2594_ _2594_/X _2500_/X _2608_/X _2607_/X _2499_/X _0804_/Q _0803_/Q VPWR VGND sg13cmos5l_mux4_1
XFILLER_132_129 VPWR VGND sg13cmos5l_fill_2
X_1545_ Tile_X0Y3_EE4BEG[7] _2532_/X VPWR VGND sg13cmos5l_buf_1
XANTENNA__0578__GATE Tile_X0Y5_FrameStrobe[0] VPWR VGND sg13cmos5l_antennanp
XANTENNA__0279__D Tile_X0Y0_FrameData[15] VPWR VGND sg13cmos5l_antennanp
XFILLER_140_173 VPWR VGND sg13cmos5l_decap_8
XFILLER_140_184 VPWR VGND sg13cmos5l_fill_2
XFILLER_262_35 VPWR VGND sg13cmos5l_fill_2
X_1476_ _1476_/Q Tile_X0Y5_FrameData[12] VGND VPWR Tile_X0Y5_FrameStrobe[6] latch
XANTENNA__2132__A1 Tile_X0Y0_W2END[2] VPWR VGND sg13cmos5l_antennanp
X_0427_ _0427_/Q Tile_X0Y1_FrameData[11] VGND VPWR Tile_X0Y5_FrameStrobe[3] latch
XANTENNA__0501__GATE Tile_X0Y5_FrameStrobe[5] VPWR VGND sg13cmos5l_antennanp
X_0358_ _0358_/Q Tile_X0Y1_FrameData[16] VGND VPWR Tile_X0Y5_FrameStrobe[1] latch
XFILLER_131_39 VPWR VGND sg13cmos5l_decap_8
XFILLER_199_107 VPWR VGND sg13cmos5l_fill_2
X_2028_ Tile_X0Y5_FrameData_O[13] Tile_X0Y5_FrameData[13] VPWR VGND sg13cmos5l_buf_1
X_0289_ _0289_/Q Tile_X0Y0_FrameData[5] VGND VPWR Tile_X0Y5_FrameStrobe[6] latch
XFILLER_54_157 VPWR VGND sg13cmos5l_decap_8
XANTENNA__1688__A Tile_X0Y0_FrameData[28] VPWR VGND sg13cmos5l_antennanp
XANTENNA__0516__GATE Tile_X0Y5_FrameStrobe[6] VPWR VGND sg13cmos5l_antennanp
XANTENNA__2136__X AXIL_S_SOC_RDATA30 VPWR VGND sg13cmos5l_antennanp
XFILLER_211_83 VPWR VGND sg13cmos5l_decap_8
XFILLER_287_43 VPWR VGND sg13cmos5l_fill_2
XANTENNA__0742__D Tile_X0Y2_FrameData[0] VPWR VGND sg13cmos5l_antennanp
XANTENNA__1975__X Tile_X0Y5_E2BEG[4] VPWR VGND sg13cmos5l_antennanp
XANTENNA__2199__A1 Tile_X0Y0_S4END[2] VPWR VGND sg13cmos5l_antennanp
XFILLER_210_177 VPWR VGND sg13cmos5l_decap_8
XFILLER_163_210 VPWR VGND sg13cmos5l_decap_8
XFILLER_108_137 VPWR VGND sg13cmos5l_decap_8
XFILLER_163_221 VPWR VGND sg13cmos5l_fill_2
XFILLER_40_69 VPWR VGND sg13cmos5l_decap_4
XFILLER_306_39 VPWR VGND sg13cmos5l_fill_1
XANTENNA__0189__D Tile_X0Y0_FrameData[9] VPWR VGND sg13cmos5l_antennanp
XFILLER_277_144 VPWR VGND sg13cmos5l_decap_4
XANTENNA__2123__A1 Tile_X0Y1_W2END[1] VPWR VGND sg13cmos5l_antennanp
XFILLER_277_199 VPWR VGND sg13cmos5l_decap_8
XANTENNA__0917__D Tile_X0Y3_FrameData[1] VPWR VGND sg13cmos5l_antennanp
XFILLER_65_66 VPWR VGND sg13cmos5l_decap_8
XFILLER_45_124 VPWR VGND sg13cmos5l_decap_8
XANTENNA__2046__X Tile_X0Y5_FrameData_O[31] VPWR VGND sg13cmos5l_antennanp
XFILLER_201_144 VPWR VGND sg13cmos5l_decap_4
XFILLER_347_126 VPWR VGND sg13cmos5l_decap_8
XANTENNA__0652__D Tile_X0Y2_FrameData[26] VPWR VGND sg13cmos5l_antennanp
XANTENNA__1885__X Tile_X0Y2_E6BEG[11] VPWR VGND sg13cmos5l_antennanp
XFILLER_324_0 VPWR VGND sg13cmos5l_fill_1
XFILLER_347_35 VPWR VGND sg13cmos5l_decap_8
XFILLER_154_221 VPWR VGND sg13cmos5l_fill_2
XFILLER_355_192 VPWR VGND sg13cmos5l_decap_8
XFILLER_355_181 VPWR VGND sg13cmos5l_fill_1
XANTENNA__1293__GATE Tile_X0Y5_FrameStrobe[0] VPWR VGND sg13cmos5l_antennanp
XANTENNA__1483__D Tile_X0Y5_FrameData[5] VPWR VGND sg13cmos5l_antennanp
XFILLER_216_28 VPWR VGND sg13cmos5l_fill_2
XFILLER_122_140 VPWR VGND sg13cmos5l_fill_2
XFILLER_268_111 VPWR VGND sg13cmos5l_fill_1
XFILLER_268_122 VPWR VGND sg13cmos5l_decap_8
X_1330_ _1330_/Q Tile_X0Y5_FrameData[30] VGND VPWR Tile_X0Y5_FrameStrobe[2] latch
XANTENNA__0099__D Tile_X0Y0_FrameData[3] VPWR VGND sg13cmos5l_antennanp
XFILLER_268_144 VPWR VGND sg13cmos5l_decap_8
XANTENNA__2114__A1 Tile_X0Y2_W2END[0] VPWR VGND sg13cmos5l_antennanp
XFILLER_209_211 VPWR VGND sg13cmos5l_decap_4
XFILLER_283_125 VPWR VGND sg13cmos5l_fill_2
X_1261_ _1261_/Q Tile_X0Y4_FrameData[25] VGND VPWR Tile_X0Y5_FrameStrobe[7] latch
X_1192_ _1192_/Q Tile_X0Y4_FrameData[30] VGND VPWR Tile_X0Y5_FrameStrobe[5] latch
X_0212_ _0212_/Q Tile_X0Y0_FrameData[18] VGND VPWR Tile_X0Y5_FrameStrobe[4] latch
XANTENNA__0827__D Tile_X0Y3_FrameData[27] VPWR VGND sg13cmos5l_antennanp
XANTENNA__1231__GATE Tile_X0Y5_FrameStrobe[6] VPWR VGND sg13cmos5l_antennanp
XANTENNA__2665__A2 Tile_X0Y4_W6END[6] VPWR VGND sg13cmos5l_antennanp
XFILLER_162_90 VPWR VGND sg13cmos5l_decap_8
X_0143_ _0143_/Q Tile_X0Y0_FrameData[23] VGND VPWR Tile_X0Y5_FrameStrobe[2] latch
XFILLER_36_102 VPWR VGND sg13cmos5l_decap_8
XFILLER_36_146 VPWR VGND sg13cmos5l_decap_4
X_0074_ _0074_/Q Tile_X0Y0_FrameData[28] VGND VPWR Tile_X0Y5_FrameStrobe[0] latch
XFILLER_36_179 VPWR VGND sg13cmos5l_decap_8
XANTENNA__1246__GATE Tile_X0Y5_FrameStrobe[6] VPWR VGND sg13cmos5l_antennanp
XANTENNA__0562__D Tile_X0Y2_FrameData[20] VPWR VGND sg13cmos5l_antennanp
XANTENNA__1795__X Tile_X0Y4_E2BEG[6] VPWR VGND sg13cmos5l_antennanp
X_0976_ _0976_/Q Tile_X0Y3_FrameData[6] VGND VPWR Tile_X0Y5_FrameStrobe[5] latch
XFILLER_353_118 VPWR VGND sg13cmos5l_decap_8
XFILLER_257_57 VPWR VGND sg13cmos5l_decap_8
X_2715_ _2715_/X Tile_X0Y3_W2MID[5] Tile_X0Y3_W2END[5] Tile_X0Y3_W6END[10] _2591_/X
+ _0886_/Q _0885_/Q VPWR VGND sg13cmos5l_mux4_1
X_2646_ _2646_/X Tile_X0Y4_WW4END[9] AXIL_S_SOC_WSTRB1 _2703_/X _2710_/X _1162_/Q
+ _1161_/Q VPWR VGND sg13cmos5l_mux4_1
XANTENNA__1393__D Tile_X0Y5_FrameData[31] VPWR VGND sg13cmos5l_antennanp
XFILLER_361_162 VPWR VGND sg13cmos5l_fill_2
XFILLER_259_100 VPWR VGND sg13cmos5l_fill_2
X_2577_ _2577_/X _2568_/X Tile_X0Y5_N4END[9] _2567_/X Tile_X0Y0_S4END[13] _0820_/Q
+ _0819_/Q VPWR VGND sg13cmos5l_mux4_1
XFILLER_113_162 VPWR VGND sg13cmos5l_decap_8
X_1528_ Tile_X0Y3_E6BEG[2] _2543_/X VPWR VGND sg13cmos5l_buf_1
XANTENNA__0440__GATE Tile_X0Y5_FrameStrobe[4] VPWR VGND sg13cmos5l_antennanp
XFILLER_19_15 VPWR VGND sg13cmos5l_fill_1
X_1459_ _1459_/Q Tile_X0Y5_FrameData[29] VGND VPWR Tile_X0Y5_FrameStrobe[6] latch
XANTENNA__2105__A1 Tile_X0Y5_W2END[0] VPWR VGND sg13cmos5l_antennanp
XFILLER_19_59 VPWR VGND sg13cmos5l_fill_1
XFILLER_274_147 VPWR VGND sg13cmos5l_fill_2
XANTENNA__0737__D Tile_X0Y2_FrameData[5] VPWR VGND sg13cmos5l_antennanp
XANTENNA__0455__GATE Tile_X0Y5_FrameStrobe[4] VPWR VGND sg13cmos5l_antennanp
XFILLER_230_206 VPWR VGND sg13cmos5l_fill_2
XFILLER_298_86 VPWR VGND sg13cmos5l_fill_1
XANTENNA__0472__D Tile_X0Y1_FrameData[30] VPWR VGND sg13cmos5l_antennanp
XFILLER_195_132 VPWR VGND sg13cmos5l_fill_1
XFILLER_195_187 VPWR VGND sg13cmos5l_decap_8
XFILLER_195_198 VPWR VGND sg13cmos5l_fill_2
XANTENNA__2042__A Tile_X0Y5_FrameData[27] VPWR VGND sg13cmos5l_antennanp
XFILLER_317_38 VPWR VGND sg13cmos5l_fill_2
XFILLER_151_213 VPWR VGND sg13cmos5l_fill_2
XFILLER_2_223 VPWR VGND sg13cmos5l_fill_1
XFILLER_297_206 VPWR VGND sg13cmos5l_fill_2
XANTENNA__2344__A1 Tile_X0Y2_W6END[5] VPWR VGND sg13cmos5l_antennanp
XFILLER_183_78 VPWR VGND sg13cmos5l_decap_8
XANTENNA__0408__GATE Tile_X0Y5_FrameStrobe[3] VPWR VGND sg13cmos5l_antennanp
XFILLER_76_10 VPWR VGND sg13cmos5l_fill_1
XFILLER_333_48 VPWR VGND sg13cmos5l_decap_8
XFILLER_65_208 VPWR VGND sg13cmos5l_fill_2
XANTENNA__0647__D Tile_X0Y2_FrameData[31] VPWR VGND sg13cmos5l_antennanp
XFILLER_274_0 VPWR VGND sg13cmos5l_fill_2
XFILLER_92_20 VPWR VGND sg13cmos5l_decap_8
XFILLER_221_206 VPWR VGND sg13cmos5l_decap_8
XFILLER_186_121 VPWR VGND sg13cmos5l_fill_1
XANTENNA__0382__D Tile_X0Y1_FrameData[24] VPWR VGND sg13cmos5l_antennanp
XANTENNA__1478__D Tile_X0Y5_FrameData[10] VPWR VGND sg13cmos5l_antennanp
X_0830_ _0830_/Q Tile_X0Y3_FrameData[24] VGND VPWR Tile_X0Y5_FrameStrobe[1] latch
XFILLER_358_78 VPWR VGND sg13cmos5l_fill_1
XFILLER_127_210 VPWR VGND sg13cmos5l_decap_4
XFILLER_127_221 VPWR VGND sg13cmos5l_fill_2
X_0761_ _0761_/Q Tile_X0Y2_FrameData[13] VGND VPWR Tile_X0Y5_FrameStrobe[6] latch
XANTENNA__2583__A1 Tile_X0Y5_N4END[11] VPWR VGND sg13cmos5l_antennanp
X_2500_ _2500_/X Tile_X0Y4_W2MID[2] Tile_X0Y4_W2END[2] Tile_X0Y4_W6END[2] _2683_/X
+ _1246_/Q _1245_/Q VPWR VGND sg13cmos5l_mux4_1
XFILLER_343_151 VPWR VGND sg13cmos5l_fill_2
XFILLER_343_140 VPWR VGND sg13cmos5l_decap_8
X_2431_ _2431_/X AXIL_S_SOC_AWADDR0 AXIL_S_SOC_AWADDR2 _2478_/X _2482_/X _0686_/Q
+ _0685_/Q VPWR VGND sg13cmos5l_mux4_1
X_0692_ _0692_/Q Tile_X0Y2_FrameData[18] VGND VPWR Tile_X0Y5_FrameStrobe[4] latch
X_2362_ _2362_/X _2342_/X _0063_/X _2341_/X Tile_X0Y0_S4END[4] _0350_/Q _0349_/Q VPWR
+ VGND sg13cmos5l_mux4_1
XFILLER_307_93 VPWR VGND sg13cmos5l_fill_1
XFILLER_110_110 VPWR VGND sg13cmos5l_decap_8
XFILLER_243_37 VPWR VGND sg13cmos5l_decap_8
X_1313_ _1313_/Q Tile_X0Y5_FrameData[15] VGND VPWR Tile_X0Y5_FrameStrobe[1] latch
X_2293_ _2293_/X AXIL_S_SOC_WDATA0 AXIL_S_SOC_WDATA8 _2373_/X _2380_/X _0506_/Q _0505_/Q
+ VPWR VGND sg13cmos5l_mux4_1
XANTENNA__1170__GATE Tile_X0Y5_FrameStrobe[4] VPWR VGND sg13cmos5l_antennanp
X_1244_ _1244_/Q Tile_X0Y4_FrameData[10] VGND VPWR Tile_X0Y5_FrameStrobe[6] latch
XANTENNA__0557__D Tile_X0Y2_FrameData[25] VPWR VGND sg13cmos5l_antennanp
XFILLER_2_95 VPWR VGND sg13cmos5l_fill_1
X_1175_ _1175_/Q Tile_X0Y4_FrameData[15] VGND VPWR Tile_X0Y5_FrameStrobe[4] latch
X_0126_ _0126_/Q Tile_X0Y0_FrameData[8] VGND VPWR Tile_X0Y5_FrameStrobe[1] latch
XANTENNA__1185__GATE Tile_X0Y5_FrameStrobe[4] VPWR VGND sg13cmos5l_antennanp
X_0057_ _0057_/X _2815_/X _2816_/X _0383_/Q VPWR VGND sg13cmos5l_mux2_1
XANTENNA__2271__A0 Tile_X0Y1_W1END[0] VPWR VGND sg13cmos5l_antennanp
XANTENNA__0292__D Tile_X0Y0_FrameData[2] VPWR VGND sg13cmos5l_antennanp
XANTENNA__1388__D Tile_X0Y5_FrameData[4] VPWR VGND sg13cmos5l_antennanp
XFILLER_177_132 VPWR VGND sg13cmos5l_fill_1
XFILLER_32_171 VPWR VGND sg13cmos5l_decap_8
XFILLER_192_102 VPWR VGND sg13cmos5l_decap_8
XFILLER_192_113 VPWR VGND sg13cmos5l_fill_2
XFILLER_118_221 VPWR VGND sg13cmos5l_fill_2
XFILLER_319_181 VPWR VGND sg13cmos5l_fill_2
XANTENNA__2574__A1 Tile_X0Y5_N4END[11] VPWR VGND sg13cmos5l_antennanp
X_0959_ _0959_/Q Tile_X0Y3_FrameData[23] VGND VPWR Tile_X0Y5_FrameStrobe[5] latch
XANTENNA__1123__GATE Tile_X0Y5_FrameStrobe[2] VPWR VGND sg13cmos5l_antennanp
XFILLER_108_9 VPWR VGND sg13cmos5l_fill_1
XANTENNA__2326__A1 Tile_X0Y0_S4END[5] VPWR VGND sg13cmos5l_antennanp
X_2629_ _2629_/X AXIL_S_SOC_WSTRB0 AXIL_S_SOC_WVALID _2711_/X _2712_/X _1196_/Q _1195_/Q
+ VPWR VGND sg13cmos5l_mux4_1
XFILLER_101_110 VPWR VGND sg13cmos5l_decap_8
XFILLER_247_103 VPWR VGND sg13cmos5l_fill_1
XANTENNA__1138__GATE Tile_X0Y5_FrameStrobe[3] VPWR VGND sg13cmos5l_antennanp
XFILLER_247_125 VPWR VGND sg13cmos5l_decap_8
XFILLER_247_147 VPWR VGND sg13cmos5l_decap_8
XANTENNA__0467__D Tile_X0Y1_FrameData[3] VPWR VGND sg13cmos5l_antennanp
XFILLER_101_187 VPWR VGND sg13cmos5l_decap_4
XFILLER_101_198 VPWR VGND sg13cmos5l_decap_8
XANTENNA__0394__GATE Tile_X0Y5_FrameStrobe[2] VPWR VGND sg13cmos5l_antennanp
XFILLER_233_92 VPWR VGND sg13cmos5l_decap_8
XFILLER_15_105 VPWR VGND sg13cmos5l_decap_4
XANTENNA__2037__A Tile_X0Y5_FrameData[22] VPWR VGND sg13cmos5l_antennanp
XANTENNA__2262__A0 Tile_X0Y1_W2MID[1] VPWR VGND sg13cmos5l_antennanp
XFILLER_102_96 VPWR VGND sg13cmos5l_decap_8
XFILLER_357_210 VPWR VGND sg13cmos5l_fill_2
XANTENNA__1298__D Tile_X0Y5_FrameData[30] VPWR VGND sg13cmos5l_antennanp
XFILLER_178_67 VPWR VGND sg13cmos5l_decap_8
XFILLER_183_124 VPWR VGND sg13cmos5l_decap_4
XANTENNA__0332__GATE Tile_X0Y5_FrameStrobe[0] VPWR VGND sg13cmos5l_antennanp
XANTENNA__0930__D Tile_X0Y3_FrameData[20] VPWR VGND sg13cmos5l_antennanp
XANTENNA__2565__A1 Tile_X0Y2_W6END[8] VPWR VGND sg13cmos5l_antennanp
XANTENNA__0962__GATE Tile_X0Y5_FrameStrobe[5] VPWR VGND sg13cmos5l_antennanp
XFILLER_325_184 VPWR VGND sg13cmos5l_decap_4
XANTENNA__2317__A1 AXIL_S_SOC_WDATA8 VPWR VGND sg13cmos5l_antennanp
XFILLER_11_93 VPWR VGND sg13cmos5l_decap_4
XFILLER_194_77 VPWR VGND sg13cmos5l_decap_8
XFILLER_2_0 VPWR VGND sg13cmos5l_fill_2
XANTENNA__0347__GATE Tile_X0Y5_FrameStrobe[1] VPWR VGND sg13cmos5l_antennanp
XFILLER_127_93 VPWR VGND sg13cmos5l_decap_8
XFILLER_87_20 VPWR VGND sg13cmos5l_decap_8
XFILLER_340_154 VPWR VGND sg13cmos5l_fill_2
XANTENNA__0977__GATE Tile_X0Y5_FrameStrobe[5] VPWR VGND sg13cmos5l_antennanp
XFILLER_87_64 VPWR VGND sg13cmos5l_fill_2
XFILLER_87_97 VPWR VGND sg13cmos5l_decap_8
XFILLER_38_208 VPWR VGND sg13cmos5l_decap_8
XANTENNA__0377__D Tile_X0Y1_FrameData[29] VPWR VGND sg13cmos5l_antennanp
XFILLER_143_81 VPWR VGND sg13cmos5l_decap_8
XFILLER_253_106 VPWR VGND sg13cmos5l_decap_4
XANTENNA__0900__GATE Tile_X0Y5_FrameStrobe[3] VPWR VGND sg13cmos5l_antennanp
XANTENNA__0915__GATE Tile_X0Y5_FrameStrobe[3] VPWR VGND sg13cmos5l_antennanp
XANTENNA__2253__A0 Tile_X0Y2_W2MID[5] VPWR VGND sg13cmos5l_antennanp
X_1931_ Tile_X0Y1_EE4BEG[12] _2321_/X VPWR VGND sg13cmos5l_buf_1
XANTENNA__1001__D Tile_X0Y3_FrameData[13] VPWR VGND sg13cmos5l_antennanp
X_1862_ Tile_X0Y4_FrameData_O[29] Tile_X0Y4_FrameData[29] VPWR VGND sg13cmos5l_buf_1
X_0813_ _0813_/Q Tile_X0Y3_FrameData[9] VGND VPWR Tile_X0Y5_FrameStrobe[0] latch
XANTENNA__0840__D Tile_X0Y3_FrameData[14] VPWR VGND sg13cmos5l_antennanp
X_1793_ Tile_X0Y4_E2BEG[4] _2621_/X VPWR VGND sg13cmos5l_buf_1
X_0744_ _0744_/Q Tile_X0Y2_FrameData[30] VGND VPWR Tile_X0Y5_FrameStrobe[6] latch
XANTENNA__2308__A1 AXIL_S_SOC_WDATA15 VPWR VGND sg13cmos5l_antennanp
X_0675_ _0675_/Q Tile_X0Y2_FrameData[3] VGND VPWR Tile_X0Y5_FrameStrobe[3] latch
XFILLER_130_216 VPWR VGND sg13cmos5l_fill_2
XFILLER_254_36 VPWR VGND sg13cmos5l_decap_8
XFILLER_254_47 VPWR VGND sg13cmos5l_fill_1
XFILLER_254_58 VPWR VGND sg13cmos5l_fill_2
X_2414_ _2414_/X AXIL_S_SOC_AWADDR5 AXIL_S_SOC_AWVALID _2483_/X _2486_/X _0720_/Q
+ _0719_/Q VPWR VGND sg13cmos5l_mux4_1
XFILLER_88_119 VPWR VGND sg13cmos5l_decap_8
XFILLER_229_103 VPWR VGND sg13cmos5l_decap_8
X_2345_ _2345_/X Tile_X0Y0_W1END[2] Tile_X0Y0_W6END[10] _2221_/X _2211_/X _0174_/Q
+ _0173_/Q VPWR VGND sg13cmos5l_mux4_1
XFILLER_96_141 VPWR VGND sg13cmos5l_decap_8
XANTENNA__0287__D Tile_X0Y0_FrameData[7] VPWR VGND sg13cmos5l_antennanp
XFILLER_270_46 VPWR VGND sg13cmos5l_decap_4
X_2276_ _2276_/X _2476_/X _2474_/X _2468_/X _2467_/X _0760_/Q _0759_/Q VPWR VGND sg13cmos5l_mux4_1
X_1227_ _1227_/Q Tile_X0Y4_FrameData[27] VGND VPWR Tile_X0Y5_FrameStrobe[6] latch
XANTENNA__2492__A0 Tile_X0Y4_W2MID[6] VPWR VGND sg13cmos5l_antennanp
X_1158_ _1158_/Q Tile_X0Y4_FrameData[0] VGND VPWR Tile_X0Y5_FrameStrobe[3] latch
XFILLER_203_84 VPWR VGND sg13cmos5l_fill_2
XFILLER_252_172 VPWR VGND sg13cmos5l_decap_8
X_0109_ _0109_/Q Tile_X0Y0_FrameData[25] VGND VPWR Tile_X0Y5_FrameStrobe[1] latch
X_1089_ _1089_/Q Tile_X0Y4_FrameData[5] VGND VPWR Tile_X0Y5_FrameStrobe[1] latch
XFILLER_200_209 VPWR VGND sg13cmos5l_decap_4
XANTENNA__2795__A1 Tile_X0Y4_W6END[10] VPWR VGND sg13cmos5l_antennanp
XFILLER_165_113 VPWR VGND sg13cmos5l_decap_8
XFILLER_165_124 VPWR VGND sg13cmos5l_fill_1
XANTENNA__0750__D Tile_X0Y2_FrameData[24] VPWR VGND sg13cmos5l_antennanp
XANTENNA__1983__X Tile_X0Y5_E2BEGb[4] VPWR VGND sg13cmos5l_antennanp
XFILLER_165_146 VPWR VGND sg13cmos5l_decap_8
XFILLER_165_157 VPWR VGND sg13cmos5l_fill_2
XFILLER_295_76 VPWR VGND sg13cmos5l_fill_1
XFILLER_295_54 VPWR VGND sg13cmos5l_decap_4
XANTENNA__1062__GATE Tile_X0Y5_FrameStrobe[0] VPWR VGND sg13cmos5l_antennanp
XFILLER_106_6 VPWR VGND sg13cmos5l_fill_2
XFILLER_307_195 VPWR VGND sg13cmos5l_fill_2
XANTENNA__1077__GATE Tile_X0Y5_FrameStrobe[1] VPWR VGND sg13cmos5l_antennanp
XFILLER_87_185 VPWR VGND sg13cmos5l_fill_2
XANTENNA__0197__D Tile_X0Y0_FrameData[1] VPWR VGND sg13cmos5l_antennanp
XANTENNA__1000__GATE Tile_X0Y5_FrameStrobe[6] VPWR VGND sg13cmos5l_antennanp
XFILLER_330_27 VPWR VGND sg13cmos5l_decap_8
XFILLER_330_16 VPWR VGND sg13cmos5l_fill_1
XANTENNA__0925__D Tile_X0Y3_FrameData[25] VPWR VGND sg13cmos5l_antennanp
XFILLER_113_84 VPWR VGND sg13cmos5l_decap_8
XFILLER_188_216 VPWR VGND sg13cmos5l_fill_2
XFILLER_73_66 VPWR VGND sg13cmos5l_decap_8
XANTENNA__1015__GATE Tile_X0Y5_FrameStrobe[7] VPWR VGND sg13cmos5l_antennanp
XFILLER_339_14 VPWR VGND sg13cmos5l_fill_2
XANTENNA__2054__X Tile_X0Y5_S2BEG[3] VPWR VGND sg13cmos5l_antennanp
XFILLER_237_0 VPWR VGND sg13cmos5l_fill_1
XFILLER_339_25 VPWR VGND sg13cmos5l_decap_8
XANTENNA__0271__GATE Tile_X0Y5_FrameStrobe[6] VPWR VGND sg13cmos5l_antennanp
XFILLER_156_135 VPWR VGND sg13cmos5l_decap_8
XFILLER_7_101 VPWR VGND sg13cmos5l_fill_1
XANTENNA__0660__D Tile_X0Y2_FrameData[18] VPWR VGND sg13cmos5l_antennanp
XANTENNA__1893__X Tile_X0Y1_FrameData_O[6] VPWR VGND sg13cmos5l_antennanp
XANTENNA__2538__A1 AXIL_S_SOC_ARADDR3 VPWR VGND sg13cmos5l_antennanp
XFILLER_156_146 VPWR VGND sg13cmos5l_fill_2
XFILLER_156_179 VPWR VGND sg13cmos5l_decap_8
XANTENNA__0286__GATE Tile_X0Y5_FrameStrobe[6] VPWR VGND sg13cmos5l_antennanp
XFILLER_98_30 VPWR VGND sg13cmos5l_decap_8
X_0460_ _0460_/Q Tile_X0Y1_FrameData[10] VGND VPWR Tile_X0Y5_FrameStrobe[4] latch
XFILLER_313_187 VPWR VGND sg13cmos5l_fill_1
XANTENNA__1491__D Tile_X0Y5_FrameData[29] VPWR VGND sg13cmos5l_antennanp
XANTENNA__2710__A1 Tile_X0Y5_N2MID[2] VPWR VGND sg13cmos5l_antennanp
XFILLER_224_28 VPWR VGND sg13cmos5l_decap_8
X_0391_ _0391_/Q Tile_X0Y1_FrameData[15] VGND VPWR Tile_X0Y5_FrameStrobe[2] latch
X_2130_ AXIL_S_SOC_RDATA24 Tile_X0Y0_W2MID[0] Tile_X0Y0_W2END[0] Tile_X0Y0_W6END[0]
+ _2241_/X _0142_/Q _0141_/Q VPWR VGND sg13cmos5l_mux4_1
XFILLER_93_122 VPWR VGND sg13cmos5l_decap_8
XFILLER_281_212 VPWR VGND sg13cmos5l_fill_2
XFILLER_281_223 VPWR VGND sg13cmos5l_fill_1
X_2061_ Tile_X0Y5_S2BEGb[2] _2831_/X VPWR VGND sg13cmos5l_buf_1
XFILLER_304_72 VPWR VGND sg13cmos5l_fill_1
X_1012_ _1012_/Q Tile_X0Y3_FrameData[2] VGND VPWR Tile_X0Y5_FrameStrobe[6] latch
XANTENNA__0224__GATE Tile_X0Y5_FrameStrobe[4] VPWR VGND sg13cmos5l_antennanp
XANTENNA__0835__D Tile_X0Y3_FrameData[19] VPWR VGND sg13cmos5l_antennanp
XFILLER_170_90 VPWR VGND sg13cmos5l_decap_8
XANTENNA__0854__GATE Tile_X0Y5_FrameStrobe[1] VPWR VGND sg13cmos5l_antennanp
XANTENNA__0239__GATE Tile_X0Y5_FrameStrobe[5] VPWR VGND sg13cmos5l_antennanp
XANTENNA__2777__A1 Tile_X0Y5_W2MID[3] VPWR VGND sg13cmos5l_antennanp
X_1914_ Tile_X0Y1_FrameData_O[27] Tile_X0Y1_FrameData[27] VPWR VGND sg13cmos5l_buf_1
XANTENNA__0869__GATE Tile_X0Y5_FrameStrobe[2] VPWR VGND sg13cmos5l_antennanp
XANTENNA__2241__A3 Tile_X0Y0_S2END[0] VPWR VGND sg13cmos5l_antennanp
XFILLER_147_124 VPWR VGND sg13cmos5l_fill_1
XFILLER_336_213 VPWR VGND sg13cmos5l_fill_2
XANTENNA__0570__D Tile_X0Y2_FrameData[12] VPWR VGND sg13cmos5l_antennanp
XANTENNA__2529__A1 AXIL_S_SOC_ARADDR8 VPWR VGND sg13cmos5l_antennanp
XFILLER_147_157 VPWR VGND sg13cmos5l_decap_8
X_1845_ Tile_X0Y4_FrameData_O[12] Tile_X0Y4_FrameData[12] VPWR VGND sg13cmos5l_buf_1
X_1776_ Tile_X0Y2_E1BEG[3] _2400_/X VPWR VGND sg13cmos5l_buf_1
XFILLER_265_46 VPWR VGND sg13cmos5l_decap_4
X_0727_ _0727_/Q Tile_X0Y2_FrameData[15] VGND VPWR Tile_X0Y5_FrameStrobe[5] latch
X_0658_ _0658_/Q Tile_X0Y2_FrameData[20] VGND VPWR Tile_X0Y5_FrameStrobe[3] latch
XFILLER_345_90 VPWR VGND sg13cmos5l_decap_8
XFILLER_281_56 VPWR VGND sg13cmos5l_decap_8
X_0589_ _0589_/Q Tile_X0Y2_FrameData[25] VGND VPWR Tile_X0Y5_FrameStrobe[1] latch
XANTENNA__0807__GATE Tile_X0Y5_FrameStrobe[0] VPWR VGND sg13cmos5l_antennanp
XANTENNA__2701__A1 Tile_X0Y5_N4END[6] VPWR VGND sg13cmos5l_antennanp
X_2328_ _2328_/X _0029_/X Tile_X0Y0_S4END[7] _2362_/X _2361_/X _0436_/Q _0435_/Q VPWR
+ VGND sg13cmos5l_mux4_1
XFILLER_84_111 VPWR VGND sg13cmos5l_decap_8
XANTENNA__2139__X AXIL_S_SOC_RRESP1 VPWR VGND sg13cmos5l_antennanp
XFILLER_272_223 VPWR VGND sg13cmos5l_fill_1
X_2259_ _2259_/X Tile_X0Y2_W2MID[2] Tile_X0Y2_W2END[2] Tile_X0Y2_W6END[2] _2486_/X
+ _0772_/Q _0771_/Q VPWR VGND sg13cmos5l_mux4_1
XFILLER_84_166 VPWR VGND sg13cmos5l_decap_8
XANTENNA__0745__D Tile_X0Y2_FrameData[29] VPWR VGND sg13cmos5l_antennanp
XANTENNA__1978__X Tile_X0Y5_E2BEG[7] VPWR VGND sg13cmos5l_antennanp
XANTENNA__2480__A3 Tile_X0Y0_S4END[8] VPWR VGND sg13cmos5l_antennanp
XFILLER_240_153 VPWR VGND sg13cmos5l_decap_8
XFILLER_240_186 VPWR VGND sg13cmos5l_fill_1
XFILLER_159_69 VPWR VGND sg13cmos5l_decap_8
XFILLER_328_7 VPWR VGND sg13cmos5l_decap_8
XANTENNA__0480__D Tile_X0Y1_FrameData[22] VPWR VGND sg13cmos5l_antennanp
XFILLER_138_179 VPWR VGND sg13cmos5l_decap_8
XFILLER_175_46 VPWR VGND sg13cmos5l_decap_8
XFILLER_4_19 VPWR VGND sg13cmos5l_fill_2
XFILLER_108_95 VPWR VGND sg13cmos5l_decap_8
XFILLER_68_44 VPWR VGND sg13cmos5l_decap_8
XFILLER_191_34 VPWR VGND sg13cmos5l_decap_8
XFILLER_310_157 VPWR VGND sg13cmos5l_fill_2
XFILLER_310_135 VPWR VGND sg13cmos5l_fill_1
XANTENNA__2049__X Tile_X0Y5_S1BEG[2] VPWR VGND sg13cmos5l_antennanp
XFILLER_124_61 VPWR VGND sg13cmos5l_decap_8
XFILLER_187_0 VPWR VGND sg13cmos5l_fill_2
XFILLER_208_128 VPWR VGND sg13cmos5l_decap_8
XFILLER_75_177 VPWR VGND sg13cmos5l_decap_8
XANTENNA__0655__D Tile_X0Y2_FrameData[23] VPWR VGND sg13cmos5l_antennanp
XANTENNA__1888__X Tile_X0Y1_FrameData_O[1] VPWR VGND sg13cmos5l_antennanp
XFILLER_84_76 VPWR VGND sg13cmos5l_decap_8
XFILLER_90_158 VPWR VGND sg13cmos5l_decap_8
XANTENNA__2208__A0 AXIL_S_SOC_WDATA19 VPWR VGND sg13cmos5l_antennanp
XANTENNA__2471__A3 Tile_X0Y0_S4END[8] VPWR VGND sg13cmos5l_antennanp
XFILLER_231_164 VPWR VGND sg13cmos5l_decap_8
XANTENNA__0390__D Tile_X0Y1_FrameData[16] VPWR VGND sg13cmos5l_antennanp
XANTENNA__1486__D Tile_X0Y5_FrameData[2] VPWR VGND sg13cmos5l_antennanp
XFILLER_219_39 VPWR VGND sg13cmos5l_decap_8
X_1630_ Tile_X0Y0_N2BEG[2] _2147_/X VPWR VGND sg13cmos5l_buf_1
XFILLER_152_160 VPWR VGND sg13cmos5l_decap_8
X_1561_ Tile_X0Y3_FrameData_O[7] Tile_X0Y3_FrameData[7] VPWR VGND sg13cmos5l_buf_1
XFILLER_98_203 VPWR VGND sg13cmos5l_decap_4
X_1492_ _1492_/Q Tile_X0Y5_FrameData[28] VGND VPWR Tile_X0Y5_FrameStrobe[7] latch
X_0512_ _0512_/Q Tile_X0Y1_FrameData[22] VGND VPWR Tile_X0Y5_FrameStrobe[6] latch
XFILLER_298_153 VPWR VGND sg13cmos5l_fill_1
XFILLER_100_208 VPWR VGND sg13cmos5l_fill_2
X_0443_ _0443_/Q Tile_X0Y1_FrameData[27] VGND VPWR Tile_X0Y5_FrameStrobe[4] latch
XFILLER_298_197 VPWR VGND sg13cmos5l_fill_1
X_0374_ _0374_/Q Tile_X0Y1_FrameData[0] VGND VPWR Tile_X0Y5_FrameStrobe[1] latch
XFILLER_251_26 VPWR VGND sg13cmos5l_decap_8
X_2113_ AXIL_S_SOC_RDATA7 Tile_X0Y3_W2MID[7] Tile_X0Y3_W2END[7] Tile_X0Y3_W6END[7]
+ _2596_/X _0848_/Q _0847_/Q VPWR VGND sg13cmos5l_mux4_1
XANTENNA__0163__GATE Tile_X0Y5_FrameStrobe[2] VPWR VGND sg13cmos5l_antennanp
XANTENNA__0793__GATE Tile_X0Y5_FrameStrobe[0] VPWR VGND sg13cmos5l_antennanp
XANTENNA__1798__X Tile_X0Y4_E2BEGb[1] VPWR VGND sg13cmos5l_antennanp
XANTENNA__2447__A0 Tile_X0Y2_W1END[1] VPWR VGND sg13cmos5l_antennanp
X_2044_ Tile_X0Y5_FrameData_O[29] Tile_X0Y5_FrameData[29] VPWR VGND sg13cmos5l_buf_1
XFILLER_81_136 VPWR VGND sg13cmos5l_decap_4
XANTENNA__0565__D Tile_X0Y2_FrameData[17] VPWR VGND sg13cmos5l_antennanp
XFILLER_331_92 VPWR VGND sg13cmos5l_fill_2
XANTENNA__0178__GATE Tile_X0Y5_FrameStrobe[3] VPWR VGND sg13cmos5l_antennanp
XFILLER_200_74 VPWR VGND sg13cmos5l_decap_8
XFILLER_200_96 VPWR VGND sg13cmos5l_fill_2
XANTENNA__1396__D Tile_X0Y5_FrameData[28] VPWR VGND sg13cmos5l_antennanp
XFILLER_276_23 VPWR VGND sg13cmos5l_fill_1
XANTENNA__0101__GATE Tile_X0Y5_FrameStrobe[0] VPWR VGND sg13cmos5l_antennanp
XFILLER_276_56 VPWR VGND sg13cmos5l_fill_1
X_1828_ Tile_X0Y4_EE4BEG[11] _2644_/X VPWR VGND sg13cmos5l_buf_1
XANTENNA__0731__GATE Tile_X0Y5_FrameStrobe[5] VPWR VGND sg13cmos5l_antennanp
XFILLER_135_149 VPWR VGND sg13cmos5l_decap_8
XFILLER_145_16 VPWR VGND sg13cmos5l_decap_8
XFILLER_289_120 VPWR VGND sg13cmos5l_fill_1
XFILLER_289_142 VPWR VGND sg13cmos5l_decap_8
X_1759_ Tile_X0Y2_FrameData_O[19] Tile_X0Y2_FrameData[19] VPWR VGND sg13cmos5l_buf_1
XANTENNA__0116__GATE Tile_X0Y5_FrameStrobe[1] VPWR VGND sg13cmos5l_antennanp
XANTENNA__0746__GATE Tile_X0Y5_FrameStrobe[6] VPWR VGND sg13cmos5l_antennanp
XANTENNA__2686__A0 Tile_X0Y0_W1END[0] VPWR VGND sg13cmos5l_antennanp
XFILLER_225_82 VPWR VGND sg13cmos5l_decap_8
XFILLER_57_111 VPWR VGND sg13cmos5l_fill_1
XFILLER_57_100 VPWR VGND sg13cmos5l_decap_8
XANTENNA__2150__A2 Tile_X0Y0_W6END[2] VPWR VGND sg13cmos5l_antennanp
XFILLER_161_15 VPWR VGND sg13cmos5l_fill_1
XFILLER_72_103 VPWR VGND sg13cmos5l_fill_1
XANTENNA__2438__A0 AXIL_S_SOC_AWADDR5 VPWR VGND sg13cmos5l_antennanp
XFILLER_241_70 VPWR VGND sg13cmos5l_fill_1
XFILLER_72_136 VPWR VGND sg13cmos5l_decap_4
XANTENNA__0475__D Tile_X0Y1_FrameData[27] VPWR VGND sg13cmos5l_antennanp
XFILLER_72_169 VPWR VGND sg13cmos5l_fill_1
XFILLER_213_164 VPWR VGND sg13cmos5l_decap_8
XANTENNA__2045__A Tile_X0Y5_FrameData[30] VPWR VGND sg13cmos5l_antennanp
XFILLER_110_63 VPWR VGND sg13cmos5l_decap_4
XFILLER_359_179 VPWR VGND sg13cmos5l_fill_1
XANTENNA__2610__A0 Tile_X0Y5_W2MID[1] VPWR VGND sg13cmos5l_antennanp
XFILLER_110_96 VPWR VGND sg13cmos5l_decap_8
XFILLER_186_12 VPWR VGND sg13cmos5l_decap_4
XFILLER_70_56 VPWR VGND sg13cmos5l_decap_8
XFILLER_186_56 VPWR VGND sg13cmos5l_fill_2
XFILLER_126_127 VPWR VGND sg13cmos5l_decap_8
XFILLER_126_138 VPWR VGND sg13cmos5l_fill_2
XFILLER_336_26 VPWR VGND sg13cmos5l_decap_8
XFILLER_102_0 VPWR VGND sg13cmos5l_fill_1
XFILLER_119_83 VPWR VGND sg13cmos5l_fill_2
XFILLER_95_206 VPWR VGND sg13cmos5l_decap_8
XFILLER_79_98 VPWR VGND sg13cmos5l_fill_1
XANTENNA__2677__A0 Tile_X0Y3_W1END[2] VPWR VGND sg13cmos5l_antennanp
XFILLER_135_60 VPWR VGND sg13cmos5l_decap_8
XFILLER_295_145 VPWR VGND sg13cmos5l_decap_4
XFILLER_236_201 VPWR VGND sg13cmos5l_decap_8
XFILLER_48_166 VPWR VGND sg13cmos5l_fill_2
XANTENNA__2429__A0 AXIL_S_SOC_AWADDR0 VPWR VGND sg13cmos5l_antennanp
XFILLER_221_18 VPWR VGND sg13cmos5l_decap_8
X_0090_ _0090_/Q Tile_X0Y0_FrameData[12] VGND VPWR Tile_X0Y5_FrameStrobe[0] latch
XFILLER_48_188 VPWR VGND sg13cmos5l_fill_2
XANTENNA__0385__D Tile_X0Y1_FrameData[21] VPWR VGND sg13cmos5l_antennanp
XFILLER_151_92 VPWR VGND sg13cmos5l_fill_1
XFILLER_63_158 VPWR VGND sg13cmos5l_decap_8
XFILLER_204_120 VPWR VGND sg13cmos5l_decap_8
XFILLER_301_51 VPWR VGND sg13cmos5l_decap_8
X_2800_ _2800_/X Tile_X0Y5_N2MID[4] Tile_X0Y5_N2END[4] _2833_/X _2717_/X _1280_/Q
+ _1279_/Q VPWR VGND sg13cmos5l_mux4_1
X_0992_ _0992_/Q Tile_X0Y3_FrameData[22] VGND VPWR Tile_X0Y5_FrameStrobe[6] latch
XANTENNA__2601__A0 Tile_X0Y2_W2MID[5] VPWR VGND sg13cmos5l_antennanp
X_2731_ _2731_/X AXIL_S_SOC_ARPROT1 AXIL_S_SOC_RREADY _2826_/X _2798_/X _1440_/Q _1439_/Q
+ VPWR VGND sg13cmos5l_mux4_1
XFILLER_358_190 VPWR VGND sg13cmos5l_decap_4
X_2662_ _2662_/X _2706_/X _2697_/X _2696_/X _2712_/X _1108_/Q _1107_/Q VPWR VGND sg13cmos5l_mux4_1
XANTENNA__1461__GATE Tile_X0Y5_FrameStrobe[6] VPWR VGND sg13cmos5l_antennanp
X_1613_ Tile_X0Y0_N4BEG[9] _1613_/A VPWR VGND sg13cmos5l_buf_1
X_2593_ _2593_/X _2498_/X _2606_/X _2605_/X _2497_/X _0806_/Q _0805_/Q VPWR VGND sg13cmos5l_mux4_1
XFILLER_125_182 VPWR VGND sg13cmos5l_fill_2
X_1544_ Tile_X0Y3_EE4BEG[6] _2531_/X VPWR VGND sg13cmos5l_buf_1
XFILLER_262_14 VPWR VGND sg13cmos5l_decap_8
XFILLER_326_70 VPWR VGND sg13cmos5l_fill_1
XANTENNA__1476__GATE Tile_X0Y5_FrameStrobe[6] VPWR VGND sg13cmos5l_antennanp
XFILLER_140_152 VPWR VGND sg13cmos5l_decap_8
XFILLER_286_156 VPWR VGND sg13cmos5l_decap_8
X_1475_ _1475_/Q Tile_X0Y5_FrameData[13] VGND VPWR Tile_X0Y5_FrameStrobe[6] latch
XFILLER_86_206 VPWR VGND sg13cmos5l_fill_2
XANTENNA__2132__A2 Tile_X0Y0_W6END[2] VPWR VGND sg13cmos5l_antennanp
XFILLER_227_201 VPWR VGND sg13cmos5l_fill_1
X_0426_ _0426_/Q Tile_X0Y1_FrameData[12] VGND VPWR Tile_X0Y5_FrameStrobe[3] latch
X_0357_ _0357_/Q Tile_X0Y1_FrameData[17] VGND VPWR Tile_X0Y5_FrameStrobe[1] latch
X_0288_ _0288_/Q Tile_X0Y0_FrameData[6] VGND VPWR Tile_X0Y5_FrameStrobe[6] latch
XFILLER_54_136 VPWR VGND sg13cmos5l_decap_8
XANTENNA__0295__D Tile_X0Y0_FrameData[31] VPWR VGND sg13cmos5l_antennanp
X_2027_ Tile_X0Y5_FrameData_O[12] Tile_X0Y5_FrameData[12] VPWR VGND sg13cmos5l_buf_1
XFILLER_211_62 VPWR VGND sg13cmos5l_decap_8
XANTENNA__1414__GATE Tile_X0Y5_FrameStrobe[4] VPWR VGND sg13cmos5l_antennanp
XFILLER_210_134 VPWR VGND sg13cmos5l_decap_8
XFILLER_287_33 VPWR VGND sg13cmos5l_fill_1
XANTENNA__0670__GATE Tile_X0Y5_FrameStrobe[3] VPWR VGND sg13cmos5l_antennanp
XFILLER_108_116 VPWR VGND sg13cmos5l_decap_8
XFILLER_40_15 VPWR VGND sg13cmos5l_fill_1
XANTENNA__1429__GATE Tile_X0Y5_FrameStrobe[5] VPWR VGND sg13cmos5l_antennanp
XFILLER_40_37 VPWR VGND sg13cmos5l_fill_2
XANTENNA__1991__X Tile_X0Y5_E6BEG[4] VPWR VGND sg13cmos5l_antennanp
XANTENNA__0685__GATE Tile_X0Y5_FrameStrobe[4] VPWR VGND sg13cmos5l_antennanp
XFILLER_236_81 VPWR VGND sg13cmos5l_decap_8
XANTENNA__2659__A0 AXIL_S_SOC_WSTRB2 VPWR VGND sg13cmos5l_antennanp
XFILLER_277_178 VPWR VGND sg13cmos5l_decap_8
XANTENNA__2123__A2 Tile_X0Y1_W6END[1] VPWR VGND sg13cmos5l_antennanp
XFILLER_218_223 VPWR VGND sg13cmos5l_fill_1
XFILLER_292_148 VPWR VGND sg13cmos5l_decap_8
XFILLER_105_96 VPWR VGND sg13cmos5l_decap_8
XFILLER_65_45 VPWR VGND sg13cmos5l_decap_8
XFILLER_45_114 VPWR VGND sg13cmos5l_fill_2
XANTENNA__0623__GATE Tile_X0Y5_FrameStrobe[2] VPWR VGND sg13cmos5l_antennanp
XANTENNA__2831__A0 Tile_X0Y4_W2MID[5] VPWR VGND sg13cmos5l_antennanp
XFILLER_121_84 VPWR VGND sg13cmos5l_decap_8
XFILLER_201_101 VPWR VGND sg13cmos5l_decap_8
XANTENNA__0933__D Tile_X0Y3_FrameData[17] VPWR VGND sg13cmos5l_antennanp
XFILLER_197_22 VPWR VGND sg13cmos5l_fill_1
XFILLER_198_196 VPWR VGND sg13cmos5l_fill_1
XFILLER_81_55 VPWR VGND sg13cmos5l_decap_4
XFILLER_347_105 VPWR VGND sg13cmos5l_decap_8
XANTENNA__0638__GATE Tile_X0Y5_FrameStrobe[2] VPWR VGND sg13cmos5l_antennanp
XFILLER_197_88 VPWR VGND sg13cmos5l_decap_4
XFILLER_81_99 VPWR VGND sg13cmos5l_decap_8
XFILLER_347_149 VPWR VGND sg13cmos5l_fill_1
XANTENNA__2062__X Tile_X0Y5_S2BEGb[3] VPWR VGND sg13cmos5l_antennanp
XFILLER_347_14 VPWR VGND sg13cmos5l_decap_8
XFILLER_317_0 VPWR VGND sg13cmos5l_fill_1
XFILLER_154_211 VPWR VGND sg13cmos5l_decap_4
XFILLER_107_182 VPWR VGND sg13cmos5l_fill_2
XFILLER_107_193 VPWR VGND sg13cmos5l_fill_2
XFILLER_283_115 VPWR VGND sg13cmos5l_fill_2
X_1260_ _1260_/Q Tile_X0Y4_FrameData[26] VGND VPWR Tile_X0Y5_FrameStrobe[7] latch
XANTENNA__2114__A2 Tile_X0Y2_W6END[0] VPWR VGND sg13cmos5l_antennanp
X_1191_ _1191_/Q Tile_X0Y4_FrameData[31] VGND VPWR Tile_X0Y5_FrameStrobe[5] latch
X_0211_ _0211_/Q Tile_X0Y0_FrameData[19] VGND VPWR Tile_X0Y5_FrameStrobe[4] latch
XFILLER_224_204 VPWR VGND sg13cmos5l_decap_8
X_0142_ _0142_/Q Tile_X0Y0_FrameData[24] VGND VPWR Tile_X0Y5_FrameStrobe[2] latch
XFILLER_312_50 VPWR VGND sg13cmos5l_decap_8
XANTENNA__1004__D Tile_X0Y3_FrameData[10] VPWR VGND sg13cmos5l_antennanp
X_0073_ _0073_/Q Tile_X0Y0_FrameData[29] VGND VPWR Tile_X0Y5_FrameStrobe[0] latch
XANTENNA__2822__A0 Tile_X0Y5_N1END[1] VPWR VGND sg13cmos5l_antennanp
XANTENNA__0843__D Tile_X0Y3_FrameData[11] VPWR VGND sg13cmos5l_antennanp
XFILLER_257_36 VPWR VGND sg13cmos5l_decap_8
X_0975_ _0975_/Q Tile_X0Y3_FrameData[7] VGND VPWR Tile_X0Y5_FrameStrobe[5] latch
X_2714_ _2714_/X Tile_X0Y3_W2MID[6] Tile_X0Y3_W2END[6] Tile_X0Y3_W6END[9] _2590_/X
+ _0888_/Q _0887_/Q VPWR VGND sg13cmos5l_mux4_1
XFILLER_346_193 VPWR VGND sg13cmos5l_decap_4
X_2645_ _2645_/X Tile_X0Y4_WW4END[8] AXIL_S_SOC_WSTRB0 _2702_/X _2711_/X _1164_/Q
+ _1163_/Q VPWR VGND sg13cmos5l_mux4_1
XFILLER_105_119 VPWR VGND sg13cmos5l_decap_4
XFILLER_361_185 VPWR VGND sg13cmos5l_fill_2
XFILLER_113_130 VPWR VGND sg13cmos5l_decap_8
XFILLER_126_29 VPWR VGND sg13cmos5l_decap_8
X_2576_ _2576_/X _2570_/X Tile_X0Y5_N4END[10] _2569_/X Tile_X0Y0_S4END[14] _0826_/Q
+ _0825_/Q VPWR VGND sg13cmos5l_mux4_1
XFILLER_206_40 VPWR VGND sg13cmos5l_fill_2
X_1527_ Tile_X0Y3_E6BEG[1] _2542_/X VPWR VGND sg13cmos5l_buf_1
XFILLER_206_73 VPWR VGND sg13cmos5l_decap_8
X_1458_ _1458_/Q Tile_X0Y5_FrameData[30] VGND VPWR Tile_X0Y5_FrameStrobe[6] latch
XFILLER_353_90 VPWR VGND sg13cmos5l_decap_8
XANTENNA__2105__A2 Tile_X0Y5_W6END[0] VPWR VGND sg13cmos5l_antennanp
XFILLER_142_28 VPWR VGND sg13cmos5l_decap_8
XFILLER_274_126 VPWR VGND sg13cmos5l_decap_8
X_0409_ _0409_/Q Tile_X0Y1_FrameData[29] VGND VPWR Tile_X0Y5_FrameStrobe[3] latch
X_1389_ _1389_/Q Tile_X0Y5_FrameData[3] VGND VPWR Tile_X0Y5_FrameStrobe[3] latch
XFILLER_222_83 VPWR VGND sg13cmos5l_decap_8
XFILLER_298_21 VPWR VGND sg13cmos5l_fill_2
XANTENNA__1353__GATE Tile_X0Y5_FrameStrobe[2] VPWR VGND sg13cmos5l_antennanp
XANTENNA__2813__A0 Tile_X0Y5_N1END[0] VPWR VGND sg13cmos5l_antennanp
XFILLER_35_191 VPWR VGND sg13cmos5l_decap_8
XFILLER_298_54 VPWR VGND sg13cmos5l_decap_4
XANTENNA__0753__D Tile_X0Y2_FrameData[21] VPWR VGND sg13cmos5l_antennanp
XANTENNA__1986__X Tile_X0Y5_E2BEGb[7] VPWR VGND sg13cmos5l_antennanp
XFILLER_195_111 VPWR VGND sg13cmos5l_decap_8
XFILLER_329_105 VPWR VGND sg13cmos5l_fill_2
XFILLER_195_122 VPWR VGND sg13cmos5l_fill_1
XFILLER_195_144 VPWR VGND sg13cmos5l_fill_2
XANTENNA__1368__GATE Tile_X0Y5_FrameStrobe[3] VPWR VGND sg13cmos5l_antennanp
XFILLER_136_222 VPWR VGND sg13cmos5l_fill_2
XFILLER_183_35 VPWR VGND sg13cmos5l_decap_8
XFILLER_352_196 VPWR VGND sg13cmos5l_decap_8
XFILLER_116_84 VPWR VGND sg13cmos5l_decap_8
XFILLER_333_27 VPWR VGND sg13cmos5l_decap_8
XANTENNA__0928__D Tile_X0Y3_FrameData[22] VPWR VGND sg13cmos5l_antennanp
XANTENNA__1306__GATE Tile_X0Y5_FrameStrobe[1] VPWR VGND sg13cmos5l_antennanp
XFILLER_281_2 VPWR VGND sg13cmos5l_fill_1
XANTENNA__0562__GATE Tile_X0Y5_FrameStrobe[0] VPWR VGND sg13cmos5l_antennanp
XFILLER_206_215 VPWR VGND sg13cmos5l_fill_2
XFILLER_267_0 VPWR VGND sg13cmos5l_fill_2
XANTENNA__2057__X Tile_X0Y5_S2BEG[6] VPWR VGND sg13cmos5l_antennanp
XFILLER_92_76 VPWR VGND sg13cmos5l_decap_8
XANTENNA__0663__D Tile_X0Y2_FrameData[15] VPWR VGND sg13cmos5l_antennanp
XANTENNA__1896__X Tile_X0Y1_FrameData_O[9] VPWR VGND sg13cmos5l_antennanp
XANTENNA__0577__GATE Tile_X0Y5_FrameStrobe[0] VPWR VGND sg13cmos5l_antennanp
XFILLER_186_144 VPWR VGND sg13cmos5l_decap_8
XFILLER_358_24 VPWR VGND sg13cmos5l_fill_2
XFILLER_186_166 VPWR VGND sg13cmos5l_decap_8
XFILLER_41_194 VPWR VGND sg13cmos5l_fill_2
XFILLER_358_57 VPWR VGND sg13cmos5l_decap_8
X_0760_ _0760_/Q Tile_X0Y2_FrameData[14] VGND VPWR Tile_X0Y5_FrameStrobe[6] latch
XFILLER_328_171 VPWR VGND sg13cmos5l_fill_1
XANTENNA__0500__GATE Tile_X0Y5_FrameStrobe[5] VPWR VGND sg13cmos5l_antennanp
XANTENNA__1494__D Tile_X0Y5_FrameData[26] VPWR VGND sg13cmos5l_antennanp
X_2430_ _2430_/X AXIL_S_SOC_AWADDR1 AXIL_S_SOC_AWVALID _2476_/X _2483_/X _0688_/Q
+ _0687_/Q VPWR VGND sg13cmos5l_mux4_1
X_0691_ _0691_/Q Tile_X0Y2_FrameData[19] VGND VPWR Tile_X0Y5_FrameStrobe[4] latch
XFILLER_307_61 VPWR VGND sg13cmos5l_decap_8
XANTENNA__0515__GATE Tile_X0Y5_FrameStrobe[6] VPWR VGND sg13cmos5l_antennanp
X_2361_ _2361_/X _2342_/X _0063_/X _2341_/X Tile_X0Y0_S4END[4] _0342_/Q _0341_/Q VPWR
+ VGND sg13cmos5l_mux4_1
XFILLER_243_27 VPWR VGND sg13cmos5l_decap_4
X_1312_ _1312_/Q Tile_X0Y5_FrameData[16] VGND VPWR Tile_X0Y5_FrameStrobe[1] latch
X_2292_ _2292_/X _2348_/X _2347_/X AXIL_S_SOC_WDATA1 AXIL_S_SOC_WDATA4 _0508_/Q _0507_/Q
+ VPWR VGND sg13cmos5l_mux4_1
XANTENNA__0838__D Tile_X0Y3_FrameData[16] VPWR VGND sg13cmos5l_antennanp
XFILLER_110_166 VPWR VGND sg13cmos5l_decap_8
XFILLER_173_90 VPWR VGND sg13cmos5l_decap_4
XFILLER_256_126 VPWR VGND sg13cmos5l_decap_4
X_1243_ _1243_/Q Tile_X0Y4_FrameData[11] VGND VPWR Tile_X0Y5_FrameStrobe[6] latch
XFILLER_2_41 VPWR VGND sg13cmos5l_fill_1
XFILLER_2_30 VPWR VGND sg13cmos5l_fill_2
XFILLER_2_63 VPWR VGND sg13cmos5l_fill_1
X_1174_ _1174_/Q Tile_X0Y4_FrameData[16] VGND VPWR Tile_X0Y5_FrameStrobe[4] latch
XFILLER_24_117 VPWR VGND sg13cmos5l_decap_8
X_0125_ _0125_/Q Tile_X0Y0_FrameData[9] VGND VPWR Tile_X0Y5_FrameStrobe[1] latch
XFILLER_212_207 VPWR VGND sg13cmos5l_decap_8
XFILLER_24_128 VPWR VGND sg13cmos5l_fill_1
X_0056_ _1608_/A _2279_/X _2280_/X _0764_/Q VPWR VGND sg13cmos5l_mux2_1
XANTENNA__0573__D Tile_X0Y2_FrameData[9] VPWR VGND sg13cmos5l_antennanp
XFILLER_32_150 VPWR VGND sg13cmos5l_decap_8
XANTENNA__2271__A1 Tile_X0Y1_WW4END[0] VPWR VGND sg13cmos5l_antennanp
XFILLER_268_35 VPWR VGND sg13cmos5l_decap_8
XFILLER_192_136 VPWR VGND sg13cmos5l_decap_8
X_0958_ _0958_/Q Tile_X0Y3_FrameData[24] VGND VPWR Tile_X0Y5_FrameStrobe[5] latch
XFILLER_137_28 VPWR VGND sg13cmos5l_decap_4
X_0889_ _0889_/Q Tile_X0Y3_FrameData[29] VGND VPWR Tile_X0Y5_FrameStrobe[3] latch
X_2628_ _2628_/X AXIL_S_SOC_WSTRB3 AXIL_S_SOC_BREADY _2711_/X _2712_/X _1198_/Q _1197_/Q
+ VPWR VGND sg13cmos5l_mux4_1
XFILLER_217_83 VPWR VGND sg13cmos5l_decap_8
X_2559_ _2559_/X Tile_X0Y3_W1END[3] Tile_X0Y3_WW4END[11] Tile_X0Y3_WW4END[15] Tile_X0Y3_W6END[7]
+ _0865_/Q _0864_/Q VPWR VGND sg13cmos5l_mux4_1
XFILLER_153_49 VPWR VGND sg13cmos5l_decap_8
XFILLER_99_194 VPWR VGND sg13cmos5l_decap_8
XANTENNA__0748__D Tile_X0Y2_FrameData[26] VPWR VGND sg13cmos5l_antennanp
XFILLER_101_166 VPWR VGND sg13cmos5l_decap_8
XFILLER_233_71 VPWR VGND sg13cmos5l_decap_8
XFILLER_255_181 VPWR VGND sg13cmos5l_decap_8
XANTENNA__1292__GATE Tile_X0Y5_FrameStrobe[0] VPWR VGND sg13cmos5l_antennanp
XANTENNA__0483__D Tile_X0Y1_FrameData[19] VPWR VGND sg13cmos5l_antennanp
XFILLER_102_75 VPWR VGND sg13cmos5l_decap_8
XFILLER_168_111 VPWR VGND sg13cmos5l_decap_8
XFILLER_62_35 VPWR VGND sg13cmos5l_fill_2
XANTENNA__2262__A1 Tile_X0Y1_W2END[1] VPWR VGND sg13cmos5l_antennanp
XFILLER_178_46 VPWR VGND sg13cmos5l_decap_8
XFILLER_357_222 VPWR VGND sg13cmos5l_fill_2
XFILLER_317_119 VPWR VGND sg13cmos5l_decap_8
XANTENNA__1230__GATE Tile_X0Y5_FrameStrobe[6] VPWR VGND sg13cmos5l_antennanp
XANTENNA__1892__A Tile_X0Y1_FrameData[5] VPWR VGND sg13cmos5l_antennanp
XFILLER_194_56 VPWR VGND sg13cmos5l_decap_8
XFILLER_344_15 VPWR VGND sg13cmos5l_fill_1
XFILLER_340_133 VPWR VGND sg13cmos5l_decap_4
XFILLER_127_72 VPWR VGND sg13cmos5l_decap_8
XFILLER_87_43 VPWR VGND sg13cmos5l_decap_8
XANTENNA__1245__GATE Tile_X0Y5_FrameStrobe[6] VPWR VGND sg13cmos5l_antennanp
XANTENNA__0658__D Tile_X0Y2_FrameData[20] VPWR VGND sg13cmos5l_antennanp
XFILLER_238_126 VPWR VGND sg13cmos5l_decap_8
XFILLER_238_137 VPWR VGND sg13cmos5l_decap_8
XFILLER_238_148 VPWR VGND sg13cmos5l_fill_1
XFILLER_87_87 VPWR VGND sg13cmos5l_fill_2
XANTENNA__0393__D Tile_X0Y1_FrameData[13] VPWR VGND sg13cmos5l_antennanp
XANTENNA__1489__D Tile_X0Y5_FrameData[31] VPWR VGND sg13cmos5l_antennanp
XFILLER_21_109 VPWR VGND sg13cmos5l_decap_4
XANTENNA__2253__A1 Tile_X0Y2_W2END[5] VPWR VGND sg13cmos5l_antennanp
XFILLER_159_111 VPWR VGND sg13cmos5l_decap_8
X_1930_ Tile_X0Y1_EE4BEG[11] _2320_/X VPWR VGND sg13cmos5l_buf_1
XFILLER_348_222 VPWR VGND sg13cmos5l_fill_2
X_1861_ Tile_X0Y4_FrameData_O[28] Tile_X0Y4_FrameData[28] VPWR VGND sg13cmos5l_buf_1
X_0812_ _0812_/Q Tile_X0Y3_FrameData[10] VGND VPWR Tile_X0Y5_FrameStrobe[0] latch
XFILLER_168_90 VPWR VGND sg13cmos5l_decap_8
XFILLER_174_169 VPWR VGND sg13cmos5l_fill_1
X_1792_ Tile_X0Y4_E2BEG[3] _2620_/X VPWR VGND sg13cmos5l_buf_1
X_0743_ _0743_/Q Tile_X0Y2_FrameData[31] VGND VPWR Tile_X0Y5_FrameStrobe[6] latch
XANTENNA__0454__GATE Tile_X0Y5_FrameStrobe[4] VPWR VGND sg13cmos5l_antennanp
X_0674_ _0674_/Q Tile_X0Y2_FrameData[4] VGND VPWR Tile_X0Y5_FrameStrobe[3] latch
X_2413_ _2413_/X AXIL_S_SOC_AWADDR4 AXIL_S_SOC_AWPROT2 _2484_/X _2485_/X _0722_/Q
+ _0721_/Q VPWR VGND sg13cmos5l_mux4_1
X_2344_ _2344_/X Tile_X0Y2_W1END[1] Tile_X0Y2_W6END[5] _2469_/X _2454_/X _0788_/Q
+ _0787_/Q VPWR VGND sg13cmos5l_mux4_1
XANTENNA__0568__D Tile_X0Y2_FrameData[14] VPWR VGND sg13cmos5l_antennanp
XFILLER_28_0 VPWR VGND sg13cmos5l_fill_2
XANTENNA__0469__GATE Tile_X0Y5_FrameStrobe[4] VPWR VGND sg13cmos5l_antennanp
XFILLER_229_159 VPWR VGND sg13cmos5l_decap_8
XFILLER_270_25 VPWR VGND sg13cmos5l_decap_8
X_2275_ _2275_/X Tile_X0Y2_W1END[2] Tile_X0Y2_WW4END[2] Tile_X0Y2_WW4END[6] Tile_X0Y2_W6END[10]
+ _0760_/Q _0759_/Q VPWR VGND sg13cmos5l_mux4_1
XFILLER_96_197 VPWR VGND sg13cmos5l_decap_4
X_1226_ _1226_/Q Tile_X0Y4_FrameData[28] VGND VPWR Tile_X0Y5_FrameStrobe[6] latch
XANTENNA__2492__A1 Tile_X0Y4_W2END[6] VPWR VGND sg13cmos5l_antennanp
XFILLER_16_17 VPWR VGND sg13cmos5l_fill_1
X_1157_ _1157_/Q Tile_X0Y4_FrameData[1] VGND VPWR Tile_X0Y5_FrameStrobe[3] latch
XFILLER_252_151 VPWR VGND sg13cmos5l_decap_8
X_0108_ _0108_/Q Tile_X0Y0_FrameData[26] VGND VPWR Tile_X0Y5_FrameStrobe[1] latch
XANTENNA__1399__D Tile_X0Y5_FrameData[25] VPWR VGND sg13cmos5l_antennanp
X_1088_ _1088_/Q Tile_X0Y4_FrameData[6] VGND VPWR Tile_X0Y5_FrameStrobe[1] latch
XFILLER_339_200 VPWR VGND sg13cmos5l_fill_2
X_0039_ _0039_/X _2686_/X _2687_/X _0152_/Q VPWR VGND sg13cmos5l_mux2_1
XANTENNA__0407__GATE Tile_X0Y5_FrameStrobe[3] VPWR VGND sg13cmos5l_antennanp
XFILLER_295_44 VPWR VGND sg13cmos5l_fill_1
XFILLER_120_9 VPWR VGND sg13cmos5l_fill_2
XFILLER_20_186 VPWR VGND sg13cmos5l_fill_1
XFILLER_180_117 VPWR VGND sg13cmos5l_fill_1
XFILLER_307_174 VPWR VGND sg13cmos5l_decap_8
XFILLER_295_99 VPWR VGND sg13cmos5l_decap_4
XFILLER_322_177 VPWR VGND sg13cmos5l_fill_2
XANTENNA__0478__D Tile_X0Y1_FrameData[24] VPWR VGND sg13cmos5l_antennanp
XANTENNA__2180__A0 AXIL_S_SOC_WDATA23 VPWR VGND sg13cmos5l_antennanp
XFILLER_180_14 VPWR VGND sg13cmos5l_fill_1
XFILLER_180_25 VPWR VGND sg13cmos5l_decap_8
XFILLER_87_164 VPWR VGND sg13cmos5l_decap_8
XFILLER_57_46 VPWR VGND sg13cmos5l_fill_1
XFILLER_180_47 VPWR VGND sg13cmos5l_fill_2
XFILLER_57_79 VPWR VGND sg13cmos5l_fill_2
XFILLER_113_63 VPWR VGND sg13cmos5l_decap_8
XFILLER_73_45 VPWR VGND sg13cmos5l_decap_8
XFILLER_43_223 VPWR VGND sg13cmos5l_fill_1
XANTENNA__1887__A Tile_X0Y1_FrameData[0] VPWR VGND sg13cmos5l_antennanp
XFILLER_188_206 VPWR VGND sg13cmos5l_fill_2
XANTENNA__1102__D Tile_X0Y4_FrameData[24] VPWR VGND sg13cmos5l_antennanp
XFILLER_244_2 VPWR VGND sg13cmos5l_fill_1
XANTENNA__0941__D Tile_X0Y3_FrameData[9] VPWR VGND sg13cmos5l_antennanp
XFILLER_132_0 VPWR VGND sg13cmos5l_fill_2
XFILLER_22_60 VPWR VGND sg13cmos5l_fill_1
XFILLER_22_71 VPWR VGND sg13cmos5l_decap_8
XFILLER_360_206 VPWR VGND sg13cmos5l_fill_1
XANTENNA__2070__X Tile_X0Y5_S4BEG[3] VPWR VGND sg13cmos5l_antennanp
XFILLER_138_82 VPWR VGND sg13cmos5l_decap_8
XFILLER_355_47 VPWR VGND sg13cmos5l_decap_8
XANTENNA__1184__GATE Tile_X0Y5_FrameStrobe[4] VPWR VGND sg13cmos5l_antennanp
XANTENNA__0388__D Tile_X0Y1_FrameData[18] VPWR VGND sg13cmos5l_antennanp
XANTENNA__2171__A0 AXIL_S_SOC_WDATA22 VPWR VGND sg13cmos5l_antennanp
XFILLER_154_81 VPWR VGND sg13cmos5l_decap_8
X_0390_ _0390_/Q Tile_X0Y1_FrameData[16] VGND VPWR Tile_X0Y5_FrameStrobe[2] latch
XFILLER_78_153 VPWR VGND sg13cmos5l_fill_2
XFILLER_78_142 VPWR VGND sg13cmos5l_decap_8
XFILLER_78_186 VPWR VGND sg13cmos5l_decap_8
XFILLER_304_40 VPWR VGND sg13cmos5l_fill_2
XANTENNA__1199__GATE Tile_X0Y5_FrameStrobe[5] VPWR VGND sg13cmos5l_antennanp
XFILLER_226_129 VPWR VGND sg13cmos5l_fill_2
X_2060_ Tile_X0Y5_S2BEGb[1] _2830_/X VPWR VGND sg13cmos5l_buf_1
X_1011_ _1011_/Q Tile_X0Y3_FrameData[3] VGND VPWR Tile_X0Y5_FrameStrobe[6] latch
XANTENNA__2474__A1 Tile_X0Y5_N4END[14] VPWR VGND sg13cmos5l_antennanp
XANTENNA__1122__GATE Tile_X0Y5_FrameStrobe[2] VPWR VGND sg13cmos5l_antennanp
XFILLER_234_195 VPWR VGND sg13cmos5l_decap_8
XANTENNA__1012__D Tile_X0Y3_FrameData[2] VPWR VGND sg13cmos5l_antennanp
XFILLER_249_15 VPWR VGND sg13cmos5l_fill_2
XFILLER_320_72 VPWR VGND sg13cmos5l_fill_2
XANTENNA__2777__A2 Tile_X0Y5_W2END[3] VPWR VGND sg13cmos5l_antennanp
XFILLER_194_209 VPWR VGND sg13cmos5l_fill_2
X_1913_ Tile_X0Y1_FrameData_O[26] Tile_X0Y1_FrameData[26] VPWR VGND sg13cmos5l_buf_1
XANTENNA__0851__D Tile_X0Y3_FrameData[3] VPWR VGND sg13cmos5l_antennanp
XANTENNA__1137__GATE Tile_X0Y5_FrameStrobe[3] VPWR VGND sg13cmos5l_antennanp
XFILLER_147_136 VPWR VGND sg13cmos5l_decap_8
X_1844_ Tile_X0Y4_FrameData_O[11] Tile_X0Y4_FrameData[11] VPWR VGND sg13cmos5l_buf_1
XFILLER_8_62 VPWR VGND sg13cmos5l_fill_2
XFILLER_265_14 VPWR VGND sg13cmos5l_fill_1
XFILLER_265_25 VPWR VGND sg13cmos5l_decap_8
X_1775_ Tile_X0Y2_E1BEG[2] _2399_/X VPWR VGND sg13cmos5l_buf_1
XANTENNA__0393__GATE Tile_X0Y5_FrameStrobe[2] VPWR VGND sg13cmos5l_antennanp
X_0726_ _0726_/Q Tile_X0Y2_FrameData[16] VGND VPWR Tile_X0Y5_FrameStrobe[5] latch
XFILLER_304_111 VPWR VGND sg13cmos5l_decap_4
XFILLER_304_100 VPWR VGND sg13cmos5l_fill_1
XFILLER_281_13 VPWR VGND sg13cmos5l_decap_8
X_0657_ _0657_/Q Tile_X0Y2_FrameData[21] VGND VPWR Tile_X0Y5_FrameStrobe[3] latch
XFILLER_304_177 VPWR VGND sg13cmos5l_fill_1
XANTENNA__0298__D Tile_X0Y0_FrameData[28] VPWR VGND sg13cmos5l_antennanp
X_0588_ _0588_/Q Tile_X0Y2_FrameData[26] VGND VPWR Tile_X0Y5_FrameStrobe[1] latch
X_2327_ _2327_/X _0030_/X Tile_X0Y0_S4END[6] _2358_/X _2357_/X _0438_/Q _0437_/Q VPWR
+ VGND sg13cmos5l_mux4_1
XFILLER_217_118 VPWR VGND sg13cmos5l_decap_8
XFILLER_272_202 VPWR VGND sg13cmos5l_decap_8
X_2258_ _2258_/X Tile_X0Y1_W2MID[3] Tile_X0Y1_W2END[3] Tile_X0Y1_W6END[3] _2377_/X
+ _0534_/Q _0533_/Q VPWR VGND sg13cmos5l_mux4_1
XANTENNA__0331__GATE Tile_X0Y5_FrameStrobe[0] VPWR VGND sg13cmos5l_antennanp
X_1209_ _1209_/Q Tile_X0Y4_FrameData[13] VGND VPWR Tile_X0Y5_FrameStrobe[5] latch
XANTENNA__0961__GATE Tile_X0Y5_FrameStrobe[5] VPWR VGND sg13cmos5l_antennanp
XANTENNA__2465__A1 Tile_X0Y5_N4END[15] VPWR VGND sg13cmos5l_antennanp
XFILLER_25_212 VPWR VGND sg13cmos5l_fill_2
XFILLER_25_223 VPWR VGND sg13cmos5l_fill_1
X_2189_ _2189_/X AXIL_S_SOC_WDATA20 AXIL_S_SOC_WDATA24 _2233_/X _2248_/X _0218_/Q
+ _0217_/Q VPWR VGND sg13cmos5l_mux4_1
XFILLER_225_184 VPWR VGND sg13cmos5l_fill_2
XFILLER_40_204 VPWR VGND sg13cmos5l_fill_2
XANTENNA__0346__GATE Tile_X0Y5_FrameStrobe[1] VPWR VGND sg13cmos5l_antennanp
XFILLER_159_15 VPWR VGND sg13cmos5l_decap_8
XFILLER_159_26 VPWR VGND sg13cmos5l_fill_1
XFILLER_159_48 VPWR VGND sg13cmos5l_decap_8
XFILLER_230_8 VPWR VGND sg13cmos5l_fill_1
XFILLER_43_59 VPWR VGND sg13cmos5l_fill_2
XANTENNA__0761__D Tile_X0Y2_FrameData[13] VPWR VGND sg13cmos5l_antennanp
XANTENNA__0976__GATE Tile_X0Y5_FrameStrobe[5] VPWR VGND sg13cmos5l_antennanp
XANTENNA__1994__X Tile_X0Y5_E6BEG[7] VPWR VGND sg13cmos5l_antennanp
XFILLER_138_125 VPWR VGND sg13cmos5l_fill_2
XFILLER_138_169 VPWR VGND sg13cmos5l_fill_2
XFILLER_153_139 VPWR VGND sg13cmos5l_decap_8
XFILLER_108_74 VPWR VGND sg13cmos5l_decap_8
XFILLER_161_161 VPWR VGND sg13cmos5l_decap_8
XFILLER_68_12 VPWR VGND sg13cmos5l_decap_4
XANTENNA__0914__GATE Tile_X0Y5_FrameStrobe[3] VPWR VGND sg13cmos5l_antennanp
XANTENNA__2153__A0 Tile_X0Y0_W1END[0] VPWR VGND sg13cmos5l_antennanp
XFILLER_68_78 VPWR VGND sg13cmos5l_decap_4
XFILLER_75_134 VPWR VGND sg13cmos5l_fill_1
XANTENNA__0936__D Tile_X0Y3_FrameData[14] VPWR VGND sg13cmos5l_antennanp
XFILLER_84_55 VPWR VGND sg13cmos5l_decap_8
XANTENNA__0929__GATE Tile_X0Y5_FrameStrobe[4] VPWR VGND sg13cmos5l_antennanp
XFILLER_90_137 VPWR VGND sg13cmos5l_decap_8
XFILLER_216_195 VPWR VGND sg13cmos5l_decap_8
XFILLER_231_121 VPWR VGND sg13cmos5l_decap_8
XANTENNA__2065__X Tile_X0Y5_S2BEGb[6] VPWR VGND sg13cmos5l_antennanp
XFILLER_347_0 VPWR VGND sg13cmos5l_decap_4
XFILLER_176_209 VPWR VGND sg13cmos5l_fill_1
XANTENNA__0671__D Tile_X0Y2_FrameData[7] VPWR VGND sg13cmos5l_antennanp
XFILLER_129_114 VPWR VGND sg13cmos5l_decap_8
XFILLER_33_81 VPWR VGND sg13cmos5l_decap_8
XFILLER_149_81 VPWR VGND sg13cmos5l_decap_8
XFILLER_137_180 VPWR VGND sg13cmos5l_fill_1
X_1560_ Tile_X0Y3_FrameData_O[6] Tile_X0Y3_FrameData[6] VPWR VGND sg13cmos5l_buf_1
XANTENNA__2392__A0 Tile_X0Y3_W2MID[2] VPWR VGND sg13cmos5l_antennanp
X_0511_ _0511_/Q Tile_X0Y1_FrameData[23] VGND VPWR Tile_X0Y5_FrameStrobe[6] latch
XFILLER_235_28 VPWR VGND sg13cmos5l_fill_2
X_1491_ _1491_/Q Tile_X0Y5_FrameData[29] VGND VPWR Tile_X0Y5_FrameStrobe[7] latch
XFILLER_98_215 VPWR VGND sg13cmos5l_fill_2
XFILLER_301_114 VPWR VGND sg13cmos5l_decap_8
XANTENNA__2144__A0 Tile_X0Y0_W1END[3] VPWR VGND sg13cmos5l_antennanp
X_0442_ _0442_/Q Tile_X0Y1_FrameData[28] VGND VPWR Tile_X0Y5_FrameStrobe[4] latch
XFILLER_315_50 VPWR VGND sg13cmos5l_decap_8
XANTENNA__1007__D Tile_X0Y3_FrameData[7] VPWR VGND sg13cmos5l_antennanp
X_0373_ _0373_/Q Tile_X0Y1_FrameData[1] VGND VPWR Tile_X0Y5_FrameStrobe[1] latch
X_2112_ AXIL_S_SOC_RDATA6 Tile_X0Y3_W2MID[6] Tile_X0Y3_W2END[6] Tile_X0Y3_W6END[6]
+ _2595_/X _0850_/Q _0849_/Q VPWR VGND sg13cmos5l_mux4_1
XFILLER_66_145 VPWR VGND sg13cmos5l_decap_8
XANTENNA__0846__D Tile_X0Y3_FrameData[8] VPWR VGND sg13cmos5l_antennanp
XANTENNA__1061__GATE Tile_X0Y5_FrameStrobe[0] VPWR VGND sg13cmos5l_antennanp
XANTENNA__2447__A1 Tile_X0Y2_WW4END[9] VPWR VGND sg13cmos5l_antennanp
X_2043_ Tile_X0Y5_FrameData_O[28] Tile_X0Y5_FrameData[28] VPWR VGND sg13cmos5l_buf_1
XFILLER_81_115 VPWR VGND sg13cmos5l_decap_8
XFILLER_66_189 VPWR VGND sg13cmos5l_fill_2
XFILLER_331_71 VPWR VGND sg13cmos5l_decap_8
XFILLER_200_20 VPWR VGND sg13cmos5l_fill_1
XFILLER_167_209 VPWR VGND sg13cmos5l_fill_1
XFILLER_222_187 VPWR VGND sg13cmos5l_decap_8
XFILLER_95_0 VPWR VGND sg13cmos5l_fill_1
XANTENNA__0581__D Tile_X0Y2_FrameData[1] VPWR VGND sg13cmos5l_antennanp
XANTENNA__1076__GATE Tile_X0Y5_FrameStrobe[1] VPWR VGND sg13cmos5l_antennanp
XFILLER_135_106 VPWR VGND sg13cmos5l_decap_8
XFILLER_276_68 VPWR VGND sg13cmos5l_fill_2
X_1827_ Tile_X0Y4_EE4BEG[10] _2643_/X VPWR VGND sg13cmos5l_buf_1
XFILLER_190_223 VPWR VGND sg13cmos5l_fill_1
XFILLER_209_40 VPWR VGND sg13cmos5l_decap_8
XANTENNA__2383__A0 Tile_X0Y0_W2MID[6] VPWR VGND sg13cmos5l_antennanp
XFILLER_209_73 VPWR VGND sg13cmos5l_decap_4
X_1758_ Tile_X0Y2_FrameData_O[18] Tile_X0Y2_FrameData[18] VPWR VGND sg13cmos5l_buf_1
XFILLER_143_161 VPWR VGND sg13cmos5l_decap_8
XFILLER_1_108 VPWR VGND sg13cmos5l_fill_1
XFILLER_292_45 VPWR VGND sg13cmos5l_fill_1
X_1689_ Tile_X0Y0_FrameData_O[29] Tile_X0Y0_FrameData[29] VPWR VGND sg13cmos5l_buf_1
X_0709_ _0709_/Q Tile_X0Y2_FrameData[1] VGND VPWR Tile_X0Y5_FrameStrobe[4] latch
XANTENNA__1014__GATE Tile_X0Y5_FrameStrobe[6] VPWR VGND sg13cmos5l_antennanp
XANTENNA__2135__A0 Tile_X0Y0_W2MID[5] VPWR VGND sg13cmos5l_antennanp
XANTENNA__2686__A1 Tile_X0Y0_WW4END[8] VPWR VGND sg13cmos5l_antennanp
XFILLER_225_61 VPWR VGND sg13cmos5l_decap_8
XANTENNA__0270__GATE Tile_X0Y5_FrameStrobe[6] VPWR VGND sg13cmos5l_antennanp
XFILLER_245_213 VPWR VGND sg13cmos5l_fill_1
XANTENNA__0756__D Tile_X0Y2_FrameData[18] VPWR VGND sg13cmos5l_antennanp
XANTENNA__1989__X Tile_X0Y5_E6BEG[2] VPWR VGND sg13cmos5l_antennanp
XFILLER_161_49 VPWR VGND sg13cmos5l_decap_8
XFILLER_57_156 VPWR VGND sg13cmos5l_decap_8
XANTENNA__1029__GATE Tile_X0Y5_FrameStrobe[7] VPWR VGND sg13cmos5l_antennanp
XFILLER_173_7 VPWR VGND sg13cmos5l_fill_1
XFILLER_72_115 VPWR VGND sg13cmos5l_decap_8
XFILLER_54_14 VPWR VGND sg13cmos5l_fill_2
XFILLER_213_110 VPWR VGND sg13cmos5l_decap_8
XFILLER_54_25 VPWR VGND sg13cmos5l_fill_2
XANTENNA__0285__GATE Tile_X0Y5_FrameStrobe[6] VPWR VGND sg13cmos5l_antennanp
XFILLER_213_121 VPWR VGND sg13cmos5l_fill_2
XFILLER_213_143 VPWR VGND sg13cmos5l_fill_2
XFILLER_54_58 VPWR VGND sg13cmos5l_decap_4
XFILLER_359_136 VPWR VGND sg13cmos5l_fill_2
XFILLER_340_7 VPWR VGND sg13cmos5l_decap_8
XFILLER_110_42 VPWR VGND sg13cmos5l_decap_8
XFILLER_359_169 VPWR VGND sg13cmos5l_fill_2
XANTENNA__0491__D Tile_X0Y1_FrameData[11] VPWR VGND sg13cmos5l_antennanp
XFILLER_110_75 VPWR VGND sg13cmos5l_decap_8
XFILLER_70_35 VPWR VGND sg13cmos5l_decap_8
XANTENNA__2610__A1 Tile_X0Y5_W2END[1] VPWR VGND sg13cmos5l_antennanp
XFILLER_181_223 VPWR VGND sg13cmos5l_fill_1
XFILLER_336_16 VPWR VGND sg13cmos5l_fill_1
XANTENNA__0223__GATE Tile_X0Y5_FrameStrobe[4] VPWR VGND sg13cmos5l_antennanp
XFILLER_119_191 VPWR VGND sg13cmos5l_decap_4
XANTENNA__0853__GATE Tile_X0Y5_FrameStrobe[1] VPWR VGND sg13cmos5l_antennanp
XANTENNA__2126__A0 Tile_X0Y1_W2MID[4] VPWR VGND sg13cmos5l_antennanp
XFILLER_295_124 VPWR VGND sg13cmos5l_decap_8
XFILLER_0_152 VPWR VGND sg13cmos5l_fill_1
XFILLER_95_21 VPWR VGND sg13cmos5l_decap_8
XANTENNA__0238__GATE Tile_X0Y5_FrameStrobe[5] VPWR VGND sg13cmos5l_antennanp
XANTENNA__2677__A1 Tile_X0Y3_W6END[10] VPWR VGND sg13cmos5l_antennanp
XANTENNA__0666__D Tile_X0Y2_FrameData[12] VPWR VGND sg13cmos5l_antennanp
XANTENNA__0868__GATE Tile_X0Y5_FrameStrobe[2] VPWR VGND sg13cmos5l_antennanp
XANTENNA__1899__X Tile_X0Y1_FrameData_O[12] VPWR VGND sg13cmos5l_antennanp
XFILLER_95_87 VPWR VGND sg13cmos5l_decap_8
XANTENNA__2429__A1 AXIL_S_SOC_AWPROT2 VPWR VGND sg13cmos5l_antennanp
XFILLER_28_81 VPWR VGND sg13cmos5l_fill_2
XFILLER_63_104 VPWR VGND sg13cmos5l_decap_4
XFILLER_151_71 VPWR VGND sg13cmos5l_decap_8
XFILLER_71_181 VPWR VGND sg13cmos5l_fill_2
XFILLER_301_74 VPWR VGND sg13cmos5l_decap_8
XANTENNA__1497__D Tile_X0Y5_FrameData[31] VPWR VGND sg13cmos5l_antennanp
X_0991_ _0991_/Q Tile_X0Y3_FrameData[23] VGND VPWR Tile_X0Y5_FrameStrobe[6] latch
XFILLER_44_91 VPWR VGND sg13cmos5l_decap_4
XANTENNA__2601__A1 Tile_X0Y2_W2END[5] VPWR VGND sg13cmos5l_antennanp
X_2730_ _2730_/X AXIL_S_SOC_ARPROT0 AXIL_S_SOC_ARVALID _2827_/X _2799_/X _1442_/Q
+ _1441_/Q VPWR VGND sg13cmos5l_mux4_1
XFILLER_81_6 VPWR VGND sg13cmos5l_decap_8
XANTENNA__0806__GATE Tile_X0Y5_FrameStrobe[0] VPWR VGND sg13cmos5l_antennanp
XFILLER_117_117 VPWR VGND sg13cmos5l_decap_4
XFILLER_172_201 VPWR VGND sg13cmos5l_decap_4
X_2661_ _2661_/X Tile_X0Y4_W1END[0] Tile_X0Y4_WW4END[12] Tile_X0Y4_W6END[4] _2707_/X
+ _1108_/Q _1107_/Q VPWR VGND sg13cmos5l_mux4_1
X_1612_ Tile_X0Y0_N4BEG[8] _1612_/A VPWR VGND sg13cmos5l_buf_1
XFILLER_306_217 VPWR VGND sg13cmos5l_fill_1
X_2592_ _2592_/X _2496_/X _2604_/X _2603_/X _2495_/X _0808_/Q _0807_/Q VPWR VGND sg13cmos5l_mux4_1
X_1543_ Tile_X0Y3_EE4BEG[5] _2530_/X VPWR VGND sg13cmos5l_buf_1
XANTENNA__2117__A0 Tile_X0Y2_W2MID[3] VPWR VGND sg13cmos5l_antennanp
XANTENNA__2380__A3 Tile_X0Y0_S2MID[7] VPWR VGND sg13cmos5l_antennanp
XFILLER_140_120 VPWR VGND sg13cmos5l_fill_1
XFILLER_286_102 VPWR VGND sg13cmos5l_decap_4
X_1474_ _1474_/Q Tile_X0Y5_FrameData[14] VGND VPWR Tile_X0Y5_FrameStrobe[6] latch
XFILLER_262_37 VPWR VGND sg13cmos5l_fill_1
XFILLER_286_135 VPWR VGND sg13cmos5l_decap_8
X_0425_ _0425_/Q Tile_X0Y1_FrameData[13] VGND VPWR Tile_X0Y5_FrameStrobe[3] latch
XFILLER_262_59 VPWR VGND sg13cmos5l_decap_8
XFILLER_39_112 VPWR VGND sg13cmos5l_fill_2
XANTENNA__0576__D Tile_X0Y2_FrameData[6] VPWR VGND sg13cmos5l_antennanp
XFILLER_10_0 VPWR VGND sg13cmos5l_fill_1
XFILLER_227_213 VPWR VGND sg13cmos5l_fill_2
X_0356_ _0356_/Q Tile_X0Y1_FrameData[18] VGND VPWR Tile_X0Y5_FrameStrobe[1] latch
XFILLER_342_70 VPWR VGND sg13cmos5l_decap_4
XANTENNA__1602__X Tile_X0Y2_EE4BEG[15] VPWR VGND sg13cmos5l_antennanp
XFILLER_242_205 VPWR VGND sg13cmos5l_decap_8
X_0287_ _0287_/Q Tile_X0Y0_FrameData[7] VGND VPWR Tile_X0Y5_FrameStrobe[6] latch
XFILLER_54_126 VPWR VGND sg13cmos5l_fill_2
X_2026_ Tile_X0Y5_FrameData_O[11] Tile_X0Y5_FrameData[11] VPWR VGND sg13cmos5l_buf_1
XFILLER_211_41 VPWR VGND sg13cmos5l_decap_4
XFILLER_210_113 VPWR VGND sg13cmos5l_decap_8
XFILLER_287_45 VPWR VGND sg13cmos5l_fill_1
XFILLER_356_128 VPWR VGND sg13cmos5l_decap_8
XANTENNA__1200__D Tile_X0Y4_FrameData[22] VPWR VGND sg13cmos5l_antennanp
XFILLER_210_157 VPWR VGND sg13cmos5l_decap_8
XFILLER_210_168 VPWR VGND sg13cmos5l_fill_2
XFILLER_156_16 VPWR VGND sg13cmos5l_decap_8
XFILLER_163_223 VPWR VGND sg13cmos5l_fill_1
XFILLER_200_9 VPWR VGND sg13cmos5l_decap_8
XFILLER_236_60 VPWR VGND sg13cmos5l_decap_8
XANTENNA__2108__A0 Tile_X0Y3_W2MID[2] VPWR VGND sg13cmos5l_antennanp
XANTENNA__2371__A3 Tile_X0Y0_S4END[4] VPWR VGND sg13cmos5l_antennanp
XFILLER_116_183 VPWR VGND sg13cmos5l_fill_2
XFILLER_116_194 VPWR VGND sg13cmos5l_fill_2
XFILLER_49_14 VPWR VGND sg13cmos5l_fill_2
XFILLER_290_7 VPWR VGND sg13cmos5l_fill_1
XFILLER_49_58 VPWR VGND sg13cmos5l_fill_1
XFILLER_105_75 VPWR VGND sg13cmos5l_decap_8
XFILLER_292_127 VPWR VGND sg13cmos5l_decap_8
XFILLER_65_24 VPWR VGND sg13cmos5l_decap_8
XANTENNA__0486__D Tile_X0Y1_FrameData[16] VPWR VGND sg13cmos5l_antennanp
XFILLER_45_104 VPWR VGND sg13cmos5l_fill_1
XFILLER_60_118 VPWR VGND sg13cmos5l_decap_8
XANTENNA__2831__A1 Tile_X0Y4_W2END[5] VPWR VGND sg13cmos5l_antennanp
XFILLER_121_63 VPWR VGND sg13cmos5l_decap_8
XFILLER_81_34 VPWR VGND sg13cmos5l_decap_8
XFILLER_53_170 VPWR VGND sg13cmos5l_decap_8
XFILLER_198_164 VPWR VGND sg13cmos5l_decap_4
XFILLER_198_175 VPWR VGND sg13cmos5l_decap_8
XFILLER_81_78 VPWR VGND sg13cmos5l_decap_8
XANTENNA__1110__D Tile_X0Y4_FrameData[16] VPWR VGND sg13cmos5l_antennanp
XANTENNA__1895__A Tile_X0Y1_FrameData[8] VPWR VGND sg13cmos5l_antennanp
XFILLER_14_61 VPWR VGND sg13cmos5l_fill_1
XFILLER_197_67 VPWR VGND sg13cmos5l_decap_8
XFILLER_14_83 VPWR VGND sg13cmos5l_decap_8
XFILLER_362_109 VPWR VGND sg13cmos5l_decap_8
XFILLER_154_223 VPWR VGND sg13cmos5l_fill_1
XFILLER_212_0 VPWR VGND sg13cmos5l_fill_1
XFILLER_5_222 VPWR VGND sg13cmos5l_fill_2
XANTENNA__0162__GATE Tile_X0Y5_FrameStrobe[2] VPWR VGND sg13cmos5l_antennanp
XANTENNA__2347__A0 Tile_X0Y0_W1END[3] VPWR VGND sg13cmos5l_antennanp
XANTENNA__0792__GATE Tile_X0Y5_FrameStrobe[0] VPWR VGND sg13cmos5l_antennanp
XANTENNA__2362__A3 Tile_X0Y0_S4END[4] VPWR VGND sg13cmos5l_antennanp
XFILLER_268_102 VPWR VGND sg13cmos5l_decap_8
XANTENNA__0177__GATE Tile_X0Y5_FrameStrobe[3] VPWR VGND sg13cmos5l_antennanp
XFILLER_122_142 VPWR VGND sg13cmos5l_fill_1
XFILLER_122_186 VPWR VGND sg13cmos5l_decap_8
XFILLER_268_168 VPWR VGND sg13cmos5l_decap_8
XFILLER_268_179 VPWR VGND sg13cmos5l_fill_1
XFILLER_232_29 VPWR VGND sg13cmos5l_decap_8
XFILLER_283_127 VPWR VGND sg13cmos5l_fill_1
X_1190_ _1190_/Q Tile_X0Y4_FrameData[0] VGND VPWR Tile_X0Y5_FrameStrobe[4] latch
X_0210_ _0210_/Q Tile_X0Y0_FrameData[20] VGND VPWR Tile_X0Y5_FrameStrobe[4] latch
XFILLER_39_91 VPWR VGND sg13cmos5l_decap_8
XANTENNA__0100__GATE Tile_X0Y5_FrameStrobe[0] VPWR VGND sg13cmos5l_antennanp
XANTENNA__0396__D Tile_X0Y1_FrameData[10] VPWR VGND sg13cmos5l_antennanp
X_0141_ _0141_/Q Tile_X0Y0_FrameData[25] VGND VPWR Tile_X0Y5_FrameStrobe[2] latch
XFILLER_91_210 VPWR VGND sg13cmos5l_fill_1
XANTENNA__0730__GATE Tile_X0Y5_FrameStrobe[5] VPWR VGND sg13cmos5l_antennanp
XFILLER_224_216 VPWR VGND sg13cmos5l_fill_2
XFILLER_91_221 VPWR VGND sg13cmos5l_fill_2
XFILLER_312_73 VPWR VGND sg13cmos5l_decap_4
X_0072_ _0072_/Q Tile_X0Y0_FrameData[30] VGND VPWR Tile_X0Y5_FrameStrobe[0] latch
XFILLER_51_118 VPWR VGND sg13cmos5l_decap_8
XANTENNA__2822__A1 Tile_X0Y5_N4END[1] VPWR VGND sg13cmos5l_antennanp
XFILLER_189_153 VPWR VGND sg13cmos5l_decap_8
XANTENNA__0115__GATE Tile_X0Y5_FrameStrobe[1] VPWR VGND sg13cmos5l_antennanp
XANTENNA__0745__GATE Tile_X0Y5_FrameStrobe[6] VPWR VGND sg13cmos5l_antennanp
XANTENNA__1020__D Tile_X0Y3_FrameData[26] VPWR VGND sg13cmos5l_antennanp
X_0974_ _0974_/Q Tile_X0Y3_FrameData[8] VGND VPWR Tile_X0Y5_FrameStrobe[5] latch
X_2713_ _2713_/X Tile_X0Y3_W2MID[7] Tile_X0Y3_W2END[7] Tile_X0Y3_W6END[8] _2589_/X
+ _0890_/Q _0889_/Q VPWR VGND sg13cmos5l_mux4_1
XFILLER_346_161 VPWR VGND sg13cmos5l_decap_8
X_2644_ _2644_/X AXIL_S_SOC_WSTRB1 AXIL_S_SOC_BREADY _2706_/X _2712_/X _1166_/Q _1165_/Q
+ VPWR VGND sg13cmos5l_mux4_1
X_2575_ _2575_/X _2570_/X Tile_X0Y5_N4END[10] _2569_/X Tile_X0Y0_S4END[14] _0818_/Q
+ _0817_/Q VPWR VGND sg13cmos5l_mux4_1
XFILLER_58_0 VPWR VGND sg13cmos5l_fill_1
XANTENNA__2353__A3 Tile_X0Y0_S4END[6] VPWR VGND sg13cmos5l_antennanp
XFILLER_273_25 VPWR VGND sg13cmos5l_decap_8
XFILLER_273_47 VPWR VGND sg13cmos5l_decap_8
XFILLER_273_58 VPWR VGND sg13cmos5l_fill_1
X_1526_ Tile_X0Y3_E6BEG[0] _2541_/X VPWR VGND sg13cmos5l_buf_1
XFILLER_113_197 VPWR VGND sg13cmos5l_decap_8
XFILLER_206_63 VPWR VGND sg13cmos5l_fill_2
X_1457_ _1457_/Q Tile_X0Y5_FrameData[31] VGND VPWR Tile_X0Y5_FrameStrobe[6] latch
XANTENNA__2510__A0 AXIL_S_SOC_ARADDR1 VPWR VGND sg13cmos5l_antennanp
X_1388_ _1388_/Q Tile_X0Y5_FrameData[4] VGND VPWR Tile_X0Y5_FrameStrobe[3] latch
X_0408_ _0408_/Q Tile_X0Y1_FrameData[30] VGND VPWR Tile_X0Y5_FrameStrobe[3] latch
XFILLER_27_115 VPWR VGND sg13cmos5l_decap_8
XFILLER_27_126 VPWR VGND sg13cmos5l_fill_2
X_0339_ _0339_/Q Tile_X0Y1_FrameData[3] VGND VPWR Tile_X0Y5_FrameStrobe[0] latch
XFILLER_222_62 VPWR VGND sg13cmos5l_decap_8
XFILLER_82_221 VPWR VGND sg13cmos5l_fill_2
XFILLER_35_27 VPWR VGND sg13cmos5l_fill_1
XANTENNA__2813__A1 Tile_X0Y5_N4END[0] VPWR VGND sg13cmos5l_antennanp
XFILLER_230_208 VPWR VGND sg13cmos5l_fill_1
X_2009_ Tile_X0Y5_EE4BEG[10] _2751_/X VPWR VGND sg13cmos5l_buf_1
XFILLER_298_33 VPWR VGND sg13cmos5l_decap_8
XFILLER_298_77 VPWR VGND sg13cmos5l_decap_8
XFILLER_136_7 VPWR VGND sg13cmos5l_decap_8
XFILLER_51_48 VPWR VGND sg13cmos5l_fill_1
XFILLER_167_59 VPWR VGND sg13cmos5l_decap_8
XANTENNA__2329__A0 AXIL_S_SOC_WDATA4 VPWR VGND sg13cmos5l_antennanp
XFILLER_303_7 VPWR VGND sg13cmos5l_decap_8
XFILLER_247_70 VPWR VGND sg13cmos5l_decap_8
XFILLER_247_92 VPWR VGND sg13cmos5l_fill_1
XFILLER_352_164 VPWR VGND sg13cmos5l_decap_8
XFILLER_104_164 VPWR VGND sg13cmos5l_decap_8
XFILLER_265_127 VPWR VGND sg13cmos5l_decap_8
XANTENNA__2501__A0 Tile_X0Y1_W1END[2] VPWR VGND sg13cmos5l_antennanp
XFILLER_18_104 VPWR VGND sg13cmos5l_fill_2
XFILLER_274_2 VPWR VGND sg13cmos5l_fill_1
XFILLER_280_108 VPWR VGND sg13cmos5l_decap_4
XANTENNA__1105__D Tile_X0Y4_FrameData[21] VPWR VGND sg13cmos5l_antennanp
XFILLER_273_160 VPWR VGND sg13cmos5l_fill_2
XANTENNA__0944__D Tile_X0Y3_FrameData[6] VPWR VGND sg13cmos5l_antennanp
XANTENNA__1460__GATE Tile_X0Y5_FrameStrobe[6] VPWR VGND sg13cmos5l_antennanp
XFILLER_132_73 VPWR VGND sg13cmos5l_decap_8
XFILLER_92_55 VPWR VGND sg13cmos5l_decap_8
XFILLER_186_112 VPWR VGND sg13cmos5l_decap_8
XANTENNA__2073__X Tile_X0Y5_S4BEG[6] VPWR VGND sg13cmos5l_antennanp
XFILLER_358_47 VPWR VGND sg13cmos5l_decap_8
XANTENNA__1475__GATE Tile_X0Y5_FrameStrobe[6] VPWR VGND sg13cmos5l_antennanp
XANTENNA__2568__A0 Tile_X0Y4_W1END[1] VPWR VGND sg13cmos5l_antennanp
XFILLER_127_223 VPWR VGND sg13cmos5l_fill_1
XANTENNA__2583__A3 Tile_X0Y0_S4END[15] VPWR VGND sg13cmos5l_antennanp
X_0690_ _0690_/Q Tile_X0Y2_FrameData[20] VGND VPWR Tile_X0Y5_FrameStrobe[4] latch
XFILLER_328_194 VPWR VGND sg13cmos5l_fill_2
XFILLER_142_204 VPWR VGND sg13cmos5l_decap_8
XANTENNA__2740__A0 AXIL_S_SOC_ARPROT0 VPWR VGND sg13cmos5l_antennanp
X_2360_ _2360_/X _2820_/X _2818_/X _2806_/X _2805_/X _1466_/Q _1465_/Q VPWR VGND sg13cmos5l_mux4_1
XFILLER_307_84 VPWR VGND sg13cmos5l_fill_2
XANTENNA__1413__GATE Tile_X0Y5_FrameStrobe[4] VPWR VGND sg13cmos5l_antennanp
X_1311_ _1311_/Q Tile_X0Y5_FrameData[17] VGND VPWR Tile_X0Y5_FrameStrobe[1] latch
X_2291_ _2291_/X _2346_/X _2345_/X AXIL_S_SOC_WDATA0 AXIL_S_SOC_WDATA5 _0510_/Q _0509_/Q
+ VPWR VGND sg13cmos5l_mux4_1
XFILLER_110_145 VPWR VGND sg13cmos5l_decap_8
X_1242_ _1242_/Q Tile_X0Y4_FrameData[12] VGND VPWR Tile_X0Y5_FrameStrobe[6] latch
XFILLER_249_190 VPWR VGND sg13cmos5l_decap_8
XFILLER_323_61 VPWR VGND sg13cmos5l_fill_1
XANTENNA__1015__D Tile_X0Y3_FrameData[31] VPWR VGND sg13cmos5l_antennanp
X_1173_ _1173_/Q Tile_X0Y4_FrameData[17] VGND VPWR Tile_X0Y5_FrameStrobe[4] latch
XANTENNA__1428__GATE Tile_X0Y5_FrameStrobe[5] VPWR VGND sg13cmos5l_antennanp
X_0124_ _0124_/Q Tile_X0Y0_FrameData[10] VGND VPWR Tile_X0Y5_FrameStrobe[1] latch
XANTENNA__0854__D Tile_X0Y3_FrameData[0] VPWR VGND sg13cmos5l_antennanp
X_0055_ _1609_/A _2277_/X _2278_/X _0761_/Q VPWR VGND sg13cmos5l_mux2_1
XANTENNA__0684__GATE Tile_X0Y5_FrameStrobe[4] VPWR VGND sg13cmos5l_antennanp
XANTENNA__2271__A2 Tile_X0Y1_WW4END[4] VPWR VGND sg13cmos5l_antennanp
XANTENNA__2559__A0 Tile_X0Y3_W1END[3] VPWR VGND sg13cmos5l_antennanp
XFILLER_118_223 VPWR VGND sg13cmos5l_fill_1
X_0957_ _0957_/Q Tile_X0Y3_FrameData[25] VGND VPWR Tile_X0Y5_FrameStrobe[5] latch
XANTENNA__0699__GATE Tile_X0Y5_FrameStrobe[4] VPWR VGND sg13cmos5l_antennanp
XANTENNA__2574__A3 Tile_X0Y0_S4END[15] VPWR VGND sg13cmos5l_antennanp
XFILLER_284_13 VPWR VGND sg13cmos5l_fill_1
XFILLER_284_24 VPWR VGND sg13cmos5l_fill_2
XFILLER_279_208 VPWR VGND sg13cmos5l_decap_4
XFILLER_284_57 VPWR VGND sg13cmos5l_decap_8
X_0888_ _0888_/Q Tile_X0Y3_FrameData[30] VGND VPWR Tile_X0Y5_FrameStrobe[3] latch
XANTENNA__0622__GATE Tile_X0Y5_FrameStrobe[2] VPWR VGND sg13cmos5l_antennanp
X_2627_ _2627_/X AXIL_S_SOC_WSTRB2 AXIL_S_SOC_WVALID _2710_/X _2683_/X _1200_/Q _1199_/Q
+ VPWR VGND sg13cmos5l_mux4_1
XANTENNA__2731__A0 AXIL_S_SOC_ARPROT1 VPWR VGND sg13cmos5l_antennanp
X_2558_ _2558_/X _2584_/X _2582_/X _2576_/X _2575_/X _0868_/Q _0867_/Q VPWR VGND sg13cmos5l_mux4_1
XFILLER_99_151 VPWR VGND sg13cmos5l_fill_1
XFILLER_99_140 VPWR VGND sg13cmos5l_decap_8
XFILLER_153_28 VPWR VGND sg13cmos5l_decap_8
X_1509_ _2669_/A3 VPWR VGND sg13cmos5l_tielo
X_2489_ _2489_/X Tile_X0Y1_W2MID[7] Tile_X0Y1_W2END[7] Tile_X0Y1_W6END[8] _2373_/X
+ _0410_/Q _0409_/Q VPWR VGND sg13cmos5l_mux4_1
XFILLER_99_173 VPWR VGND sg13cmos5l_decap_8
XFILLER_101_145 VPWR VGND sg13cmos5l_decap_8
XANTENNA__0637__GATE Tile_X0Y5_FrameStrobe[2] VPWR VGND sg13cmos5l_antennanp
XFILLER_255_160 VPWR VGND sg13cmos5l_decap_8
XFILLER_46_48 VPWR VGND sg13cmos5l_fill_1
XANTENNA__1997__X Tile_X0Y5_E6BEG[10] VPWR VGND sg13cmos5l_antennanp
XANTENNA__0764__D Tile_X0Y2_FrameData[10] VPWR VGND sg13cmos5l_antennanp
XFILLER_102_32 VPWR VGND sg13cmos5l_fill_1
XFILLER_203_208 VPWR VGND sg13cmos5l_fill_2
XFILLER_253_7 VPWR VGND sg13cmos5l_decap_8
XANTENNA__2798__A0 Tile_X0Y5_N2MID[6] VPWR VGND sg13cmos5l_antennanp
XFILLER_270_185 VPWR VGND sg13cmos5l_decap_8
XANTENNA__2262__A2 Tile_X0Y1_W6END[1] VPWR VGND sg13cmos5l_antennanp
XFILLER_168_134 VPWR VGND sg13cmos5l_decap_4
XFILLER_168_145 VPWR VGND sg13cmos5l_decap_8
XFILLER_183_104 VPWR VGND sg13cmos5l_fill_2
XFILLER_23_184 VPWR VGND sg13cmos5l_fill_1
XFILLER_109_223 VPWR VGND sg13cmos5l_fill_1
XFILLER_328_39 VPWR VGND sg13cmos5l_decap_8
XFILLER_328_28 VPWR VGND sg13cmos5l_fill_1
XFILLER_328_17 VPWR VGND sg13cmos5l_decap_8
XFILLER_194_46 VPWR VGND sg13cmos5l_fill_2
XFILLER_191_181 VPWR VGND sg13cmos5l_fill_1
XFILLER_340_101 VPWR VGND sg13cmos5l_fill_1
XANTENNA__2722__A0 Tile_X0Y5_N1END[1] VPWR VGND sg13cmos5l_antennanp
XFILLER_344_38 VPWR VGND sg13cmos5l_fill_2
XFILLER_344_27 VPWR VGND sg13cmos5l_decap_8
XFILLER_340_167 VPWR VGND sg13cmos5l_decap_8
XANTENNA__0939__D Tile_X0Y3_FrameData[11] VPWR VGND sg13cmos5l_antennanp
XFILLER_143_50 VPWR VGND sg13cmos5l_fill_2
XANTENNA__2068__X Tile_X0Y5_S4BEG[1] VPWR VGND sg13cmos5l_antennanp
XFILLER_46_210 VPWR VGND sg13cmos5l_fill_1
XFILLER_360_59 VPWR VGND sg13cmos5l_decap_8
XFILLER_360_48 VPWR VGND sg13cmos5l_fill_2
XANTENNA__0674__D Tile_X0Y2_FrameData[4] VPWR VGND sg13cmos5l_antennanp
XFILLER_261_141 VPWR VGND sg13cmos5l_fill_2
XANTENNA__1700__X Tile_X0Y0_EE4BEG[8] VPWR VGND sg13cmos5l_antennanp
XANTENNA__2789__A0 Tile_X0Y5_N1END[0] VPWR VGND sg13cmos5l_antennanp
XANTENNA__2253__A2 Tile_X0Y2_W6END[5] VPWR VGND sg13cmos5l_antennanp
X_1860_ Tile_X0Y4_FrameData_O[27] Tile_X0Y4_FrameData[27] VPWR VGND sg13cmos5l_buf_1
X_1791_ Tile_X0Y4_E2BEG[2] _2619_/X VPWR VGND sg13cmos5l_buf_1
X_0811_ _0811_/Q Tile_X0Y3_FrameData[11] VGND VPWR Tile_X0Y5_FrameStrobe[0] latch
X_0742_ _0742_/Q Tile_X0Y2_FrameData[0] VGND VPWR Tile_X0Y5_FrameStrobe[5] latch
XFILLER_316_153 VPWR VGND sg13cmos5l_fill_2
XFILLER_316_142 VPWR VGND sg13cmos5l_decap_4
X_0673_ _0673_/Q Tile_X0Y2_FrameData[5] VGND VPWR Tile_X0Y5_FrameStrobe[3] latch
XFILLER_331_123 VPWR VGND sg13cmos5l_decap_8
XFILLER_331_101 VPWR VGND sg13cmos5l_decap_8
XFILLER_318_94 VPWR VGND sg13cmos5l_fill_1
XANTENNA__1352__GATE Tile_X0Y5_FrameStrobe[2] VPWR VGND sg13cmos5l_antennanp
XANTENNA__2713__A0 Tile_X0Y3_W2MID[7] VPWR VGND sg13cmos5l_antennanp
XFILLER_184_90 VPWR VGND sg13cmos5l_fill_2
XFILLER_254_27 VPWR VGND sg13cmos5l_decap_4
X_2412_ _2412_/X AXIL_S_SOC_AWADDR3 AXIL_S_SOC_AWPROT1 _2484_/X _2485_/X _0724_/Q
+ _0723_/Q VPWR VGND sg13cmos5l_mux4_1
XANTENNA__0849__D Tile_X0Y3_FrameData[5] VPWR VGND sg13cmos5l_antennanp
X_2343_ _2343_/X Tile_X0Y0_W1END[1] Tile_X0Y0_W6END[9] _2225_/X _2210_/X _0176_/Q
+ _0175_/Q VPWR VGND sg13cmos5l_mux4_1
XFILLER_229_138 VPWR VGND sg13cmos5l_decap_8
XFILLER_284_200 VPWR VGND sg13cmos5l_fill_2
XFILLER_334_71 VPWR VGND sg13cmos5l_fill_1
X_2274_ _2274_/X _2475_/X _2473_/X _2466_/X _2465_/X _0757_/Q _0756_/Q VPWR VGND sg13cmos5l_mux4_1
XFILLER_96_176 VPWR VGND sg13cmos5l_decap_8
XANTENNA__1367__GATE Tile_X0Y5_FrameStrobe[3] VPWR VGND sg13cmos5l_antennanp
XFILLER_203_20 VPWR VGND sg13cmos5l_fill_2
XFILLER_237_160 VPWR VGND sg13cmos5l_decap_8
X_1225_ _1225_/Q Tile_X0Y4_FrameData[29] VGND VPWR Tile_X0Y5_FrameStrobe[6] latch
X_1156_ _1156_/Q Tile_X0Y4_FrameData[2] VGND VPWR Tile_X0Y5_FrameStrobe[3] latch
XANTENNA__0584__D Tile_X0Y2_FrameData[30] VPWR VGND sg13cmos5l_antennanp
XANTENNA__2492__A2 Tile_X0Y4_W6END[6] VPWR VGND sg13cmos5l_antennanp
XFILLER_203_97 VPWR VGND sg13cmos5l_fill_2
XFILLER_279_13 VPWR VGND sg13cmos5l_decap_8
X_0107_ _0107_/Q Tile_X0Y0_FrameData[27] VGND VPWR Tile_X0Y5_FrameStrobe[1] latch
XANTENNA__1610__X Tile_X0Y0_N4BEG[6] VPWR VGND sg13cmos5l_antennanp
XFILLER_197_207 VPWR VGND sg13cmos5l_decap_4
X_1087_ _1087_/Q Tile_X0Y4_FrameData[7] VGND VPWR Tile_X0Y5_FrameStrobe[1] latch
XANTENNA__2244__A2 Tile_X0Y0_S2MID[3] VPWR VGND sg13cmos5l_antennanp
X_0038_ _2081_/A _2785_/X _2786_/X _1332_/Q VPWR VGND sg13cmos5l_mux2_1
XANTENNA__1305__GATE Tile_X0Y5_FrameStrobe[1] VPWR VGND sg13cmos5l_antennanp
X_1989_ Tile_X0Y5_E6BEG[2] _2759_/X VPWR VGND sg13cmos5l_buf_1
XFILLER_307_131 VPWR VGND sg13cmos5l_fill_2
XANTENNA__0561__GATE Tile_X0Y5_FrameStrobe[0] VPWR VGND sg13cmos5l_antennanp
XFILLER_173_170 VPWR VGND sg13cmos5l_decap_8
XFILLER_173_192 VPWR VGND sg13cmos5l_fill_2
XFILLER_228_94 VPWR VGND sg13cmos5l_decap_8
XANTENNA__0759__D Tile_X0Y2_FrameData[15] VPWR VGND sg13cmos5l_antennanp
XANTENNA__0576__GATE Tile_X0Y5_FrameStrobe[0] VPWR VGND sg13cmos5l_antennanp
XANTENNA__2180__A1 AXIL_S_SOC_WDATA31 VPWR VGND sg13cmos5l_antennanp
XFILLER_87_143 VPWR VGND sg13cmos5l_decap_8
XFILLER_57_25 VPWR VGND sg13cmos5l_fill_2
XFILLER_57_14 VPWR VGND sg13cmos5l_fill_2
XFILLER_235_108 VPWR VGND sg13cmos5l_decap_8
XFILLER_113_42 VPWR VGND sg13cmos5l_decap_8
XFILLER_73_13 VPWR VGND sg13cmos5l_decap_4
XANTENNA__0494__D Tile_X0Y1_FrameData[8] VPWR VGND sg13cmos5l_antennanp
XFILLER_243_141 VPWR VGND sg13cmos5l_fill_2
XFILLER_73_24 VPWR VGND sg13cmos5l_decap_8
XFILLER_189_35 VPWR VGND sg13cmos5l_decap_8
XANTENNA__2235__A2 Tile_X0Y0_S1END[3] VPWR VGND sg13cmos5l_antennanp
XANTENNA__0514__GATE Tile_X0Y5_FrameStrobe[6] VPWR VGND sg13cmos5l_antennanp
XFILLER_156_126 VPWR VGND sg13cmos5l_fill_2
XANTENNA__0529__GATE Tile_X0Y5_FrameStrobe[6] VPWR VGND sg13cmos5l_antennanp
XFILLER_355_26 VPWR VGND sg13cmos5l_decap_4
XFILLER_164_192 VPWR VGND sg13cmos5l_decap_8
XFILLER_98_76 VPWR VGND sg13cmos5l_decap_8
XANTENNA__0669__D Tile_X0Y2_FrameData[9] VPWR VGND sg13cmos5l_antennanp
XFILLER_313_178 VPWR VGND sg13cmos5l_fill_2
XANTENNA__2171__A1 AXIL_S_SOC_WDATA30 VPWR VGND sg13cmos5l_antennanp
XFILLER_154_60 VPWR VGND sg13cmos5l_decap_8
XFILLER_21_8 VPWR VGND sg13cmos5l_fill_1
XFILLER_93_113 VPWR VGND sg13cmos5l_fill_2
XFILLER_78_165 VPWR VGND sg13cmos5l_decap_8
XFILLER_226_108 VPWR VGND sg13cmos5l_decap_8
XFILLER_219_193 VPWR VGND sg13cmos5l_decap_4
X_1010_ _1010_/Q Tile_X0Y3_FrameData[4] VGND VPWR Tile_X0Y5_FrameStrobe[6] latch
XFILLER_93_168 VPWR VGND sg13cmos5l_fill_2
XFILLER_93_157 VPWR VGND sg13cmos5l_decap_8
XFILLER_47_80 VPWR VGND sg13cmos5l_decap_4
XFILLER_34_202 VPWR VGND sg13cmos5l_decap_8
XFILLER_234_174 VPWR VGND sg13cmos5l_decap_8
XANTENNA__2226__A2 Tile_X0Y0_S1END[1] VPWR VGND sg13cmos5l_antennanp
X_1912_ Tile_X0Y1_FrameData_O[25] Tile_X0Y1_FrameData[25] VPWR VGND sg13cmos5l_buf_1
X_1843_ Tile_X0Y4_FrameData_O[10] Tile_X0Y4_FrameData[10] VPWR VGND sg13cmos5l_buf_1
XFILLER_8_85 VPWR VGND sg13cmos5l_fill_2
XFILLER_162_118 VPWR VGND sg13cmos5l_fill_2
X_1774_ Tile_X0Y2_E1BEG[1] _2398_/X VPWR VGND sg13cmos5l_buf_1
XFILLER_329_82 VPWR VGND sg13cmos5l_decap_8
XFILLER_155_181 VPWR VGND sg13cmos5l_decap_8
X_0725_ _0725_/Q Tile_X0Y2_FrameData[17] VGND VPWR Tile_X0Y5_FrameStrobe[5] latch
XFILLER_304_123 VPWR VGND sg13cmos5l_decap_4
XANTENNA__1291__GATE Tile_X0Y5_FrameStrobe[0] VPWR VGND sg13cmos5l_antennanp
XFILLER_103_207 VPWR VGND sg13cmos5l_fill_2
XFILLER_170_140 VPWR VGND sg13cmos5l_decap_8
X_0656_ _0656_/Q Tile_X0Y2_FrameData[22] VGND VPWR Tile_X0Y5_FrameStrobe[3] latch
XFILLER_304_145 VPWR VGND sg13cmos5l_fill_1
XANTENNA__0579__D Tile_X0Y2_FrameData[3] VPWR VGND sg13cmos5l_antennanp
XFILLER_170_184 VPWR VGND sg13cmos5l_decap_8
XFILLER_69_110 VPWR VGND sg13cmos5l_fill_1
XANTENNA__1605__X Tile_X0Y0_N4BEG[1] VPWR VGND sg13cmos5l_antennanp
XANTENNA__2162__A1 Tile_X0Y0_S1END[1] VPWR VGND sg13cmos5l_antennanp
XFILLER_281_25 VPWR VGND sg13cmos5l_fill_1
XFILLER_281_47 VPWR VGND sg13cmos5l_fill_2
X_0587_ _0587_/Q Tile_X0Y2_FrameData[27] VGND VPWR Tile_X0Y5_FrameStrobe[1] latch
XFILLER_69_143 VPWR VGND sg13cmos5l_decap_8
X_2326_ _2326_/X _0031_/X Tile_X0Y0_S4END[5] _2354_/X _2353_/X _0440_/Q _0439_/Q VPWR
+ VGND sg13cmos5l_mux4_1
XFILLER_214_63 VPWR VGND sg13cmos5l_decap_8
X_2257_ _2257_/X Tile_X0Y2_W2MID[3] Tile_X0Y2_W2END[3] Tile_X0Y2_W6END[3] _2485_/X
+ _0774_/Q _0773_/Q VPWR VGND sg13cmos5l_mux4_1
XFILLER_69_187 VPWR VGND sg13cmos5l_fill_1
X_1208_ _1208_/Q Tile_X0Y4_FrameData[14] VGND VPWR Tile_X0Y5_FrameStrobe[5] latch
X_2188_ _2188_/X AXIL_S_SOC_WDATA23 AXIL_S_SOC_WDATA27 _2230_/X _2241_/X _0220_/Q
+ _0219_/Q VPWR VGND sg13cmos5l_mux4_1
XANTENNA__1203__D Tile_X0Y4_FrameData[19] VPWR VGND sg13cmos5l_antennanp
XFILLER_225_163 VPWR VGND sg13cmos5l_decap_8
X_1139_ _1139_/Q Tile_X0Y4_FrameData[19] VGND VPWR Tile_X0Y5_FrameStrobe[3] latch
XANTENNA__2217__A2 Tile_X0Y0_S1END[3] VPWR VGND sg13cmos5l_antennanp
XFILLER_225_196 VPWR VGND sg13cmos5l_fill_2
XFILLER_230_95 VPWR VGND sg13cmos5l_decap_4
XANTENNA__1244__GATE Tile_X0Y5_FrameStrobe[6] VPWR VGND sg13cmos5l_antennanp
XFILLER_138_104 VPWR VGND sg13cmos5l_decap_4
XFILLER_193_210 VPWR VGND sg13cmos5l_fill_2
XFILLER_138_148 VPWR VGND sg13cmos5l_decap_8
XFILLER_153_118 VPWR VGND sg13cmos5l_decap_8
XANTENNA__1259__GATE Tile_X0Y5_FrameStrobe[7] VPWR VGND sg13cmos5l_antennanp
XFILLER_146_170 VPWR VGND sg13cmos5l_decap_4
XFILLER_108_42 VPWR VGND sg13cmos5l_fill_1
XFILLER_108_53 VPWR VGND sg13cmos5l_decap_8
XFILLER_161_140 VPWR VGND sg13cmos5l_decap_8
XANTENNA__0489__D Tile_X0Y1_FrameData[13] VPWR VGND sg13cmos5l_antennanp
XANTENNA__2153__A1 Tile_X0Y0_WW4END[0] VPWR VGND sg13cmos5l_antennanp
XFILLER_191_14 VPWR VGND sg13cmos5l_fill_2
XFILLER_187_2 VPWR VGND sg13cmos5l_fill_1
XFILLER_124_96 VPWR VGND sg13cmos5l_decap_8
XFILLER_84_34 VPWR VGND sg13cmos5l_decap_8
XANTENNA__1898__A Tile_X0Y1_FrameData[11] VPWR VGND sg13cmos5l_antennanp
XANTENNA__2456__A2 Tile_X0Y2_W6END[3] VPWR VGND sg13cmos5l_antennanp
XFILLER_90_116 VPWR VGND sg13cmos5l_decap_8
XANTENNA__1113__D Tile_X0Y4_FrameData[13] VPWR VGND sg13cmos5l_antennanp
XFILLER_216_163 VPWR VGND sg13cmos5l_decap_4
XFILLER_216_174 VPWR VGND sg13cmos5l_decap_8
XANTENNA__0453__GATE Tile_X0Y5_FrameStrobe[4] VPWR VGND sg13cmos5l_antennanp
XANTENNA__0952__D Tile_X0Y3_FrameData[30] VPWR VGND sg13cmos5l_antennanp
XFILLER_242_0 VPWR VGND sg13cmos5l_fill_1
XFILLER_129_137 VPWR VGND sg13cmos5l_decap_4
XANTENNA__0468__GATE Tile_X0Y5_FrameStrobe[4] VPWR VGND sg13cmos5l_antennanp
XANTENNA__2081__X Tile_X0Y5_S4BEG[14] VPWR VGND sg13cmos5l_antennanp
XANTENNA__2392__A1 Tile_X0Y3_W2END[2] VPWR VGND sg13cmos5l_antennanp
X_0510_ _0510_/Q Tile_X0Y1_FrameData[24] VGND VPWR Tile_X0Y5_FrameStrobe[6] latch
XFILLER_298_122 VPWR VGND sg13cmos5l_fill_2
XANTENNA__0399__D Tile_X0Y1_FrameData[7] VPWR VGND sg13cmos5l_antennanp
X_1490_ _1490_/Q Tile_X0Y5_FrameData[30] VGND VPWR Tile_X0Y5_FrameStrobe[7] latch
XFILLER_298_166 VPWR VGND sg13cmos5l_decap_4
XANTENNA__2144__A1 Tile_X0Y0_W6END[7] VPWR VGND sg13cmos5l_antennanp
XFILLER_152_195 VPWR VGND sg13cmos5l_decap_8
X_0441_ _0441_/Q Tile_X0Y1_FrameData[29] VGND VPWR Tile_X0Y5_FrameStrobe[4] latch
XFILLER_315_40 VPWR VGND sg13cmos5l_fill_2
XFILLER_301_148 VPWR VGND sg13cmos5l_decap_4
XFILLER_298_188 VPWR VGND sg13cmos5l_decap_8
X_0372_ _0372_/Q Tile_X0Y1_FrameData[2] VGND VPWR Tile_X0Y5_FrameStrobe[1] latch
XFILLER_301_159 VPWR VGND sg13cmos5l_decap_8
XANTENNA__0406__GATE Tile_X0Y5_FrameStrobe[2] VPWR VGND sg13cmos5l_antennanp
X_2111_ AXIL_S_SOC_RDATA5 Tile_X0Y3_W2MID[5] Tile_X0Y3_W2END[5] Tile_X0Y3_W6END[5]
+ _2594_/X _0852_/Q _0851_/Q VPWR VGND sg13cmos5l_mux4_1
XFILLER_181_91 VPWR VGND sg13cmos5l_decap_4
X_2042_ Tile_X0Y5_FrameData_O[27] Tile_X0Y5_FrameData[27] VPWR VGND sg13cmos5l_buf_1
XANTENNA__2447__A2 Tile_X0Y2_WW4END[13] VPWR VGND sg13cmos5l_antennanp
XANTENNA__1023__D Tile_X0Y3_FrameData[23] VPWR VGND sg13cmos5l_antennanp
XANTENNA__0862__D Tile_X0Y3_FrameData[24] VPWR VGND sg13cmos5l_antennanp
XFILLER_222_166 VPWR VGND sg13cmos5l_decap_8
XFILLER_276_14 VPWR VGND sg13cmos5l_decap_8
X_1826_ Tile_X0Y4_EE4BEG[9] _2642_/X VPWR VGND sg13cmos5l_buf_1
XFILLER_128_181 VPWR VGND sg13cmos5l_decap_8
XFILLER_190_213 VPWR VGND sg13cmos5l_fill_2
XANTENNA__2383__A1 Tile_X0Y0_W2END[6] VPWR VGND sg13cmos5l_antennanp
X_1757_ Tile_X0Y2_FrameData_O[17] Tile_X0Y2_FrameData[17] VPWR VGND sg13cmos5l_buf_1
XFILLER_356_91 VPWR VGND sg13cmos5l_fill_2
XFILLER_292_35 VPWR VGND sg13cmos5l_fill_2
X_1688_ Tile_X0Y0_FrameData_O[28] Tile_X0Y0_FrameData[28] VPWR VGND sg13cmos5l_buf_1
X_0708_ _0708_/Q Tile_X0Y2_FrameData[2] VGND VPWR Tile_X0Y5_FrameStrobe[4] latch
XANTENNA__0102__D Tile_X0Y0_FrameData[0] VPWR VGND sg13cmos5l_antennanp
XANTENNA__2135__A1 Tile_X0Y0_W2END[5] VPWR VGND sg13cmos5l_antennanp
XFILLER_289_188 VPWR VGND sg13cmos5l_fill_1
XFILLER_289_199 VPWR VGND sg13cmos5l_decap_4
XFILLER_292_68 VPWR VGND sg13cmos5l_decap_4
X_0639_ _0639_/Q Tile_X0Y2_FrameData[7] VGND VPWR Tile_X0Y5_FrameStrobe[2] latch
XFILLER_38_16 VPWR VGND sg13cmos5l_fill_2
XANTENNA__2686__A2 Tile_X0Y0_WW4END[12] VPWR VGND sg13cmos5l_antennanp
X_2309_ _2309_/X AXIL_S_SOC_WDATA0 AXIL_S_SOC_WDATA12 _2349_/X _2380_/X _0474_/Q _0473_/Q
+ VPWR VGND sg13cmos5l_mux4_1
XFILLER_57_135 VPWR VGND sg13cmos5l_decap_8
XFILLER_241_83 VPWR VGND sg13cmos5l_decap_8
XFILLER_159_6 VPWR VGND sg13cmos5l_decap_4
XFILLER_359_115 VPWR VGND sg13cmos5l_decap_8
XANTENNA__0772__D Tile_X0Y2_FrameData[2] VPWR VGND sg13cmos5l_antennanp
XANTENNA__1183__GATE Tile_X0Y5_FrameStrobe[4] VPWR VGND sg13cmos5l_antennanp
XFILLER_359_148 VPWR VGND sg13cmos5l_decap_8
XFILLER_70_14 VPWR VGND sg13cmos5l_decap_8
XANTENNA__2610__A2 Tile_X0Y5_W6END[1] VPWR VGND sg13cmos5l_antennanp
XFILLER_181_202 VPWR VGND sg13cmos5l_fill_1
XFILLER_315_207 VPWR VGND sg13cmos5l_fill_2
XANTENNA__1198__GATE Tile_X0Y5_FrameStrobe[5] VPWR VGND sg13cmos5l_antennanp
XFILLER_119_30 VPWR VGND sg13cmos5l_fill_1
XFILLER_119_41 VPWR VGND sg13cmos5l_decap_8
XFILLER_119_85 VPWR VGND sg13cmos5l_fill_1
XFILLER_79_45 VPWR VGND sg13cmos5l_fill_2
XFILLER_79_34 VPWR VGND sg13cmos5l_decap_8
XANTENNA__1121__GATE Tile_X0Y5_FrameStrobe[2] VPWR VGND sg13cmos5l_antennanp
XANTENNA__1108__D Tile_X0Y4_FrameData[18] VPWR VGND sg13cmos5l_antennanp
XANTENNA__2126__A1 Tile_X0Y1_W2END[4] VPWR VGND sg13cmos5l_antennanp
XFILLER_79_89 VPWR VGND sg13cmos5l_decap_8
XFILLER_352_49 VPWR VGND sg13cmos5l_fill_2
XFILLER_352_38 VPWR VGND sg13cmos5l_decap_8
XANTENNA__0947__D Tile_X0Y3_FrameData[3] VPWR VGND sg13cmos5l_antennanp
XFILLER_192_0 VPWR VGND sg13cmos5l_decap_8
XFILLER_95_66 VPWR VGND sg13cmos5l_decap_8
XANTENNA__1136__GATE Tile_X0Y5_FrameStrobe[3] VPWR VGND sg13cmos5l_antennanp
XANTENNA__0392__GATE Tile_X0Y5_FrameStrobe[2] VPWR VGND sg13cmos5l_antennanp
XANTENNA__2076__X Tile_X0Y5_S4BEG[9] VPWR VGND sg13cmos5l_antennanp
XFILLER_301_20 VPWR VGND sg13cmos5l_fill_1
XANTENNA__0682__D Tile_X0Y2_FrameData[28] VPWR VGND sg13cmos5l_antennanp
XFILLER_204_155 VPWR VGND sg13cmos5l_decap_4
XFILLER_301_86 VPWR VGND sg13cmos5l_decap_8
X_0990_ _0990_/Q Tile_X0Y3_FrameData[24] VGND VPWR Tile_X0Y5_FrameStrobe[6] latch
XANTENNA__2601__A2 Tile_X0Y2_W6END[10] VPWR VGND sg13cmos5l_antennanp
XFILLER_157_221 VPWR VGND sg13cmos5l_fill_2
X_2660_ _2660_/X AXIL_S_SOC_WSTRB3 _2707_/X _2706_/X _2681_/X _1134_/Q _1133_/Q VPWR
+ VGND sg13cmos5l_mux4_1
X_1611_ Tile_X0Y0_N4BEG[7] _1611_/A VPWR VGND sg13cmos5l_buf_1
XANTENNA__0330__GATE Tile_X0Y5_FrameStrobe[0] VPWR VGND sg13cmos5l_antennanp
XFILLER_176_80 VPWR VGND sg13cmos5l_decap_8
X_2591_ _2591_/X _2494_/X _2602_/X _2601_/X _2493_/X _0810_/Q _0809_/Q VPWR VGND sg13cmos5l_mux4_1
XANTENNA__0960__GATE Tile_X0Y5_FrameStrobe[5] VPWR VGND sg13cmos5l_antennanp
X_1542_ Tile_X0Y3_EE4BEG[4] _2529_/X VPWR VGND sg13cmos5l_buf_1
XANTENNA__1018__D Tile_X0Y3_FrameData[28] VPWR VGND sg13cmos5l_antennanp
XFILLER_125_184 VPWR VGND sg13cmos5l_fill_1
XFILLER_286_114 VPWR VGND sg13cmos5l_decap_8
X_1473_ _1473_/Q Tile_X0Y5_FrameData[15] VGND VPWR Tile_X0Y5_FrameStrobe[6] latch
XANTENNA__0345__GATE Tile_X0Y5_FrameStrobe[1] VPWR VGND sg13cmos5l_antennanp
XANTENNA__2117__A1 Tile_X0Y2_W2END[3] VPWR VGND sg13cmos5l_antennanp
X_0424_ _0424_/Q Tile_X0Y1_FrameData[14] VGND VPWR Tile_X0Y5_FrameStrobe[3] latch
XANTENNA__0857__D Tile_X0Y3_FrameData[29] VPWR VGND sg13cmos5l_antennanp
XANTENNA__0975__GATE Tile_X0Y5_FrameStrobe[5] VPWR VGND sg13cmos5l_antennanp
XFILLER_39_124 VPWR VGND sg13cmos5l_decap_8
X_0355_ _0355_/Q Tile_X0Y1_FrameData[19] VGND VPWR Tile_X0Y5_FrameStrobe[1] latch
XFILLER_39_157 VPWR VGND sg13cmos5l_decap_8
X_0286_ _0286_/Q Tile_X0Y0_FrameData[8] VGND VPWR Tile_X0Y5_FrameStrobe[6] latch
XFILLER_54_105 VPWR VGND sg13cmos5l_decap_8
XFILLER_342_93 VPWR VGND sg13cmos5l_decap_8
X_2025_ Tile_X0Y5_FrameData_O[10] Tile_X0Y5_FrameData[10] VPWR VGND sg13cmos5l_buf_1
XFILLER_47_190 VPWR VGND sg13cmos5l_decap_8
XANTENNA__0592__D Tile_X0Y2_FrameData[22] VPWR VGND sg13cmos5l_antennanp
XFILLER_211_97 VPWR VGND sg13cmos5l_decap_4
XFILLER_287_13 VPWR VGND sg13cmos5l_decap_8
XFILLER_287_24 VPWR VGND sg13cmos5l_fill_1
XFILLER_356_107 VPWR VGND sg13cmos5l_decap_8
XANTENNA__0913__GATE Tile_X0Y5_FrameStrobe[3] VPWR VGND sg13cmos5l_antennanp
XFILLER_287_68 VPWR VGND sg13cmos5l_decap_8
XANTENNA__0928__GATE Tile_X0Y5_FrameStrobe[4] VPWR VGND sg13cmos5l_antennanp
XFILLER_156_39 VPWR VGND sg13cmos5l_decap_8
X_1809_ Tile_X0Y4_E6BEG[4] _2653_/X VPWR VGND sg13cmos5l_buf_1
X_2789_ _2789_/X Tile_X0Y5_N1END[0] _2793_/X Tile_X0Y5_W6END[0] _2789_/A3 _1272_/Q
+ _1271_/Q VPWR VGND sg13cmos5l_mux4_1
XFILLER_116_162 VPWR VGND sg13cmos5l_decap_8
XFILLER_131_132 VPWR VGND sg13cmos5l_decap_8
XFILLER_277_103 VPWR VGND sg13cmos5l_fill_1
XFILLER_277_114 VPWR VGND sg13cmos5l_fill_2
XANTENNA__2108__A1 Tile_X0Y3_W2END[2] VPWR VGND sg13cmos5l_antennanp
XANTENNA__0767__D Tile_X0Y2_FrameData[7] VPWR VGND sg13cmos5l_antennanp
XFILLER_131_187 VPWR VGND sg13cmos5l_decap_8
XFILLER_131_198 VPWR VGND sg13cmos5l_fill_2
XFILLER_292_117 VPWR VGND sg13cmos5l_fill_2
XFILLER_45_116 VPWR VGND sg13cmos5l_fill_1
XFILLER_45_138 VPWR VGND sg13cmos5l_decap_8
XFILLER_121_42 VPWR VGND sg13cmos5l_decap_8
XANTENNA__2831__A2 Tile_X0Y4_W6END[10] VPWR VGND sg13cmos5l_antennanp
XFILLER_198_143 VPWR VGND sg13cmos5l_decap_8
XFILLER_81_13 VPWR VGND sg13cmos5l_decap_8
XFILLER_197_13 VPWR VGND sg13cmos5l_decap_8
XFILLER_355_173 VPWR VGND sg13cmos5l_fill_2
XFILLER_347_49 VPWR VGND sg13cmos5l_decap_8
XANTENNA__2347__A1 Tile_X0Y0_W6END[11] VPWR VGND sg13cmos5l_antennanp
XFILLER_205_0 VPWR VGND sg13cmos5l_fill_1
XANTENNA__1060__GATE Tile_X0Y5_FrameStrobe[0] VPWR VGND sg13cmos5l_antennanp
XFILLER_30_83 VPWR VGND sg13cmos5l_decap_8
XFILLER_107_184 VPWR VGND sg13cmos5l_fill_1
XFILLER_122_110 VPWR VGND sg13cmos5l_decap_8
XFILLER_122_132 VPWR VGND sg13cmos5l_decap_4
XFILLER_146_83 VPWR VGND sg13cmos5l_decap_8
XANTENNA__0677__D Tile_X0Y2_FrameData[1] VPWR VGND sg13cmos5l_antennanp
XANTENNA__1075__GATE Tile_X0Y5_FrameStrobe[1] VPWR VGND sg13cmos5l_antennanp
XFILLER_268_158 VPWR VGND sg13cmos5l_fill_2
XANTENNA__1703__X Tile_X0Y0_EE4BEG[11] VPWR VGND sg13cmos5l_antennanp
XFILLER_283_117 VPWR VGND sg13cmos5l_fill_1
X_0140_ _0140_/Q Tile_X0Y0_FrameData[26] VGND VPWR Tile_X0Y5_FrameStrobe[2] latch
XFILLER_36_116 VPWR VGND sg13cmos5l_decap_4
X_0071_ _0071_/X _2690_/X _2691_/X _0149_/Q VPWR VGND sg13cmos5l_mux2_1
XANTENNA__2283__A0 Tile_X0Y3_W1END[2] VPWR VGND sg13cmos5l_antennanp
XFILLER_189_132 VPWR VGND sg13cmos5l_decap_8
XANTENNA__1301__D Tile_X0Y5_FrameData[27] VPWR VGND sg13cmos5l_antennanp
XANTENNA__1013__GATE Tile_X0Y5_FrameStrobe[6] VPWR VGND sg13cmos5l_antennanp
XANTENNA__2586__A1 Tile_X0Y5_N4END[9] VPWR VGND sg13cmos5l_antennanp
X_2712_ _2712_/X _2606_/X Tile_X0Y5_N2MID[4] _2717_/X _2605_/X _1046_/Q _1045_/Q VPWR
+ VGND sg13cmos5l_mux4_1
X_0973_ _0973_/Q Tile_X0Y3_FrameData[9] VGND VPWR Tile_X0Y5_FrameStrobe[5] latch
XFILLER_145_213 VPWR VGND sg13cmos5l_fill_2
XANTENNA__1028__GATE Tile_X0Y5_FrameStrobe[7] VPWR VGND sg13cmos5l_antennanp
X_2643_ _2643_/X AXIL_S_SOC_WSTRB0 AXIL_S_SOC_WVALID _2704_/X _2683_/X _1168_/Q _1167_/Q
+ VPWR VGND sg13cmos5l_mux4_1
XFILLER_361_132 VPWR VGND sg13cmos5l_fill_1
X_2574_ _2574_/X _2572_/X Tile_X0Y5_N4END[11] _2571_/X Tile_X0Y0_S4END[15] _0824_/Q
+ _0823_/Q VPWR VGND sg13cmos5l_mux4_1
XFILLER_337_71 VPWR VGND sg13cmos5l_decap_8
X_1525_ Tile_X0Y3_E2BEGb[7] _2524_/X VPWR VGND sg13cmos5l_buf_1
XANTENNA__0284__GATE Tile_X0Y5_FrameStrobe[6] VPWR VGND sg13cmos5l_antennanp
XANTENNA__0587__D Tile_X0Y2_FrameData[27] VPWR VGND sg13cmos5l_antennanp
XFILLER_113_176 VPWR VGND sg13cmos5l_decap_8
X_1456_ _1456_/Q Tile_X0Y5_FrameData[0] VGND VPWR Tile_X0Y5_FrameStrobe[5] latch
XANTENNA__1613__X Tile_X0Y0_N4BEG[9] VPWR VGND sg13cmos5l_antennanp
X_1387_ _1387_/Q Tile_X0Y5_FrameData[5] VGND VPWR Tile_X0Y5_FrameStrobe[3] latch
X_0407_ _0407_/Q Tile_X0Y1_FrameData[31] VGND VPWR Tile_X0Y5_FrameStrobe[3] latch
XANTENNA__0299__GATE Tile_X0Y5_FrameStrobe[7] VPWR VGND sg13cmos5l_antennanp
XANTENNA__2510__A1 AXIL_S_SOC_ARADDR9 VPWR VGND sg13cmos5l_antennanp
XFILLER_267_191 VPWR VGND sg13cmos5l_decap_8
X_0338_ _0338_/Q Tile_X0Y1_FrameData[4] VGND VPWR Tile_X0Y5_FrameStrobe[0] latch
XFILLER_27_138 VPWR VGND sg13cmos5l_decap_4
XFILLER_27_149 VPWR VGND sg13cmos5l_decap_8
XFILLER_282_150 VPWR VGND sg13cmos5l_fill_1
X_0269_ _0269_/Q Tile_X0Y0_FrameData[25] VGND VPWR Tile_X0Y5_FrameStrobe[6] latch
XANTENNA__0222__GATE Tile_X0Y5_FrameStrobe[4] VPWR VGND sg13cmos5l_antennanp
X_2008_ Tile_X0Y5_EE4BEG[9] _2750_/X VPWR VGND sg13cmos5l_buf_1
XFILLER_35_182 VPWR VGND sg13cmos5l_fill_2
XANTENNA__0852__GATE Tile_X0Y5_FrameStrobe[1] VPWR VGND sg13cmos5l_antennanp
XANTENNA__1211__D Tile_X0Y4_FrameData[11] VPWR VGND sg13cmos5l_antennanp
XFILLER_195_102 VPWR VGND sg13cmos5l_fill_2
XFILLER_195_146 VPWR VGND sg13cmos5l_fill_1
XANTENNA__2577__A1 Tile_X0Y5_N4END[9] VPWR VGND sg13cmos5l_antennanp
XFILLER_195_168 VPWR VGND sg13cmos5l_decap_8
XFILLER_195_179 VPWR VGND sg13cmos5l_fill_1
XANTENNA__0237__GATE Tile_X0Y5_FrameStrobe[5] VPWR VGND sg13cmos5l_antennanp
XANTENNA__0867__GATE Tile_X0Y5_FrameStrobe[2] VPWR VGND sg13cmos5l_antennanp
XFILLER_352_143 VPWR VGND sg13cmos5l_fill_2
XFILLER_317_19 VPWR VGND sg13cmos5l_fill_1
XFILLER_183_15 VPWR VGND sg13cmos5l_decap_8
XFILLER_352_154 VPWR VGND sg13cmos5l_decap_4
XFILLER_104_121 VPWR VGND sg13cmos5l_decap_8
XFILLER_104_143 VPWR VGND sg13cmos5l_decap_8
XFILLER_183_59 VPWR VGND sg13cmos5l_decap_4
XANTENNA__0497__D Tile_X0Y1_FrameData[5] VPWR VGND sg13cmos5l_antennanp
XFILLER_104_176 VPWR VGND sg13cmos5l_decap_8
XFILLER_104_187 VPWR VGND sg13cmos5l_fill_1
XFILLER_116_64 VPWR VGND sg13cmos5l_decap_8
XFILLER_116_75 VPWR VGND sg13cmos5l_fill_2
XFILLER_263_70 VPWR VGND sg13cmos5l_decap_8
XFILLER_265_106 VPWR VGND sg13cmos5l_decap_8
XANTENNA__1523__X Tile_X0Y3_E2BEGb[5] VPWR VGND sg13cmos5l_antennanp
XFILLER_76_35 VPWR VGND sg13cmos5l_decap_4
XANTENNA__0805__GATE Tile_X0Y5_FrameStrobe[0] VPWR VGND sg13cmos5l_antennanp
XANTENNA__2501__A1 Tile_X0Y1_W2MID[1] VPWR VGND sg13cmos5l_antennanp
XFILLER_132_41 VPWR VGND sg13cmos5l_decap_8
XFILLER_18_127 VPWR VGND sg13cmos5l_decap_4
XFILLER_206_217 VPWR VGND sg13cmos5l_fill_1
XFILLER_73_211 VPWR VGND sg13cmos5l_fill_1
XFILLER_267_2 VPWR VGND sg13cmos5l_fill_1
XFILLER_273_183 VPWR VGND sg13cmos5l_fill_2
XFILLER_92_34 VPWR VGND sg13cmos5l_decap_8
XANTENNA__2265__A0 Tile_X0Y1_W1END[3] VPWR VGND sg13cmos5l_antennanp
XFILLER_26_171 VPWR VGND sg13cmos5l_decap_4
XANTENNA__1121__D Tile_X0Y4_FrameData[5] VPWR VGND sg13cmos5l_antennanp
XFILLER_155_0 VPWR VGND sg13cmos5l_fill_2
XFILLER_25_61 VPWR VGND sg13cmos5l_fill_1
XFILLER_25_72 VPWR VGND sg13cmos5l_decap_8
XFILLER_25_83 VPWR VGND sg13cmos5l_fill_1
XANTENNA__0960__D Tile_X0Y3_FrameData[22] VPWR VGND sg13cmos5l_antennanp
XANTENNA__2568__A1 Tile_X0Y4_W6END[5] VPWR VGND sg13cmos5l_antennanp
XFILLER_41_196 VPWR VGND sg13cmos5l_fill_1
XFILLER_328_140 VPWR VGND sg13cmos5l_decap_8
XFILLER_322_0 VPWR VGND sg13cmos5l_fill_2
XFILLER_227_19 VPWR VGND sg13cmos5l_decap_8
XFILLER_41_82 VPWR VGND sg13cmos5l_decap_8
XFILLER_157_82 VPWR VGND sg13cmos5l_fill_1
XFILLER_307_30 VPWR VGND sg13cmos5l_decap_8
XANTENNA__2740__A1 AXIL_S_SOC_ARPROT2 VPWR VGND sg13cmos5l_antennanp
XFILLER_307_74 VPWR VGND sg13cmos5l_decap_8
X_1310_ _1310_/Q Tile_X0Y5_FrameData[18] VGND VPWR Tile_X0Y5_FrameStrobe[1] latch
X_2290_ _2290_/X _2344_/X _2343_/X AXIL_S_SOC_WDATA3 AXIL_S_SOC_WDATA6 _0512_/Q _0511_/Q
+ VPWR VGND sg13cmos5l_mux4_1
XFILLER_110_124 VPWR VGND sg13cmos5l_decap_8
XFILLER_256_139 VPWR VGND sg13cmos5l_decap_4
X_1241_ _1241_/Q Tile_X0Y4_FrameData[13] VGND VPWR Tile_X0Y5_FrameStrobe[6] latch
XANTENNA__0200__D Tile_X0Y0_FrameData[30] VPWR VGND sg13cmos5l_antennanp
X_1172_ _1172_/Q Tile_X0Y4_FrameData[18] VGND VPWR Tile_X0Y5_FrameStrobe[4] latch
X_0123_ _0123_/Q Tile_X0Y0_FrameData[11] VGND VPWR Tile_X0Y5_FrameStrobe[1] latch
XANTENNA__2256__A0 Tile_X0Y1_W2MID[4] VPWR VGND sg13cmos5l_antennanp
XFILLER_17_160 VPWR VGND sg13cmos5l_fill_1
X_0054_ _1610_/A _2275_/X _2276_/X _0758_/Q VPWR VGND sg13cmos5l_mux2_1
XANTENNA__1031__D Tile_X0Y3_FrameData[31] VPWR VGND sg13cmos5l_antennanp
XANTENNA__2271__A3 Tile_X0Y1_W6END[8] VPWR VGND sg13cmos5l_antennanp
XANTENNA__0870__D Tile_X0Y3_FrameData[16] VPWR VGND sg13cmos5l_antennanp
XANTENNA__2559__A1 Tile_X0Y3_WW4END[11] VPWR VGND sg13cmos5l_antennanp
X_0956_ _0956_/Q Tile_X0Y3_FrameData[26] VGND VPWR Tile_X0Y5_FrameStrobe[5] latch
XFILLER_70_0 VPWR VGND sg13cmos5l_fill_2
XFILLER_319_162 VPWR VGND sg13cmos5l_decap_8
XFILLER_348_81 VPWR VGND sg13cmos5l_decap_8
XANTENNA__1608__X Tile_X0Y0_N4BEG[4] VPWR VGND sg13cmos5l_antennanp
XFILLER_284_36 VPWR VGND sg13cmos5l_decap_8
X_2626_ _2626_/X AXIL_S_SOC_WSTRB1 AXIL_S_SOC_WSTRB3 _2709_/X _2682_/X _1202_/Q _1201_/Q
+ VPWR VGND sg13cmos5l_mux4_1
X_0887_ _0887_/Q Tile_X0Y3_FrameData[31] VGND VPWR Tile_X0Y5_FrameStrobe[3] latch
XFILLER_217_52 VPWR VGND sg13cmos5l_decap_8
XANTENNA__2731__A1 AXIL_S_SOC_RREADY VPWR VGND sg13cmos5l_antennanp
X_2557_ _2557_/X Tile_X0Y3_W1END[2] Tile_X0Y3_WW4END[10] Tile_X0Y3_WW4END[14] Tile_X0Y3_W6END[6]
+ _0868_/Q _0867_/Q VPWR VGND sg13cmos5l_mux4_1
X_1508_ _2790_/A3 VPWR VGND sg13cmos5l_tielo
X_2488_ _2488_/X _2396_/X _2504_/X _2503_/X _2395_/X _0560_/Q _0559_/Q VPWR VGND sg13cmos5l_mux4_1
XANTENNA__1206__D Tile_X0Y4_FrameData[16] VPWR VGND sg13cmos5l_antennanp
XFILLER_101_124 VPWR VGND sg13cmos5l_decap_8
X_1439_ _1439_/Q Tile_X0Y5_FrameData[17] VGND VPWR Tile_X0Y5_FrameStrobe[5] latch
XANTENNA__0110__D Tile_X0Y0_FrameData[24] VPWR VGND sg13cmos5l_antennanp
XANTENNA__2495__A0 Tile_X0Y1_W2MID[4] VPWR VGND sg13cmos5l_antennanp
XFILLER_55_211 VPWR VGND sg13cmos5l_fill_2
XFILLER_46_38 VPWR VGND sg13cmos5l_fill_1
XANTENNA__0161__GATE Tile_X0Y5_FrameStrobe[2] VPWR VGND sg13cmos5l_antennanp
XFILLER_260_9 VPWR VGND sg13cmos5l_decap_8
XANTENNA__0791__GATE Tile_X0Y5_FrameStrobe[0] VPWR VGND sg13cmos5l_antennanp
XFILLER_270_164 VPWR VGND sg13cmos5l_decap_8
XANTENNA__2798__A1 Tile_X0Y5_N2END[6] VPWR VGND sg13cmos5l_antennanp
XFILLER_62_26 VPWR VGND sg13cmos5l_fill_2
XFILLER_62_15 VPWR VGND sg13cmos5l_fill_2
XFILLER_178_26 VPWR VGND sg13cmos5l_fill_2
XANTENNA__0176__GATE Tile_X0Y5_FrameStrobe[3] VPWR VGND sg13cmos5l_antennanp
XANTENNA__0780__D Tile_X0Y2_FrameData[26] VPWR VGND sg13cmos5l_antennanp
XFILLER_168_168 VPWR VGND sg13cmos5l_decap_8
XFILLER_194_14 VPWR VGND sg13cmos5l_decap_8
XFILLER_124_205 VPWR VGND sg13cmos5l_fill_2
XFILLER_191_160 VPWR VGND sg13cmos5l_decap_8
XFILLER_194_25 VPWR VGND sg13cmos5l_fill_1
XFILLER_11_74 VPWR VGND sg13cmos5l_fill_2
XFILLER_11_85 VPWR VGND sg13cmos5l_decap_4
XANTENNA__0114__GATE Tile_X0Y5_FrameStrobe[1] VPWR VGND sg13cmos5l_antennanp
XFILLER_340_179 VPWR VGND sg13cmos5l_decap_8
XANTENNA__0744__GATE Tile_X0Y5_FrameStrobe[6] VPWR VGND sg13cmos5l_antennanp
XANTENNA__1116__D Tile_X0Y4_FrameData[10] VPWR VGND sg13cmos5l_antennanp
XFILLER_87_89 VPWR VGND sg13cmos5l_fill_1
XANTENNA__0955__D Tile_X0Y3_FrameData[27] VPWR VGND sg13cmos5l_antennanp
XFILLER_272_0 VPWR VGND sg13cmos5l_fill_2
XANTENNA__0129__GATE Tile_X0Y5_FrameStrobe[1] VPWR VGND sg13cmos5l_antennanp
XANTENNA__0759__GATE Tile_X0Y5_FrameStrobe[6] VPWR VGND sg13cmos5l_antennanp
XANTENNA__2084__X Tile_X0Y3_E1BEG[0] VPWR VGND sg13cmos5l_antennanp
XFILLER_261_175 VPWR VGND sg13cmos5l_decap_8
XFILLER_159_102 VPWR VGND sg13cmos5l_decap_4
XANTENNA__0690__D Tile_X0Y2_FrameData[20] VPWR VGND sg13cmos5l_antennanp
XFILLER_159_157 VPWR VGND sg13cmos5l_decap_8
XFILLER_159_179 VPWR VGND sg13cmos5l_decap_8
XFILLER_174_127 VPWR VGND sg13cmos5l_decap_8
XFILLER_238_18 VPWR VGND sg13cmos5l_fill_2
X_1790_ Tile_X0Y4_E2BEG[1] _2618_/X VPWR VGND sg13cmos5l_buf_1
X_0810_ _0810_/Q Tile_X0Y3_FrameData[12] VGND VPWR Tile_X0Y5_FrameStrobe[0] latch
XANTENNA__2410__A0 AXIL_S_SOC_AWADDR1 VPWR VGND sg13cmos5l_antennanp
XFILLER_174_138 VPWR VGND sg13cmos5l_fill_1
X_0741_ _0741_/Q Tile_X0Y2_FrameData[1] VGND VPWR Tile_X0Y5_FrameStrobe[5] latch
XFILLER_182_182 VPWR VGND sg13cmos5l_fill_1
X_0672_ _0672_/Q Tile_X0Y2_FrameData[6] VGND VPWR Tile_X0Y5_FrameStrobe[3] latch
XFILLER_130_208 VPWR VGND sg13cmos5l_decap_4
X_2411_ _2411_/X AXIL_S_SOC_AWADDR2 AXIL_S_SOC_AWPROT0 _2483_/X _2486_/X _0726_/Q
+ _0725_/Q VPWR VGND sg13cmos5l_mux4_1
XFILLER_331_146 VPWR VGND sg13cmos5l_decap_4
XANTENNA__2713__A1 Tile_X0Y3_W2END[7] VPWR VGND sg13cmos5l_antennanp
X_2342_ _2342_/X Tile_X0Y2_W1END[0] Tile_X0Y2_W6END[4] _2471_/X _2453_/X _0790_/Q
+ _0789_/Q VPWR VGND sg13cmos5l_mux4_1
XFILLER_229_117 VPWR VGND sg13cmos5l_decap_8
XFILLER_284_223 VPWR VGND sg13cmos5l_fill_1
XANTENNA__1026__D Tile_X0Y3_FrameData[20] VPWR VGND sg13cmos5l_antennanp
X_2273_ _2273_/X Tile_X0Y2_W1END[3] Tile_X0Y2_WW4END[3] Tile_X0Y2_WW4END[7] Tile_X0Y2_W6END[11]
+ _0757_/Q _0756_/Q VPWR VGND sg13cmos5l_mux4_1
XFILLER_96_155 VPWR VGND sg13cmos5l_decap_8
XANTENNA__0865__D Tile_X0Y3_FrameData[21] VPWR VGND sg13cmos5l_antennanp
X_1224_ _1224_/Q Tile_X0Y4_FrameData[30] VGND VPWR Tile_X0Y5_FrameStrobe[6] latch
XFILLER_37_211 VPWR VGND sg13cmos5l_fill_1
XFILLER_203_43 VPWR VGND sg13cmos5l_decap_8
X_1155_ _1155_/Q Tile_X0Y4_FrameData[3] VGND VPWR Tile_X0Y5_FrameStrobe[3] latch
X_1086_ _1086_/Q Tile_X0Y4_FrameData[8] VGND VPWR Tile_X0Y5_FrameStrobe[1] latch
X_0106_ _0106_/Q Tile_X0Y0_FrameData[28] VGND VPWR Tile_X0Y5_FrameStrobe[1] latch
XFILLER_252_186 VPWR VGND sg13cmos5l_decap_8
XFILLER_279_47 VPWR VGND sg13cmos5l_decap_8
X_0037_ _2082_/A _2787_/X _2788_/X _1329_/Q VPWR VGND sg13cmos5l_mux2_1
XANTENNA__2244__A3 Tile_X0Y0_S2END[3] VPWR VGND sg13cmos5l_antennanp
XFILLER_279_69 VPWR VGND sg13cmos5l_decap_8
XFILLER_339_202 VPWR VGND sg13cmos5l_fill_1
XFILLER_20_122 VPWR VGND sg13cmos5l_decap_8
XFILLER_32_18 VPWR VGND sg13cmos5l_fill_2
XANTENNA__2401__A0 AXIL_S_SOC_AWADDR0 VPWR VGND sg13cmos5l_antennanp
X_1988_ Tile_X0Y5_E6BEG[1] _2758_/X VPWR VGND sg13cmos5l_buf_1
XANTENNA__0105__D Tile_X0Y0_FrameData[29] VPWR VGND sg13cmos5l_antennanp
X_0939_ _0939_/Q Tile_X0Y3_FrameData[11] VGND VPWR Tile_X0Y5_FrameStrobe[4] latch
XFILLER_307_165 VPWR VGND sg13cmos5l_fill_2
XFILLER_228_73 VPWR VGND sg13cmos5l_decap_8
XFILLER_164_17 VPWR VGND sg13cmos5l_decap_8
X_2609_ _2609_/X Tile_X0Y2_W1END[2] Tile_X0Y2_W2MID[1] Tile_X0Y2_W2END[1] _2487_/X
+ _0638_/Q _0637_/Q VPWR VGND sg13cmos5l_mux4_1
XANTENNA__2704__A1 Tile_X0Y5_N4END[5] VPWR VGND sg13cmos5l_antennanp
XFILLER_244_61 VPWR VGND sg13cmos5l_decap_8
XFILLER_275_223 VPWR VGND sg13cmos5l_fill_1
XFILLER_87_122 VPWR VGND sg13cmos5l_decap_8
XANTENNA__1474__GATE Tile_X0Y5_FrameStrobe[6] VPWR VGND sg13cmos5l_antennanp
XFILLER_196_7 VPWR VGND sg13cmos5l_decap_8
XFILLER_57_59 VPWR VGND sg13cmos5l_fill_2
XFILLER_180_49 VPWR VGND sg13cmos5l_fill_1
XANTENNA__0775__D Tile_X0Y2_FrameData[31] VPWR VGND sg13cmos5l_antennanp
XANTENNA__1801__X Tile_X0Y4_E2BEGb[4] VPWR VGND sg13cmos5l_antennanp
XFILLER_113_98 VPWR VGND sg13cmos5l_decap_8
XFILLER_260_82 VPWR VGND sg13cmos5l_decap_8
XANTENNA__1489__GATE Tile_X0Y5_FrameStrobe[7] VPWR VGND sg13cmos5l_antennanp
XFILLER_188_208 VPWR VGND sg13cmos5l_fill_1
XFILLER_189_14 VPWR VGND sg13cmos5l_decap_8
XANTENNA__2235__A3 Tile_X0Y0_S4END[3] VPWR VGND sg13cmos5l_antennanp
XANTENNA__2640__A0 AXIL_S_SOC_WSTRB1 VPWR VGND sg13cmos5l_antennanp
XFILLER_11_122 VPWR VGND sg13cmos5l_fill_2
XFILLER_339_39 VPWR VGND sg13cmos5l_decap_8
XANTENNA__1412__GATE Tile_X0Y5_FrameStrobe[4] VPWR VGND sg13cmos5l_antennanp
XFILLER_132_2 VPWR VGND sg13cmos5l_fill_1
XFILLER_156_105 VPWR VGND sg13cmos5l_decap_8
XFILLER_171_108 VPWR VGND sg13cmos5l_fill_1
XANTENNA__1427__GATE Tile_X0Y5_FrameStrobe[5] VPWR VGND sg13cmos5l_antennanp
XFILLER_164_171 VPWR VGND sg13cmos5l_decap_8
XFILLER_98_44 VPWR VGND sg13cmos5l_decap_4
XFILLER_112_208 VPWR VGND sg13cmos5l_fill_2
XANTENNA__0683__GATE Tile_X0Y5_FrameStrobe[4] VPWR VGND sg13cmos5l_antennanp
XFILLER_321_190 VPWR VGND sg13cmos5l_fill_2
XANTENNA__2079__X Tile_X0Y5_S4BEG[12] VPWR VGND sg13cmos5l_antennanp
XANTENNA__2459__A0 Tile_X0Y1_W1END[1] VPWR VGND sg13cmos5l_antennanp
XFILLER_219_150 VPWR VGND sg13cmos5l_decap_8
XFILLER_304_53 VPWR VGND sg13cmos5l_decap_4
XFILLER_304_42 VPWR VGND sg13cmos5l_fill_1
XANTENNA__0685__D Tile_X0Y2_FrameData[25] VPWR VGND sg13cmos5l_antennanp
XANTENNA__0698__GATE Tile_X0Y5_FrameStrobe[4] VPWR VGND sg13cmos5l_antennanp
XFILLER_170_60 VPWR VGND sg13cmos5l_decap_8
XFILLER_219_172 VPWR VGND sg13cmos5l_decap_8
XFILLER_47_92 VPWR VGND sg13cmos5l_decap_4
XFILLER_304_86 VPWR VGND sg13cmos5l_decap_4
XANTENNA__1711__X Tile_X0Y0_E6BEG[3] VPWR VGND sg13cmos5l_antennanp
XANTENNA__2474__A3 Tile_X0Y0_S4END[10] VPWR VGND sg13cmos5l_antennanp
XFILLER_234_153 VPWR VGND sg13cmos5l_decap_8
XFILLER_320_30 VPWR VGND sg13cmos5l_fill_2
XANTENNA__0621__GATE Tile_X0Y5_FrameStrobe[2] VPWR VGND sg13cmos5l_antennanp
XANTENNA__2226__A3 Tile_X0Y0_S4END[1] VPWR VGND sg13cmos5l_antennanp
XANTENNA__2631__A0 AXIL_S_SOC_WSTRB0 VPWR VGND sg13cmos5l_antennanp
XFILLER_249_17 VPWR VGND sg13cmos5l_fill_1
XFILLER_249_28 VPWR VGND sg13cmos5l_decap_8
XFILLER_249_39 VPWR VGND sg13cmos5l_fill_2
X_1911_ Tile_X0Y1_FrameData_O[24] Tile_X0Y1_FrameData[24] VPWR VGND sg13cmos5l_buf_1
X_1842_ Tile_X0Y4_FrameData_O[9] Tile_X0Y4_FrameData[9] VPWR VGND sg13cmos5l_buf_1
XANTENNA__0636__GATE Tile_X0Y5_FrameStrobe[2] VPWR VGND sg13cmos5l_antennanp
X_1773_ Tile_X0Y2_E1BEG[0] _2397_/X VPWR VGND sg13cmos5l_buf_1
XFILLER_155_160 VPWR VGND sg13cmos5l_decap_8
X_0724_ _0724_/Q Tile_X0Y2_FrameData[18] VGND VPWR Tile_X0Y5_FrameStrobe[5] latch
X_0655_ _0655_/Q Tile_X0Y2_FrameData[23] VGND VPWR Tile_X0Y5_FrameStrobe[3] latch
XANTENNA__2698__A0 Tile_X0Y0_W1END[3] VPWR VGND sg13cmos5l_antennanp
XFILLER_170_163 VPWR VGND sg13cmos5l_decap_8
XFILLER_345_60 VPWR VGND sg13cmos5l_decap_4
XANTENNA__2162__A2 AXIL_S_SOC_WDATA19 VPWR VGND sg13cmos5l_antennanp
X_0586_ _0586_/Q Tile_X0Y2_FrameData[28] VGND VPWR Tile_X0Y5_FrameStrobe[1] latch
XFILLER_69_122 VPWR VGND sg13cmos5l_decap_8
XFILLER_257_223 VPWR VGND sg13cmos5l_fill_1
X_2325_ _2325_/X _0063_/X Tile_X0Y0_S4END[4] _2350_/X _2349_/X _0442_/Q _0441_/Q VPWR
+ VGND sg13cmos5l_mux4_1
XFILLER_214_42 VPWR VGND sg13cmos5l_decap_8
XFILLER_27_18 VPWR VGND sg13cmos5l_fill_2
X_2256_ _2256_/X Tile_X0Y1_W2MID[4] Tile_X0Y1_W2END[4] Tile_X0Y1_W6END[4] _2376_/X
+ _0536_/Q _0535_/Q VPWR VGND sg13cmos5l_mux4_1
XFILLER_84_136 VPWR VGND sg13cmos5l_decap_8
XFILLER_84_125 VPWR VGND sg13cmos5l_decap_4
XFILLER_361_70 VPWR VGND sg13cmos5l_fill_1
XANTENNA__0595__D Tile_X0Y2_FrameData[19] VPWR VGND sg13cmos5l_antennanp
XFILLER_150_19 VPWR VGND sg13cmos5l_decap_4
X_1207_ _1207_/Q Tile_X0Y4_FrameData[15] VGND VPWR Tile_X0Y5_FrameStrobe[5] latch
XFILLER_361_81 VPWR VGND sg13cmos5l_fill_2
XANTENNA__1621__X Tile_X0Y0_N2BEGb[1] VPWR VGND sg13cmos5l_antennanp
XANTENNA__2465__A3 Tile_X0Y0_S4END[11] VPWR VGND sg13cmos5l_antennanp
XFILLER_225_142 VPWR VGND sg13cmos5l_decap_8
X_2187_ _2187_/X AXIL_S_SOC_WDATA22 AXIL_S_SOC_WDATA26 _2226_/X _2242_/X _0222_/Q
+ _0221_/Q VPWR VGND sg13cmos5l_mux4_1
X_1138_ _1138_/Q Tile_X0Y4_FrameData[20] VGND VPWR Tile_X0Y5_FrameStrobe[3] latch
XFILLER_92_180 VPWR VGND sg13cmos5l_decap_8
XANTENNA__2217__A3 Tile_X0Y0_S4END[3] VPWR VGND sg13cmos5l_antennanp
XFILLER_230_63 VPWR VGND sg13cmos5l_decap_4
X_1069_ _1069_/Q Tile_X0Y4_FrameData[25] VGND VPWR Tile_X0Y5_FrameStrobe[1] latch
XFILLER_40_206 VPWR VGND sg13cmos5l_fill_1
XANTENNA__2622__A0 AXIL_S_SOC_WSTRB1 VPWR VGND sg13cmos5l_antennanp
XFILLER_240_167 VPWR VGND sg13cmos5l_decap_8
XFILLER_239_83 VPWR VGND sg13cmos5l_decap_8
XFILLER_4_107 VPWR VGND sg13cmos5l_fill_1
XFILLER_108_32 VPWR VGND sg13cmos5l_fill_1
XANTENNA__2153__A2 Tile_X0Y0_WW4END[4] VPWR VGND sg13cmos5l_antennanp
XFILLER_161_196 VPWR VGND sg13cmos5l_fill_2
XFILLER_68_69 VPWR VGND sg13cmos5l_fill_2
XFILLER_191_48 VPWR VGND sg13cmos5l_decap_4
XFILLER_191_59 VPWR VGND sg13cmos5l_decap_8
XFILLER_208_109 VPWR VGND sg13cmos5l_decap_8
XFILLER_84_13 VPWR VGND sg13cmos5l_decap_8
XFILLER_75_125 VPWR VGND sg13cmos5l_decap_8
XFILLER_124_75 VPWR VGND sg13cmos5l_decap_8
XFILLER_271_81 VPWR VGND sg13cmos5l_fill_1
XANTENNA__1531__X Tile_X0Y3_E6BEG[5] VPWR VGND sg13cmos5l_antennanp
XFILLER_216_142 VPWR VGND sg13cmos5l_decap_8
XFILLER_140_74 VPWR VGND sg13cmos5l_decap_8
XANTENNA__1351__GATE Tile_X0Y5_FrameStrobe[2] VPWR VGND sg13cmos5l_antennanp
XFILLER_231_178 VPWR VGND sg13cmos5l_decap_8
XFILLER_235_0 VPWR VGND sg13cmos5l_fill_2
XFILLER_129_149 VPWR VGND sg13cmos5l_decap_8
XANTENNA__1366__GATE Tile_X0Y5_FrameStrobe[3] VPWR VGND sg13cmos5l_antennanp
XANTENNA__2392__A2 Tile_X0Y3_W6END[2] VPWR VGND sg13cmos5l_antennanp
XFILLER_298_101 VPWR VGND sg13cmos5l_fill_2
XANTENNA__1706__X Tile_X0Y0_EE4BEG[14] VPWR VGND sg13cmos5l_antennanp
XFILLER_152_174 VPWR VGND sg13cmos5l_decap_8
XFILLER_98_217 VPWR VGND sg13cmos5l_fill_1
XFILLER_298_145 VPWR VGND sg13cmos5l_fill_1
XFILLER_165_93 VPWR VGND sg13cmos5l_decap_4
X_0440_ _0440_/Q Tile_X0Y1_FrameData[30] VGND VPWR Tile_X0Y5_FrameStrobe[4] latch
XFILLER_301_127 VPWR VGND sg13cmos5l_decap_8
X_0371_ _0371_/Q Tile_X0Y1_FrameData[3] VGND VPWR Tile_X0Y5_FrameStrobe[1] latch
X_2110_ AXIL_S_SOC_RDATA4 Tile_X0Y3_W2MID[4] Tile_X0Y3_W2END[4] Tile_X0Y3_W6END[4]
+ _2593_/X _0854_/Q _0853_/Q VPWR VGND sg13cmos5l_mux4_1
XANTENNA__1304__GATE Tile_X0Y5_FrameStrobe[1] VPWR VGND sg13cmos5l_antennanp
X_2041_ Tile_X0Y5_FrameData_O[26] Tile_X0Y5_FrameData[26] VPWR VGND sg13cmos5l_buf_1
XANTENNA__1304__D Tile_X0Y5_FrameData[24] VPWR VGND sg13cmos5l_antennanp
XANTENNA__2447__A3 Tile_X0Y2_W6END[5] VPWR VGND sg13cmos5l_antennanp
XFILLER_81_106 VPWR VGND sg13cmos5l_decap_4
XANTENNA__0560__GATE Tile_X0Y5_FrameStrobe[0] VPWR VGND sg13cmos5l_antennanp
XFILLER_207_153 VPWR VGND sg13cmos5l_decap_8
XFILLER_222_101 VPWR VGND sg13cmos5l_fill_1
XFILLER_74_180 VPWR VGND sg13cmos5l_fill_2
XFILLER_222_134 VPWR VGND sg13cmos5l_decap_8
XFILLER_74_90 VPWR VGND sg13cmos5l_decap_8
XANTENNA__1319__GATE Tile_X0Y5_FrameStrobe[1] VPWR VGND sg13cmos5l_antennanp
XANTENNA__2604__A0 Tile_X0Y5_W2MID[4] VPWR VGND sg13cmos5l_antennanp
XANTENNA__0575__GATE Tile_X0Y5_FrameStrobe[0] VPWR VGND sg13cmos5l_antennanp
X_1825_ Tile_X0Y4_EE4BEG[8] _2641_/X VPWR VGND sg13cmos5l_buf_1
X_1756_ Tile_X0Y2_FrameData_O[16] Tile_X0Y2_FrameData[16] VPWR VGND sg13cmos5l_buf_1
XANTENNA__2383__A2 Tile_X0Y0_W6END[9] VPWR VGND sg13cmos5l_antennanp
X_0707_ _0707_/Q Tile_X0Y2_FrameData[3] VGND VPWR Tile_X0Y5_FrameStrobe[4] latch
XANTENNA__1616__X Tile_X0Y0_N4BEG[12] VPWR VGND sg13cmos5l_antennanp
XFILLER_289_156 VPWR VGND sg13cmos5l_decap_8
XFILLER_292_25 VPWR VGND sg13cmos5l_decap_8
X_1687_ Tile_X0Y0_FrameData_O[27] Tile_X0Y0_FrameData[27] VPWR VGND sg13cmos5l_buf_1
X_0638_ _0638_/Q Tile_X0Y2_FrameData[8] VGND VPWR Tile_X0Y5_FrameStrobe[2] latch
XANTENNA__0513__GATE Tile_X0Y5_FrameStrobe[6] VPWR VGND sg13cmos5l_antennanp
XANTENNA__2135__A2 Tile_X0Y0_W6END[5] VPWR VGND sg13cmos5l_antennanp
X_0569_ _0569_/Q Tile_X0Y2_FrameData[13] VGND VPWR Tile_X0Y5_FrameStrobe[0] latch
XANTENNA__2686__A3 Tile_X0Y0_W6END[4] VPWR VGND sg13cmos5l_antennanp
XFILLER_225_96 VPWR VGND sg13cmos5l_fill_2
X_2308_ _2308_/X AXIL_S_SOC_WDATA7 AXIL_S_SOC_WDATA15 _2373_/X _2380_/X _0476_/Q _0475_/Q
+ VPWR VGND sg13cmos5l_mux4_1
XANTENNA__1214__D Tile_X0Y4_FrameData[8] VPWR VGND sg13cmos5l_antennanp
X_2239_ _2239_/X _2213_/X _0049_/X Tile_X0Y0_S1END[0] Tile_X0Y0_S4END[0] _0118_/Q
+ _0117_/Q VPWR VGND sg13cmos5l_mux4_1
XANTENNA__0528__GATE Tile_X0Y5_FrameStrobe[6] VPWR VGND sg13cmos5l_antennanp
XFILLER_213_134 VPWR VGND sg13cmos5l_fill_2
XFILLER_110_33 VPWR VGND sg13cmos5l_fill_2
XFILLER_213_145 VPWR VGND sg13cmos5l_fill_1
XFILLER_213_178 VPWR VGND sg13cmos5l_decap_8
XFILLER_80_172 VPWR VGND sg13cmos5l_fill_1
XFILLER_166_211 VPWR VGND sg13cmos5l_fill_1
XFILLER_326_7 VPWR VGND sg13cmos5l_decap_8
XFILLER_186_37 VPWR VGND sg13cmos5l_decap_8
XFILLER_119_160 VPWR VGND sg13cmos5l_decap_8
XFILLER_266_92 VPWR VGND sg13cmos5l_decap_8
XFILLER_79_13 VPWR VGND sg13cmos5l_decap_8
XANTENNA__1526__X Tile_X0Y3_E6BEG[0] VPWR VGND sg13cmos5l_antennanp
XFILLER_134_152 VPWR VGND sg13cmos5l_fill_2
XFILLER_134_185 VPWR VGND sg13cmos5l_decap_8
XANTENNA__2126__A2 Tile_X0Y1_W6END[4] VPWR VGND sg13cmos5l_antennanp
XFILLER_135_74 VPWR VGND sg13cmos5l_decap_4
XFILLER_295_159 VPWR VGND sg13cmos5l_decap_8
XFILLER_135_85 VPWR VGND sg13cmos5l_decap_8
XFILLER_95_45 VPWR VGND sg13cmos5l_decap_8
XFILLER_185_0 VPWR VGND sg13cmos5l_fill_2
XFILLER_48_136 VPWR VGND sg13cmos5l_fill_1
XANTENNA__1124__D Tile_X0Y4_FrameData[2] VPWR VGND sg13cmos5l_antennanp
XFILLER_63_128 VPWR VGND sg13cmos5l_fill_2
XFILLER_63_117 VPWR VGND sg13cmos5l_decap_8
XANTENNA__2834__A0 Tile_X0Y4_W1END[1] VPWR VGND sg13cmos5l_antennanp
XFILLER_28_94 VPWR VGND sg13cmos5l_fill_1
XFILLER_56_180 VPWR VGND sg13cmos5l_decap_8
XANTENNA__0963__D Tile_X0Y3_FrameData[19] VPWR VGND sg13cmos5l_antennanp
XANTENNA__1290__GATE Tile_X0Y5_FrameStrobe[0] VPWR VGND sg13cmos5l_antennanp
XFILLER_204_134 VPWR VGND sg13cmos5l_decap_8
XFILLER_352_0 VPWR VGND sg13cmos5l_fill_2
XFILLER_301_32 VPWR VGND sg13cmos5l_decap_8
XANTENNA__2092__X Tile_X0Y3_E2BEG[4] VPWR VGND sg13cmos5l_antennanp
XFILLER_246_18 VPWR VGND sg13cmos5l_fill_2
X_1610_ Tile_X0Y0_N4BEG[6] _1610_/A VPWR VGND sg13cmos5l_buf_1
XFILLER_67_6 VPWR VGND sg13cmos5l_fill_1
X_2590_ _2590_/X _2492_/X _2600_/X _2599_/X _2491_/X _0812_/Q _0811_/Q VPWR VGND sg13cmos5l_mux4_1
XANTENNA__0203__D Tile_X0Y0_FrameData[27] VPWR VGND sg13cmos5l_antennanp
X_1541_ Tile_X0Y3_EE4BEG[3] _2528_/X VPWR VGND sg13cmos5l_buf_1
XFILLER_140_100 VPWR VGND sg13cmos5l_decap_8
XFILLER_140_111 VPWR VGND sg13cmos5l_decap_8
X_1472_ _1472_/Q Tile_X0Y5_FrameData[16] VGND VPWR Tile_X0Y5_FrameStrobe[6] latch
XANTENNA__2117__A2 Tile_X0Y2_W6END[3] VPWR VGND sg13cmos5l_antennanp
XFILLER_140_166 VPWR VGND sg13cmos5l_decap_8
XFILLER_262_28 VPWR VGND sg13cmos5l_decap_8
X_0423_ _0423_/Q Tile_X0Y1_FrameData[15] VGND VPWR Tile_X0Y5_FrameStrobe[3] latch
XANTENNA__1243__GATE Tile_X0Y5_FrameStrobe[6] VPWR VGND sg13cmos5l_antennanp
X_0354_ _0354_/Q Tile_X0Y1_FrameData[20] VGND VPWR Tile_X0Y5_FrameStrobe[1] latch
XANTENNA__1034__D Tile_X0Y4_FrameData[28] VPWR VGND sg13cmos5l_antennanp
X_0285_ _0285_/Q Tile_X0Y0_FrameData[9] VGND VPWR Tile_X0Y5_FrameStrobe[6] latch
XANTENNA__2825__A0 Tile_X0Y5_N2MID[0] VPWR VGND sg13cmos5l_antennanp
X_2024_ Tile_X0Y5_FrameData_O[9] Tile_X0Y5_FrameData[9] VPWR VGND sg13cmos5l_buf_1
XFILLER_54_128 VPWR VGND sg13cmos5l_fill_1
XANTENNA__0873__D Tile_X0Y3_FrameData[13] VPWR VGND sg13cmos5l_antennanp
XANTENNA__1258__GATE Tile_X0Y5_FrameStrobe[7] VPWR VGND sg13cmos5l_antennanp
XFILLER_211_76 VPWR VGND sg13cmos5l_decap_8
XFILLER_62_183 VPWR VGND sg13cmos5l_fill_1
XFILLER_62_161 VPWR VGND sg13cmos5l_decap_8
XFILLER_210_148 VPWR VGND sg13cmos5l_fill_2
X_1808_ Tile_X0Y4_E6BEG[3] _2652_/X VPWR VGND sg13cmos5l_buf_1
X_2788_ _2788_/X _2817_/X _2802_/X _2801_/X _2797_/X _1331_/Q _1330_/Q VPWR VGND sg13cmos5l_mux4_1
XANTENNA__0113__D Tile_X0Y0_FrameData[21] VPWR VGND sg13cmos5l_antennanp
XANTENNA__1209__D Tile_X0Y4_FrameData[13] VPWR VGND sg13cmos5l_antennanp
XFILLER_116_141 VPWR VGND sg13cmos5l_decap_8
X_1739_ Tile_X0Y0_E1BEG[3] _2164_/X VPWR VGND sg13cmos5l_buf_1
XFILLER_131_100 VPWR VGND sg13cmos5l_fill_1
XFILLER_320_222 VPWR VGND sg13cmos5l_fill_2
XFILLER_320_200 VPWR VGND sg13cmos5l_fill_1
XANTENNA__0452__GATE Tile_X0Y5_FrameStrobe[4] VPWR VGND sg13cmos5l_antennanp
XANTENNA__2108__A2 Tile_X0Y3_W6END[2] VPWR VGND sg13cmos5l_antennanp
XFILLER_236_95 VPWR VGND sg13cmos5l_decap_8
XFILLER_277_148 VPWR VGND sg13cmos5l_fill_2
XFILLER_85_220 VPWR VGND sg13cmos5l_decap_4
XANTENNA__0467__GATE Tile_X0Y5_FrameStrobe[4] VPWR VGND sg13cmos5l_antennanp
XFILLER_276_7 VPWR VGND sg13cmos5l_decap_8
XFILLER_269_6 VPWR VGND sg13cmos5l_fill_1
XFILLER_65_59 VPWR VGND sg13cmos5l_decap_8
XANTENNA__0783__D Tile_X0Y2_FrameData[23] VPWR VGND sg13cmos5l_antennanp
XFILLER_121_21 VPWR VGND sg13cmos5l_decap_4
XFILLER_201_115 VPWR VGND sg13cmos5l_decap_4
XFILLER_139_211 VPWR VGND sg13cmos5l_decap_4
XFILLER_201_137 VPWR VGND sg13cmos5l_decap_8
XFILLER_201_148 VPWR VGND sg13cmos5l_fill_1
XFILLER_347_119 VPWR VGND sg13cmos5l_decap_8
XFILLER_347_28 VPWR VGND sg13cmos5l_decap_8
XANTENNA__0405__GATE Tile_X0Y5_FrameStrobe[2] VPWR VGND sg13cmos5l_antennanp
XFILLER_277_91 VPWR VGND sg13cmos5l_fill_1
XFILLER_355_185 VPWR VGND sg13cmos5l_decap_8
XANTENNA__1119__D Tile_X0Y4_FrameData[7] VPWR VGND sg13cmos5l_antennanp
XFILLER_107_163 VPWR VGND sg13cmos5l_decap_4
XFILLER_30_62 VPWR VGND sg13cmos5l_decap_8
XFILLER_268_115 VPWR VGND sg13cmos5l_decap_8
XFILLER_311_222 VPWR VGND sg13cmos5l_fill_2
XANTENNA__0958__D Tile_X0Y3_FrameData[24] VPWR VGND sg13cmos5l_antennanp
XFILLER_268_137 VPWR VGND sg13cmos5l_decap_8
XFILLER_122_177 VPWR VGND sg13cmos5l_fill_2
XANTENNA__2087__X Tile_X0Y3_E1BEG[3] VPWR VGND sg13cmos5l_antennanp
XFILLER_312_20 VPWR VGND sg13cmos5l_fill_2
XANTENNA__2807__A0 Tile_X0Y1_W1END[1] VPWR VGND sg13cmos5l_antennanp
XFILLER_291_151 VPWR VGND sg13cmos5l_decap_8
X_0070_ _1613_/A _2269_/X _2270_/X _0521_/Q VPWR VGND sg13cmos5l_mux2_1
XFILLER_91_223 VPWR VGND sg13cmos5l_fill_1
XFILLER_36_139 VPWR VGND sg13cmos5l_decap_8
XFILLER_312_31 VPWR VGND sg13cmos5l_fill_2
XANTENNA__0693__D Tile_X0Y2_FrameData[17] VPWR VGND sg13cmos5l_antennanp
XANTENNA__2283__A1 Tile_X0Y3_WW4END[2] VPWR VGND sg13cmos5l_antennanp
X_0972_ _0972_/Q Tile_X0Y3_FrameData[10] VGND VPWR Tile_X0Y5_FrameStrobe[5] latch
X_2711_ _2711_/X _2604_/X Tile_X0Y5_N2MID[3] _2716_/X _2603_/X _1048_/Q _1047_/Q VPWR
+ VGND sg13cmos5l_mux4_1
XFILLER_145_203 VPWR VGND sg13cmos5l_decap_4
X_2642_ _2642_/X AXIL_S_SOC_WSTRB3 AXIL_S_SOC_BREADY _2701_/X _2682_/X _1170_/Q _1169_/Q
+ VPWR VGND sg13cmos5l_mux4_1
XFILLER_337_50 VPWR VGND sg13cmos5l_decap_8
XANTENNA__1029__D Tile_X0Y3_FrameData[17] VPWR VGND sg13cmos5l_antennanp
XANTENNA__2338__A2 Tile_X0Y1_W6END[1] VPWR VGND sg13cmos5l_antennanp
XFILLER_160_206 VPWR VGND sg13cmos5l_decap_4
X_2573_ _2573_/X _2572_/X Tile_X0Y5_N4END[11] _2571_/X Tile_X0Y0_S4END[15] _0816_/Q
+ _0815_/Q VPWR VGND sg13cmos5l_mux4_1
X_1524_ Tile_X0Y3_E2BEGb[6] _2523_/X VPWR VGND sg13cmos5l_buf_1
XANTENNA__0868__D Tile_X0Y3_FrameData[18] VPWR VGND sg13cmos5l_antennanp
XFILLER_113_144 VPWR VGND sg13cmos5l_decap_4
XFILLER_113_155 VPWR VGND sg13cmos5l_decap_8
XANTENNA__1182__GATE Tile_X0Y5_FrameStrobe[4] VPWR VGND sg13cmos5l_antennanp
XFILLER_19_19 VPWR VGND sg13cmos5l_fill_1
XFILLER_206_65 VPWR VGND sg13cmos5l_fill_1
X_1455_ _1455_/Q Tile_X0Y5_FrameData[1] VGND VPWR Tile_X0Y5_FrameStrobe[5] latch
XFILLER_206_87 VPWR VGND sg13cmos5l_decap_4
X_1386_ _1386_/Q Tile_X0Y5_FrameData[6] VGND VPWR Tile_X0Y5_FrameStrobe[3] latch
X_0406_ _0406_/Q Tile_X0Y1_FrameData[0] VGND VPWR Tile_X0Y5_FrameStrobe[2] latch
X_0337_ _0337_/Q Tile_X0Y1_FrameData[5] VGND VPWR Tile_X0Y5_FrameStrobe[0] latch
XANTENNA__1197__GATE Tile_X0Y5_FrameStrobe[5] VPWR VGND sg13cmos5l_antennanp
XFILLER_222_53 VPWR VGND sg13cmos5l_fill_2
XFILLER_82_223 VPWR VGND sg13cmos5l_fill_1
XFILLER_222_97 VPWR VGND sg13cmos5l_decap_4
X_2007_ Tile_X0Y5_EE4BEG[8] _2749_/X VPWR VGND sg13cmos5l_buf_1
X_0268_ _0268_/Q Tile_X0Y0_FrameData[26] VGND VPWR Tile_X0Y5_FrameStrobe[6] latch
XFILLER_42_109 VPWR VGND sg13cmos5l_decap_8
X_0199_ _0199_/Q Tile_X0Y0_FrameData[31] VGND VPWR Tile_X0Y5_FrameStrobe[4] latch
XANTENNA__1120__GATE Tile_X0Y5_FrameStrobe[2] VPWR VGND sg13cmos5l_antennanp
XANTENNA__0108__D Tile_X0Y0_FrameData[26] VPWR VGND sg13cmos5l_antennanp
XANTENNA__1135__GATE Tile_X0Y5_FrameStrobe[3] VPWR VGND sg13cmos5l_antennanp
XFILLER_352_122 VPWR VGND sg13cmos5l_decap_8
XFILLER_151_206 VPWR VGND sg13cmos5l_decap_8
XANTENNA__0391__GATE Tile_X0Y5_FrameStrobe[2] VPWR VGND sg13cmos5l_antennanp
XFILLER_104_100 VPWR VGND sg13cmos5l_decap_8
XANTENNA__0778__D Tile_X0Y2_FrameData[28] VPWR VGND sg13cmos5l_antennanp
XFILLER_183_49 VPWR VGND sg13cmos5l_decap_4
XANTENNA__1804__X Tile_X0Y4_E2BEGb[7] VPWR VGND sg13cmos5l_antennanp
XFILLER_76_14 VPWR VGND sg13cmos5l_decap_4
XFILLER_104_199 VPWR VGND sg13cmos5l_decap_4
XFILLER_116_98 VPWR VGND sg13cmos5l_decap_8
XANTENNA__2501__A2 Tile_X0Y1_W2END[1] VPWR VGND sg13cmos5l_antennanp
XFILLER_132_20 VPWR VGND sg13cmos5l_decap_8
XFILLER_92_13 VPWR VGND sg13cmos5l_decap_8
XANTENNA__1402__D Tile_X0Y5_FrameData[22] VPWR VGND sg13cmos5l_antennanp
XANTENNA__2265__A1 Tile_X0Y1_WW4END[3] VPWR VGND sg13cmos5l_antennanp
XFILLER_132_97 VPWR VGND sg13cmos5l_decap_8
XFILLER_25_51 VPWR VGND sg13cmos5l_fill_1
XANTENNA__2083__A Tile_X0Y5_UserCLK VPWR VGND sg13cmos5l_antennanp
XFILLER_148_0 VPWR VGND sg13cmos5l_decap_4
XFILLER_186_136 VPWR VGND sg13cmos5l_fill_1
XFILLER_41_142 VPWR VGND sg13cmos5l_decap_8
XANTENNA__0344__GATE Tile_X0Y5_FrameStrobe[1] VPWR VGND sg13cmos5l_antennanp
XANTENNA__0974__GATE Tile_X0Y5_FrameStrobe[5] VPWR VGND sg13cmos5l_antennanp
XFILLER_127_214 VPWR VGND sg13cmos5l_fill_1
XFILLER_315_0 VPWR VGND sg13cmos5l_fill_1
XFILLER_157_50 VPWR VGND sg13cmos5l_decap_4
XFILLER_194_180 VPWR VGND sg13cmos5l_fill_1
XFILLER_343_133 VPWR VGND sg13cmos5l_decap_8
XANTENNA__0359__GATE Tile_X0Y5_FrameStrobe[1] VPWR VGND sg13cmos5l_antennanp
XFILLER_157_61 VPWR VGND sg13cmos5l_decap_8
XFILLER_41_94 VPWR VGND sg13cmos5l_decap_8
XANTENNA__0989__GATE Tile_X0Y5_FrameStrobe[6] VPWR VGND sg13cmos5l_antennanp
XANTENNA__0688__D Tile_X0Y2_FrameData[22] VPWR VGND sg13cmos5l_antennanp
XANTENNA__1714__X Tile_X0Y0_E6BEG[6] VPWR VGND sg13cmos5l_antennanp
XFILLER_110_103 VPWR VGND sg13cmos5l_decap_8
XFILLER_307_97 VPWR VGND sg13cmos5l_fill_2
XANTENNA__0912__GATE Tile_X0Y5_FrameStrobe[3] VPWR VGND sg13cmos5l_antennanp
X_1240_ _1240_/Q Tile_X0Y4_FrameData[14] VGND VPWR Tile_X0Y5_FrameStrobe[6] latch
XFILLER_323_30 VPWR VGND sg13cmos5l_decap_4
X_1171_ _1171_/Q Tile_X0Y4_FrameData[19] VGND VPWR Tile_X0Y5_FrameStrobe[4] latch
XFILLER_64_201 VPWR VGND sg13cmos5l_fill_1
XFILLER_2_55 VPWR VGND sg13cmos5l_fill_2
X_0122_ _0122_/Q Tile_X0Y0_FrameData[12] VGND VPWR Tile_X0Y5_FrameStrobe[1] latch
XFILLER_264_184 VPWR VGND sg13cmos5l_decap_4
XANTENNA__0927__GATE Tile_X0Y5_FrameStrobe[4] VPWR VGND sg13cmos5l_antennanp
XANTENNA__1312__D Tile_X0Y5_FrameData[16] VPWR VGND sg13cmos5l_antennanp
XANTENNA__2256__A1 Tile_X0Y1_W2END[4] VPWR VGND sg13cmos5l_antennanp
XFILLER_17_172 VPWR VGND sg13cmos5l_fill_2
X_0053_ _2071_/A _2553_/X _2554_/X _0872_/Q VPWR VGND sg13cmos5l_mux2_1
XFILLER_220_221 VPWR VGND sg13cmos5l_fill_2
XANTENNA__2559__A2 Tile_X0Y3_WW4END[15] VPWR VGND sg13cmos5l_antennanp
XFILLER_268_49 VPWR VGND sg13cmos5l_decap_4
XFILLER_32_186 VPWR VGND sg13cmos5l_fill_1
X_0955_ _0955_/Q Tile_X0Y3_FrameData[27] VGND VPWR Tile_X0Y5_FrameStrobe[5] latch
XFILLER_348_60 VPWR VGND sg13cmos5l_decap_8
X_0886_ _0886_/Q Tile_X0Y3_FrameData[0] VGND VPWR Tile_X0Y5_FrameStrobe[2] latch
XFILLER_334_100 VPWR VGND sg13cmos5l_decap_8
X_2625_ _2625_/X AXIL_S_SOC_WSTRB0 AXIL_S_SOC_WSTRB2 _2708_/X _2681_/X _1204_/Q _1203_/Q
+ VPWR VGND sg13cmos5l_mux4_1
XFILLER_63_0 VPWR VGND sg13cmos5l_fill_2
XFILLER_217_31 VPWR VGND sg13cmos5l_decap_8
XANTENNA__0598__D Tile_X0Y2_FrameData[16] VPWR VGND sg13cmos5l_antennanp
XANTENNA__2192__A0 AXIL_S_SOC_WDATA23 VPWR VGND sg13cmos5l_antennanp
X_2556_ _2556_/X _2586_/X _2585_/X _2578_/X _2577_/X _0871_/Q _0870_/Q VPWR VGND sg13cmos5l_mux4_1
XANTENNA__1624__X Tile_X0Y0_N2BEGb[4] VPWR VGND sg13cmos5l_antennanp
XFILLER_101_103 VPWR VGND sg13cmos5l_decap_8
XFILLER_217_97 VPWR VGND sg13cmos5l_decap_8
X_1507_ _2791_/A3 VPWR VGND sg13cmos5l_tielo
X_2487_ _2487_/X _2394_/X _2502_/X _2501_/X _2393_/X _0562_/Q _0561_/Q VPWR VGND sg13cmos5l_mux4_1
XFILLER_247_118 VPWR VGND sg13cmos5l_decap_8
X_1438_ _1438_/Q Tile_X0Y5_FrameData[18] VGND VPWR Tile_X0Y5_FrameStrobe[5] latch
XANTENNA__2495__A1 Tile_X0Y1_W2END[4] VPWR VGND sg13cmos5l_antennanp
XFILLER_233_85 VPWR VGND sg13cmos5l_decap_8
X_1369_ _1369_/Q Tile_X0Y5_FrameData[23] VGND VPWR Tile_X0Y5_FrameStrobe[3] latch
XFILLER_255_195 VPWR VGND sg13cmos5l_decap_4
XANTENNA__1222__D Tile_X0Y4_FrameData[0] VPWR VGND sg13cmos5l_antennanp
XFILLER_15_109 VPWR VGND sg13cmos5l_fill_2
XFILLER_270_143 VPWR VGND sg13cmos5l_decap_8
XFILLER_102_89 VPWR VGND sg13cmos5l_decap_8
XFILLER_141_7 VPWR VGND sg13cmos5l_decap_8
XFILLER_168_125 VPWR VGND sg13cmos5l_fill_2
XFILLER_211_221 VPWR VGND sg13cmos5l_fill_2
XFILLER_357_203 VPWR VGND sg13cmos5l_decap_8
XANTENNA__1074__GATE Tile_X0Y5_FrameStrobe[1] VPWR VGND sg13cmos5l_antennanp
XFILLER_109_203 VPWR VGND sg13cmos5l_fill_2
XFILLER_134_6 VPWR VGND sg13cmos5l_decap_8
XFILLER_183_117 VPWR VGND sg13cmos5l_decap_8
XFILLER_194_48 VPWR VGND sg13cmos5l_fill_1
XANTENNA__1089__GATE Tile_X0Y5_FrameStrobe[1] VPWR VGND sg13cmos5l_antennanp
XFILLER_325_188 VPWR VGND sg13cmos5l_fill_2
XANTENNA__2183__A0 AXIL_S_SOC_WDATA18 VPWR VGND sg13cmos5l_antennanp
XFILLER_87_13 VPWR VGND sg13cmos5l_decap_8
XFILLER_340_147 VPWR VGND sg13cmos5l_decap_8
XANTENNA__1534__X Tile_X0Y3_E6BEG[8] VPWR VGND sg13cmos5l_antennanp
XANTENNA__2722__A2 AXIL_S_SOC_ARPROT1 VPWR VGND sg13cmos5l_antennanp
XFILLER_127_86 VPWR VGND sg13cmos5l_decap_8
XFILLER_87_57 VPWR VGND sg13cmos5l_decap_8
XANTENNA__0301__D Tile_X0Y0_FrameData[25] VPWR VGND sg13cmos5l_antennanp
XANTENNA__1012__GATE Tile_X0Y5_FrameStrobe[6] VPWR VGND sg13cmos5l_antennanp
XFILLER_293_202 VPWR VGND sg13cmos5l_fill_1
XFILLER_143_52 VPWR VGND sg13cmos5l_fill_1
XFILLER_143_74 VPWR VGND sg13cmos5l_decap_8
XFILLER_143_96 VPWR VGND sg13cmos5l_decap_4
XFILLER_261_121 VPWR VGND sg13cmos5l_decap_8
XANTENNA__1027__GATE Tile_X0Y5_FrameStrobe[7] VPWR VGND sg13cmos5l_antennanp
XANTENNA__1132__D Tile_X0Y4_FrameData[26] VPWR VGND sg13cmos5l_antennanp
XFILLER_261_132 VPWR VGND sg13cmos5l_fill_2
XFILLER_265_0 VPWR VGND sg13cmos5l_decap_8
XANTENNA__2789__A2 Tile_X0Y5_W6END[0] VPWR VGND sg13cmos5l_antennanp
XFILLER_14_120 VPWR VGND sg13cmos5l_fill_1
XANTENNA__0283__GATE Tile_X0Y5_FrameStrobe[6] VPWR VGND sg13cmos5l_antennanp
XANTENNA__0971__D Tile_X0Y3_FrameData[11] VPWR VGND sg13cmos5l_antennanp
XFILLER_159_125 VPWR VGND sg13cmos5l_decap_4
XFILLER_202_221 VPWR VGND sg13cmos5l_fill_2
XFILLER_99_9 VPWR VGND sg13cmos5l_fill_1
XFILLER_52_93 VPWR VGND sg13cmos5l_fill_1
XANTENNA__1709__X Tile_X0Y0_E6BEG[1] VPWR VGND sg13cmos5l_antennanp
XANTENNA__2410__A1 AXIL_S_SOC_AWADDR9 VPWR VGND sg13cmos5l_antennanp
XFILLER_168_71 VPWR VGND sg13cmos5l_decap_8
XFILLER_168_82 VPWR VGND sg13cmos5l_fill_1
X_0740_ _0740_/Q Tile_X0Y2_FrameData[2] VGND VPWR Tile_X0Y5_FrameStrobe[5] latch
XFILLER_316_100 VPWR VGND sg13cmos5l_fill_1
XANTENNA__0298__GATE Tile_X0Y5_FrameStrobe[7] VPWR VGND sg13cmos5l_antennanp
XFILLER_318_41 VPWR VGND sg13cmos5l_decap_8
XFILLER_115_217 VPWR VGND sg13cmos5l_fill_1
X_2410_ _2410_/X AXIL_S_SOC_AWADDR1 AXIL_S_SOC_AWADDR9 _2482_/X _2487_/X _0728_/Q
+ _0727_/Q VPWR VGND sg13cmos5l_mux4_1
X_0671_ _0671_/Q Tile_X0Y2_FrameData[7] VGND VPWR Tile_X0Y5_FrameStrobe[3] latch
XANTENNA__2174__A0 AXIL_S_SOC_WDATA17 VPWR VGND sg13cmos5l_antennanp
XFILLER_269_221 VPWR VGND sg13cmos5l_fill_2
XANTENNA__0221__GATE Tile_X0Y5_FrameStrobe[4] VPWR VGND sg13cmos5l_antennanp
XANTENNA__1307__D Tile_X0Y5_FrameData[21] VPWR VGND sg13cmos5l_antennanp
XANTENNA__2713__A2 Tile_X0Y3_W6END[8] VPWR VGND sg13cmos5l_antennanp
X_2341_ _2341_/X Tile_X0Y0_W1END[0] Tile_X0Y0_W6END[8] _2229_/X _2209_/X _0178_/Q
+ _0177_/Q VPWR VGND sg13cmos5l_mux4_1
XFILLER_96_112 VPWR VGND sg13cmos5l_fill_1
XANTENNA__0211__D Tile_X0Y0_FrameData[19] VPWR VGND sg13cmos5l_antennanp
XANTENNA__0851__GATE Tile_X0Y5_FrameStrobe[1] VPWR VGND sg13cmos5l_antennanp
XFILLER_284_202 VPWR VGND sg13cmos5l_fill_1
X_2272_ _2272_/X _2372_/X _2371_/X _2362_/X _2361_/X _0526_/Q _0525_/Q VPWR VGND sg13cmos5l_mux4_1
XFILLER_270_17 VPWR VGND sg13cmos5l_decap_4
X_1223_ _1223_/Q Tile_X0Y4_FrameData[31] VGND VPWR Tile_X0Y5_FrameStrobe[6] latch
XANTENNA__0236__GATE Tile_X0Y5_FrameStrobe[5] VPWR VGND sg13cmos5l_antennanp
XANTENNA__2477__A1 Tile_X0Y5_N4END[13] VPWR VGND sg13cmos5l_antennanp
XFILLER_270_39 VPWR VGND sg13cmos5l_decap_8
XANTENNA__0866__GATE Tile_X0Y5_FrameStrobe[2] VPWR VGND sg13cmos5l_antennanp
XFILLER_237_195 VPWR VGND sg13cmos5l_fill_2
X_1154_ _1154_/Q Tile_X0Y4_FrameData[4] VGND VPWR Tile_X0Y5_FrameStrobe[3] latch
XANTENNA__1042__D Tile_X0Y4_FrameData[20] VPWR VGND sg13cmos5l_antennanp
X_1085_ _1085_/Q Tile_X0Y4_FrameData[9] VGND VPWR Tile_X0Y5_FrameStrobe[1] latch
X_0105_ _0105_/Q Tile_X0Y0_FrameData[29] VGND VPWR Tile_X0Y5_FrameStrobe[1] latch
XFILLER_350_83 VPWR VGND sg13cmos5l_fill_2
XFILLER_252_165 VPWR VGND sg13cmos5l_decap_8
XFILLER_279_37 VPWR VGND sg13cmos5l_fill_2
X_0036_ _1619_/A _2159_/X _2160_/X _0275_/Q VPWR VGND sg13cmos5l_mux2_1
XANTENNA__0881__D Tile_X0Y3_FrameData[5] VPWR VGND sg13cmos5l_antennanp
XFILLER_165_106 VPWR VGND sg13cmos5l_decap_8
X_1987_ Tile_X0Y5_E6BEG[0] _2757_/X VPWR VGND sg13cmos5l_buf_1
XFILLER_354_217 VPWR VGND sg13cmos5l_fill_1
XFILLER_354_206 VPWR VGND sg13cmos5l_decap_4
XFILLER_295_25 VPWR VGND sg13cmos5l_fill_1
XFILLER_295_14 VPWR VGND sg13cmos5l_fill_1
XANTENNA__1619__X Tile_X0Y0_N4BEG[15] VPWR VGND sg13cmos5l_antennanp
XANTENNA__2401__A1 AXIL_S_SOC_AWADDR8 VPWR VGND sg13cmos5l_antennanp
XFILLER_165_139 VPWR VGND sg13cmos5l_decap_8
X_0938_ _0938_/Q Tile_X0Y3_FrameData[12] VGND VPWR Tile_X0Y5_FrameStrobe[4] latch
XANTENNA__0804__GATE Tile_X0Y5_FrameStrobe[0] VPWR VGND sg13cmos5l_antennanp
XFILLER_228_52 VPWR VGND sg13cmos5l_decap_8
XFILLER_307_133 VPWR VGND sg13cmos5l_fill_1
XFILLER_295_69 VPWR VGND sg13cmos5l_fill_1
X_0869_ _0869_/Q Tile_X0Y3_FrameData[17] VGND VPWR Tile_X0Y5_FrameStrobe[2] latch
XFILLER_322_103 VPWR VGND sg13cmos5l_fill_1
XFILLER_307_188 VPWR VGND sg13cmos5l_decap_8
XANTENNA__2165__A0 AXIL_S_SOC_WDATA16 VPWR VGND sg13cmos5l_antennanp
XFILLER_173_194 VPWR VGND sg13cmos5l_fill_1
X_2608_ _2608_/X Tile_X0Y5_W2MID[2] Tile_X0Y5_W2END[2] Tile_X0Y5_W6END[2] _2799_/X
+ _1478_/Q _1477_/Q VPWR VGND sg13cmos5l_mux4_1
XFILLER_322_125 VPWR VGND sg13cmos5l_fill_2
XANTENNA__0819__GATE Tile_X0Y5_FrameStrobe[0] VPWR VGND sg13cmos5l_antennanp
XANTENNA__1217__D Tile_X0Y4_FrameData[5] VPWR VGND sg13cmos5l_antennanp
X_2539_ _2539_/X AXIL_S_SOC_ARADDR2 AXIL_S_SOC_ARADDR4 _2586_/X _2590_/X _0926_/Q
+ _0925_/Q VPWR VGND sg13cmos5l_mux4_1
XANTENNA__0121__D Tile_X0Y0_FrameData[13] VPWR VGND sg13cmos5l_antennanp
XFILLER_87_178 VPWR VGND sg13cmos5l_decap_8
XANTENNA__2468__A1 Tile_X0Y5_N4END[14] VPWR VGND sg13cmos5l_antennanp
XFILLER_189_7 VPWR VGND sg13cmos5l_decap_8
XFILLER_260_50 VPWR VGND sg13cmos5l_fill_2
XFILLER_113_77 VPWR VGND sg13cmos5l_decap_8
XFILLER_243_132 VPWR VGND sg13cmos5l_fill_1
XFILLER_243_165 VPWR VGND sg13cmos5l_fill_2
XFILLER_73_59 VPWR VGND sg13cmos5l_decap_8
XANTENNA__0791__D Tile_X0Y2_FrameData[31] VPWR VGND sg13cmos5l_antennanp
XANTENNA__2640__A1 AXIL_S_SOC_BREADY VPWR VGND sg13cmos5l_antennanp
XFILLER_11_145 VPWR VGND sg13cmos5l_fill_1
XANTENNA__1529__X Tile_X0Y3_E6BEG[3] VPWR VGND sg13cmos5l_antennanp
XFILLER_149_180 VPWR VGND sg13cmos5l_decap_8
XFILLER_138_30 VPWR VGND sg13cmos5l_decap_8
XFILLER_164_150 VPWR VGND sg13cmos5l_decap_8
XFILLER_22_85 VPWR VGND sg13cmos5l_decap_4
XFILLER_98_23 VPWR VGND sg13cmos5l_decap_8
XFILLER_138_96 VPWR VGND sg13cmos5l_fill_1
XFILLER_313_136 VPWR VGND sg13cmos5l_decap_8
XANTENNA__1127__D Tile_X0Y4_FrameData[31] VPWR VGND sg13cmos5l_antennanp
XFILLER_154_51 VPWR VGND sg13cmos5l_fill_2
XFILLER_78_112 VPWR VGND sg13cmos5l_fill_2
XANTENNA__0966__D Tile_X0Y3_FrameData[16] VPWR VGND sg13cmos5l_antennanp
XANTENNA__2459__A1 Tile_X0Y1_W6END[9] VPWR VGND sg13cmos5l_antennanp
XFILLER_304_76 VPWR VGND sg13cmos5l_decap_8
XANTENNA__2095__X Tile_X0Y3_E2BEG[7] VPWR VGND sg13cmos5l_antennanp
XFILLER_170_83 VPWR VGND sg13cmos5l_decap_8
XFILLER_234_132 VPWR VGND sg13cmos5l_decap_8
XFILLER_179_209 VPWR VGND sg13cmos5l_fill_2
XFILLER_320_42 VPWR VGND sg13cmos5l_decap_8
XFILLER_320_64 VPWR VGND sg13cmos5l_fill_1
XANTENNA__2631__A1 AXIL_S_SOC_WSTRB2 VPWR VGND sg13cmos5l_antennanp
X_1910_ Tile_X0Y1_FrameData_O[23] Tile_X0Y1_FrameData[23] VPWR VGND sg13cmos5l_buf_1
XFILLER_63_92 VPWR VGND sg13cmos5l_decap_4
XFILLER_147_106 VPWR VGND sg13cmos5l_fill_1
XFILLER_147_117 VPWR VGND sg13cmos5l_decap_8
X_1841_ Tile_X0Y4_FrameData_O[8] Tile_X0Y4_FrameData[8] VPWR VGND sg13cmos5l_buf_1
XANTENNA__0206__D Tile_X0Y0_FrameData[24] VPWR VGND sg13cmos5l_antennanp
XANTENNA__2395__A0 Tile_X0Y0_W1END[3] VPWR VGND sg13cmos5l_antennanp
X_1772_ Tile_X0Y2_UserCLKo Tile_X0Y2_UserCLK VPWR VGND sg13cmos5l_buf_1
XFILLER_265_39 VPWR VGND sg13cmos5l_decap_8
X_0723_ _0723_/Q Tile_X0Y2_FrameData[19] VGND VPWR Tile_X0Y5_FrameStrobe[5] latch
XANTENNA__0160__GATE Tile_X0Y5_FrameStrobe[2] VPWR VGND sg13cmos5l_antennanp
XANTENNA__2147__A0 Tile_X0Y0_W2MID[5] VPWR VGND sg13cmos5l_antennanp
X_0654_ _0654_/Q Tile_X0Y2_FrameData[24] VGND VPWR Tile_X0Y5_FrameStrobe[3] latch
XANTENNA__0790__GATE Tile_X0Y5_FrameStrobe[7] VPWR VGND sg13cmos5l_antennanp
XANTENNA__1037__D Tile_X0Y4_FrameData[25] VPWR VGND sg13cmos5l_antennanp
XANTENNA__2698__A1 Tile_X0Y0_WW4END[11] VPWR VGND sg13cmos5l_antennanp
XFILLER_345_83 VPWR VGND sg13cmos5l_fill_2
XANTENNA__2162__A3 AXIL_S_SOC_WDATA22 VPWR VGND sg13cmos5l_antennanp
X_2324_ _2324_/X AXIL_S_SOC_WDATA3 AXIL_S_SOC_WDATA15 _2372_/X _2373_/X _0444_/Q _0443_/Q
+ VPWR VGND sg13cmos5l_mux4_1
X_0585_ _0585_/Q Tile_X0Y2_FrameData[29] VGND VPWR Tile_X0Y5_FrameStrobe[1] latch
XANTENNA__0175__GATE Tile_X0Y5_FrameStrobe[3] VPWR VGND sg13cmos5l_antennanp
XANTENNA__0876__D Tile_X0Y3_FrameData[10] VPWR VGND sg13cmos5l_antennanp
XFILLER_26_0 VPWR VGND sg13cmos5l_fill_2
XANTENNA__1902__X Tile_X0Y1_FrameData_O[15] VPWR VGND sg13cmos5l_antennanp
X_2255_ _2255_/X Tile_X0Y2_W2MID[4] Tile_X0Y2_W2END[4] Tile_X0Y2_W6END[4] _2484_/X
+ _0776_/Q _0775_/Q VPWR VGND sg13cmos5l_mux4_1
XFILLER_84_104 VPWR VGND sg13cmos5l_decap_8
X_2186_ _2186_/X AXIL_S_SOC_WDATA21 AXIL_S_SOC_WDATA25 _2222_/X _2243_/X _0224_/Q
+ _0223_/Q VPWR VGND sg13cmos5l_mux4_1
X_1206_ _1206_/Q Tile_X0Y4_FrameData[16] VGND VPWR Tile_X0Y5_FrameStrobe[5] latch
XFILLER_84_159 VPWR VGND sg13cmos5l_decap_8
XFILLER_25_204 VPWR VGND sg13cmos5l_fill_2
X_1137_ _1137_/Q Tile_X0Y4_FrameData[21] VGND VPWR Tile_X0Y5_FrameStrobe[3] latch
XFILLER_230_86 VPWR VGND sg13cmos5l_fill_2
X_1068_ _1068_/Q Tile_X0Y4_FrameData[26] VGND VPWR Tile_X0Y5_FrameStrobe[1] latch
XANTENNA__2622__A1 AXIL_S_SOC_BREADY VPWR VGND sg13cmos5l_antennanp
XANTENNA__0113__GATE Tile_X0Y5_FrameStrobe[1] VPWR VGND sg13cmos5l_antennanp
XANTENNA__0116__D Tile_X0Y0_FrameData[18] VPWR VGND sg13cmos5l_antennanp
XANTENNA__0743__GATE Tile_X0Y5_FrameStrobe[6] VPWR VGND sg13cmos5l_antennanp
XFILLER_193_223 VPWR VGND sg13cmos5l_fill_1
XANTENNA__2386__A0 Tile_X0Y3_W2MID[5] VPWR VGND sg13cmos5l_antennanp
XFILLER_146_183 VPWR VGND sg13cmos5l_fill_1
XFILLER_175_39 VPWR VGND sg13cmos5l_decap_8
XANTENNA__0128__GATE Tile_X0Y5_FrameStrobe[1] VPWR VGND sg13cmos5l_antennanp
XANTENNA__0758__GATE Tile_X0Y5_FrameStrobe[6] VPWR VGND sg13cmos5l_antennanp
XANTENNA__2138__A0 Tile_X0Y5_W2MID[1] VPWR VGND sg13cmos5l_antennanp
XFILLER_161_175 VPWR VGND sg13cmos5l_decap_8
XFILLER_255_83 VPWR VGND sg13cmos5l_fill_2
XANTENNA__2689__A1 Tile_X0Y5_N4END[6] VPWR VGND sg13cmos5l_antennanp
XFILLER_108_88 VPWR VGND sg13cmos5l_decap_8
XFILLER_191_16 VPWR VGND sg13cmos5l_fill_1
XFILLER_191_27 VPWR VGND sg13cmos5l_decap_4
XANTENNA__0786__D Tile_X0Y2_FrameData[20] VPWR VGND sg13cmos5l_antennanp
XANTENNA__2153__A3 Tile_X0Y0_W6END[8] VPWR VGND sg13cmos5l_antennanp
XANTENNA__1812__X Tile_X0Y4_E6BEG[7] VPWR VGND sg13cmos5l_antennanp
XFILLER_124_54 VPWR VGND sg13cmos5l_decap_8
XANTENNA__2310__A0 AXIL_S_SOC_WDATA1 VPWR VGND sg13cmos5l_antennanp
XFILLER_84_69 VPWR VGND sg13cmos5l_decap_8
XFILLER_17_85 VPWR VGND sg13cmos5l_decap_4
XFILLER_231_113 VPWR VGND sg13cmos5l_fill_1
XANTENNA__1410__D Tile_X0Y5_FrameData[14] VPWR VGND sg13cmos5l_antennanp
XFILLER_231_157 VPWR VGND sg13cmos5l_decap_8
XFILLER_33_95 VPWR VGND sg13cmos5l_fill_1
XANTENNA__2129__A0 Tile_X0Y1_W2MID[7] VPWR VGND sg13cmos5l_antennanp
XFILLER_152_131 VPWR VGND sg13cmos5l_decap_8
XFILLER_298_113 VPWR VGND sg13cmos5l_decap_4
XFILLER_152_153 VPWR VGND sg13cmos5l_decap_8
XFILLER_98_207 VPWR VGND sg13cmos5l_fill_2
XFILLER_3_130 VPWR VGND sg13cmos5l_fill_2
XFILLER_315_20 VPWR VGND sg13cmos5l_decap_8
X_0370_ _0370_/Q Tile_X0Y1_FrameData[4] VGND VPWR Tile_X0Y5_FrameStrobe[1] latch
XFILLER_315_64 VPWR VGND sg13cmos5l_fill_1
XANTENNA__0696__D Tile_X0Y2_FrameData[14] VPWR VGND sg13cmos5l_antennanp
XFILLER_58_92 VPWR VGND sg13cmos5l_decap_4
XANTENNA__1722__X Tile_X0Y0_E2BEGb[2] VPWR VGND sg13cmos5l_antennanp
X_2040_ Tile_X0Y5_FrameData_O[25] Tile_X0Y5_FrameData[25] VPWR VGND sg13cmos5l_buf_1
XFILLER_66_159 VPWR VGND sg13cmos5l_fill_2
XANTENNA__2301__A0 AXIL_S_SOC_WDATA0 VPWR VGND sg13cmos5l_antennanp
XFILLER_207_132 VPWR VGND sg13cmos5l_decap_8
XFILLER_81_129 VPWR VGND sg13cmos5l_decap_8
XANTENNA__1320__D Tile_X0Y5_FrameData[8] VPWR VGND sg13cmos5l_antennanp
XANTENNA__2604__A1 Tile_X0Y5_W2END[4] VPWR VGND sg13cmos5l_antennanp
XFILLER_200_34 VPWR VGND sg13cmos5l_decap_4
XFILLER_200_67 VPWR VGND sg13cmos5l_decap_8
XANTENNA__1473__GATE Tile_X0Y5_FrameStrobe[6] VPWR VGND sg13cmos5l_antennanp
X_1824_ Tile_X0Y4_EE4BEG[7] _2640_/X VPWR VGND sg13cmos5l_buf_1
XFILLER_209_54 VPWR VGND sg13cmos5l_decap_4
X_1755_ Tile_X0Y2_FrameData_O[15] Tile_X0Y2_FrameData[15] VPWR VGND sg13cmos5l_buf_1
XFILLER_143_131 VPWR VGND sg13cmos5l_fill_2
XFILLER_289_102 VPWR VGND sg13cmos5l_decap_8
X_0706_ _0706_/Q Tile_X0Y2_FrameData[4] VGND VPWR Tile_X0Y5_FrameStrobe[4] latch
XFILLER_356_93 VPWR VGND sg13cmos5l_fill_1
XFILLER_356_82 VPWR VGND sg13cmos5l_decap_4
XANTENNA__1488__GATE Tile_X0Y5_FrameStrobe[6] VPWR VGND sg13cmos5l_antennanp
XFILLER_289_135 VPWR VGND sg13cmos5l_decap_8
X_1686_ Tile_X0Y0_FrameData_O[26] Tile_X0Y0_FrameData[26] VPWR VGND sg13cmos5l_buf_1
X_0637_ _0637_/Q Tile_X0Y2_FrameData[9] VGND VPWR Tile_X0Y5_FrameStrobe[2] latch
XANTENNA__2540__A0 AXIL_S_SOC_ARADDR3 VPWR VGND sg13cmos5l_antennanp
XFILLER_225_42 VPWR VGND sg13cmos5l_fill_1
XFILLER_225_75 VPWR VGND sg13cmos5l_decap_8
X_0568_ _0568_/Q Tile_X0Y2_FrameData[14] VGND VPWR Tile_X0Y5_FrameStrobe[0] latch
XANTENNA__1411__GATE Tile_X0Y5_FrameStrobe[4] VPWR VGND sg13cmos5l_antennanp
XFILLER_161_19 VPWR VGND sg13cmos5l_fill_1
X_2307_ _2307_/X AXIL_S_SOC_WDATA6 AXIL_S_SOC_WDATA14 _2374_/X _2379_/X _0478_/Q _0477_/Q
+ VPWR VGND sg13cmos5l_mux4_1
XFILLER_57_126 VPWR VGND sg13cmos5l_fill_2
XANTENNA__1632__X Tile_X0Y0_N2BEG[4] VPWR VGND sg13cmos5l_antennanp
X_2238_ _2238_/X _2214_/X _0066_/X Tile_X0Y0_S1END[1] Tile_X0Y0_S4END[1] _0124_/Q
+ _0123_/Q VPWR VGND sg13cmos5l_mux4_1
X_0499_ _0499_/Q Tile_X0Y1_FrameData[3] VGND VPWR Tile_X0Y5_FrameStrobe[5] latch
XFILLER_241_74 VPWR VGND sg13cmos5l_fill_1
X_2169_ _2169_/X AXIL_S_SOC_WDATA20 AXIL_S_SOC_WDATA28 _2244_/X _2245_/X _0258_/Q
+ _0257_/Q VPWR VGND sg13cmos5l_mux4_1
XFILLER_72_129 VPWR VGND sg13cmos5l_decap_8
XANTENNA__1426__GATE Tile_X0Y5_FrameStrobe[5] VPWR VGND sg13cmos5l_antennanp
XFILLER_80_151 VPWR VGND sg13cmos5l_decap_8
XANTENNA__1230__D Tile_X0Y4_FrameData[24] VPWR VGND sg13cmos5l_antennanp
XFILLER_213_157 VPWR VGND sg13cmos5l_decap_8
XANTENNA__0682__GATE Tile_X0Y5_FrameStrobe[4] VPWR VGND sg13cmos5l_antennanp
XFILLER_110_56 VPWR VGND sg13cmos5l_decap_8
XFILLER_110_67 VPWR VGND sg13cmos5l_fill_1
XFILLER_110_89 VPWR VGND sg13cmos5l_decap_8
XFILLER_70_49 VPWR VGND sg13cmos5l_decap_8
XANTENNA__2359__A0 Tile_X0Y5_W1END[2] VPWR VGND sg13cmos5l_antennanp
XANTENNA__0697__GATE Tile_X0Y5_FrameStrobe[4] VPWR VGND sg13cmos5l_antennanp
XANTENNA__1807__X Tile_X0Y4_E6BEG[2] VPWR VGND sg13cmos5l_antennanp
XANTENNA__2374__A3 Tile_X0Y0_S2MID[1] VPWR VGND sg13cmos5l_antennanp
XFILLER_119_76 VPWR VGND sg13cmos5l_decap_8
XFILLER_266_71 VPWR VGND sg13cmos5l_decap_8
XANTENNA__0620__GATE Tile_X0Y5_FrameStrobe[2] VPWR VGND sg13cmos5l_antennanp
XANTENNA__2531__A0 AXIL_S_SOC_ARADDR0 VPWR VGND sg13cmos5l_antennanp
XFILLER_0_144 VPWR VGND sg13cmos5l_fill_1
XFILLER_135_42 VPWR VGND sg13cmos5l_decap_8
XFILLER_135_53 VPWR VGND sg13cmos5l_decap_8
XFILLER_282_70 VPWR VGND sg13cmos5l_decap_8
XFILLER_95_13 VPWR VGND sg13cmos5l_decap_4
XFILLER_295_138 VPWR VGND sg13cmos5l_decap_8
XANTENNA__1405__D Tile_X0Y5_FrameData[19] VPWR VGND sg13cmos5l_antennanp
XFILLER_0_166 VPWR VGND sg13cmos5l_fill_1
XFILLER_282_81 VPWR VGND sg13cmos5l_fill_2
XFILLER_95_35 VPWR VGND sg13cmos5l_fill_2
XFILLER_48_115 VPWR VGND sg13cmos5l_fill_1
XANTENNA__1542__X Tile_X0Y3_EE4BEG[4] VPWR VGND sg13cmos5l_antennanp
XANTENNA__0635__GATE Tile_X0Y5_FrameStrobe[2] VPWR VGND sg13cmos5l_antennanp
XFILLER_151_52 VPWR VGND sg13cmos5l_decap_4
XFILLER_28_62 VPWR VGND sg13cmos5l_fill_2
XANTENNA__2834__A1 Tile_X0Y4_W2MID[2] VPWR VGND sg13cmos5l_antennanp
XFILLER_151_85 VPWR VGND sg13cmos5l_decap_8
XFILLER_178_0 VPWR VGND sg13cmos5l_fill_2
XFILLER_204_113 VPWR VGND sg13cmos5l_decap_8
XFILLER_301_44 VPWR VGND sg13cmos5l_decap_8
XANTENNA__1140__D Tile_X0Y4_FrameData[18] VPWR VGND sg13cmos5l_antennanp
XFILLER_345_0 VPWR VGND sg13cmos5l_fill_1
XANTENNA__2598__A0 Tile_X0Y5_W2MID[7] VPWR VGND sg13cmos5l_antennanp
XFILLER_157_223 VPWR VGND sg13cmos5l_fill_1
XANTENNA__1717__X Tile_X0Y0_E6BEG[9] VPWR VGND sg13cmos5l_antennanp
XANTENNA__2365__A3 Tile_X0Y0_S4END[7] VPWR VGND sg13cmos5l_antennanp
X_1540_ Tile_X0Y3_EE4BEG[2] _2527_/X VPWR VGND sg13cmos5l_buf_1
XANTENNA__2770__A0 Tile_X0Y5_W1END[1] VPWR VGND sg13cmos5l_antennanp
XFILLER_125_153 VPWR VGND sg13cmos5l_fill_1
XFILLER_326_30 VPWR VGND sg13cmos5l_fill_1
X_1471_ _1471_/Q Tile_X0Y5_FrameData[17] VGND VPWR Tile_X0Y5_FrameStrobe[6] latch
XFILLER_140_145 VPWR VGND sg13cmos5l_decap_8
XFILLER_286_149 VPWR VGND sg13cmos5l_decap_8
X_0422_ _0422_/Q Tile_X0Y1_FrameData[16] VGND VPWR Tile_X0Y5_FrameStrobe[3] latch
XANTENNA__2522__A0 AXIL_S_SOC_ARADDR3 VPWR VGND sg13cmos5l_antennanp
X_0353_ _0353_/Q Tile_X0Y1_FrameData[21] VGND VPWR Tile_X0Y5_FrameStrobe[1] latch
XANTENNA__1315__D Tile_X0Y5_FrameData[13] VPWR VGND sg13cmos5l_antennanp
XFILLER_294_160 VPWR VGND sg13cmos5l_decap_8
XFILLER_294_182 VPWR VGND sg13cmos5l_decap_8
XFILLER_94_221 VPWR VGND sg13cmos5l_fill_2
X_0284_ _0284_/Q Tile_X0Y0_FrameData[10] VGND VPWR Tile_X0Y5_FrameStrobe[6] latch
XANTENNA__2825__A1 Tile_X0Y5_N2END[0] VPWR VGND sg13cmos5l_antennanp
X_2023_ Tile_X0Y5_FrameData_O[8] Tile_X0Y5_FrameData[8] VPWR VGND sg13cmos5l_buf_1
XANTENNA__1050__D Tile_X0Y4_FrameData[12] VPWR VGND sg13cmos5l_antennanp
XFILLER_211_55 VPWR VGND sg13cmos5l_decap_8
XFILLER_210_127 VPWR VGND sg13cmos5l_decap_8
XFILLER_93_0 VPWR VGND sg13cmos5l_fill_2
XFILLER_148_223 VPWR VGND sg13cmos5l_fill_1
XFILLER_108_109 VPWR VGND sg13cmos5l_decap_8
X_1807_ Tile_X0Y4_E6BEG[2] _2651_/X VPWR VGND sg13cmos5l_buf_1
XANTENNA__1627__X Tile_X0Y0_N2BEGb[7] VPWR VGND sg13cmos5l_antennanp
XFILLER_116_120 VPWR VGND sg13cmos5l_decap_8
X_2787_ _2787_/X Tile_X0Y5_W1END[3] Tile_X0Y5_WW4END[15] Tile_X0Y5_W6END[7] _2819_/X
+ _1331_/Q _1330_/Q VPWR VGND sg13cmos5l_mux4_1
XANTENNA__2761__A0 AXIL_S_SOC_RREADY VPWR VGND sg13cmos5l_antennanp
X_1738_ Tile_X0Y0_E1BEG[2] _2163_/X VPWR VGND sg13cmos5l_buf_1
XFILLER_236_74 VPWR VGND sg13cmos5l_decap_8
X_1669_ Tile_X0Y0_FrameData_O[9] Tile_X0Y0_FrameData[9] VPWR VGND sg13cmos5l_buf_1
XANTENNA__1350__GATE Tile_X0Y5_FrameStrobe[2] VPWR VGND sg13cmos5l_antennanp
XANTENNA__2513__A0 AXIL_S_SOC_ARADDR2 VPWR VGND sg13cmos5l_antennanp
XANTENNA__1225__D Tile_X0Y4_FrameData[29] VPWR VGND sg13cmos5l_antennanp
XFILLER_105_34 VPWR VGND sg13cmos5l_decap_4
XFILLER_218_216 VPWR VGND sg13cmos5l_fill_2
XFILLER_292_119 VPWR VGND sg13cmos5l_fill_1
XFILLER_105_89 VPWR VGND sg13cmos5l_decap_8
XFILLER_65_38 VPWR VGND sg13cmos5l_decap_8
XANTENNA__1365__GATE Tile_X0Y5_FrameStrobe[3] VPWR VGND sg13cmos5l_antennanp
XANTENNA__2292__A2 AXIL_S_SOC_WDATA1 VPWR VGND sg13cmos5l_antennanp
XFILLER_121_77 VPWR VGND sg13cmos5l_decap_8
XFILLER_197_26 VPWR VGND sg13cmos5l_decap_4
XFILLER_81_59 VPWR VGND sg13cmos5l_fill_1
XFILLER_81_48 VPWR VGND sg13cmos5l_decap_8
XFILLER_198_189 VPWR VGND sg13cmos5l_decap_8
XFILLER_14_75 VPWR VGND sg13cmos5l_fill_1
XFILLER_355_142 VPWR VGND sg13cmos5l_decap_8
XFILLER_154_204 VPWR VGND sg13cmos5l_decap_8
XFILLER_355_153 VPWR VGND sg13cmos5l_fill_1
XANTENNA__0304__D Tile_X0Y0_FrameData[22] VPWR VGND sg13cmos5l_antennanp
XANTENNA__1303__GATE Tile_X0Y5_FrameStrobe[1] VPWR VGND sg13cmos5l_antennanp
XANTENNA__1537__X Tile_X0Y3_E6BEG[11] VPWR VGND sg13cmos5l_antennanp
XANTENNA__2752__A0 AXIL_S_SOC_ARPROT1 VPWR VGND sg13cmos5l_antennanp
XFILLER_107_142 VPWR VGND sg13cmos5l_decap_8
XFILLER_146_41 VPWR VGND sg13cmos5l_decap_8
XFILLER_107_175 VPWR VGND sg13cmos5l_decap_8
XANTENNA__1318__GATE Tile_X0Y5_FrameStrobe[1] VPWR VGND sg13cmos5l_antennanp
XANTENNA__2504__A0 Tile_X0Y4_W2MID[0] VPWR VGND sg13cmos5l_antennanp
XFILLER_295_0 VPWR VGND sg13cmos5l_fill_2
XANTENNA__0574__GATE Tile_X0Y5_FrameStrobe[0] VPWR VGND sg13cmos5l_antennanp
XANTENNA__1135__D Tile_X0Y4_FrameData[23] VPWR VGND sg13cmos5l_antennanp
XFILLER_162_40 VPWR VGND sg13cmos5l_decap_8
XFILLER_209_205 VPWR VGND sg13cmos5l_fill_2
XFILLER_283_108 VPWR VGND sg13cmos5l_decap_8
XANTENNA__0974__D Tile_X0Y3_FrameData[8] VPWR VGND sg13cmos5l_antennanp
XANTENNA__2807__A1 Tile_X0Y1_WW4END[9] VPWR VGND sg13cmos5l_antennanp
XANTENNA__0589__GATE Tile_X0Y5_FrameStrobe[1] VPWR VGND sg13cmos5l_antennanp
XANTENNA__2283__A2 Tile_X0Y3_WW4END[6] VPWR VGND sg13cmos5l_antennanp
XFILLER_189_167 VPWR VGND sg13cmos5l_decap_8
X_0971_ _0971_/Q Tile_X0Y3_FrameData[11] VGND VPWR Tile_X0Y5_FrameStrobe[5] latch
XANTENNA__0512__GATE Tile_X0Y5_FrameStrobe[6] VPWR VGND sg13cmos5l_antennanp
XANTENNA__2586__A3 Tile_X0Y0_S4END[13] VPWR VGND sg13cmos5l_antennanp
X_2710_ _2710_/X _2602_/X Tile_X0Y5_N2MID[2] _2715_/X _2601_/X _1050_/Q _1049_/Q VPWR
+ VGND sg13cmos5l_mux4_1
XFILLER_346_131 VPWR VGND sg13cmos5l_decap_8
XFILLER_200_182 VPWR VGND sg13cmos5l_decap_8
XFILLER_257_29 VPWR VGND sg13cmos5l_decap_8
XANTENNA__0214__D Tile_X0Y0_FrameData[16] VPWR VGND sg13cmos5l_antennanp
XFILLER_200_193 VPWR VGND sg13cmos5l_fill_2
X_2641_ _2641_/X AXIL_S_SOC_WSTRB2 AXIL_S_SOC_WVALID _2700_/X _2681_/X _1172_/Q _1171_/Q
+ VPWR VGND sg13cmos5l_mux4_1
XFILLER_346_197 VPWR VGND sg13cmos5l_fill_1
XFILLER_346_186 VPWR VGND sg13cmos5l_fill_1
XANTENNA__2743__A0 AXIL_S_SOC_ARPROT2 VPWR VGND sg13cmos5l_antennanp
X_2572_ _2572_/X Tile_X0Y4_W1END[3] Tile_X0Y4_W6END[7] _2684_/X _2672_/X _1258_/Q
+ _1257_/Q VPWR VGND sg13cmos5l_mux4_1
XFILLER_361_145 VPWR VGND sg13cmos5l_fill_1
XANTENNA__0527__GATE Tile_X0Y5_FrameStrobe[6] VPWR VGND sg13cmos5l_antennanp
XFILLER_113_112 VPWR VGND sg13cmos5l_decap_4
XFILLER_273_39 VPWR VGND sg13cmos5l_fill_1
X_1523_ Tile_X0Y3_E2BEGb[5] _2522_/X VPWR VGND sg13cmos5l_buf_1
XFILLER_113_123 VPWR VGND sg13cmos5l_decap_8
XFILLER_206_33 VPWR VGND sg13cmos5l_decap_8
X_1454_ _1454_/Q Tile_X0Y5_FrameData[2] VGND VPWR Tile_X0Y5_FrameStrobe[5] latch
X_0405_ _0405_/Q Tile_X0Y1_FrameData[1] VGND VPWR Tile_X0Y5_FrameStrobe[2] latch
XANTENNA__1045__D Tile_X0Y4_FrameData[17] VPWR VGND sg13cmos5l_antennanp
X_1385_ _1385_/Q Tile_X0Y5_FrameData[7] VGND VPWR Tile_X0Y5_FrameStrobe[3] latch
XFILLER_353_83 VPWR VGND sg13cmos5l_decap_8
X_0336_ _0336_/Q Tile_X0Y1_FrameData[6] VGND VPWR Tile_X0Y5_FrameStrobe[0] latch
XANTENNA__0884__D Tile_X0Y3_FrameData[2] VPWR VGND sg13cmos5l_antennanp
XFILLER_222_32 VPWR VGND sg13cmos5l_decap_8
X_0267_ _0267_/Q Tile_X0Y0_FrameData[27] VGND VPWR Tile_X0Y5_FrameStrobe[6] latch
XFILLER_82_213 VPWR VGND sg13cmos5l_fill_2
XANTENNA__1910__X Tile_X0Y1_FrameData_O[23] VPWR VGND sg13cmos5l_antennanp
X_2006_ Tile_X0Y5_EE4BEG[7] _2748_/X VPWR VGND sg13cmos5l_buf_1
XFILLER_35_140 VPWR VGND sg13cmos5l_decap_4
X_0198_ _0198_/Q Tile_X0Y0_FrameData[0] VGND VPWR Tile_X0Y5_FrameStrobe[3] latch
XFILLER_35_173 VPWR VGND sg13cmos5l_fill_2
XFILLER_35_151 VPWR VGND sg13cmos5l_decap_8
XFILLER_298_58 VPWR VGND sg13cmos5l_fill_2
XFILLER_298_47 VPWR VGND sg13cmos5l_decap_8
XFILLER_195_137 VPWR VGND sg13cmos5l_decap_8
XANTENNA__2577__A3 Tile_X0Y0_S4END[13] VPWR VGND sg13cmos5l_antennanp
XFILLER_136_204 VPWR VGND sg13cmos5l_decap_4
XFILLER_337_153 VPWR VGND sg13cmos5l_fill_2
XFILLER_337_142 VPWR VGND sg13cmos5l_decap_4
XANTENNA__0124__D Tile_X0Y0_FrameData[10] VPWR VGND sg13cmos5l_antennanp
XFILLER_352_101 VPWR VGND sg13cmos5l_decap_8
XFILLER_337_197 VPWR VGND sg13cmos5l_fill_1
XANTENNA__2734__A0 AXIL_S_SOC_ARPROT1 VPWR VGND sg13cmos5l_antennanp
XFILLER_352_189 VPWR VGND sg13cmos5l_decap_8
XFILLER_352_178 VPWR VGND sg13cmos5l_fill_1
XFILLER_258_171 VPWR VGND sg13cmos5l_decap_8
XFILLER_263_94 VPWR VGND sg13cmos5l_fill_2
XFILLER_281_6 VPWR VGND sg13cmos5l_decap_8
XANTENNA__0794__D Tile_X0Y3_FrameData[28] VPWR VGND sg13cmos5l_antennanp
XFILLER_206_208 VPWR VGND sg13cmos5l_decap_8
XFILLER_73_202 VPWR VGND sg13cmos5l_decap_8
XANTENNA__1820__X Tile_X0Y4_EE4BEG[3] VPWR VGND sg13cmos5l_antennanp
XFILLER_132_87 VPWR VGND sg13cmos5l_fill_2
XANTENNA__2265__A2 Tile_X0Y1_WW4END[7] VPWR VGND sg13cmos5l_antennanp
XFILLER_92_69 VPWR VGND sg13cmos5l_decap_8
XFILLER_155_2 VPWR VGND sg13cmos5l_fill_1
XFILLER_186_159 VPWR VGND sg13cmos5l_decap_8
XFILLER_41_187 VPWR VGND sg13cmos5l_decap_8
XANTENNA__1242__GATE Tile_X0Y5_FrameStrobe[6] VPWR VGND sg13cmos5l_antennanp
XFILLER_328_164 VPWR VGND sg13cmos5l_decap_8
XFILLER_210_0 VPWR VGND sg13cmos5l_decap_4
XFILLER_343_112 VPWR VGND sg13cmos5l_decap_4
XFILLER_328_186 VPWR VGND sg13cmos5l_fill_1
XFILLER_308_0 VPWR VGND sg13cmos5l_fill_1
XANTENNA__0969__D Tile_X0Y3_FrameData[13] VPWR VGND sg13cmos5l_antennanp
XANTENNA__1257__GATE Tile_X0Y5_FrameStrobe[7] VPWR VGND sg13cmos5l_antennanp
XANTENNA__2725__A0 AXIL_S_SOC_ARPROT0 VPWR VGND sg13cmos5l_antennanp
XFILLER_296_222 VPWR VGND sg13cmos5l_fill_2
XFILLER_296_200 VPWR VGND sg13cmos5l_fill_1
XANTENNA__2098__X Tile_X0Y3_E2BEGb[2] VPWR VGND sg13cmos5l_antennanp
XFILLER_173_83 VPWR VGND sg13cmos5l_decap_8
XFILLER_173_94 VPWR VGND sg13cmos5l_fill_1
XFILLER_256_119 VPWR VGND sg13cmos5l_decap_8
XFILLER_110_159 VPWR VGND sg13cmos5l_decap_8
X_1170_ _1170_/Q Tile_X0Y4_FrameData[20] VGND VPWR Tile_X0Y5_FrameStrobe[4] latch
XFILLER_323_53 VPWR VGND sg13cmos5l_fill_1
XFILLER_323_42 VPWR VGND sg13cmos5l_decap_8
X_0121_ _0121_/Q Tile_X0Y0_FrameData[13] VGND VPWR Tile_X0Y5_FrameStrobe[1] latch
XANTENNA__1730__X Tile_X0Y0_E2BEG[2] VPWR VGND sg13cmos5l_antennanp
XANTENNA__2256__A2 Tile_X0Y1_W6END[4] VPWR VGND sg13cmos5l_antennanp
X_0052_ _1605_/A _2285_/X _2286_/X _1001_/Q VPWR VGND sg13cmos5l_mux2_1
XANTENNA__0209__D Tile_X0Y0_FrameData[21] VPWR VGND sg13cmos5l_antennanp
XANTENNA__0451__GATE Tile_X0Y5_FrameStrobe[4] VPWR VGND sg13cmos5l_antennanp
XFILLER_220_211 VPWR VGND sg13cmos5l_decap_8
XFILLER_268_28 VPWR VGND sg13cmos5l_decap_8
XFILLER_82_80 VPWR VGND sg13cmos5l_decap_8
XFILLER_177_137 VPWR VGND sg13cmos5l_fill_1
XFILLER_319_120 VPWR VGND sg13cmos5l_fill_1
XANTENNA__2559__A3 Tile_X0Y3_W6END[7] VPWR VGND sg13cmos5l_antennanp
XFILLER_118_204 VPWR VGND sg13cmos5l_fill_1
XFILLER_192_129 VPWR VGND sg13cmos5l_decap_8
X_0954_ _0954_/Q Tile_X0Y3_FrameData[28] VGND VPWR Tile_X0Y5_FrameStrobe[5] latch
XFILLER_319_153 VPWR VGND sg13cmos5l_decap_4
X_0885_ _0885_/Q Tile_X0Y3_FrameData[1] VGND VPWR Tile_X0Y5_FrameStrobe[2] latch
XANTENNA__0466__GATE Tile_X0Y5_FrameStrobe[4] VPWR VGND sg13cmos5l_antennanp
XFILLER_133_207 VPWR VGND sg13cmos5l_decap_4
X_2624_ _2624_/X AXIL_S_SOC_WSTRB1 AXIL_S_SOC_WSTRB3 _2708_/X _2681_/X _1206_/Q _1205_/Q
+ VPWR VGND sg13cmos5l_mux4_1
XANTENNA__0879__D Tile_X0Y3_FrameData[7] VPWR VGND sg13cmos5l_antennanp
XANTENNA__2716__A0 Tile_X0Y3_W2MID[4] VPWR VGND sg13cmos5l_antennanp
XFILLER_56_0 VPWR VGND sg13cmos5l_fill_2
XANTENNA__1905__X Tile_X0Y1_FrameData_O[18] VPWR VGND sg13cmos5l_antennanp
XANTENNA__2192__A1 AXIL_S_SOC_WDATA27 VPWR VGND sg13cmos5l_antennanp
XFILLER_217_76 VPWR VGND sg13cmos5l_decap_8
XFILLER_287_211 VPWR VGND sg13cmos5l_fill_1
X_2555_ _2555_/X Tile_X0Y3_W1END[1] Tile_X0Y3_WW4END[9] Tile_X0Y3_WW4END[13] Tile_X0Y3_W6END[5]
+ _0871_/Q _0870_/Q VPWR VGND sg13cmos5l_mux4_1
X_1506_ _2792_/A3 VPWR VGND sg13cmos5l_tielo
X_2486_ _2486_/X _2392_/X _2500_/X _2499_/X _2391_/X _0564_/Q _0563_/Q VPWR VGND sg13cmos5l_mux4_1
XFILLER_99_187 VPWR VGND sg13cmos5l_decap_8
X_1437_ _1437_/Q Tile_X0Y5_FrameData[19] VGND VPWR Tile_X0Y5_FrameStrobe[5] latch
XFILLER_101_159 VPWR VGND sg13cmos5l_decap_8
XFILLER_233_64 VPWR VGND sg13cmos5l_decap_8
X_1368_ _1368_/Q Tile_X0Y5_FrameData[24] VGND VPWR Tile_X0Y5_FrameStrobe[3] latch
XANTENNA__0404__GATE Tile_X0Y5_FrameStrobe[2] VPWR VGND sg13cmos5l_antennanp
XANTENNA__2495__A2 Tile_X0Y1_W6END[11] VPWR VGND sg13cmos5l_antennanp
X_0319_ _0319_/Q Tile_X0Y1_FrameData[23] VGND VPWR Tile_X0Y5_FrameStrobe[0] latch
XANTENNA__1640__X Tile_X0Y0_FrameStrobe_O[0] VPWR VGND sg13cmos5l_antennanp
XFILLER_255_174 VPWR VGND sg13cmos5l_decap_8
XFILLER_270_111 VPWR VGND sg13cmos5l_fill_1
XFILLER_270_122 VPWR VGND sg13cmos5l_decap_8
X_1299_ _1299_/Q Tile_X0Y5_FrameData[29] VGND VPWR Tile_X0Y5_FrameStrobe[1] latch
XANTENNA__2247__A2 Tile_X0Y0_S2MID[6] VPWR VGND sg13cmos5l_antennanp
XANTENNA__0119__D Tile_X0Y0_FrameData[15] VPWR VGND sg13cmos5l_antennanp
XFILLER_102_68 VPWR VGND sg13cmos5l_decap_8
XFILLER_23_121 VPWR VGND sg13cmos5l_fill_1
XFILLER_62_28 VPWR VGND sg13cmos5l_fill_1
XANTENNA__0419__GATE Tile_X0Y5_FrameStrobe[3] VPWR VGND sg13cmos5l_antennanp
XFILLER_168_104 VPWR VGND sg13cmos5l_decap_8
XFILLER_211_211 VPWR VGND sg13cmos5l_decap_8
XFILLER_23_143 VPWR VGND sg13cmos5l_decap_4
XFILLER_270_199 VPWR VGND sg13cmos5l_decap_8
XFILLER_176_181 VPWR VGND sg13cmos5l_fill_2
XANTENNA__0789__D Tile_X0Y2_FrameData[17] VPWR VGND sg13cmos5l_antennanp
XFILLER_11_43 VPWR VGND sg13cmos5l_fill_2
XFILLER_127_32 VPWR VGND sg13cmos5l_decap_4
XANTENNA__1815__X Tile_X0Y4_E6BEG[10] VPWR VGND sg13cmos5l_antennanp
XANTENNA__2183__A1 AXIL_S_SOC_WDATA30 VPWR VGND sg13cmos5l_antennanp
XFILLER_127_65 VPWR VGND sg13cmos5l_decap_8
XFILLER_344_19 VPWR VGND sg13cmos5l_fill_2
XANTENNA__2722__A3 AXIL_S_SOC_ARVALID VPWR VGND sg13cmos5l_antennanp
XFILLER_87_36 VPWR VGND sg13cmos5l_decap_8
XFILLER_360_29 VPWR VGND sg13cmos5l_fill_2
XFILLER_360_18 VPWR VGND sg13cmos5l_fill_2
XFILLER_100_170 VPWR VGND sg13cmos5l_fill_2
XANTENNA__1413__D Tile_X0Y5_FrameData[11] VPWR VGND sg13cmos5l_antennanp
XANTENNA__1550__X Tile_X0Y3_EE4BEG[12] VPWR VGND sg13cmos5l_antennanp
XFILLER_272_2 VPWR VGND sg13cmos5l_fill_1
XANTENNA__2238__A2 Tile_X0Y0_S1END[1] VPWR VGND sg13cmos5l_antennanp
XFILLER_258_0 VPWR VGND sg13cmos5l_decap_8
XFILLER_299_90 VPWR VGND sg13cmos5l_fill_1
XANTENNA__1181__GATE Tile_X0Y5_FrameStrobe[4] VPWR VGND sg13cmos5l_antennanp
XFILLER_168_50 VPWR VGND sg13cmos5l_decap_8
XFILLER_167_181 VPWR VGND sg13cmos5l_decap_8
XFILLER_318_20 VPWR VGND sg13cmos5l_decap_8
X_0670_ _0670_/Q Tile_X0Y2_FrameData[8] VGND VPWR Tile_X0Y5_FrameStrobe[3] latch
XANTENNA__0699__D Tile_X0Y2_FrameData[11] VPWR VGND sg13cmos5l_antennanp
XANTENNA__1196__GATE Tile_X0Y5_FrameStrobe[5] VPWR VGND sg13cmos5l_antennanp
XFILLER_182_162 VPWR VGND sg13cmos5l_fill_2
XANTENNA__1725__X Tile_X0Y0_E2BEGb[5] VPWR VGND sg13cmos5l_antennanp
XANTENNA__2174__A1 AXIL_S_SOC_WDATA25 VPWR VGND sg13cmos5l_antennanp
XFILLER_331_137 VPWR VGND sg13cmos5l_decap_4
X_2340_ _2340_/X _2348_/X _2347_/X Tile_X0Y1_W6END[3] _2340_/A3 _0312_/Q _0551_/Q
+ VPWR VGND sg13cmos5l_mux4_1
X_2271_ _2271_/X Tile_X0Y1_W1END[0] Tile_X0Y1_WW4END[0] Tile_X0Y1_WW4END[4] Tile_X0Y1_W6END[8]
+ _0526_/Q _0525_/Q VPWR VGND sg13cmos5l_mux4_1
XFILLER_334_41 VPWR VGND sg13cmos5l_decap_8
X_1222_ _1222_/Q Tile_X0Y4_FrameData[0] VGND VPWR Tile_X0Y5_FrameStrobe[5] latch
XFILLER_77_91 VPWR VGND sg13cmos5l_decap_8
XFILLER_237_152 VPWR VGND sg13cmos5l_fill_1
XFILLER_37_202 VPWR VGND sg13cmos5l_decap_8
XANTENNA__1134__GATE Tile_X0Y5_FrameStrobe[3] VPWR VGND sg13cmos5l_antennanp
XANTENNA__1323__D Tile_X0Y5_FrameData[5] VPWR VGND sg13cmos5l_antennanp
XANTENNA__1901__A Tile_X0Y1_FrameData[14] VPWR VGND sg13cmos5l_antennanp
XFILLER_237_174 VPWR VGND sg13cmos5l_decap_4
X_1153_ _1153_/Q Tile_X0Y4_FrameData[5] VGND VPWR Tile_X0Y5_FrameStrobe[3] latch
XANTENNA__2229__A2 Tile_X0Y0_S1END[0] VPWR VGND sg13cmos5l_antennanp
XFILLER_252_122 VPWR VGND sg13cmos5l_decap_4
XFILLER_252_144 VPWR VGND sg13cmos5l_decap_8
X_1084_ _1084_/Q Tile_X0Y4_FrameData[10] VGND VPWR Tile_X0Y5_FrameStrobe[1] latch
X_0104_ _0104_/Q Tile_X0Y0_FrameData[30] VGND VPWR Tile_X0Y5_FrameStrobe[1] latch
XFILLER_350_62 VPWR VGND sg13cmos5l_decap_8
XANTENNA__0390__GATE Tile_X0Y5_FrameStrobe[2] VPWR VGND sg13cmos5l_antennanp
X_0035_ _1618_/A _2157_/X _2158_/X _0278_/Q VPWR VGND sg13cmos5l_mux2_1
XFILLER_350_95 VPWR VGND sg13cmos5l_decap_8
XANTENNA__1149__GATE Tile_X0Y5_FrameStrobe[3] VPWR VGND sg13cmos5l_antennanp
XFILLER_359_71 VPWR VGND sg13cmos5l_fill_1
X_1986_ Tile_X0Y5_E2BEGb[7] _2740_/X VPWR VGND sg13cmos5l_buf_1
XFILLER_359_93 VPWR VGND sg13cmos5l_fill_2
X_0937_ _0937_/Q Tile_X0Y3_FrameData[13] VGND VPWR Tile_X0Y5_FrameStrobe[4] latch
XFILLER_173_151 VPWR VGND sg13cmos5l_decap_4
XFILLER_228_31 VPWR VGND sg13cmos5l_decap_8
XFILLER_173_184 VPWR VGND sg13cmos5l_fill_1
X_0868_ _0868_/Q Tile_X0Y3_FrameData[18] VGND VPWR Tile_X0Y5_FrameStrobe[2] latch
XANTENNA__0402__D Tile_X0Y1_FrameData[4] VPWR VGND sg13cmos5l_antennanp
XANTENNA__1635__X Tile_X0Y0_N2BEG[7] VPWR VGND sg13cmos5l_antennanp
XANTENNA__2165__A1 AXIL_S_SOC_WDATA24 VPWR VGND sg13cmos5l_antennanp
X_2607_ _2607_/X Tile_X0Y2_W1END[1] Tile_X0Y2_W2MID[2] Tile_X0Y2_W2END[2] _2486_/X
+ _0640_/Q _0639_/Q VPWR VGND sg13cmos5l_mux4_1
X_0799_ _0799_/Q Tile_X0Y3_FrameData[23] VGND VPWR Tile_X0Y5_FrameStrobe[0] latch
X_2538_ _2538_/X AXIL_S_SOC_ARADDR1 AXIL_S_SOC_ARADDR3 _2584_/X _2591_/X _0928_/Q
+ _0927_/Q VPWR VGND sg13cmos5l_mux4_1
XFILLER_330_181 VPWR VGND sg13cmos5l_decap_8
XANTENNA__0343__GATE Tile_X0Y5_FrameStrobe[1] VPWR VGND sg13cmos5l_antennanp
X_2469_ _2469_/X _2460_/X Tile_X0Y5_N4END[13] _2459_/X Tile_X0Y0_S4END[9] _0580_/Q
+ _0579_/Q VPWR VGND sg13cmos5l_mux4_1
XFILLER_87_157 VPWR VGND sg13cmos5l_decap_8
XFILLER_57_39 VPWR VGND sg13cmos5l_decap_8
XANTENNA__0973__GATE Tile_X0Y5_FrameStrobe[5] VPWR VGND sg13cmos5l_antennanp
XFILLER_228_152 VPWR VGND sg13cmos5l_decap_8
XANTENNA__1233__D Tile_X0Y4_FrameData[21] VPWR VGND sg13cmos5l_antennanp
XFILLER_243_100 VPWR VGND sg13cmos5l_decap_8
XFILLER_113_56 VPWR VGND sg13cmos5l_decap_8
XFILLER_228_196 VPWR VGND sg13cmos5l_decap_4
XFILLER_73_38 VPWR VGND sg13cmos5l_decap_8
XFILLER_43_205 VPWR VGND sg13cmos5l_fill_2
XANTENNA__0358__GATE Tile_X0Y5_FrameStrobe[1] VPWR VGND sg13cmos5l_antennanp
XANTENNA__0988__GATE Tile_X0Y5_FrameStrobe[6] VPWR VGND sg13cmos5l_antennanp
XFILLER_244_6 VPWR VGND sg13cmos5l_fill_2
XFILLER_339_19 VPWR VGND sg13cmos5l_fill_2
XFILLER_269_93 VPWR VGND sg13cmos5l_fill_2
XANTENNA__0911__GATE Tile_X0Y5_FrameStrobe[3] VPWR VGND sg13cmos5l_antennanp
XFILLER_7_139 VPWR VGND sg13cmos5l_fill_1
XFILLER_149_192 VPWR VGND sg13cmos5l_decap_4
XFILLER_22_64 VPWR VGND sg13cmos5l_decap_8
XFILLER_138_75 VPWR VGND sg13cmos5l_decap_8
XANTENNA__0312__D Tile_X0Y1_FrameData[30] VPWR VGND sg13cmos5l_antennanp
XANTENNA__0926__GATE Tile_X0Y5_FrameStrobe[4] VPWR VGND sg13cmos5l_antennanp
XANTENNA__1408__D Tile_X0Y5_FrameData[16] VPWR VGND sg13cmos5l_antennanp
XANTENNA__1545__X Tile_X0Y3_EE4BEG[7] VPWR VGND sg13cmos5l_antennanp
XFILLER_154_30 VPWR VGND sg13cmos5l_decap_8
XFILLER_154_74 VPWR VGND sg13cmos5l_decap_8
XFILLER_78_179 VPWR VGND sg13cmos5l_decap_8
XFILLER_304_33 VPWR VGND sg13cmos5l_decap_8
XANTENNA__1143__D Tile_X0Y4_FrameData[15] VPWR VGND sg13cmos5l_antennanp
XFILLER_234_100 VPWR VGND sg13cmos5l_fill_2
XFILLER_234_111 VPWR VGND sg13cmos5l_decap_8
XANTENNA__0982__D Tile_X0Y3_FrameData[0] VPWR VGND sg13cmos5l_antennanp
XFILLER_234_188 VPWR VGND sg13cmos5l_decap_8
X_1840_ Tile_X0Y4_FrameData_O[7] Tile_X0Y4_FrameData[7] VPWR VGND sg13cmos5l_buf_1
XFILLER_147_129 VPWR VGND sg13cmos5l_decap_8
XANTENNA__2395__A1 Tile_X0Y0_W2MID[0] VPWR VGND sg13cmos5l_antennanp
X_1771_ Tile_X0Y2_FrameData_O[31] Tile_X0Y2_FrameData[31] VPWR VGND sg13cmos5l_buf_1
XFILLER_329_96 VPWR VGND sg13cmos5l_fill_2
XFILLER_265_18 VPWR VGND sg13cmos5l_decap_8
X_0722_ _0722_/Q Tile_X0Y2_FrameData[20] VGND VPWR Tile_X0Y5_FrameStrobe[5] latch
XANTENNA__1318__D Tile_X0Y5_FrameData[10] VPWR VGND sg13cmos5l_antennanp
XANTENNA__2147__A1 Tile_X0Y0_W2END[5] VPWR VGND sg13cmos5l_antennanp
XFILLER_155_195 VPWR VGND sg13cmos5l_decap_8
X_0653_ _0653_/Q Tile_X0Y2_FrameData[25] VGND VPWR Tile_X0Y5_FrameStrobe[3] latch
XFILLER_304_115 VPWR VGND sg13cmos5l_fill_1
XANTENNA__0222__D Tile_X0Y0_FrameData[8] VPWR VGND sg13cmos5l_antennanp
XFILLER_170_154 VPWR VGND sg13cmos5l_decap_4
X_0584_ _0584_/Q Tile_X0Y2_FrameData[30] VGND VPWR Tile_X0Y5_FrameStrobe[1] latch
XANTENNA__2698__A2 Tile_X0Y0_WW4END[15] VPWR VGND sg13cmos5l_antennanp
XFILLER_170_198 VPWR VGND sg13cmos5l_decap_8
X_2323_ _2323_/X AXIL_S_SOC_WDATA2 AXIL_S_SOC_WDATA14 _2370_/X _2374_/X _0446_/Q _0445_/Q
+ VPWR VGND sg13cmos5l_mux4_1
XFILLER_312_170 VPWR VGND sg13cmos5l_fill_2
XANTENNA__1073__GATE Tile_X0Y5_FrameStrobe[1] VPWR VGND sg13cmos5l_antennanp
X_2254_ _2254_/X Tile_X0Y1_W2MID[5] Tile_X0Y1_W2END[5] Tile_X0Y1_W6END[5] _2375_/X
+ _0538_/Q _0537_/Q VPWR VGND sg13cmos5l_mux4_1
XFILLER_361_61 VPWR VGND sg13cmos5l_fill_1
XFILLER_361_50 VPWR VGND sg13cmos5l_fill_2
XANTENNA__1053__D Tile_X0Y4_FrameData[9] VPWR VGND sg13cmos5l_antennanp
XFILLER_214_77 VPWR VGND sg13cmos5l_fill_2
X_2185_ _2185_/X AXIL_S_SOC_WDATA20 AXIL_S_SOC_WDATA24 _2218_/X _2244_/X _0226_/Q
+ _0225_/Q VPWR VGND sg13cmos5l_mux4_1
X_1205_ _1205_/Q Tile_X0Y4_FrameData[17] VGND VPWR Tile_X0Y5_FrameStrobe[5] latch
X_1136_ _1136_/Q Tile_X0Y4_FrameData[22] VGND VPWR Tile_X0Y5_FrameStrobe[3] latch
XANTENNA__0892__D Tile_X0Y3_FrameData[26] VPWR VGND sg13cmos5l_antennanp
XFILLER_225_177 VPWR VGND sg13cmos5l_decap_8
XANTENNA__1088__GATE Tile_X0Y5_FrameStrobe[1] VPWR VGND sg13cmos5l_antennanp
XFILLER_230_76 VPWR VGND sg13cmos5l_decap_4
X_1067_ _1067_/Q Tile_X0Y4_FrameData[27] VGND VPWR Tile_X0Y5_FrameStrobe[1] latch
XANTENNA__1011__GATE Tile_X0Y5_FrameStrobe[6] VPWR VGND sg13cmos5l_antennanp
XFILLER_239_52 VPWR VGND sg13cmos5l_decap_8
XANTENNA__2386__A1 Tile_X0Y3_W2END[5] VPWR VGND sg13cmos5l_antennanp
XFILLER_239_63 VPWR VGND sg13cmos5l_fill_2
X_1969_ Tile_X0Y5_E1BEG[2] _2723_/X VPWR VGND sg13cmos5l_buf_1
XFILLER_111_9 VPWR VGND sg13cmos5l_fill_2
XANTENNA__1228__D Tile_X0Y4_FrameData[26] VPWR VGND sg13cmos5l_antennanp
XANTENNA__0132__D Tile_X0Y0_FrameData[2] VPWR VGND sg13cmos5l_antennanp
XANTENNA__1026__GATE Tile_X0Y5_FrameStrobe[7] VPWR VGND sg13cmos5l_antennanp
XANTENNA__2138__A1 Tile_X0Y5_W2END[1] VPWR VGND sg13cmos5l_antennanp
XFILLER_108_67 VPWR VGND sg13cmos5l_decap_8
XFILLER_161_154 VPWR VGND sg13cmos5l_decap_8
XANTENNA__0282__GATE Tile_X0Y5_FrameStrobe[6] VPWR VGND sg13cmos5l_antennanp
XFILLER_124_22 VPWR VGND sg13cmos5l_decap_8
XFILLER_271_50 VPWR VGND sg13cmos5l_fill_1
XFILLER_75_149 VPWR VGND sg13cmos5l_decap_8
XANTENNA__0297__GATE Tile_X0Y5_FrameStrobe[7] VPWR VGND sg13cmos5l_antennanp
XANTENNA__2310__A1 AXIL_S_SOC_WDATA13 VPWR VGND sg13cmos5l_antennanp
XFILLER_216_133 VPWR VGND sg13cmos5l_fill_2
XFILLER_84_48 VPWR VGND sg13cmos5l_decap_8
XFILLER_83_160 VPWR VGND sg13cmos5l_fill_2
XFILLER_140_10 VPWR VGND sg13cmos5l_fill_1
XFILLER_17_97 VPWR VGND sg13cmos5l_decap_4
XFILLER_216_188 VPWR VGND sg13cmos5l_decap_8
XANTENNA__0220__GATE Tile_X0Y5_FrameStrobe[4] VPWR VGND sg13cmos5l_antennanp
XANTENNA__2613__A2 AXIL_S_SOC_WSTRB1 VPWR VGND sg13cmos5l_antennanp
XFILLER_169_221 VPWR VGND sg13cmos5l_fill_2
XANTENNA__0307__D Tile_X0Y0_FrameData[19] VPWR VGND sg13cmos5l_antennanp
XANTENNA__0850__GATE Tile_X0Y5_FrameStrobe[1] VPWR VGND sg13cmos5l_antennanp
XFILLER_129_107 VPWR VGND sg13cmos5l_decap_8
XFILLER_149_41 VPWR VGND sg13cmos5l_decap_8
XFILLER_33_74 VPWR VGND sg13cmos5l_decap_8
XANTENNA__0235__GATE Tile_X0Y5_FrameStrobe[5] VPWR VGND sg13cmos5l_antennanp
XFILLER_137_151 VPWR VGND sg13cmos5l_fill_1
XANTENNA__0865__GATE Tile_X0Y5_FrameStrobe[2] VPWR VGND sg13cmos5l_antennanp
XANTENNA__1138__D Tile_X0Y4_FrameData[20] VPWR VGND sg13cmos5l_antennanp
XFILLER_137_195 VPWR VGND sg13cmos5l_fill_2
XFILLER_298_103 VPWR VGND sg13cmos5l_fill_1
XANTENNA__2129__A1 Tile_X0Y1_W2END[7] VPWR VGND sg13cmos5l_antennanp
XFILLER_165_62 VPWR VGND sg13cmos5l_fill_2
XFILLER_298_158 VPWR VGND sg13cmos5l_fill_2
XANTENNA__0977__D Tile_X0Y3_FrameData[5] VPWR VGND sg13cmos5l_antennanp
XFILLER_301_107 VPWR VGND sg13cmos5l_decap_8
XFILLER_12_7 VPWR VGND sg13cmos5l_fill_1
XFILLER_181_72 VPWR VGND sg13cmos5l_fill_2
XFILLER_66_138 VPWR VGND sg13cmos5l_decap_8
XFILLER_59_190 VPWR VGND sg13cmos5l_decap_4
XANTENNA__0803__GATE Tile_X0Y5_FrameStrobe[0] VPWR VGND sg13cmos5l_antennanp
XANTENNA__2301__A1 AXIL_S_SOC_WDATA8 VPWR VGND sg13cmos5l_antennanp
XFILLER_207_111 VPWR VGND sg13cmos5l_decap_8
XFILLER_331_53 VPWR VGND sg13cmos5l_decap_8
XFILLER_331_64 VPWR VGND sg13cmos5l_decap_8
XANTENNA__2604__A2 Tile_X0Y5_W6END[4] VPWR VGND sg13cmos5l_antennanp
XFILLER_200_24 VPWR VGND sg13cmos5l_fill_1
XANTENNA__0217__D Tile_X0Y0_FrameData[13] VPWR VGND sg13cmos5l_antennanp
XANTENNA__0818__GATE Tile_X0Y5_FrameStrobe[0] VPWR VGND sg13cmos5l_antennanp
XFILLER_175_202 VPWR VGND sg13cmos5l_fill_2
XFILLER_175_213 VPWR VGND sg13cmos5l_fill_2
X_1823_ Tile_X0Y4_EE4BEG[6] _2639_/X VPWR VGND sg13cmos5l_buf_1
XFILLER_128_173 VPWR VGND sg13cmos5l_fill_1
XFILLER_209_33 VPWR VGND sg13cmos5l_decap_8
X_1754_ Tile_X0Y2_FrameData_O[14] Tile_X0Y2_FrameData[14] VPWR VGND sg13cmos5l_buf_1
XANTENNA__1048__D Tile_X0Y4_FrameData[14] VPWR VGND sg13cmos5l_antennanp
XFILLER_128_195 VPWR VGND sg13cmos5l_decap_8
XFILLER_209_66 VPWR VGND sg13cmos5l_decap_8
XFILLER_209_77 VPWR VGND sg13cmos5l_fill_1
X_0705_ _0705_/Q Tile_X0Y2_FrameData[5] VGND VPWR Tile_X0Y5_FrameStrobe[4] latch
XFILLER_143_154 VPWR VGND sg13cmos5l_decap_8
XFILLER_292_16 VPWR VGND sg13cmos5l_decap_4
X_1685_ Tile_X0Y0_FrameData_O[25] Tile_X0Y0_FrameData[25] VPWR VGND sg13cmos5l_buf_1
XANTENNA__0887__D Tile_X0Y3_FrameData[31] VPWR VGND sg13cmos5l_antennanp
XFILLER_292_49 VPWR VGND sg13cmos5l_fill_2
X_0636_ _0636_/Q Tile_X0Y2_FrameData[10] VGND VPWR Tile_X0Y5_FrameStrobe[2] latch
XANTENNA__1913__X Tile_X0Y1_FrameData_O[26] VPWR VGND sg13cmos5l_antennanp
X_0567_ _0567_/Q Tile_X0Y2_FrameData[15] VGND VPWR Tile_X0Y5_FrameStrobe[0] latch
XANTENNA__2540__A1 AXIL_S_SOC_ARADDR5 VPWR VGND sg13cmos5l_antennanp
XFILLER_225_98 VPWR VGND sg13cmos5l_fill_1
X_2306_ _2306_/X AXIL_S_SOC_WDATA5 AXIL_S_SOC_WDATA13 _2375_/X _2378_/X _0480_/Q _0479_/Q
+ VPWR VGND sg13cmos5l_mux4_1
X_2237_ _2237_/X _2214_/X _0066_/X Tile_X0Y0_S1END[1] Tile_X0Y0_S4END[1] _0116_/Q
+ _0115_/Q VPWR VGND sg13cmos5l_mux4_1
X_0498_ _0498_/Q Tile_X0Y1_FrameData[4] VGND VPWR Tile_X0Y5_FrameStrobe[5] latch
XFILLER_57_149 VPWR VGND sg13cmos5l_decap_8
XFILLER_300_195 VPWR VGND sg13cmos5l_decap_8
X_2168_ _2168_/X AXIL_S_SOC_WDATA19 AXIL_S_SOC_WDATA27 _2244_/X _2245_/X _0260_/Q
+ _0259_/Q VPWR VGND sg13cmos5l_mux4_1
XFILLER_65_182 VPWR VGND sg13cmos5l_fill_1
XFILLER_65_171 VPWR VGND sg13cmos5l_decap_8
XFILLER_213_103 VPWR VGND sg13cmos5l_decap_8
XFILLER_241_97 VPWR VGND sg13cmos5l_decap_8
X_2099_ Tile_X0Y3_E2BEGb[3] _2520_/X VPWR VGND sg13cmos5l_buf_1
X_1119_ _1119_/Q Tile_X0Y4_FrameData[7] VGND VPWR Tile_X0Y5_FrameStrobe[2] latch
XFILLER_80_130 VPWR VGND sg13cmos5l_decap_8
XFILLER_359_129 VPWR VGND sg13cmos5l_decap_8
XANTENNA__0127__D Tile_X0Y0_FrameData[7] VPWR VGND sg13cmos5l_antennanp
XFILLER_70_28 VPWR VGND sg13cmos5l_decap_8
XANTENNA__2359__A1 Tile_X0Y5_WW4END[2] VPWR VGND sg13cmos5l_antennanp
XFILLER_119_184 VPWR VGND sg13cmos5l_decap_8
XFILLER_119_55 VPWR VGND sg13cmos5l_decap_8
XFILLER_323_210 VPWR VGND sg13cmos5l_fill_1
XFILLER_134_143 VPWR VGND sg13cmos5l_fill_2
XFILLER_134_154 VPWR VGND sg13cmos5l_fill_1
XANTENNA__0797__D Tile_X0Y3_FrameData[25] VPWR VGND sg13cmos5l_antennanp
XFILLER_134_176 VPWR VGND sg13cmos5l_fill_2
XFILLER_135_21 VPWR VGND sg13cmos5l_decap_8
XANTENNA__1823__X Tile_X0Y4_EE4BEG[6] VPWR VGND sg13cmos5l_antennanp
XFILLER_0_123 VPWR VGND sg13cmos5l_fill_1
XFILLER_295_117 VPWR VGND sg13cmos5l_decap_8
XANTENNA__2531__A1 AXIL_S_SOC_ARADDR6 VPWR VGND sg13cmos5l_antennanp
XFILLER_0_156 VPWR VGND sg13cmos5l_fill_1
XANTENNA__2295__A0 AXIL_S_SOC_WDATA2 VPWR VGND sg13cmos5l_antennanp
XFILLER_185_2 VPWR VGND sg13cmos5l_fill_1
XFILLER_28_74 VPWR VGND sg13cmos5l_decap_8
XFILLER_63_108 VPWR VGND sg13cmos5l_fill_2
XANTENNA__2834__A2 Tile_X0Y4_W2END[2] VPWR VGND sg13cmos5l_antennanp
XFILLER_151_64 VPWR VGND sg13cmos5l_decap_8
XANTENNA__1421__D Tile_X0Y5_FrameData[3] VPWR VGND sg13cmos5l_antennanp
XFILLER_71_174 VPWR VGND sg13cmos5l_decap_8
XANTENNA__2598__A1 Tile_X0Y5_W2END[7] VPWR VGND sg13cmos5l_antennanp
XFILLER_240_0 VPWR VGND sg13cmos5l_fill_2
XFILLER_44_95 VPWR VGND sg13cmos5l_fill_1
XFILLER_44_84 VPWR VGND sg13cmos5l_decap_8
XFILLER_44_73 VPWR VGND sg13cmos5l_decap_4
XFILLER_338_0 VPWR VGND sg13cmos5l_fill_2
XFILLER_358_173 VPWR VGND sg13cmos5l_decap_4
XANTENNA__0174__GATE Tile_X0Y5_FrameStrobe[3] VPWR VGND sg13cmos5l_antennanp
XFILLER_8_223 VPWR VGND sg13cmos5l_fill_1
XFILLER_172_205 VPWR VGND sg13cmos5l_fill_2
XFILLER_176_50 VPWR VGND sg13cmos5l_decap_8
XANTENNA__2770__A1 Tile_X0Y5_W6END[9] VPWR VGND sg13cmos5l_antennanp
XFILLER_176_94 VPWR VGND sg13cmos5l_decap_8
XANTENNA__0189__GATE Tile_X0Y5_FrameStrobe[3] VPWR VGND sg13cmos5l_antennanp
XFILLER_286_106 VPWR VGND sg13cmos5l_fill_2
X_1470_ _1470_/Q Tile_X0Y5_FrameData[18] VGND VPWR Tile_X0Y5_FrameStrobe[6] latch
XFILLER_5_67 VPWR VGND sg13cmos5l_fill_1
XANTENNA__1733__X Tile_X0Y0_E2BEG[5] VPWR VGND sg13cmos5l_antennanp
XFILLER_140_135 VPWR VGND sg13cmos5l_fill_2
XFILLER_286_128 VPWR VGND sg13cmos5l_decap_8
X_0421_ _0421_/Q Tile_X0Y1_FrameData[17] VGND VPWR Tile_X0Y5_FrameStrobe[3] latch
XANTENNA__0500__D Tile_X0Y1_FrameData[2] VPWR VGND sg13cmos5l_antennanp
XANTENNA__2522__A1 AXIL_S_SOC_ARADDR5 VPWR VGND sg13cmos5l_antennanp
X_0352_ _0352_/Q Tile_X0Y1_FrameData[22] VGND VPWR Tile_X0Y5_FrameStrobe[1] latch
XANTENNA__0112__GATE Tile_X0Y5_FrameStrobe[1] VPWR VGND sg13cmos5l_antennanp
XANTENNA__0742__GATE Tile_X0Y5_FrameStrobe[5] VPWR VGND sg13cmos5l_antennanp
XFILLER_39_138 VPWR VGND sg13cmos5l_decap_4
XFILLER_342_63 VPWR VGND sg13cmos5l_decap_8
X_0283_ _0283_/Q Tile_X0Y0_FrameData[11] VGND VPWR Tile_X0Y5_FrameStrobe[6] latch
XFILLER_342_74 VPWR VGND sg13cmos5l_fill_2
X_2022_ Tile_X0Y5_FrameData_O[7] Tile_X0Y5_FrameData[7] VPWR VGND sg13cmos5l_buf_1
XFILLER_54_119 VPWR VGND sg13cmos5l_decap_8
XANTENNA__0127__GATE Tile_X0Y5_FrameStrobe[1] VPWR VGND sg13cmos5l_antennanp
XANTENNA__1331__D Tile_X0Y5_FrameData[29] VPWR VGND sg13cmos5l_antennanp
XFILLER_211_34 VPWR VGND sg13cmos5l_decap_8
XANTENNA__0757__GATE Tile_X0Y5_FrameStrobe[6] VPWR VGND sg13cmos5l_antennanp
XFILLER_287_49 VPWR VGND sg13cmos5l_decap_4
XFILLER_86_0 VPWR VGND sg13cmos5l_fill_2
XANTENNA__1908__X Tile_X0Y1_FrameData_O[21] VPWR VGND sg13cmos5l_antennanp
X_1806_ Tile_X0Y4_E6BEG[1] _2650_/X VPWR VGND sg13cmos5l_buf_1
X_2786_ _2786_/X _2818_/X _2806_/X _2805_/X _2798_/X _1334_/Q _1333_/Q VPWR VGND sg13cmos5l_mux4_1
X_1737_ Tile_X0Y0_E1BEG[1] _2162_/X VPWR VGND sg13cmos5l_buf_1
XFILLER_116_176 VPWR VGND sg13cmos5l_decap_8
X_1668_ Tile_X0Y0_FrameData_O[8] Tile_X0Y0_FrameData[8] VPWR VGND sg13cmos5l_buf_1
XFILLER_131_146 VPWR VGND sg13cmos5l_decap_4
X_0619_ _0619_/Q Tile_X0Y2_FrameData[27] VGND VPWR Tile_X0Y5_FrameStrobe[2] latch
XANTENNA__0410__D Tile_X0Y1_FrameData[28] VPWR VGND sg13cmos5l_antennanp
XANTENNA__1643__X Tile_X0Y0_FrameStrobe_O[3] VPWR VGND sg13cmos5l_antennanp
XANTENNA__2513__A1 AXIL_S_SOC_ARADDR4 VPWR VGND sg13cmos5l_antennanp
X_1599_ Tile_X0Y2_EE4BEG[12] _2429_/X VPWR VGND sg13cmos5l_buf_1
XFILLER_105_68 VPWR VGND sg13cmos5l_decap_8
XFILLER_252_63 VPWR VGND sg13cmos5l_fill_1
XFILLER_252_85 VPWR VGND sg13cmos5l_fill_2
XANTENNA__2277__A0 Tile_X0Y2_W1END[1] VPWR VGND sg13cmos5l_antennanp
XANTENNA__1241__D Tile_X0Y4_FrameData[13] VPWR VGND sg13cmos5l_antennanp
XFILLER_121_12 VPWR VGND sg13cmos5l_decap_4
XFILLER_53_141 VPWR VGND sg13cmos5l_fill_1
XANTENNA__2292__A3 AXIL_S_SOC_WDATA4 VPWR VGND sg13cmos5l_antennanp
XFILLER_121_56 VPWR VGND sg13cmos5l_decap_8
XFILLER_157_6 VPWR VGND sg13cmos5l_decap_4
XFILLER_81_27 VPWR VGND sg13cmos5l_decap_8
XFILLER_198_157 VPWR VGND sg13cmos5l_decap_8
XFILLER_201_128 VPWR VGND sg13cmos5l_decap_4
XFILLER_355_121 VPWR VGND sg13cmos5l_decap_8
XANTENNA__1818__X Tile_X0Y4_EE4BEG[1] VPWR VGND sg13cmos5l_antennanp
XANTENNA__2201__A0 AXIL_S_SOC_WDATA20 VPWR VGND sg13cmos5l_antennanp
XFILLER_107_121 VPWR VGND sg13cmos5l_decap_8
XANTENNA__2752__A1 AXIL_S_SOC_ARPROT2 VPWR VGND sg13cmos5l_antennanp
XFILLER_146_20 VPWR VGND sg13cmos5l_decap_8
XFILLER_293_70 VPWR VGND sg13cmos5l_decap_8
XFILLER_30_97 VPWR VGND sg13cmos5l_decap_4
XANTENNA__1416__D Tile_X0Y5_FrameData[8] VPWR VGND sg13cmos5l_antennanp
XFILLER_122_124 VPWR VGND sg13cmos5l_fill_1
XFILLER_146_97 VPWR VGND sg13cmos5l_decap_8
XANTENNA__0320__D Tile_X0Y1_FrameData[22] VPWR VGND sg13cmos5l_antennanp
XANTENNA__1553__X Tile_X0Y3_EE4BEG[15] VPWR VGND sg13cmos5l_antennanp
XANTENNA__2504__A1 Tile_X0Y4_W2END[0] VPWR VGND sg13cmos5l_antennanp
XFILLER_190_0 VPWR VGND sg13cmos5l_fill_2
XFILLER_76_222 VPWR VGND sg13cmos5l_fill_2
XFILLER_39_84 VPWR VGND sg13cmos5l_decap_8
XANTENNA__1472__GATE Tile_X0Y5_FrameStrobe[6] VPWR VGND sg13cmos5l_antennanp
XFILLER_288_0 VPWR VGND sg13cmos5l_fill_1
XANTENNA__2807__A2 Tile_X0Y1_WW4END[13] VPWR VGND sg13cmos5l_antennanp
XFILLER_91_214 VPWR VGND sg13cmos5l_fill_1
XFILLER_312_33 VPWR VGND sg13cmos5l_fill_1
XANTENNA__1151__D Tile_X0Y4_FrameData[7] VPWR VGND sg13cmos5l_antennanp
XFILLER_291_197 VPWR VGND sg13cmos5l_decap_8
XFILLER_312_66 VPWR VGND sg13cmos5l_decap_8
XFILLER_29_182 VPWR VGND sg13cmos5l_fill_2
XANTENNA__2283__A3 Tile_X0Y3_W6END[10] VPWR VGND sg13cmos5l_antennanp
XANTENNA__0990__D Tile_X0Y3_FrameData[24] VPWR VGND sg13cmos5l_antennanp
XANTENNA__1487__GATE Tile_X0Y5_FrameStrobe[6] VPWR VGND sg13cmos5l_antennanp
XFILLER_44_185 VPWR VGND sg13cmos5l_fill_1
X_0970_ _0970_/Q Tile_X0Y3_FrameData[12] VGND VPWR Tile_X0Y5_FrameStrobe[5] latch
XANTENNA__2440__A0 AXIL_S_SOC_AWADDR7 VPWR VGND sg13cmos5l_antennanp
XFILLER_200_150 VPWR VGND sg13cmos5l_decap_8
XFILLER_346_110 VPWR VGND sg13cmos5l_decap_8
XANTENNA__1410__GATE Tile_X0Y5_FrameStrobe[4] VPWR VGND sg13cmos5l_antennanp
XANTENNA__1728__X Tile_X0Y0_E2BEG[0] VPWR VGND sg13cmos5l_antennanp
X_2640_ _2640_/X AXIL_S_SOC_WSTRB1 AXIL_S_SOC_BREADY _2697_/X _2708_/X _1174_/Q _1173_/Q
+ VPWR VGND sg13cmos5l_mux4_1
XFILLER_346_154 VPWR VGND sg13cmos5l_decap_8
X_2571_ _2571_/X Tile_X0Y2_W1END[3] Tile_X0Y2_W6END[11] _2465_/X _2456_/X _0652_/Q
+ _0651_/Q VPWR VGND sg13cmos5l_mux4_1
XANTENNA__2743__A1 AXIL_S_SOC_RREADY VPWR VGND sg13cmos5l_antennanp
XFILLER_273_18 VPWR VGND sg13cmos5l_decap_8
X_1522_ Tile_X0Y3_E2BEGb[4] _2521_/X VPWR VGND sg13cmos5l_buf_1
XFILLER_337_96 VPWR VGND sg13cmos5l_decap_4
XANTENNA__1326__D Tile_X0Y5_FrameData[2] VPWR VGND sg13cmos5l_antennanp
XANTENNA__1425__GATE Tile_X0Y5_FrameStrobe[5] VPWR VGND sg13cmos5l_antennanp
XFILLER_259_139 VPWR VGND sg13cmos5l_decap_4
X_1453_ _1453_/Q Tile_X0Y5_FrameData[3] VGND VPWR Tile_X0Y5_FrameStrobe[5] latch
XANTENNA__0230__D Tile_X0Y0_FrameData[0] VPWR VGND sg13cmos5l_antennanp
XANTENNA__1904__A Tile_X0Y1_FrameData[17] VPWR VGND sg13cmos5l_antennanp
XFILLER_206_56 VPWR VGND sg13cmos5l_decap_8
X_0404_ _0404_/Q Tile_X0Y1_FrameData[2] VGND VPWR Tile_X0Y5_FrameStrobe[2] latch
XFILLER_353_62 VPWR VGND sg13cmos5l_decap_8
XFILLER_353_40 VPWR VGND sg13cmos5l_decap_8
XANTENNA__0681__GATE Tile_X0Y5_FrameStrobe[4] VPWR VGND sg13cmos5l_antennanp
X_1384_ _1384_/Q Tile_X0Y5_FrameData[8] VGND VPWR Tile_X0Y5_FrameStrobe[3] latch
XFILLER_67_222 VPWR VGND sg13cmos5l_fill_2
XFILLER_222_11 VPWR VGND sg13cmos5l_decap_8
X_0335_ _0335_/Q Tile_X0Y1_FrameData[7] VGND VPWR Tile_X0Y5_FrameStrobe[0] latch
XANTENNA__2259__A0 Tile_X0Y2_W2MID[2] VPWR VGND sg13cmos5l_antennanp
X_0266_ _0266_/Q Tile_X0Y0_FrameData[28] VGND VPWR Tile_X0Y5_FrameStrobe[6] latch
XANTENNA__0696__GATE Tile_X0Y5_FrameStrobe[4] VPWR VGND sg13cmos5l_antennanp
XANTENNA__1061__D Tile_X0Y4_FrameData[1] VPWR VGND sg13cmos5l_antennanp
XFILLER_222_77 VPWR VGND sg13cmos5l_fill_2
X_2005_ Tile_X0Y5_EE4BEG[6] _2747_/X VPWR VGND sg13cmos5l_buf_1
X_0197_ _0197_/Q Tile_X0Y0_FrameData[1] VGND VPWR Tile_X0Y5_FrameStrobe[3] latch
XFILLER_298_26 VPWR VGND sg13cmos5l_decap_8
XANTENNA__2431__A0 AXIL_S_SOC_AWADDR0 VPWR VGND sg13cmos5l_antennanp
XANTENNA__0405__D Tile_X0Y1_FrameData[1] VPWR VGND sg13cmos5l_antennanp
XANTENNA__1638__X Tile_X0Y0_N1BEG[2] VPWR VGND sg13cmos5l_antennanp
XANTENNA__0634__GATE Tile_X0Y5_FrameStrobe[2] VPWR VGND sg13cmos5l_antennanp
XFILLER_247_63 VPWR VGND sg13cmos5l_decap_8
X_2769_ _2769_/X Tile_X0Y5_W1END[0] Tile_X0Y5_W6END[8] _2813_/X _2789_/X _1364_/Q
+ _1363_/Q VPWR VGND sg13cmos5l_mux4_1
XANTENNA__2734__A1 AXIL_S_SOC_RREADY VPWR VGND sg13cmos5l_antennanp
XFILLER_183_29 VPWR VGND sg13cmos5l_fill_2
XANTENNA__1236__D Tile_X0Y4_FrameData[18] VPWR VGND sg13cmos5l_antennanp
XANTENNA__0140__D Tile_X0Y0_FrameData[26] VPWR VGND sg13cmos5l_antennanp
XANTENNA__0649__GATE Tile_X0Y5_FrameStrobe[3] VPWR VGND sg13cmos5l_antennanp
XANTENNA__2498__A0 Tile_X0Y4_W2MID[3] VPWR VGND sg13cmos5l_antennanp
XFILLER_104_157 VPWR VGND sg13cmos5l_decap_8
XFILLER_116_56 VPWR VGND sg13cmos5l_fill_1
XFILLER_258_150 VPWR VGND sg13cmos5l_decap_8
XFILLER_273_142 VPWR VGND sg13cmos5l_decap_8
XFILLER_274_6 VPWR VGND sg13cmos5l_decap_4
XANTENNA__2265__A3 Tile_X0Y1_W6END[11] VPWR VGND sg13cmos5l_antennanp
XFILLER_25_20 VPWR VGND sg13cmos5l_fill_1
XFILLER_92_48 VPWR VGND sg13cmos5l_decap_8
XFILLER_41_122 VPWR VGND sg13cmos5l_decap_8
XFILLER_186_105 VPWR VGND sg13cmos5l_decap_8
XFILLER_41_133 VPWR VGND sg13cmos5l_fill_2
XFILLER_358_29 VPWR VGND sg13cmos5l_decap_4
XANTENNA__2422__A0 AXIL_S_SOC_AWADDR5 VPWR VGND sg13cmos5l_antennanp
XFILLER_288_81 VPWR VGND sg13cmos5l_decap_8
XANTENNA__0315__D Tile_X0Y1_FrameData[27] VPWR VGND sg13cmos5l_antennanp
XANTENNA__1548__X Tile_X0Y3_EE4BEG[10] VPWR VGND sg13cmos5l_antennanp
XFILLER_328_154 VPWR VGND sg13cmos5l_fill_2
XFILLER_203_0 VPWR VGND sg13cmos5l_fill_1
XANTENNA__2725__A1 AXIL_S_SOC_ARVALID VPWR VGND sg13cmos5l_antennanp
XFILLER_307_44 VPWR VGND sg13cmos5l_fill_2
XFILLER_307_22 VPWR VGND sg13cmos5l_fill_1
XANTENNA__1146__D Tile_X0Y4_FrameData[12] VPWR VGND sg13cmos5l_antennanp
XFILLER_173_62 VPWR VGND sg13cmos5l_decap_8
XFILLER_307_99 VPWR VGND sg13cmos5l_fill_1
XANTENNA__2489__A0 Tile_X0Y1_W2MID[7] VPWR VGND sg13cmos5l_antennanp
XFILLER_110_138 VPWR VGND sg13cmos5l_decap_8
XANTENNA__0985__D Tile_X0Y3_FrameData[29] VPWR VGND sg13cmos5l_antennanp
XFILLER_249_183 VPWR VGND sg13cmos5l_decap_8
X_0120_ _0120_/Q Tile_X0Y0_FrameData[14] VGND VPWR Tile_X0Y5_FrameStrobe[1] latch
X_0051_ _1607_/A _2281_/X _2282_/X _0995_/Q VPWR VGND sg13cmos5l_mux2_1
XANTENNA__2661__A0 Tile_X0Y4_W1END[0] VPWR VGND sg13cmos5l_antennanp
XFILLER_220_223 VPWR VGND sg13cmos5l_fill_1
XANTENNA__2413__A0 AXIL_S_SOC_AWADDR4 VPWR VGND sg13cmos5l_antennanp
XANTENNA__0225__D Tile_X0Y0_FrameData[5] VPWR VGND sg13cmos5l_antennanp
X_0953_ _0953_/Q Tile_X0Y3_FrameData[29] VGND VPWR Tile_X0Y5_FrameStrobe[5] latch
XFILLER_185_182 VPWR VGND sg13cmos5l_decap_8
X_0884_ _0884_/Q Tile_X0Y3_FrameData[2] VGND VPWR Tile_X0Y5_FrameStrobe[2] latch
XFILLER_348_95 VPWR VGND sg13cmos5l_decap_8
XFILLER_284_17 VPWR VGND sg13cmos5l_decap_8
X_2623_ _2623_/X AXIL_S_SOC_WSTRB0 AXIL_S_SOC_WSTRB2 _2709_/X _2682_/X _1208_/Q _1207_/Q
+ VPWR VGND sg13cmos5l_mux4_1
XANTENNA__1364__GATE Tile_X0Y5_FrameStrobe[3] VPWR VGND sg13cmos5l_antennanp
XANTENNA__2716__A1 Tile_X0Y3_W2END[4] VPWR VGND sg13cmos5l_antennanp
X_2554_ _2554_/X _2588_/X _2587_/X _2580_/X _2579_/X _0874_/Q _0873_/Q VPWR VGND sg13cmos5l_mux4_1
XFILLER_217_66 VPWR VGND sg13cmos5l_fill_2
X_1505_ _2671_/A3 VPWR VGND sg13cmos5l_tielo
XFILLER_99_133 VPWR VGND sg13cmos5l_decap_8
XANTENNA__1056__D Tile_X0Y4_FrameData[6] VPWR VGND sg13cmos5l_antennanp
X_2485_ _2485_/X _2390_/X _2498_/X _2497_/X _2389_/X _0566_/Q _0565_/Q VPWR VGND sg13cmos5l_mux4_1
XFILLER_99_166 VPWR VGND sg13cmos5l_decap_8
XANTENNA__1379__GATE Tile_X0Y5_FrameStrobe[3] VPWR VGND sg13cmos5l_antennanp
XFILLER_101_138 VPWR VGND sg13cmos5l_decap_8
X_1436_ _1436_/Q Tile_X0Y5_FrameData[20] VGND VPWR Tile_X0Y5_FrameStrobe[5] latch
XANTENNA__0895__D Tile_X0Y3_FrameData[23] VPWR VGND sg13cmos5l_antennanp
X_1367_ _1367_/Q Tile_X0Y5_FrameData[25] VGND VPWR Tile_X0Y5_FrameStrobe[3] latch
XANTENNA__1921__X Tile_X0Y1_EE4BEG[2] VPWR VGND sg13cmos5l_antennanp
XFILLER_255_153 VPWR VGND sg13cmos5l_decap_8
X_0318_ _0318_/Q Tile_X0Y1_FrameData[24] VGND VPWR Tile_X0Y5_FrameStrobe[0] latch
XANTENNA__1302__GATE Tile_X0Y5_FrameStrobe[1] VPWR VGND sg13cmos5l_antennanp
X_1298_ _1298_/Q Tile_X0Y5_FrameData[30] VGND VPWR Tile_X0Y5_FrameStrobe[1] latch
XANTENNA__2247__A3 Tile_X0Y0_S2END[6] VPWR VGND sg13cmos5l_antennanp
X_0249_ _0249_/Q Tile_X0Y0_FrameData[13] VGND VPWR Tile_X0Y5_FrameStrobe[5] latch
XANTENNA__2652__A0 Tile_X0Y5_N4END[7] VPWR VGND sg13cmos5l_antennanp
XFILLER_270_178 VPWR VGND sg13cmos5l_decap_8
XFILLER_211_223 VPWR VGND sg13cmos5l_fill_1
XANTENNA__1317__GATE Tile_X0Y5_FrameStrobe[1] VPWR VGND sg13cmos5l_antennanp
XANTENNA__2404__A0 AXIL_S_SOC_AWADDR3 VPWR VGND sg13cmos5l_antennanp
XANTENNA__0135__D Tile_X0Y0_FrameData[31] VPWR VGND sg13cmos5l_antennanp
XANTENNA__0573__GATE Tile_X0Y5_FrameStrobe[0] VPWR VGND sg13cmos5l_antennanp
XFILLER_194_39 VPWR VGND sg13cmos5l_decap_8
XANTENNA__2707__A1 Tile_X0Y5_N4END[4] VPWR VGND sg13cmos5l_antennanp
XANTENNA__0588__GATE Tile_X0Y5_FrameStrobe[1] VPWR VGND sg13cmos5l_antennanp
XFILLER_278_223 VPWR VGND sg13cmos5l_fill_1
XFILLER_143_43 VPWR VGND sg13cmos5l_decap_8
XANTENNA__0511__GATE Tile_X0Y5_FrameStrobe[6] VPWR VGND sg13cmos5l_antennanp
XANTENNA__1831__X Tile_X0Y4_EE4BEG[14] VPWR VGND sg13cmos5l_antennanp
XFILLER_290_71 VPWR VGND sg13cmos5l_decap_8
XFILLER_290_82 VPWR VGND sg13cmos5l_fill_2
XANTENNA__2238__A3 Tile_X0Y0_S4END[1] VPWR VGND sg13cmos5l_antennanp
XANTENNA__0526__GATE Tile_X0Y5_FrameStrobe[6] VPWR VGND sg13cmos5l_antennanp
XANTENNA__2643__A0 AXIL_S_SOC_WSTRB0 VPWR VGND sg13cmos5l_antennanp
XFILLER_153_0 VPWR VGND sg13cmos5l_fill_2
XFILLER_202_223 VPWR VGND sg13cmos5l_fill_1
XFILLER_261_189 VPWR VGND sg13cmos5l_fill_2
XFILLER_320_0 VPWR VGND sg13cmos5l_fill_1
XFILLER_167_160 VPWR VGND sg13cmos5l_decap_8
XFILLER_168_62 VPWR VGND sg13cmos5l_fill_2
XFILLER_182_174 VPWR VGND sg13cmos5l_fill_1
XFILLER_318_87 VPWR VGND sg13cmos5l_decap_8
XFILLER_331_116 VPWR VGND sg13cmos5l_decap_8
XFILLER_184_83 VPWR VGND sg13cmos5l_decap_8
XFILLER_269_223 VPWR VGND sg13cmos5l_fill_1
X_2270_ _2270_/X _2370_/X _2369_/X _2358_/X _2357_/X _0523_/Q _0522_/Q VPWR VGND sg13cmos5l_mux4_1
XFILLER_334_64 VPWR VGND sg13cmos5l_decap_8
X_1221_ _1221_/Q Tile_X0Y4_FrameData[1] VGND VPWR Tile_X0Y5_FrameStrobe[5] latch
XFILLER_96_169 VPWR VGND sg13cmos5l_decap_8
XFILLER_77_70 VPWR VGND sg13cmos5l_decap_8
XANTENNA__1741__X Tile_X0Y2_FrameData_O[1] VPWR VGND sg13cmos5l_antennanp
XANTENNA__2477__A3 Tile_X0Y0_S4END[9] VPWR VGND sg13cmos5l_antennanp
X_1152_ _1152_/Q Tile_X0Y4_FrameData[6] VGND VPWR Tile_X0Y5_FrameStrobe[3] latch
XFILLER_350_41 VPWR VGND sg13cmos5l_decap_8
XANTENNA__2229__A3 Tile_X0Y0_S4END[0] VPWR VGND sg13cmos5l_antennanp
XFILLER_203_68 VPWR VGND sg13cmos5l_decap_4
XFILLER_237_197 VPWR VGND sg13cmos5l_fill_1
XFILLER_252_134 VPWR VGND sg13cmos5l_fill_2
X_1083_ _1083_/Q Tile_X0Y4_FrameData[11] VGND VPWR Tile_X0Y5_FrameStrobe[1] latch
X_0103_ _0103_/Q Tile_X0Y0_FrameData[31] VGND VPWR Tile_X0Y5_FrameStrobe[1] latch
XANTENNA__2634__A0 Tile_X0Y4_WW4END[5] VPWR VGND sg13cmos5l_antennanp
X_0034_ _1617_/A _2155_/X _2156_/X _0281_/Q VPWR VGND sg13cmos5l_mux2_1
XFILLER_279_39 VPWR VGND sg13cmos5l_fill_1
XFILLER_359_50 VPWR VGND sg13cmos5l_decap_8
XFILLER_20_136 VPWR VGND sg13cmos5l_fill_2
X_1985_ Tile_X0Y5_E2BEGb[6] _2739_/X VPWR VGND sg13cmos5l_buf_1
X_0936_ _0936_/Q Tile_X0Y3_FrameData[14] VGND VPWR Tile_X0Y5_FrameStrobe[4] latch
XFILLER_158_193 VPWR VGND sg13cmos5l_fill_2
XFILLER_173_130 VPWR VGND sg13cmos5l_decap_8
XANTENNA__1916__X Tile_X0Y1_FrameData_O[29] VPWR VGND sg13cmos5l_antennanp
XFILLER_173_163 VPWR VGND sg13cmos5l_decap_8
X_2606_ _2606_/X Tile_X0Y5_W2MID[3] Tile_X0Y5_W2END[3] Tile_X0Y5_W6END[3] _2800_/X
+ _1480_/Q _1479_/Q VPWR VGND sg13cmos5l_mux4_1
X_0867_ _0867_/Q Tile_X0Y3_FrameData[19] VGND VPWR Tile_X0Y5_FrameStrobe[2] latch
XFILLER_228_87 VPWR VGND sg13cmos5l_decap_8
X_0798_ _0798_/Q Tile_X0Y3_FrameData[24] VGND VPWR Tile_X0Y5_FrameStrobe[0] latch
XFILLER_244_20 VPWR VGND sg13cmos5l_fill_1
X_2537_ _2537_/X AXIL_S_SOC_ARADDR0 AXIL_S_SOC_ARADDR2 _2583_/X _2592_/X _0930_/Q
+ _0929_/Q VPWR VGND sg13cmos5l_mux4_1
XFILLER_275_204 VPWR VGND sg13cmos5l_decap_8
X_2468_ _2468_/X _2462_/X Tile_X0Y5_N4END[14] _2461_/X Tile_X0Y0_S4END[10] _0586_/Q
+ _0585_/Q VPWR VGND sg13cmos5l_mux4_1
XFILLER_87_136 VPWR VGND sg13cmos5l_decap_8
XFILLER_330_160 VPWR VGND sg13cmos5l_decap_8
X_1419_ _1419_/Q Tile_X0Y5_FrameData[5] VGND VPWR Tile_X0Y5_FrameStrobe[4] latch
XANTENNA__1241__GATE Tile_X0Y5_FrameStrobe[6] VPWR VGND sg13cmos5l_antennanp
XANTENNA__1651__X Tile_X0Y0_FrameStrobe_O[11] VPWR VGND sg13cmos5l_antennanp
XANTENNA__2468__A3 Tile_X0Y0_S4END[10] VPWR VGND sg13cmos5l_antennanp
XFILLER_113_13 VPWR VGND sg13cmos5l_fill_2
XFILLER_28_214 VPWR VGND sg13cmos5l_fill_1
X_2399_ _2399_/X _2462_/X _2461_/X AXIL_S_SOC_AWADDR0 AXIL_S_SOC_AWADDR5 _0750_/Q
+ _0749_/Q VPWR VGND sg13cmos5l_mux4_1
XANTENNA__2625__A0 AXIL_S_SOC_WSTRB0 VPWR VGND sg13cmos5l_antennanp
XFILLER_189_28 VPWR VGND sg13cmos5l_decap_8
XFILLER_243_178 VPWR VGND sg13cmos5l_fill_1
XFILLER_260_96 VPWR VGND sg13cmos5l_fill_1
XANTENNA__1256__GATE Tile_X0Y5_FrameStrobe[7] VPWR VGND sg13cmos5l_antennanp
XFILLER_269_72 VPWR VGND sg13cmos5l_decap_8
XFILLER_156_119 VPWR VGND sg13cmos5l_decap_8
XANTENNA__1826__X Tile_X0Y4_EE4BEG[9] VPWR VGND sg13cmos5l_antennanp
XFILLER_22_98 VPWR VGND sg13cmos5l_decap_4
XFILLER_355_19 VPWR VGND sg13cmos5l_decap_8
XFILLER_164_185 VPWR VGND sg13cmos5l_decap_8
XFILLER_98_69 VPWR VGND sg13cmos5l_decap_8
XANTENNA__0450__GATE Tile_X0Y5_FrameStrobe[4] VPWR VGND sg13cmos5l_antennanp
XFILLER_154_97 VPWR VGND sg13cmos5l_decap_8
XFILLER_304_12 VPWR VGND sg13cmos5l_fill_1
XANTENNA__1209__GATE Tile_X0Y5_FrameStrobe[5] VPWR VGND sg13cmos5l_antennanp
XANTENNA__1424__D Tile_X0Y5_FrameData[0] VPWR VGND sg13cmos5l_antennanp
XANTENNA__1561__X Tile_X0Y3_FrameData_O[7] VPWR VGND sg13cmos5l_antennanp
XFILLER_219_142 VPWR VGND sg13cmos5l_fill_1
XFILLER_93_106 VPWR VGND sg13cmos5l_decap_8
XFILLER_270_0 VPWR VGND sg13cmos5l_decap_8
XFILLER_47_73 VPWR VGND sg13cmos5l_decap_8
XANTENNA__0465__GATE Tile_X0Y5_FrameStrobe[4] VPWR VGND sg13cmos5l_antennanp
XFILLER_170_74 VPWR VGND sg13cmos5l_fill_2
XFILLER_219_186 VPWR VGND sg13cmos5l_decap_8
XFILLER_219_197 VPWR VGND sg13cmos5l_fill_2
XFILLER_47_84 VPWR VGND sg13cmos5l_fill_1
XFILLER_234_167 VPWR VGND sg13cmos5l_decap_8
XFILLER_34_217 VPWR VGND sg13cmos5l_fill_1
XFILLER_103_90 VPWR VGND sg13cmos5l_fill_2
XFILLER_187_222 VPWR VGND sg13cmos5l_fill_2
XFILLER_8_23 VPWR VGND sg13cmos5l_fill_2
X_1770_ Tile_X0Y2_FrameData_O[30] Tile_X0Y2_FrameData[30] VPWR VGND sg13cmos5l_buf_1
XFILLER_8_67 VPWR VGND sg13cmos5l_fill_2
XANTENNA__2395__A2 Tile_X0Y0_W2END[0] VPWR VGND sg13cmos5l_antennanp
X_0721_ _0721_/Q Tile_X0Y2_FrameData[21] VGND VPWR Tile_X0Y5_FrameStrobe[5] latch
XFILLER_329_75 VPWR VGND sg13cmos5l_decap_8
XANTENNA__0403__GATE Tile_X0Y5_FrameStrobe[2] VPWR VGND sg13cmos5l_antennanp
XANTENNA__0503__D Tile_X0Y1_FrameData[31] VPWR VGND sg13cmos5l_antennanp
XANTENNA__1736__X Tile_X0Y0_E1BEG[0] VPWR VGND sg13cmos5l_antennanp
XFILLER_155_174 VPWR VGND sg13cmos5l_decap_8
XFILLER_195_60 VPWR VGND sg13cmos5l_fill_2
XFILLER_170_111 VPWR VGND sg13cmos5l_decap_8
XFILLER_170_133 VPWR VGND sg13cmos5l_decap_8
X_0652_ _0652_/Q Tile_X0Y2_FrameData[26] VGND VPWR Tile_X0Y5_FrameStrobe[3] latch
XFILLER_304_127 VPWR VGND sg13cmos5l_fill_1
XANTENNA__2147__A2 Tile_X0Y0_W6END[5] VPWR VGND sg13cmos5l_antennanp
X_0583_ _0583_/Q Tile_X0Y2_FrameData[31] VGND VPWR Tile_X0Y5_FrameStrobe[1] latch
XANTENNA__0418__GATE Tile_X0Y5_FrameStrobe[3] VPWR VGND sg13cmos5l_antennanp
XANTENNA__2698__A3 Tile_X0Y0_W6END[7] VPWR VGND sg13cmos5l_antennanp
XFILLER_170_177 VPWR VGND sg13cmos5l_decap_8
XFILLER_281_29 VPWR VGND sg13cmos5l_fill_1
X_2322_ _2322_/X AXIL_S_SOC_WDATA1 AXIL_S_SOC_WDATA13 _2368_/X _2375_/X _0448_/Q _0447_/Q
+ VPWR VGND sg13cmos5l_mux4_1
XFILLER_88_91 VPWR VGND sg13cmos5l_decap_8
XFILLER_345_85 VPWR VGND sg13cmos5l_fill_1
XFILLER_69_136 VPWR VGND sg13cmos5l_decap_8
XANTENNA__1334__D Tile_X0Y5_FrameData[26] VPWR VGND sg13cmos5l_antennanp
XANTENNA__1912__A Tile_X0Y1_FrameData[25] VPWR VGND sg13cmos5l_antennanp
XFILLER_214_56 VPWR VGND sg13cmos5l_decap_8
X_2253_ _2253_/X Tile_X0Y2_W2MID[5] Tile_X0Y2_W2END[5] Tile_X0Y2_W6END[5] _2483_/X
+ _0778_/Q _0777_/Q VPWR VGND sg13cmos5l_mux4_1
X_2184_ _2184_/X AXIL_S_SOC_WDATA19 AXIL_S_SOC_WDATA31 _2229_/X _2245_/X _0228_/Q
+ _0227_/Q VPWR VGND sg13cmos5l_mux4_1
X_1204_ _1204_/Q Tile_X0Y4_FrameData[18] VGND VPWR Tile_X0Y5_FrameStrobe[5] latch
XFILLER_77_191 VPWR VGND sg13cmos5l_fill_2
X_1135_ _1135_/Q Tile_X0Y4_FrameData[23] VGND VPWR Tile_X0Y5_FrameStrobe[3] latch
XANTENNA__2607__A0 Tile_X0Y2_W1END[1] VPWR VGND sg13cmos5l_antennanp
XFILLER_225_156 VPWR VGND sg13cmos5l_decap_8
XFILLER_230_22 VPWR VGND sg13cmos5l_decap_4
XFILLER_230_33 VPWR VGND sg13cmos5l_fill_2
XFILLER_92_194 VPWR VGND sg13cmos5l_fill_1
XFILLER_240_126 VPWR VGND sg13cmos5l_decap_4
X_1066_ _1066_/Q Tile_X0Y4_FrameData[28] VGND VPWR Tile_X0Y5_FrameStrobe[1] latch
XFILLER_138_108 VPWR VGND sg13cmos5l_fill_2
XANTENNA__2386__A2 Tile_X0Y3_W6END[5] VPWR VGND sg13cmos5l_antennanp
XFILLER_239_75 VPWR VGND sg13cmos5l_decap_4
X_1968_ Tile_X0Y5_E1BEG[1] _2722_/X VPWR VGND sg13cmos5l_buf_1
XANTENNA__0413__D Tile_X0Y1_FrameData[25] VPWR VGND sg13cmos5l_antennanp
XANTENNA__1646__X Tile_X0Y0_FrameStrobe_O[6] VPWR VGND sg13cmos5l_antennanp
XFILLER_146_163 VPWR VGND sg13cmos5l_decap_8
XFILLER_146_174 VPWR VGND sg13cmos5l_fill_2
XFILLER_239_97 VPWR VGND sg13cmos5l_decap_8
X_1899_ Tile_X0Y1_FrameData_O[12] Tile_X0Y1_FrameData[12] VPWR VGND sg13cmos5l_buf_1
X_0919_ _0919_/Q Tile_X0Y3_FrameData[31] VGND VPWR Tile_X0Y5_FrameStrobe[4] latch
XFILLER_161_133 VPWR VGND sg13cmos5l_decap_8
XFILLER_350_222 VPWR VGND sg13cmos5l_fill_2
XANTENNA__2138__A2 Tile_X0Y5_W6END[1] VPWR VGND sg13cmos5l_antennanp
XFILLER_255_41 VPWR VGND sg13cmos5l_fill_1
XFILLER_255_52 VPWR VGND sg13cmos5l_decap_4
XFILLER_303_171 VPWR VGND sg13cmos5l_fill_1
XANTENNA__1180__GATE Tile_X0Y5_FrameStrobe[4] VPWR VGND sg13cmos5l_antennanp
XANTENNA__1244__D Tile_X0Y4_FrameData[10] VPWR VGND sg13cmos5l_antennanp
XFILLER_194_7 VPWR VGND sg13cmos5l_decap_8
XFILLER_124_89 VPWR VGND sg13cmos5l_decap_8
XFILLER_216_101 VPWR VGND sg13cmos5l_decap_4
XFILLER_84_27 VPWR VGND sg13cmos5l_decap_8
XFILLER_68_191 VPWR VGND sg13cmos5l_fill_1
XFILLER_90_109 VPWR VGND sg13cmos5l_decap_8
XANTENNA__1195__GATE Tile_X0Y5_FrameStrobe[5] VPWR VGND sg13cmos5l_antennanp
XFILLER_17_54 VPWR VGND sg13cmos5l_fill_2
XFILLER_17_65 VPWR VGND sg13cmos5l_decap_4
XFILLER_216_156 VPWR VGND sg13cmos5l_decap_8
XANTENNA__2613__A3 AXIL_S_SOC_WSTRB2 VPWR VGND sg13cmos5l_antennanp
XFILLER_140_88 VPWR VGND sg13cmos5l_decap_4
XFILLER_149_20 VPWR VGND sg13cmos5l_decap_8
XFILLER_137_130 VPWR VGND sg13cmos5l_fill_1
XANTENNA__0323__D Tile_X0Y1_FrameData[19] VPWR VGND sg13cmos5l_antennanp
XANTENNA__1419__D Tile_X0Y5_FrameData[5] VPWR VGND sg13cmos5l_antennanp
XANTENNA__1556__X Tile_X0Y3_FrameData_O[2] VPWR VGND sg13cmos5l_antennanp
XANTENNA__1133__GATE Tile_X0Y5_FrameStrobe[3] VPWR VGND sg13cmos5l_antennanp
XANTENNA__2129__A2 Tile_X0Y1_W6END[7] VPWR VGND sg13cmos5l_antennanp
XFILLER_165_52 VPWR VGND sg13cmos5l_fill_2
XFILLER_152_188 VPWR VGND sg13cmos5l_decap_8
XFILLER_3_187 VPWR VGND sg13cmos5l_fill_1
XFILLER_315_33 VPWR VGND sg13cmos5l_decap_8
XANTENNA__1148__GATE Tile_X0Y5_FrameStrobe[3] VPWR VGND sg13cmos5l_antennanp
XANTENNA__1154__D Tile_X0Y4_FrameData[4] VPWR VGND sg13cmos5l_antennanp
XFILLER_181_51 VPWR VGND sg13cmos5l_decap_8
XFILLER_181_84 VPWR VGND sg13cmos5l_decap_8
XANTENNA__0993__D Tile_X0Y3_FrameData[21] VPWR VGND sg13cmos5l_antennanp
XFILLER_181_95 VPWR VGND sg13cmos5l_fill_2
XFILLER_331_32 VPWR VGND sg13cmos5l_decap_8
XFILLER_207_167 VPWR VGND sg13cmos5l_decap_8
XFILLER_222_159 VPWR VGND sg13cmos5l_decap_8
X_1822_ Tile_X0Y4_EE4BEG[5] _2638_/X VPWR VGND sg13cmos5l_buf_1
XFILLER_90_81 VPWR VGND sg13cmos5l_decap_8
XANTENNA__0342__GATE Tile_X0Y5_FrameStrobe[0] VPWR VGND sg13cmos5l_antennanp
XFILLER_209_12 VPWR VGND sg13cmos5l_decap_8
XANTENNA__0233__D Tile_X0Y0_FrameData[29] VPWR VGND sg13cmos5l_antennanp
XANTENNA__0972__GATE Tile_X0Y5_FrameStrobe[5] VPWR VGND sg13cmos5l_antennanp
XANTENNA__1329__D Tile_X0Y5_FrameData[31] VPWR VGND sg13cmos5l_antennanp
XFILLER_190_206 VPWR VGND sg13cmos5l_decap_8
X_1753_ Tile_X0Y2_FrameData_O[13] Tile_X0Y2_FrameData[13] VPWR VGND sg13cmos5l_buf_1
XANTENNA__1907__A Tile_X0Y1_FrameData[20] VPWR VGND sg13cmos5l_antennanp
XFILLER_143_100 VPWR VGND sg13cmos5l_fill_1
X_1684_ Tile_X0Y0_FrameData_O[24] Tile_X0Y0_FrameData[24] VPWR VGND sg13cmos5l_buf_1
X_0704_ _0704_/Q Tile_X0Y2_FrameData[6] VGND VPWR Tile_X0Y5_FrameStrobe[4] latch
XFILLER_332_222 VPWR VGND sg13cmos5l_fill_2
X_0635_ _0635_/Q Tile_X0Y2_FrameData[11] VGND VPWR Tile_X0Y5_FrameStrobe[2] latch
XFILLER_99_90 VPWR VGND sg13cmos5l_decap_8
XFILLER_89_209 VPWR VGND sg13cmos5l_decap_4
XANTENNA__0357__GATE Tile_X0Y5_FrameStrobe[1] VPWR VGND sg13cmos5l_antennanp
XANTENNA__0987__GATE Tile_X0Y5_FrameStrobe[6] VPWR VGND sg13cmos5l_antennanp
X_0566_ _0566_/Q Tile_X0Y2_FrameData[16] VGND VPWR Tile_X0Y5_FrameStrobe[0] latch
XANTENNA__1064__D Tile_X0Y4_FrameData[30] VPWR VGND sg13cmos5l_antennanp
XANTENNA__1642__A Tile_X0Y5_FrameStrobe[2] VPWR VGND sg13cmos5l_antennanp
X_2305_ _2305_/X AXIL_S_SOC_WDATA4 AXIL_S_SOC_WDATA12 _2376_/X _2377_/X _0482_/Q _0481_/Q
+ VPWR VGND sg13cmos5l_mux4_1
X_0497_ _0497_/Q Tile_X0Y1_FrameData[5] VGND VPWR Tile_X0Y5_FrameStrobe[5] latch
XFILLER_300_152 VPWR VGND sg13cmos5l_fill_1
XFILLER_300_130 VPWR VGND sg13cmos5l_fill_1
XANTENNA__0910__GATE Tile_X0Y5_FrameStrobe[3] VPWR VGND sg13cmos5l_antennanp
XANTENNA__2828__A0 Tile_X0Y5_N2MID[3] VPWR VGND sg13cmos5l_antennanp
X_2236_ _2236_/X _2215_/X _0064_/X Tile_X0Y0_S1END[2] Tile_X0Y0_S4END[2] _0122_/Q
+ _0121_/Q VPWR VGND sg13cmos5l_mux4_1
XFILLER_300_163 VPWR VGND sg13cmos5l_fill_1
XFILLER_241_21 VPWR VGND sg13cmos5l_decap_8
XFILLER_65_150 VPWR VGND sg13cmos5l_decap_8
XFILLER_241_54 VPWR VGND sg13cmos5l_fill_2
X_2167_ _2167_/X AXIL_S_SOC_WDATA18 AXIL_S_SOC_WDATA26 _2243_/X _2246_/X _0262_/Q
+ _0261_/Q VPWR VGND sg13cmos5l_mux4_1
X_2098_ Tile_X0Y3_E2BEGb[2] _2519_/X VPWR VGND sg13cmos5l_buf_1
X_1118_ _1118_/Q Tile_X0Y4_FrameData[8] VGND VPWR Tile_X0Y5_FrameStrobe[2] latch
XFILLER_359_108 VPWR VGND sg13cmos5l_decap_8
XANTENNA__0408__D Tile_X0Y1_FrameData[30] VPWR VGND sg13cmos5l_antennanp
XANTENNA__0925__GATE Tile_X0Y5_FrameStrobe[4] VPWR VGND sg13cmos5l_antennanp
XFILLER_110_14 VPWR VGND sg13cmos5l_fill_1
X_1049_ _1049_/Q Tile_X0Y4_FrameData[13] VGND VPWR Tile_X0Y5_FrameStrobe[0] latch
XFILLER_221_192 VPWR VGND sg13cmos5l_decap_8
XANTENNA__1239__D Tile_X0Y4_FrameData[15] VPWR VGND sg13cmos5l_antennanp
XANTENNA__2359__A2 Tile_X0Y5_WW4END[8] VPWR VGND sg13cmos5l_antennanp
XFILLER_119_34 VPWR VGND sg13cmos5l_decap_8
XFILLER_181_217 VPWR VGND sg13cmos5l_fill_1
XANTENNA__0143__D Tile_X0Y0_FrameData[23] VPWR VGND sg13cmos5l_antennanp
XFILLER_266_51 VPWR VGND sg13cmos5l_decap_8
XFILLER_266_62 VPWR VGND sg13cmos5l_fill_1
XFILLER_79_27 VPWR VGND sg13cmos5l_decap_8
XFILLER_0_113 VPWR VGND sg13cmos5l_fill_1
XFILLER_282_50 VPWR VGND sg13cmos5l_decap_8
XFILLER_282_61 VPWR VGND sg13cmos5l_fill_2
XFILLER_135_99 VPWR VGND sg13cmos5l_decap_8
XFILLER_95_37 VPWR VGND sg13cmos5l_fill_1
XANTENNA__2000__X Tile_X0Y5_EE4BEG[1] VPWR VGND sg13cmos5l_antennanp
XANTENNA__2819__A0 Tile_X0Y5_N1END[3] VPWR VGND sg13cmos5l_antennanp
XFILLER_95_59 VPWR VGND sg13cmos5l_decap_8
XFILLER_48_128 VPWR VGND sg13cmos5l_fill_1
XANTENNA__2295__A1 AXIL_S_SOC_WDATA10 VPWR VGND sg13cmos5l_antennanp
XFILLER_56_150 VPWR VGND sg13cmos5l_decap_8
XFILLER_56_194 VPWR VGND sg13cmos5l_decap_8
XANTENNA__0318__D Tile_X0Y1_FrameData[24] VPWR VGND sg13cmos5l_antennanp
XFILLER_204_148 VPWR VGND sg13cmos5l_decap_8
XFILLER_204_159 VPWR VGND sg13cmos5l_fill_1
XFILLER_71_153 VPWR VGND sg13cmos5l_decap_8
XANTENNA__2598__A2 Tile_X0Y5_W6END[7] VPWR VGND sg13cmos5l_antennanp
XFILLER_157_214 VPWR VGND sg13cmos5l_decap_4
XANTENNA__1072__GATE Tile_X0Y5_FrameStrobe[1] VPWR VGND sg13cmos5l_antennanp
XANTENNA__1149__D Tile_X0Y4_FrameData[9] VPWR VGND sg13cmos5l_antennanp
XFILLER_176_73 VPWR VGND sg13cmos5l_decap_8
XANTENNA__0988__D Tile_X0Y3_FrameData[26] VPWR VGND sg13cmos5l_antennanp
XFILLER_326_21 VPWR VGND sg13cmos5l_fill_1
XANTENNA__1087__GATE Tile_X0Y5_FrameStrobe[1] VPWR VGND sg13cmos5l_antennanp
X_0420_ _0420_/Q Tile_X0Y1_FrameData[18] VGND VPWR Tile_X0Y5_FrameStrobe[3] latch
XFILLER_326_98 VPWR VGND sg13cmos5l_decap_4
XFILLER_279_192 VPWR VGND sg13cmos5l_fill_2
X_0351_ _0351_/Q Tile_X0Y1_FrameData[23] VGND VPWR Tile_X0Y5_FrameStrobe[1] latch
XFILLER_94_223 VPWR VGND sg13cmos5l_fill_1
XFILLER_39_117 VPWR VGND sg13cmos5l_decap_8
XFILLER_342_42 VPWR VGND sg13cmos5l_decap_8
XANTENNA__1010__GATE Tile_X0Y5_FrameStrobe[6] VPWR VGND sg13cmos5l_antennanp
X_2021_ Tile_X0Y5_FrameData_O[6] Tile_X0Y5_FrameData[6] VPWR VGND sg13cmos5l_buf_1
X_0282_ _0282_/Q Tile_X0Y0_FrameData[12] VGND VPWR Tile_X0Y5_FrameStrobe[6] latch
XFILLER_342_86 VPWR VGND sg13cmos5l_decap_8
XANTENNA__0228__D Tile_X0Y0_FrameData[2] VPWR VGND sg13cmos5l_antennanp
XANTENNA__1025__GATE Tile_X0Y5_FrameStrobe[7] VPWR VGND sg13cmos5l_antennanp
XFILLER_62_175 VPWR VGND sg13cmos5l_fill_1
XFILLER_93_2 VPWR VGND sg13cmos5l_fill_1
XANTENNA__0281__GATE Tile_X0Y5_FrameStrobe[6] VPWR VGND sg13cmos5l_antennanp
XFILLER_349_141 VPWR VGND sg13cmos5l_fill_2
XFILLER_203_192 VPWR VGND sg13cmos5l_decap_8
XANTENNA__1059__D Tile_X0Y4_FrameData[3] VPWR VGND sg13cmos5l_antennanp
XFILLER_163_217 VPWR VGND sg13cmos5l_fill_1
X_1805_ Tile_X0Y4_E6BEG[0] _2649_/X VPWR VGND sg13cmos5l_buf_1
X_2785_ _2785_/X Tile_X0Y5_W1END[2] Tile_X0Y5_WW4END[14] Tile_X0Y5_W6END[6] _2820_/X
+ _1334_/Q _1333_/Q VPWR VGND sg13cmos5l_mux4_1
XFILLER_79_0 VPWR VGND sg13cmos5l_fill_2
XANTENNA__2210__A1 Tile_X0Y0_S1END[1] VPWR VGND sg13cmos5l_antennanp
X_1736_ Tile_X0Y0_E1BEG[0] _2161_/X VPWR VGND sg13cmos5l_buf_1
XANTENNA__0296__GATE Tile_X0Y5_FrameStrobe[7] VPWR VGND sg13cmos5l_antennanp
XANTENNA__0898__D Tile_X0Y3_FrameData[20] VPWR VGND sg13cmos5l_antennanp
XFILLER_116_155 VPWR VGND sg13cmos5l_decap_8
XFILLER_305_222 VPWR VGND sg13cmos5l_fill_2
XANTENNA__1924__X Tile_X0Y1_EE4BEG[5] VPWR VGND sg13cmos5l_antennanp
X_1667_ Tile_X0Y0_FrameData_O[7] Tile_X0Y0_FrameData[7] VPWR VGND sg13cmos5l_buf_1
XFILLER_116_199 VPWR VGND sg13cmos5l_decap_8
XFILLER_131_125 VPWR VGND sg13cmos5l_decap_8
X_1598_ Tile_X0Y2_EE4BEG[11] _2428_/X VPWR VGND sg13cmos5l_buf_1
X_0618_ _0618_/Q Tile_X0Y2_FrameData[28] VGND VPWR Tile_X0Y5_FrameStrobe[2] latch
XFILLER_105_14 VPWR VGND sg13cmos5l_fill_2
X_0549_ _0549_/Q Tile_X0Y1_FrameData[17] VGND VPWR Tile_X0Y5_FrameStrobe[7] latch
XFILLER_85_212 VPWR VGND sg13cmos5l_decap_4
XANTENNA__0234__GATE Tile_X0Y5_FrameStrobe[5] VPWR VGND sg13cmos5l_antennanp
XANTENNA__2277__A1 Tile_X0Y2_WW4END[1] VPWR VGND sg13cmos5l_antennanp
X_2219_ _2219_/X Tile_X0Y4_W1END[0] Tile_X0Y4_WW4END[0] Tile_X0Y4_W6END[8] _2707_/X
+ _1240_/Q _1239_/Q VPWR VGND sg13cmos5l_mux4_1
XANTENNA__0864__GATE Tile_X0Y5_FrameStrobe[2] VPWR VGND sg13cmos5l_antennanp
XFILLER_121_35 VPWR VGND sg13cmos5l_decap_8
XANTENNA__0138__D Tile_X0Y0_FrameData[28] VPWR VGND sg13cmos5l_antennanp
XFILLER_198_136 VPWR VGND sg13cmos5l_decap_8
XANTENNA__0249__GATE Tile_X0Y5_FrameStrobe[5] VPWR VGND sg13cmos5l_antennanp
XFILLER_14_44 VPWR VGND sg13cmos5l_fill_1
XANTENNA__0879__GATE Tile_X0Y5_FrameStrobe[2] VPWR VGND sg13cmos5l_antennanp
XFILLER_277_72 VPWR VGND sg13cmos5l_fill_1
XFILLER_355_166 VPWR VGND sg13cmos5l_decap_8
XFILLER_355_199 VPWR VGND sg13cmos5l_decap_8
XANTENNA__0802__GATE Tile_X0Y5_FrameStrobe[0] VPWR VGND sg13cmos5l_antennanp
XANTENNA__0601__D Tile_X0Y2_FrameData[13] VPWR VGND sg13cmos5l_antennanp
XANTENNA__1834__X Tile_X0Y4_FrameData_O[1] VPWR VGND sg13cmos5l_antennanp
XFILLER_122_103 VPWR VGND sg13cmos5l_decap_8
XFILLER_30_76 VPWR VGND sg13cmos5l_decap_8
XFILLER_107_199 VPWR VGND sg13cmos5l_fill_2
XFILLER_146_76 VPWR VGND sg13cmos5l_decap_8
XFILLER_268_129 VPWR VGND sg13cmos5l_fill_1
XANTENNA__0817__GATE Tile_X0Y5_FrameStrobe[0] VPWR VGND sg13cmos5l_antennanp
XANTENNA__2504__A2 Tile_X0Y4_W6END[0] VPWR VGND sg13cmos5l_antennanp
XFILLER_209_207 VPWR VGND sg13cmos5l_fill_1
XFILLER_276_140 VPWR VGND sg13cmos5l_decap_4
XFILLER_291_121 VPWR VGND sg13cmos5l_fill_2
XANTENNA__1432__D Tile_X0Y5_FrameData[24] VPWR VGND sg13cmos5l_antennanp
XFILLER_162_97 VPWR VGND sg13cmos5l_decap_8
XFILLER_291_165 VPWR VGND sg13cmos5l_decap_8
XFILLER_36_109 VPWR VGND sg13cmos5l_decap_8
XFILLER_29_161 VPWR VGND sg13cmos5l_decap_8
XANTENNA__2807__A3 Tile_X0Y1_W6END[5] VPWR VGND sg13cmos5l_antennanp
XFILLER_291_176 VPWR VGND sg13cmos5l_decap_8
XFILLER_55_95 VPWR VGND sg13cmos5l_decap_4
XFILLER_44_164 VPWR VGND sg13cmos5l_fill_2
XFILLER_44_153 VPWR VGND sg13cmos5l_decap_8
XFILLER_350_0 VPWR VGND sg13cmos5l_fill_2
XFILLER_361_125 VPWR VGND sg13cmos5l_fill_1
XFILLER_361_114 VPWR VGND sg13cmos5l_fill_1
XFILLER_337_42 VPWR VGND sg13cmos5l_decap_4
X_2570_ _2570_/X Tile_X0Y4_W1END[2] Tile_X0Y4_W6END[6] _2688_/X _2671_/X _1260_/Q
+ _1259_/Q VPWR VGND sg13cmos5l_mux4_1
XFILLER_337_64 VPWR VGND sg13cmos5l_decap_8
XANTENNA__1744__X Tile_X0Y2_FrameData_O[4] VPWR VGND sg13cmos5l_antennanp
X_1521_ _2454_/A3 VPWR VGND sg13cmos5l_tielo
XANTENNA__0511__D Tile_X0Y1_FrameData[23] VPWR VGND sg13cmos5l_antennanp
X_1452_ _1452_/Q Tile_X0Y5_FrameData[4] VGND VPWR Tile_X0Y5_FrameStrobe[5] latch
XFILLER_113_169 VPWR VGND sg13cmos5l_decap_8
X_0403_ _0403_/Q Tile_X0Y1_FrameData[3] VGND VPWR Tile_X0Y5_FrameStrobe[2] latch
X_1383_ _1383_/Q Tile_X0Y5_FrameData[9] VGND VPWR Tile_X0Y5_FrameStrobe[3] latch
XFILLER_67_201 VPWR VGND sg13cmos5l_decap_4
XFILLER_267_184 VPWR VGND sg13cmos5l_decap_8
X_0334_ _0334_/Q Tile_X0Y1_FrameData[8] VGND VPWR Tile_X0Y5_FrameStrobe[0] latch
XANTENNA__1342__D Tile_X0Y5_FrameData[18] VPWR VGND sg13cmos5l_antennanp
XANTENNA__2259__A1 Tile_X0Y2_W2END[2] VPWR VGND sg13cmos5l_antennanp
XFILLER_282_132 VPWR VGND sg13cmos5l_fill_2
X_0265_ _0265_/Q Tile_X0Y0_FrameData[29] VGND VPWR Tile_X0Y5_FrameStrobe[6] latch
X_2004_ Tile_X0Y5_EE4BEG[5] _2746_/X VPWR VGND sg13cmos5l_buf_1
XFILLER_35_131 VPWR VGND sg13cmos5l_fill_2
XFILLER_223_221 VPWR VGND sg13cmos5l_fill_2
X_0196_ _0196_/Q Tile_X0Y0_FrameData[2] VGND VPWR Tile_X0Y5_FrameStrobe[3] latch
XFILLER_298_16 VPWR VGND sg13cmos5l_fill_2
XFILLER_50_101 VPWR VGND sg13cmos5l_fill_2
XANTENNA__1919__X Tile_X0Y1_EE4BEG[0] VPWR VGND sg13cmos5l_antennanp
XANTENNA__2431__A1 AXIL_S_SOC_AWADDR2 VPWR VGND sg13cmos5l_antennanp
XFILLER_188_191 VPWR VGND sg13cmos5l_decap_8
XFILLER_337_122 VPWR VGND sg13cmos5l_decap_4
XFILLER_337_100 VPWR VGND sg13cmos5l_fill_1
XANTENNA__2195__A0 AXIL_S_SOC_WDATA18 VPWR VGND sg13cmos5l_antennanp
X_2768_ _2768_/X AXIL_S_SOC_ARVALID _2824_/X _2823_/X _2797_/X _1366_/Q _1365_/Q VPWR
+ VGND sg13cmos5l_mux4_1
XFILLER_352_158 VPWR VGND sg13cmos5l_fill_2
XFILLER_352_136 VPWR VGND sg13cmos5l_decap_8
XANTENNA__1654__X Tile_X0Y0_FrameStrobe_O[14] VPWR VGND sg13cmos5l_antennanp
X_1719_ Tile_X0Y0_E6BEG[11] _2208_/X VPWR VGND sg13cmos5l_buf_1
X_2699_ _2699_/X _2235_/X _2233_/X _2218_/X _2217_/X _0145_/Q _0144_/Q VPWR VGND sg13cmos5l_mux4_1
XANTENNA__0421__D Tile_X0Y1_FrameData[17] VPWR VGND sg13cmos5l_antennanp
XFILLER_104_114 VPWR VGND sg13cmos5l_decap_8
XFILLER_104_136 VPWR VGND sg13cmos5l_decap_8
XFILLER_360_191 VPWR VGND sg13cmos5l_fill_1
XFILLER_263_63 VPWR VGND sg13cmos5l_decap_8
XANTENNA__2498__A1 Tile_X0Y4_W2END[3] VPWR VGND sg13cmos5l_antennanp
XFILLER_76_28 VPWR VGND sg13cmos5l_decap_8
XANTENNA__0173__GATE Tile_X0Y5_FrameStrobe[3] VPWR VGND sg13cmos5l_antennanp
XANTENNA__1252__D Tile_X0Y4_FrameData[2] VPWR VGND sg13cmos5l_antennanp
XFILLER_132_34 VPWR VGND sg13cmos5l_decap_8
XFILLER_267_6 VPWR VGND sg13cmos5l_decap_4
XFILLER_273_176 VPWR VGND sg13cmos5l_decap_8
XFILLER_92_27 VPWR VGND sg13cmos5l_decap_8
XFILLER_132_89 VPWR VGND sg13cmos5l_fill_1
XFILLER_214_221 VPWR VGND sg13cmos5l_fill_2
XFILLER_26_142 VPWR VGND sg13cmos5l_fill_1
XANTENNA__0188__GATE Tile_X0Y5_FrameStrobe[3] VPWR VGND sg13cmos5l_antennanp
XFILLER_26_175 VPWR VGND sg13cmos5l_fill_1
XFILLER_26_197 VPWR VGND sg13cmos5l_decap_4
XFILLER_41_101 VPWR VGND sg13cmos5l_decap_8
XFILLER_25_65 VPWR VGND sg13cmos5l_decap_8
XFILLER_41_156 VPWR VGND sg13cmos5l_fill_2
XANTENNA__1829__X Tile_X0Y4_EE4BEG[12] VPWR VGND sg13cmos5l_antennanp
XANTENNA__2422__A1 AXIL_S_SOC_AWADDR9 VPWR VGND sg13cmos5l_antennanp
XFILLER_179_180 VPWR VGND sg13cmos5l_fill_1
XANTENNA__0111__GATE Tile_X0Y5_FrameStrobe[1] VPWR VGND sg13cmos5l_antennanp
XFILLER_328_133 VPWR VGND sg13cmos5l_decap_8
XANTENNA__0741__GATE Tile_X0Y5_FrameStrobe[5] VPWR VGND sg13cmos5l_antennanp
XFILLER_41_75 VPWR VGND sg13cmos5l_decap_8
XANTENNA__2186__A0 AXIL_S_SOC_WDATA21 VPWR VGND sg13cmos5l_antennanp
XFILLER_157_75 VPWR VGND sg13cmos5l_decap_8
XFILLER_343_147 VPWR VGND sg13cmos5l_decap_4
XANTENNA__1427__D Tile_X0Y5_FrameData[29] VPWR VGND sg13cmos5l_antennanp
XFILLER_307_12 VPWR VGND sg13cmos5l_fill_1
XANTENNA__0126__GATE Tile_X0Y5_FrameStrobe[1] VPWR VGND sg13cmos5l_antennanp
XANTENNA__0331__D Tile_X0Y1_FrameData[11] VPWR VGND sg13cmos5l_antennanp
XANTENNA__1564__X Tile_X0Y3_FrameData_O[10] VPWR VGND sg13cmos5l_antennanp
XFILLER_307_56 VPWR VGND sg13cmos5l_fill_2
XANTENNA__0756__GATE Tile_X0Y5_FrameStrobe[6] VPWR VGND sg13cmos5l_antennanp
XFILLER_307_89 VPWR VGND sg13cmos5l_decap_4
XANTENNA__2489__A1 Tile_X0Y1_W2END[7] VPWR VGND sg13cmos5l_antennanp
XFILLER_110_117 VPWR VGND sg13cmos5l_decap_8
XFILLER_49_212 VPWR VGND sg13cmos5l_fill_1
XFILLER_49_201 VPWR VGND sg13cmos5l_decap_4
XFILLER_323_11 VPWR VGND sg13cmos5l_fill_2
XFILLER_249_162 VPWR VGND sg13cmos5l_decap_8
XFILLER_264_110 VPWR VGND sg13cmos5l_fill_1
XANTENNA__1162__D Tile_X0Y4_FrameData[28] VPWR VGND sg13cmos5l_antennanp
XFILLER_264_154 VPWR VGND sg13cmos5l_fill_2
XANTENNA__1740__A Tile_X0Y2_FrameData[0] VPWR VGND sg13cmos5l_antennanp
X_0050_ _1606_/A _2283_/X _2284_/X _0998_/Q VPWR VGND sg13cmos5l_mux2_1
XANTENNA__2110__A0 Tile_X0Y3_W2MID[4] VPWR VGND sg13cmos5l_antennanp
XANTENNA__2661__A1 Tile_X0Y4_WW4END[12] VPWR VGND sg13cmos5l_antennanp
XFILLER_177_117 VPWR VGND sg13cmos5l_decap_4
XANTENNA__0506__D Tile_X0Y1_FrameData[28] VPWR VGND sg13cmos5l_antennanp
XANTENNA__1739__X Tile_X0Y0_E1BEG[3] VPWR VGND sg13cmos5l_antennanp
XANTENNA__2413__A1 AXIL_S_SOC_AWPROT2 VPWR VGND sg13cmos5l_antennanp
XFILLER_177_128 VPWR VGND sg13cmos5l_decap_4
X_0952_ _0952_/Q Tile_X0Y3_FrameData[30] VGND VPWR Tile_X0Y5_FrameStrobe[5] latch
XFILLER_32_178 VPWR VGND sg13cmos5l_fill_1
XFILLER_319_111 VPWR VGND sg13cmos5l_decap_8
XFILLER_192_109 VPWR VGND sg13cmos5l_decap_4
XANTENNA__0709__GATE Tile_X0Y5_FrameStrobe[4] VPWR VGND sg13cmos5l_antennanp
X_0883_ _0883_/Q Tile_X0Y3_FrameData[3] VGND VPWR Tile_X0Y5_FrameStrobe[2] latch
XFILLER_348_74 VPWR VGND sg13cmos5l_decap_8
XFILLER_319_177 VPWR VGND sg13cmos5l_decap_4
XANTENNA__2177__A0 AXIL_S_SOC_WDATA20 VPWR VGND sg13cmos5l_antennanp
XFILLER_284_29 VPWR VGND sg13cmos5l_decap_8
X_2622_ _2622_/X AXIL_S_SOC_WSTRB1 AXIL_S_SOC_BREADY _2710_/X _2683_/X _1210_/Q _1209_/Q
+ VPWR VGND sg13cmos5l_mux4_1
XFILLER_334_147 VPWR VGND sg13cmos5l_decap_4
XANTENNA__1337__D Tile_X0Y5_FrameData[23] VPWR VGND sg13cmos5l_antennanp
XANTENNA__2716__A2 Tile_X0Y3_W6END[11] VPWR VGND sg13cmos5l_antennanp
X_2553_ _2553_/X Tile_X0Y3_W1END[0] Tile_X0Y3_WW4END[8] Tile_X0Y3_WW4END[12] Tile_X0Y3_W6END[4]
+ _0874_/Q _0873_/Q VPWR VGND sg13cmos5l_mux4_1
XANTENNA__0241__D Tile_X0Y0_FrameData[21] VPWR VGND sg13cmos5l_antennanp
XANTENNA__1915__A Tile_X0Y1_FrameData[28] VPWR VGND sg13cmos5l_antennanp
XFILLER_217_45 VPWR VGND sg13cmos5l_decap_8
X_1504_ _2672_/A3 VPWR VGND sg13cmos5l_tielo
X_2484_ _2484_/X _2388_/X _2496_/X _2495_/X _2387_/X _0568_/Q _0567_/Q VPWR VGND sg13cmos5l_mux4_1
XFILLER_101_117 VPWR VGND sg13cmos5l_decap_8
X_1435_ _1435_/Q Tile_X0Y5_FrameData[21] VGND VPWR Tile_X0Y5_FrameStrobe[5] latch
X_1366_ _1366_/Q Tile_X0Y5_FrameData[26] VGND VPWR Tile_X0Y5_FrameStrobe[3] latch
XANTENNA__1072__D Tile_X0Y4_FrameData[22] VPWR VGND sg13cmos5l_antennanp
X_0317_ _0317_/Q Tile_X0Y1_FrameData[25] VGND VPWR Tile_X0Y5_FrameStrobe[0] latch
XANTENNA__1650__A Tile_X0Y5_FrameStrobe[10] VPWR VGND sg13cmos5l_antennanp
XFILLER_233_99 VPWR VGND sg13cmos5l_decap_8
X_1297_ _1297_/Q Tile_X0Y5_FrameData[31] VGND VPWR Tile_X0Y5_FrameStrobe[1] latch
XANTENNA__2101__A0 Tile_X0Y4_W2MID[1] VPWR VGND sg13cmos5l_antennanp
X_0248_ _0248_/Q Tile_X0Y0_FrameData[14] VGND VPWR Tile_X0Y5_FrameStrobe[5] latch
XFILLER_23_101 VPWR VGND sg13cmos5l_fill_1
XFILLER_270_157 VPWR VGND sg13cmos5l_decap_8
X_0179_ _0179_/Q Tile_X0Y0_FrameData[19] VGND VPWR Tile_X0Y5_FrameStrobe[3] latch
XANTENNA__0416__D Tile_X0Y1_FrameData[22] VPWR VGND sg13cmos5l_antennanp
XANTENNA__1649__X Tile_X0Y0_FrameStrobe_O[9] VPWR VGND sg13cmos5l_antennanp
XANTENNA__2404__A1 AXIL_S_SOC_AWPROT1 VPWR VGND sg13cmos5l_antennanp
XFILLER_176_183 VPWR VGND sg13cmos5l_fill_1
XANTENNA__1471__GATE Tile_X0Y5_FrameStrobe[6] VPWR VGND sg13cmos5l_antennanp
XANTENNA__2168__A0 AXIL_S_SOC_WDATA19 VPWR VGND sg13cmos5l_antennanp
XANTENNA__1247__D Tile_X0Y4_FrameData[7] VPWR VGND sg13cmos5l_antennanp
XFILLER_191_153 VPWR VGND sg13cmos5l_decap_8
XANTENNA__0151__D Tile_X0Y0_FrameData[15] VPWR VGND sg13cmos5l_antennanp
XFILLER_11_89 VPWR VGND sg13cmos5l_fill_1
XFILLER_274_51 VPWR VGND sg13cmos5l_decap_8
XFILLER_274_62 VPWR VGND sg13cmos5l_fill_2
XFILLER_87_27 VPWR VGND sg13cmos5l_fill_2
XANTENNA__1486__GATE Tile_X0Y5_FrameStrobe[6] VPWR VGND sg13cmos5l_antennanp
XFILLER_290_50 VPWR VGND sg13cmos5l_decap_8
XFILLER_293_216 VPWR VGND sg13cmos5l_fill_2
XFILLER_143_88 VPWR VGND sg13cmos5l_fill_1
XANTENNA__1560__A Tile_X0Y3_FrameData[6] VPWR VGND sg13cmos5l_antennanp
XFILLER_100_172 VPWR VGND sg13cmos5l_fill_1
XANTENNA__2643__A1 AXIL_S_SOC_WVALID VPWR VGND sg13cmos5l_antennanp
XANTENNA__1424__GATE Tile_X0Y5_FrameStrobe[4] VPWR VGND sg13cmos5l_antennanp
XFILLER_159_106 VPWR VGND sg13cmos5l_fill_2
XFILLER_202_213 VPWR VGND sg13cmos5l_fill_2
XANTENNA__0326__D Tile_X0Y1_FrameData[16] VPWR VGND sg13cmos5l_antennanp
XANTENNA__1559__X Tile_X0Y3_FrameData_O[5] VPWR VGND sg13cmos5l_antennanp
XFILLER_146_0 VPWR VGND sg13cmos5l_decap_8
XANTENNA__0680__GATE Tile_X0Y5_FrameStrobe[4] VPWR VGND sg13cmos5l_antennanp
XFILLER_313_0 VPWR VGND sg13cmos5l_fill_2
XANTENNA__1439__GATE Tile_X0Y5_FrameStrobe[5] VPWR VGND sg13cmos5l_antennanp
XANTENNA__2159__A0 Tile_X0Y0_W1END[3] VPWR VGND sg13cmos5l_antennanp
XANTENNA__1157__D Tile_X0Y4_FrameData[1] VPWR VGND sg13cmos5l_antennanp
XFILLER_182_153 VPWR VGND sg13cmos5l_decap_4
XANTENNA__0695__GATE Tile_X0Y5_FrameStrobe[4] VPWR VGND sg13cmos5l_antennanp
XANTENNA__0996__D Tile_X0Y3_FrameData[18] VPWR VGND sg13cmos5l_antennanp
XFILLER_269_213 VPWR VGND sg13cmos5l_fill_2
X_1220_ _1220_/Q Tile_X0Y4_FrameData[2] VGND VPWR Tile_X0Y5_FrameStrobe[5] latch
XFILLER_96_148 VPWR VGND sg13cmos5l_decap_8
XANTENNA__2331__A0 AXIL_S_SOC_WDATA6 VPWR VGND sg13cmos5l_antennanp
XFILLER_237_132 VPWR VGND sg13cmos5l_decap_8
X_1151_ _1151_/Q Tile_X0Y4_FrameData[7] VGND VPWR Tile_X0Y5_FrameStrobe[3] latch
XFILLER_203_25 VPWR VGND sg13cmos5l_fill_1
X_0102_ _0102_/Q Tile_X0Y0_FrameData[0] VGND VPWR Tile_X0Y5_FrameStrobe[0] latch
XANTENNA__0633__GATE Tile_X0Y5_FrameStrobe[2] VPWR VGND sg13cmos5l_antennanp
X_1082_ _1082_/Q Tile_X0Y4_FrameData[12] VGND VPWR Tile_X0Y5_FrameStrobe[1] latch
XFILLER_52_207 VPWR VGND sg13cmos5l_fill_2
XANTENNA__2634__A1 AXIL_S_SOC_WSTRB1 VPWR VGND sg13cmos5l_antennanp
XFILLER_252_179 VPWR VGND sg13cmos5l_decap_8
X_0033_ _1616_/A _2153_/X _2154_/X _0284_/Q VPWR VGND sg13cmos5l_mux2_1
XANTENNA__0236__D Tile_X0Y0_FrameData[26] VPWR VGND sg13cmos5l_antennanp
XANTENNA__0648__GATE Tile_X0Y5_FrameStrobe[3] VPWR VGND sg13cmos5l_antennanp
XFILLER_20_115 VPWR VGND sg13cmos5l_decap_8
X_1984_ Tile_X0Y5_E2BEGb[5] _2738_/X VPWR VGND sg13cmos5l_buf_1
XFILLER_158_172 VPWR VGND sg13cmos5l_decap_8
X_0935_ _0935_/Q Tile_X0Y3_FrameData[15] VGND VPWR Tile_X0Y5_FrameStrobe[4] latch
XFILLER_307_103 VPWR VGND sg13cmos5l_decap_8
X_0866_ _0866_/Q Tile_X0Y3_FrameData[20] VGND VPWR Tile_X0Y5_FrameStrobe[2] latch
XFILLER_106_209 VPWR VGND sg13cmos5l_fill_2
XFILLER_228_66 VPWR VGND sg13cmos5l_decap_8
X_2605_ _2605_/X Tile_X0Y2_W1END[0] Tile_X0Y2_W2MID[3] Tile_X0Y2_W2END[3] _2485_/X
+ _0642_/Q _0641_/Q VPWR VGND sg13cmos5l_mux4_1
XFILLER_61_0 VPWR VGND sg13cmos5l_fill_2
XANTENNA__1067__D Tile_X0Y4_FrameData[27] VPWR VGND sg13cmos5l_antennanp
XANTENNA__1645__A Tile_X0Y5_FrameStrobe[5] VPWR VGND sg13cmos5l_antennanp
X_0797_ _0797_/Q Tile_X0Y3_FrameData[25] VGND VPWR Tile_X0Y5_FrameStrobe[0] latch
XANTENNA__2570__A0 Tile_X0Y4_W1END[2] VPWR VGND sg13cmos5l_antennanp
X_2536_ _2536_/X AXIL_S_SOC_ARADDR1 AXIL_S_SOC_ARADDR7 _2587_/X _2593_/X _0932_/Q
+ _0931_/Q VPWR VGND sg13cmos5l_mux4_1
XFILLER_244_43 VPWR VGND sg13cmos5l_fill_2
X_2467_ _2467_/X _2462_/X Tile_X0Y5_N4END[14] _2461_/X Tile_X0Y0_S4END[10] _0578_/Q
+ _0577_/Q VPWR VGND sg13cmos5l_mux4_1
XFILLER_87_115 VPWR VGND sg13cmos5l_decap_8
XFILLER_87_104 VPWR VGND sg13cmos5l_decap_8
XANTENNA__1932__X Tile_X0Y1_EE4BEG[13] VPWR VGND sg13cmos5l_antennanp
X_1418_ _1418_/Q Tile_X0Y5_FrameData[6] VGND VPWR Tile_X0Y5_FrameStrobe[4] latch
XANTENNA__2322__A0 AXIL_S_SOC_WDATA1 VPWR VGND sg13cmos5l_antennanp
X_2398_ _2398_/X _2460_/X _2459_/X AXIL_S_SOC_AWADDR3 AXIL_S_SOC_AWADDR6 _0752_/Q
+ _0751_/Q VPWR VGND sg13cmos5l_mux4_1
XFILLER_260_31 VPWR VGND sg13cmos5l_decap_4
XFILLER_260_42 VPWR VGND sg13cmos5l_fill_1
X_1349_ _1349_/Q Tile_X0Y5_FrameData[11] VGND VPWR Tile_X0Y5_FrameStrobe[2] latch
XFILLER_95_192 VPWR VGND sg13cmos5l_decap_8
XFILLER_260_75 VPWR VGND sg13cmos5l_decap_8
XFILLER_43_207 VPWR VGND sg13cmos5l_fill_1
XANTENNA__2625__A1 AXIL_S_SOC_WSTRB2 VPWR VGND sg13cmos5l_antennanp
XANTENNA__0146__D Tile_X0Y0_FrameData[20] VPWR VGND sg13cmos5l_antennanp
XANTENNA__2389__A0 Tile_X0Y0_W1END[0] VPWR VGND sg13cmos5l_antennanp
XFILLER_269_95 VPWR VGND sg13cmos5l_fill_1
XFILLER_132_6 VPWR VGND sg13cmos5l_decap_8
XFILLER_345_209 VPWR VGND sg13cmos5l_fill_1
XFILLER_138_44 VPWR VGND sg13cmos5l_fill_2
XFILLER_164_164 VPWR VGND sg13cmos5l_decap_8
XANTENNA__1555__A Tile_X0Y3_FrameData[1] VPWR VGND sg13cmos5l_antennanp
XFILLER_98_37 VPWR VGND sg13cmos5l_decap_8
XANTENNA__2003__X Tile_X0Y5_EE4BEG[4] VPWR VGND sg13cmos5l_antennanp
XFILLER_306_180 VPWR VGND sg13cmos5l_decap_4
XFILLER_120_212 VPWR VGND sg13cmos5l_fill_1
XANTENNA__1842__X Tile_X0Y4_FrameData_O[9] VPWR VGND sg13cmos5l_antennanp
XANTENNA__2313__A0 AXIL_S_SOC_WDATA4 VPWR VGND sg13cmos5l_antennanp
XFILLER_304_57 VPWR VGND sg13cmos5l_fill_2
XFILLER_304_46 VPWR VGND sg13cmos5l_decap_8
XFILLER_219_165 VPWR VGND sg13cmos5l_decap_8
XFILLER_281_208 VPWR VGND sg13cmos5l_decap_4
XFILLER_86_192 VPWR VGND sg13cmos5l_decap_8
XFILLER_304_68 VPWR VGND sg13cmos5l_decap_4
XFILLER_170_53 VPWR VGND sg13cmos5l_decap_8
XANTENNA__1363__GATE Tile_X0Y5_FrameStrobe[3] VPWR VGND sg13cmos5l_antennanp
XANTENNA__1440__D Tile_X0Y5_FrameData[16] VPWR VGND sg13cmos5l_antennanp
XFILLER_170_97 VPWR VGND sg13cmos5l_decap_8
XFILLER_234_146 VPWR VGND sg13cmos5l_decap_8
XFILLER_263_0 VPWR VGND sg13cmos5l_decap_8
XFILLER_320_23 VPWR VGND sg13cmos5l_decap_8
XFILLER_179_40 VPWR VGND sg13cmos5l_fill_2
XANTENNA__1378__GATE Tile_X0Y5_FrameStrobe[3] VPWR VGND sg13cmos5l_antennanp
XFILLER_329_43 VPWR VGND sg13cmos5l_fill_1
X_0720_ _0720_/Q Tile_X0Y2_FrameData[22] VGND VPWR Tile_X0Y5_FrameStrobe[5] latch
XFILLER_155_153 VPWR VGND sg13cmos5l_decap_8
XANTENNA__1301__GATE Tile_X0Y5_FrameStrobe[1] VPWR VGND sg13cmos5l_antennanp
X_0651_ _0651_/Q Tile_X0Y2_FrameData[27] VGND VPWR Tile_X0Y5_FrameStrobe[3] latch
XANTENNA__2552__A0 AXIL_S_SOC_ARADDR3 VPWR VGND sg13cmos5l_antennanp
X_0582_ _0582_/Q Tile_X0Y2_FrameData[0] VGND VPWR Tile_X0Y5_FrameStrobe[0] latch
XFILLER_345_64 VPWR VGND sg13cmos5l_fill_2
XFILLER_345_53 VPWR VGND sg13cmos5l_decap_8
X_2321_ _2321_/X AXIL_S_SOC_WDATA0 AXIL_S_SOC_WDATA12 _2367_/X _2376_/X _0450_/Q _0449_/Q
+ VPWR VGND sg13cmos5l_mux4_1
XFILLER_69_115 VPWR VGND sg13cmos5l_decap_8
XFILLER_345_97 VPWR VGND sg13cmos5l_decap_8
XANTENNA__1316__GATE Tile_X0Y5_FrameStrobe[1] VPWR VGND sg13cmos5l_antennanp
XANTENNA__1752__X Tile_X0Y2_FrameData_O[12] VPWR VGND sg13cmos5l_antennanp
XFILLER_214_13 VPWR VGND sg13cmos5l_fill_1
X_2252_ _2252_/X Tile_X0Y1_W2MID[6] Tile_X0Y1_W2END[6] Tile_X0Y1_W6END[6] _2374_/X
+ _0540_/Q _0539_/Q VPWR VGND sg13cmos5l_mux4_1
XFILLER_312_172 VPWR VGND sg13cmos5l_fill_1
XANTENNA__2304__A0 AXIL_S_SOC_WDATA3 VPWR VGND sg13cmos5l_antennanp
X_1203_ _1203_/Q Tile_X0Y4_FrameData[19] VGND VPWR Tile_X0Y5_FrameStrobe[5] latch
XFILLER_84_118 VPWR VGND sg13cmos5l_decap_8
XFILLER_214_79 VPWR VGND sg13cmos5l_fill_1
X_2183_ _2183_/X AXIL_S_SOC_WDATA18 AXIL_S_SOC_WDATA30 _2225_/X _2246_/X _0230_/Q
+ _0229_/Q VPWR VGND sg13cmos5l_mux4_1
XANTENNA__0572__GATE Tile_X0Y5_FrameStrobe[0] VPWR VGND sg13cmos5l_antennanp
XFILLER_225_135 VPWR VGND sg13cmos5l_decap_8
X_1134_ _1134_/Q Tile_X0Y4_FrameData[24] VGND VPWR Tile_X0Y5_FrameStrobe[3] latch
XANTENNA__1350__D Tile_X0Y5_FrameData[10] VPWR VGND sg13cmos5l_antennanp
XANTENNA__2607__A1 Tile_X0Y2_W2MID[2] VPWR VGND sg13cmos5l_antennanp
X_1065_ _1065_/Q Tile_X0Y4_FrameData[29] VGND VPWR Tile_X0Y5_FrameStrobe[1] latch
XFILLER_92_173 VPWR VGND sg13cmos5l_decap_8
XFILLER_230_67 VPWR VGND sg13cmos5l_fill_2
XANTENNA__0587__GATE Tile_X0Y5_FrameStrobe[1] VPWR VGND sg13cmos5l_antennanp
XFILLER_178_223 VPWR VGND sg13cmos5l_fill_1
XFILLER_239_43 VPWR VGND sg13cmos5l_decap_4
XANTENNA__0510__GATE Tile_X0Y5_FrameStrobe[6] VPWR VGND sg13cmos5l_antennanp
XANTENNA__1927__X Tile_X0Y1_EE4BEG[8] VPWR VGND sg13cmos5l_antennanp
X_1967_ Tile_X0Y5_E1BEG[0] _2721_/X VPWR VGND sg13cmos5l_buf_1
XANTENNA__2791__A0 Tile_X0Y5_N1END[2] VPWR VGND sg13cmos5l_antennanp
X_1898_ Tile_X0Y1_FrameData_O[11] Tile_X0Y1_FrameData[11] VPWR VGND sg13cmos5l_buf_1
X_0918_ _0918_/Q Tile_X0Y3_FrameData[0] VGND VPWR Tile_X0Y5_FrameStrobe[3] latch
X_0849_ _0849_/Q Tile_X0Y3_FrameData[5] VGND VPWR Tile_X0Y5_FrameStrobe[1] latch
XFILLER_108_36 VPWR VGND sg13cmos5l_fill_2
XANTENNA__0525__GATE Tile_X0Y5_FrameStrobe[6] VPWR VGND sg13cmos5l_antennanp
XANTENNA__2543__A0 Tile_X0Y5_N4END[10] VPWR VGND sg13cmos5l_antennanp
XFILLER_161_189 VPWR VGND sg13cmos5l_decap_8
X_2519_ _2519_/X AXIL_S_SOC_ARADDR0 AXIL_S_SOC_ARADDR2 _2591_/X _2594_/X _0966_/Q
+ _0965_/Q VPWR VGND sg13cmos5l_mux4_1
XFILLER_303_150 VPWR VGND sg13cmos5l_decap_8
XANTENNA__1662__X Tile_X0Y0_FrameData_O[2] VPWR VGND sg13cmos5l_antennanp
XFILLER_102_223 VPWR VGND sg13cmos5l_fill_1
XFILLER_303_183 VPWR VGND sg13cmos5l_fill_1
XFILLER_124_68 VPWR VGND sg13cmos5l_decap_8
XFILLER_263_208 VPWR VGND sg13cmos5l_fill_2
XFILLER_68_181 VPWR VGND sg13cmos5l_fill_1
XANTENNA__1260__D Tile_X0Y4_FrameData[26] VPWR VGND sg13cmos5l_antennanp
XFILLER_17_44 VPWR VGND sg13cmos5l_fill_2
XFILLER_169_212 VPWR VGND sg13cmos5l_fill_2
XFILLER_169_223 VPWR VGND sg13cmos5l_fill_1
XFILLER_224_190 VPWR VGND sg13cmos5l_decap_8
XANTENNA__0604__D Tile_X0Y2_FrameData[10] VPWR VGND sg13cmos5l_antennanp
XANTENNA__1837__X Tile_X0Y4_FrameData_O[4] VPWR VGND sg13cmos5l_antennanp
XFILLER_296_82 VPWR VGND sg13cmos5l_decap_4
XFILLER_296_71 VPWR VGND sg13cmos5l_fill_1
XANTENNA__2377__A3 Tile_X0Y0_S2MID[4] VPWR VGND sg13cmos5l_antennanp
XFILLER_296_93 VPWR VGND sg13cmos5l_fill_2
XFILLER_137_197 VPWR VGND sg13cmos5l_fill_1
XFILLER_165_31 VPWR VGND sg13cmos5l_decap_8
XFILLER_165_64 VPWR VGND sg13cmos5l_fill_1
XFILLER_298_149 VPWR VGND sg13cmos5l_decap_4
XFILLER_298_138 VPWR VGND sg13cmos5l_decap_8
XANTENNA__2534__A0 AXIL_S_SOC_ARADDR5 VPWR VGND sg13cmos5l_antennanp
XFILLER_152_167 VPWR VGND sg13cmos5l_decap_8
XFILLER_165_86 VPWR VGND sg13cmos5l_decap_8
XFILLER_165_97 VPWR VGND sg13cmos5l_fill_2
XANTENNA__1435__D Tile_X0Y5_FrameData[21] VPWR VGND sg13cmos5l_antennanp
XANTENNA__1572__X Tile_X0Y3_FrameData_O[18] VPWR VGND sg13cmos5l_antennanp
XFILLER_239_205 VPWR VGND sg13cmos5l_decap_4
XFILLER_58_40 VPWR VGND sg13cmos5l_fill_1
XFILLER_315_45 VPWR VGND sg13cmos5l_fill_2
XFILLER_59_181 VPWR VGND sg13cmos5l_fill_2
XANTENNA__1170__D Tile_X0Y4_FrameData[20] VPWR VGND sg13cmos5l_antennanp
XFILLER_207_146 VPWR VGND sg13cmos5l_decap_8
XFILLER_74_173 VPWR VGND sg13cmos5l_decap_8
XFILLER_74_83 VPWR VGND sg13cmos5l_decap_8
XFILLER_230_182 VPWR VGND sg13cmos5l_decap_8
X_1821_ Tile_X0Y4_EE4BEG[4] _2637_/X VPWR VGND sg13cmos5l_buf_1
XANTENNA__0514__D Tile_X0Y1_FrameData[20] VPWR VGND sg13cmos5l_antennanp
XANTENNA__1747__X Tile_X0Y2_FrameData_O[7] VPWR VGND sg13cmos5l_antennanp
XANTENNA__1240__GATE Tile_X0Y5_FrameStrobe[6] VPWR VGND sg13cmos5l_antennanp
XANTENNA__2368__A3 Tile_X0Y0_S4END[6] VPWR VGND sg13cmos5l_antennanp
XANTENNA__2773__A0 Tile_X0Y5_W2MID[7] VPWR VGND sg13cmos5l_antennanp
XFILLER_128_142 VPWR VGND sg13cmos5l_decap_8
X_1752_ Tile_X0Y2_FrameData_O[12] Tile_X0Y2_FrameData[12] VPWR VGND sg13cmos5l_buf_1
XFILLER_356_30 VPWR VGND sg13cmos5l_decap_8
XFILLER_143_112 VPWR VGND sg13cmos5l_decap_8
X_1683_ Tile_X0Y0_FrameData_O[23] Tile_X0Y0_FrameData[23] VPWR VGND sg13cmos5l_buf_1
X_0703_ _0703_/Q Tile_X0Y2_FrameData[7] VGND VPWR Tile_X0Y5_FrameStrobe[4] latch
XFILLER_356_63 VPWR VGND sg13cmos5l_decap_4
XFILLER_289_116 VPWR VGND sg13cmos5l_decap_4
X_0634_ _0634_/Q Tile_X0Y2_FrameData[12] VGND VPWR Tile_X0Y5_FrameStrobe[2] latch
XANTENNA__2525__A0 AXIL_S_SOC_ARADDR0 VPWR VGND sg13cmos5l_antennanp
XFILLER_143_178 VPWR VGND sg13cmos5l_fill_2
XFILLER_225_12 VPWR VGND sg13cmos5l_fill_2
XFILLER_289_149 VPWR VGND sg13cmos5l_decap_8
XANTENNA__1255__GATE Tile_X0Y5_FrameStrobe[7] VPWR VGND sg13cmos5l_antennanp
XANTENNA__1345__D Tile_X0Y5_FrameData[15] VPWR VGND sg13cmos5l_antennanp
X_0565_ _0565_/Q Tile_X0Y2_FrameData[17] VGND VPWR Tile_X0Y5_FrameStrobe[0] latch
XFILLER_97_221 VPWR VGND sg13cmos5l_fill_2
XFILLER_225_89 VPWR VGND sg13cmos5l_decap_8
XFILLER_24_0 VPWR VGND sg13cmos5l_fill_1
X_2304_ _2304_/X AXIL_S_SOC_WDATA3 AXIL_S_SOC_WDATA11 _2376_/X _2377_/X _0484_/Q _0483_/Q
+ VPWR VGND sg13cmos5l_mux4_1
X_0496_ _0496_/Q Tile_X0Y1_FrameData[6] VGND VPWR Tile_X0Y5_FrameStrobe[5] latch
XFILLER_57_107 VPWR VGND sg13cmos5l_decap_4
XANTENNA__2828__A1 Tile_X0Y5_N2END[3] VPWR VGND sg13cmos5l_antennanp
X_2235_ _2235_/X _2216_/X _0065_/X Tile_X0Y0_S1END[3] Tile_X0Y0_S4END[3] _0120_/Q
+ _0119_/Q VPWR VGND sg13cmos5l_mux4_1
X_2166_ _2166_/X AXIL_S_SOC_WDATA17 AXIL_S_SOC_WDATA25 _2242_/X _2247_/X _0264_/Q
+ _0263_/Q VPWR VGND sg13cmos5l_mux4_1
XFILLER_241_66 VPWR VGND sg13cmos5l_decap_4
X_1117_ _1117_/Q Tile_X0Y4_FrameData[9] VGND VPWR Tile_X0Y5_FrameStrobe[2] latch
XANTENNA__1080__D Tile_X0Y4_FrameData[14] VPWR VGND sg13cmos5l_antennanp
X_2097_ Tile_X0Y3_E2BEGb[1] _2518_/X VPWR VGND sg13cmos5l_buf_1
X_1048_ _1048_/Q Tile_X0Y4_FrameData[14] VGND VPWR Tile_X0Y5_FrameStrobe[0] latch
XFILLER_80_165 VPWR VGND sg13cmos5l_decap_8
XFILLER_166_204 VPWR VGND sg13cmos5l_decap_8
XANTENNA__0424__D Tile_X0Y1_FrameData[14] VPWR VGND sg13cmos5l_antennanp
XANTENNA__1657__X Tile_X0Y0_FrameStrobe_O[17] VPWR VGND sg13cmos5l_antennanp
XANTENNA__1208__GATE Tile_X0Y5_FrameStrobe[5] VPWR VGND sg13cmos5l_antennanp
XANTENNA__2359__A3 Tile_X0Y5_W6END[10] VPWR VGND sg13cmos5l_antennanp
XANTENNA__2764__A0 AXIL_S_SOC_ARPROT2 VPWR VGND sg13cmos5l_antennanp
XFILLER_119_153 VPWR VGND sg13cmos5l_decap_8
XFILLER_134_101 VPWR VGND sg13cmos5l_fill_1
XFILLER_323_201 VPWR VGND sg13cmos5l_fill_2
XANTENNA__0464__GATE Tile_X0Y5_FrameStrobe[4] VPWR VGND sg13cmos5l_antennanp
XFILLER_266_85 VPWR VGND sg13cmos5l_decap_8
XANTENNA__2516__A0 AXIL_S_SOC_ARADDR5 VPWR VGND sg13cmos5l_antennanp
XANTENNA__1255__D Tile_X0Y4_FrameData[31] VPWR VGND sg13cmos5l_antennanp
XANTENNA__1833__A Tile_X0Y4_FrameData[0] VPWR VGND sg13cmos5l_antennanp
XANTENNA__0479__GATE Tile_X0Y5_FrameStrobe[5] VPWR VGND sg13cmos5l_antennanp
XFILLER_135_67 VPWR VGND sg13cmos5l_decap_8
XANTENNA__2819__A1 Tile_X0Y5_N4END[3] VPWR VGND sg13cmos5l_antennanp
XFILLER_236_208 VPWR VGND sg13cmos5l_decap_4
XANTENNA__0402__GATE Tile_X0Y5_FrameStrobe[2] VPWR VGND sg13cmos5l_antennanp
XFILLER_56_173 VPWR VGND sg13cmos5l_decap_8
XFILLER_204_127 VPWR VGND sg13cmos5l_decap_8
XFILLER_301_58 VPWR VGND sg13cmos5l_decap_8
XFILLER_358_131 VPWR VGND sg13cmos5l_fill_2
XANTENNA__0417__GATE Tile_X0Y5_FrameStrobe[3] VPWR VGND sg13cmos5l_antennanp
XFILLER_212_182 VPWR VGND sg13cmos5l_decap_4
XFILLER_338_2 VPWR VGND sg13cmos5l_fill_1
XANTENNA__0334__D Tile_X0Y1_FrameData[8] VPWR VGND sg13cmos5l_antennanp
XANTENNA__1567__X Tile_X0Y3_FrameData_O[13] VPWR VGND sg13cmos5l_antennanp
XFILLER_212_193 VPWR VGND sg13cmos5l_decap_8
XFILLER_8_214 VPWR VGND sg13cmos5l_fill_1
XANTENNA__2755__A0 AXIL_S_SOC_ARPROT2 VPWR VGND sg13cmos5l_antennanp
XFILLER_100_92 VPWR VGND sg13cmos5l_decap_8
XFILLER_176_41 VPWR VGND sg13cmos5l_fill_2
XFILLER_60_85 VPWR VGND sg13cmos5l_fill_1
XFILLER_5_25 VPWR VGND sg13cmos5l_fill_1
XFILLER_326_44 VPWR VGND sg13cmos5l_decap_4
XANTENNA__1165__D Tile_X0Y4_FrameData[25] VPWR VGND sg13cmos5l_antennanp
XANTENNA__1743__A Tile_X0Y2_FrameData[3] VPWR VGND sg13cmos5l_antennanp
XFILLER_140_137 VPWR VGND sg13cmos5l_fill_1
XFILLER_79_221 VPWR VGND sg13cmos5l_fill_2
XFILLER_140_159 VPWR VGND sg13cmos5l_decap_8
XFILLER_192_95 VPWR VGND sg13cmos5l_decap_8
X_0350_ _0350_/Q Tile_X0Y1_FrameData[24] VGND VPWR Tile_X0Y5_FrameStrobe[1] latch
X_0281_ _0281_/Q Tile_X0Y0_FrameData[13] VGND VPWR Tile_X0Y5_FrameStrobe[6] latch
XFILLER_342_21 VPWR VGND sg13cmos5l_decap_8
XFILLER_294_196 VPWR VGND sg13cmos5l_decap_8
X_2020_ Tile_X0Y5_FrameData_O[5] Tile_X0Y5_FrameData[5] VPWR VGND sg13cmos5l_buf_1
XANTENNA__0509__D Tile_X0Y1_FrameData[25] VPWR VGND sg13cmos5l_antennanp
XFILLER_47_151 VPWR VGND sg13cmos5l_decap_8
XFILLER_211_69 VPWR VGND sg13cmos5l_decap_8
XFILLER_250_222 VPWR VGND sg13cmos5l_fill_2
XFILLER_62_143 VPWR VGND sg13cmos5l_decap_4
XFILLER_148_215 VPWR VGND sg13cmos5l_fill_2
XANTENNA__0244__D Tile_X0Y0_FrameData[18] VPWR VGND sg13cmos5l_antennanp
XANTENNA__1918__A Tile_X0Y1_FrameData[31] VPWR VGND sg13cmos5l_antennanp
X_1804_ Tile_X0Y4_E2BEGb[7] _2632_/X VPWR VGND sg13cmos5l_buf_1
X_2784_ _2784_/X _2822_/X _2821_/X _2810_/X _2809_/X _1337_/Q _1336_/Q VPWR VGND sg13cmos5l_mux4_1
XANTENNA__2746__A0 AXIL_S_SOC_ARPROT0 VPWR VGND sg13cmos5l_antennanp
XFILLER_116_112 VPWR VGND sg13cmos5l_fill_1
X_1735_ Tile_X0Y0_E2BEG[7] _2172_/X VPWR VGND sg13cmos5l_buf_1
XANTENNA__2210__A2 Tile_X0Y0_W6END[1] VPWR VGND sg13cmos5l_antennanp
XFILLER_116_134 VPWR VGND sg13cmos5l_decap_8
XANTENNA__1194__GATE Tile_X0Y5_FrameStrobe[5] VPWR VGND sg13cmos5l_antennanp
XFILLER_116_189 VPWR VGND sg13cmos5l_fill_1
XFILLER_236_55 VPWR VGND sg13cmos5l_fill_2
X_1666_ Tile_X0Y0_FrameData_O[6] Tile_X0Y0_FrameData[6] VPWR VGND sg13cmos5l_buf_1
XANTENNA__1075__D Tile_X0Y4_FrameData[19] VPWR VGND sg13cmos5l_antennanp
XANTENNA__1653__A Tile_X0Y5_FrameStrobe[13] VPWR VGND sg13cmos5l_antennanp
XFILLER_131_115 VPWR VGND sg13cmos5l_fill_2
XFILLER_236_88 VPWR VGND sg13cmos5l_decap_8
X_1597_ Tile_X0Y2_EE4BEG[10] _2427_/X VPWR VGND sg13cmos5l_buf_1
X_0617_ _0617_/Q Tile_X0Y2_FrameData[29] VGND VPWR Tile_X0Y5_FrameStrobe[2] latch
XANTENNA__2101__X AXIL_S_SOC_WREADY VPWR VGND sg13cmos5l_antennanp
X_0548_ _0548_/Q Tile_X0Y1_FrameData[18] VGND VPWR Tile_X0Y5_FrameStrobe[7] latch
XFILLER_285_152 VPWR VGND sg13cmos5l_decap_4
XANTENNA__1940__X Tile_X0Y1_E6BEG[5] VPWR VGND sg13cmos5l_antennanp
XFILLER_252_87 VPWR VGND sg13cmos5l_fill_1
XFILLER_285_185 VPWR VGND sg13cmos5l_decap_4
X_0479_ _0479_/Q Tile_X0Y1_FrameData[23] VGND VPWR Tile_X0Y5_FrameStrobe[5] latch
XANTENNA__2277__A2 Tile_X0Y2_WW4END[5] VPWR VGND sg13cmos5l_antennanp
X_2218_ _2218_/X _2216_/X _0065_/X Tile_X0Y0_S1END[3] Tile_X0Y0_S4END[3] _0104_/Q
+ _0103_/Q VPWR VGND sg13cmos5l_mux4_1
XFILLER_38_151 VPWR VGND sg13cmos5l_decap_4
XANTENNA__0419__D Tile_X0Y1_FrameData[19] VPWR VGND sg13cmos5l_antennanp
XANTENNA__1132__GATE Tile_X0Y5_FrameStrobe[3] VPWR VGND sg13cmos5l_antennanp
X_2149_ _2149_/X Tile_X0Y0_W2MID[3] Tile_X0Y0_W2END[3] Tile_X0Y0_W6END[3] _2245_/X
+ _0294_/Q _0293_/Q VPWR VGND sg13cmos5l_mux4_1
XFILLER_201_108 VPWR VGND sg13cmos5l_decap_8
XFILLER_139_204 VPWR VGND sg13cmos5l_decap_8
XFILLER_201_119 VPWR VGND sg13cmos5l_fill_2
XFILLER_331_9 VPWR VGND sg13cmos5l_decap_8
XANTENNA__0154__D Tile_X0Y0_FrameData[12] VPWR VGND sg13cmos5l_antennanp
XANTENNA__1147__GATE Tile_X0Y5_FrameStrobe[3] VPWR VGND sg13cmos5l_antennanp
XFILLER_355_112 VPWR VGND sg13cmos5l_decap_4
XFILLER_277_51 VPWR VGND sg13cmos5l_decap_8
XANTENNA__2737__A0 AXIL_S_SOC_ARPROT2 VPWR VGND sg13cmos5l_antennanp
XFILLER_107_156 VPWR VGND sg13cmos5l_decap_8
XFILLER_107_167 VPWR VGND sg13cmos5l_fill_1
XFILLER_146_55 VPWR VGND sg13cmos5l_decap_8
XANTENNA__1563__A Tile_X0Y3_FrameData[9] VPWR VGND sg13cmos5l_antennanp
XFILLER_107_189 VPWR VGND sg13cmos5l_decap_4
XANTENNA__2011__X Tile_X0Y5_EE4BEG[12] VPWR VGND sg13cmos5l_antennanp
XFILLER_190_2 VPWR VGND sg13cmos5l_fill_1
XFILLER_276_152 VPWR VGND sg13cmos5l_decap_4
XANTENNA__1850__X Tile_X0Y4_FrameData_O[17] VPWR VGND sg13cmos5l_antennanp
XFILLER_162_54 VPWR VGND sg13cmos5l_decap_4
XFILLER_162_65 VPWR VGND sg13cmos5l_decap_4
XFILLER_291_100 VPWR VGND sg13cmos5l_decap_8
XANTENNA__0341__GATE Tile_X0Y5_FrameStrobe[0] VPWR VGND sg13cmos5l_antennanp
XFILLER_291_144 VPWR VGND sg13cmos5l_decap_8
XANTENNA__0329__D Tile_X0Y1_FrameData[13] VPWR VGND sg13cmos5l_antennanp
XANTENNA__0971__GATE Tile_X0Y5_FrameStrobe[5] VPWR VGND sg13cmos5l_antennanp
XFILLER_176_0 VPWR VGND sg13cmos5l_fill_2
XFILLER_232_200 VPWR VGND sg13cmos5l_decap_4
XFILLER_312_57 VPWR VGND sg13cmos5l_fill_2
XANTENNA__0356__GATE Tile_X0Y5_FrameStrobe[1] VPWR VGND sg13cmos5l_antennanp
XFILLER_343_0 VPWR VGND sg13cmos5l_fill_2
XANTENNA__0986__GATE Tile_X0Y5_FrameStrobe[6] VPWR VGND sg13cmos5l_antennanp
XFILLER_111_91 VPWR VGND sg13cmos5l_decap_8
XFILLER_200_130 VPWR VGND sg13cmos5l_decap_8
XFILLER_200_141 VPWR VGND sg13cmos5l_fill_2
XFILLER_71_73 VPWR VGND sg13cmos5l_decap_4
XFILLER_145_207 VPWR VGND sg13cmos5l_fill_2
XFILLER_187_73 VPWR VGND sg13cmos5l_fill_1
XFILLER_346_145 VPWR VGND sg13cmos5l_fill_2
XANTENNA__0999__D Tile_X0Y3_FrameData[15] VPWR VGND sg13cmos5l_antennanp
XANTENNA__2728__A0 AXIL_S_SOC_ARPROT1 VPWR VGND sg13cmos5l_antennanp
XFILLER_337_21 VPWR VGND sg13cmos5l_decap_8
X_1520_ _2337_/A3 VPWR VGND sg13cmos5l_tielo
XFILLER_113_137 VPWR VGND sg13cmos5l_decap_8
XFILLER_206_14 VPWR VGND sg13cmos5l_fill_2
X_1451_ _1451_/Q Tile_X0Y5_FrameData[5] VGND VPWR Tile_X0Y5_FrameStrobe[5] latch
XANTENNA__0924__GATE Tile_X0Y5_FrameStrobe[4] VPWR VGND sg13cmos5l_antennanp
X_1382_ _1382_/Q Tile_X0Y5_FrameData[10] VGND VPWR Tile_X0Y5_FrameStrobe[3] latch
X_0402_ _0402_/Q Tile_X0Y1_FrameData[4] VGND VPWR Tile_X0Y5_FrameStrobe[2] latch
XFILLER_96_70 VPWR VGND sg13cmos5l_decap_8
XFILLER_353_97 VPWR VGND sg13cmos5l_decap_8
XANTENNA__0309__GATE Tile_X0Y5_FrameStrobe[7] VPWR VGND sg13cmos5l_antennanp
XANTENNA__1760__X Tile_X0Y2_FrameData_O[20] VPWR VGND sg13cmos5l_antennanp
XFILLER_282_111 VPWR VGND sg13cmos5l_decap_8
X_0333_ _0333_/Q Tile_X0Y1_FrameData[9] VGND VPWR Tile_X0Y5_FrameStrobe[0] latch
XANTENNA__0939__GATE Tile_X0Y5_FrameStrobe[4] VPWR VGND sg13cmos5l_antennanp
XANTENNA__2259__A2 Tile_X0Y2_W6END[2] VPWR VGND sg13cmos5l_antennanp
X_0264_ _0264_/Q Tile_X0Y0_FrameData[30] VGND VPWR Tile_X0Y5_FrameStrobe[6] latch
XANTENNA__0239__D Tile_X0Y0_FrameData[23] VPWR VGND sg13cmos5l_antennanp
XFILLER_222_46 VPWR VGND sg13cmos5l_decap_8
X_2003_ Tile_X0Y5_EE4BEG[4] _2745_/X VPWR VGND sg13cmos5l_buf_1
X_0195_ _0195_/Q Tile_X0Y0_FrameData[3] VGND VPWR Tile_X0Y5_FrameStrobe[3] latch
XFILLER_35_110 VPWR VGND sg13cmos5l_decap_8
XFILLER_223_211 VPWR VGND sg13cmos5l_decap_8
XFILLER_35_198 VPWR VGND sg13cmos5l_fill_2
XFILLER_195_118 VPWR VGND sg13cmos5l_decap_4
XFILLER_50_157 VPWR VGND sg13cmos5l_fill_2
XANTENNA__1648__A Tile_X0Y5_FrameStrobe[8] VPWR VGND sg13cmos5l_antennanp
X_2836_ _2836_/X Tile_X0Y4_W1END[3] Tile_X0Y4_W2MID[0] Tile_X0Y4_W2END[0] _2681_/X
+ _1110_/Q _1109_/Q VPWR VGND sg13cmos5l_mux4_1
XANTENNA__2719__A0 Tile_X0Y3_W1END[2] VPWR VGND sg13cmos5l_antennanp
XFILLER_247_21 VPWR VGND sg13cmos5l_fill_1
XFILLER_247_32 VPWR VGND sg13cmos5l_fill_2
XFILLER_352_115 VPWR VGND sg13cmos5l_decap_8
XANTENNA__0702__D Tile_X0Y2_FrameData[8] VPWR VGND sg13cmos5l_antennanp
XANTENNA__1935__X Tile_X0Y1_E6BEG[0] VPWR VGND sg13cmos5l_antennanp
XANTENNA__2195__A1 AXIL_S_SOC_WDATA30 VPWR VGND sg13cmos5l_antennanp
X_2767_ _2767_/X AXIL_S_SOC_ARPROT2 _2822_/X _2821_/X _2798_/X _1368_/Q _1367_/Q VPWR
+ VGND sg13cmos5l_mux4_1
X_1718_ Tile_X0Y0_E6BEG[10] _2207_/X VPWR VGND sg13cmos5l_buf_1
X_2698_ _2698_/X Tile_X0Y0_W1END[3] Tile_X0Y0_WW4END[11] Tile_X0Y0_WW4END[15] Tile_X0Y0_W6END[7]
+ _0145_/Q _0144_/Q VPWR VGND sg13cmos5l_mux4_1
X_1649_ Tile_X0Y0_FrameStrobe_O[9] Tile_X0Y5_FrameStrobe[9] VPWR VGND sg13cmos5l_buf_1
XANTENNA__2498__A2 Tile_X0Y4_W6END[3] VPWR VGND sg13cmos5l_antennanp
XFILLER_112_170 VPWR VGND sg13cmos5l_fill_2
XFILLER_76_18 VPWR VGND sg13cmos5l_fill_1
XANTENNA__1670__X Tile_X0Y0_FrameData_O[10] VPWR VGND sg13cmos5l_antennanp
XFILLER_273_111 VPWR VGND sg13cmos5l_fill_2
XFILLER_132_13 VPWR VGND sg13cmos5l_decap_8
XANTENNA__0149__D Tile_X0Y0_FrameData[17] VPWR VGND sg13cmos5l_antennanp
XANTENNA__1071__GATE Tile_X0Y5_FrameStrobe[1] VPWR VGND sg13cmos5l_antennanp
XANTENNA__2670__A2 Tile_X0Y4_W6END[1] VPWR VGND sg13cmos5l_antennanp
XANTENNA__1086__GATE Tile_X0Y5_FrameStrobe[1] VPWR VGND sg13cmos5l_antennanp
XFILLER_148_4 VPWR VGND sg13cmos5l_fill_1
XFILLER_186_129 VPWR VGND sg13cmos5l_decap_8
XANTENNA__1558__A Tile_X0Y3_FrameData[4] VPWR VGND sg13cmos5l_antennanp
XANTENNA__2006__X Tile_X0Y5_EE4BEG[7] VPWR VGND sg13cmos5l_antennanp
XFILLER_194_140 VPWR VGND sg13cmos5l_fill_1
XFILLER_328_156 VPWR VGND sg13cmos5l_fill_1
XFILLER_157_10 VPWR VGND sg13cmos5l_fill_2
XFILLER_194_173 VPWR VGND sg13cmos5l_decap_8
XFILLER_41_65 VPWR VGND sg13cmos5l_fill_1
XANTENNA__0612__D Tile_X0Y2_FrameData[2] VPWR VGND sg13cmos5l_antennanp
XANTENNA__1845__X Tile_X0Y4_FrameData_O[12] VPWR VGND sg13cmos5l_antennanp
XANTENNA__2186__A1 AXIL_S_SOC_WDATA25 VPWR VGND sg13cmos5l_antennanp
XFILLER_157_43 VPWR VGND sg13cmos5l_decap_8
XFILLER_351_170 VPWR VGND sg13cmos5l_fill_2
XFILLER_307_68 VPWR VGND sg13cmos5l_fill_2
XANTENNA__1024__GATE Tile_X0Y5_FrameStrobe[7] VPWR VGND sg13cmos5l_antennanp
XANTENNA__2489__A2 Tile_X0Y1_W6END[8] VPWR VGND sg13cmos5l_antennanp
XFILLER_293_0 VPWR VGND sg13cmos5l_fill_2
XANTENNA__0280__GATE Tile_X0Y5_FrameStrobe[6] VPWR VGND sg13cmos5l_antennanp
XANTENNA__1443__D Tile_X0Y5_FrameData[13] VPWR VGND sg13cmos5l_antennanp
XANTENNA__1580__X Tile_X0Y3_FrameData_O[26] VPWR VGND sg13cmos5l_antennanp
XFILLER_106_80 VPWR VGND sg13cmos5l_decap_8
XFILLER_323_34 VPWR VGND sg13cmos5l_fill_1
XFILLER_323_23 VPWR VGND sg13cmos5l_decap_8
XANTENNA__1039__GATE Tile_X0Y5_FrameStrobe[0] VPWR VGND sg13cmos5l_antennanp
XFILLER_64_216 VPWR VGND sg13cmos5l_fill_2
XFILLER_264_188 VPWR VGND sg13cmos5l_fill_2
XANTENNA__0295__GATE Tile_X0Y5_FrameStrobe[7] VPWR VGND sg13cmos5l_antennanp
XANTENNA__2110__A1 Tile_X0Y3_W2END[4] VPWR VGND sg13cmos5l_antennanp
XANTENNA__2661__A2 Tile_X0Y4_W6END[4] VPWR VGND sg13cmos5l_antennanp
X_0951_ _0951_/Q Tile_X0Y3_FrameData[31] VGND VPWR Tile_X0Y5_FrameStrobe[5] latch
XFILLER_82_94 VPWR VGND sg13cmos5l_decap_4
XFILLER_32_157 VPWR VGND sg13cmos5l_decap_8
XFILLER_185_140 VPWR VGND sg13cmos5l_fill_1
XFILLER_348_42 VPWR VGND sg13cmos5l_fill_1
XFILLER_348_31 VPWR VGND sg13cmos5l_decap_8
XFILLER_185_151 VPWR VGND sg13cmos5l_fill_2
X_0882_ _0882_/Q Tile_X0Y3_FrameData[4] VGND VPWR Tile_X0Y5_FrameStrobe[2] latch
XFILLER_348_53 VPWR VGND sg13cmos5l_decap_8
XFILLER_334_115 VPWR VGND sg13cmos5l_decap_4
XANTENNA__0522__D Tile_X0Y1_FrameData[12] VPWR VGND sg13cmos5l_antennanp
XANTENNA__1755__X Tile_X0Y2_FrameData_O[15] VPWR VGND sg13cmos5l_antennanp
XANTENNA__2177__A1 AXIL_S_SOC_WDATA28 VPWR VGND sg13cmos5l_antennanp
X_2621_ _2621_/X AXIL_S_SOC_WSTRB0 AXIL_S_SOC_WVALID _2711_/X _2712_/X _1212_/Q _1211_/Q
+ VPWR VGND sg13cmos5l_mux4_1
XANTENNA__0233__GATE Tile_X0Y5_FrameStrobe[5] VPWR VGND sg13cmos5l_antennanp
XFILLER_217_24 VPWR VGND sg13cmos5l_decap_8
X_2552_ _2552_/X AXIL_S_SOC_ARADDR3 _2588_/X _2587_/X _2596_/X _0900_/Q _0899_/Q VPWR
+ VGND sg13cmos5l_mux4_1
XANTENNA__0863__GATE Tile_X0Y5_FrameStrobe[2] VPWR VGND sg13cmos5l_antennanp
XFILLER_141_221 VPWR VGND sg13cmos5l_fill_2
XFILLER_217_68 VPWR VGND sg13cmos5l_fill_1
X_1503_ _2561_/A3 VPWR VGND sg13cmos5l_tielo
X_2483_ _2483_/X _2386_/X _2494_/X _2493_/X _2385_/X _0570_/Q _0569_/Q VPWR VGND sg13cmos5l_mux4_1
XFILLER_342_192 VPWR VGND sg13cmos5l_fill_2
X_1434_ _1434_/Q Tile_X0Y5_FrameData[22] VGND VPWR Tile_X0Y5_FrameStrobe[5] latch
XANTENNA__0248__GATE Tile_X0Y5_FrameStrobe[5] VPWR VGND sg13cmos5l_antennanp
XANTENNA__0878__GATE Tile_X0Y5_FrameStrobe[2] VPWR VGND sg13cmos5l_antennanp
XANTENNA__1353__D Tile_X0Y5_FrameData[7] VPWR VGND sg13cmos5l_antennanp
X_1365_ _1365_/Q Tile_X0Y5_FrameData[27] VGND VPWR Tile_X0Y5_FrameStrobe[3] latch
XFILLER_233_78 VPWR VGND sg13cmos5l_decap_8
X_0316_ _0316_/Q Tile_X0Y1_FrameData[26] VGND VPWR Tile_X0Y5_FrameStrobe[0] latch
X_1296_ _1296_/Q Tile_X0Y5_FrameData[0] VGND VPWR Tile_X0Y5_FrameStrobe[0] latch
XANTENNA__0801__GATE Tile_X0Y5_FrameStrobe[0] VPWR VGND sg13cmos5l_antennanp
XANTENNA__2101__A1 Tile_X0Y4_W2END[1] VPWR VGND sg13cmos5l_antennanp
XFILLER_255_188 VPWR VGND sg13cmos5l_decap_8
XFILLER_255_199 VPWR VGND sg13cmos5l_fill_2
XFILLER_270_136 VPWR VGND sg13cmos5l_decap_8
X_0247_ _0247_/Q Tile_X0Y0_FrameData[15] VGND VPWR Tile_X0Y5_FrameStrobe[5] latch
X_0178_ _0178_/Q Tile_X0Y0_FrameData[20] VGND VPWR Tile_X0Y5_FrameStrobe[3] latch
XFILLER_168_118 VPWR VGND sg13cmos5l_decap_8
XANTENNA__0816__GATE Tile_X0Y5_FrameStrobe[0] VPWR VGND sg13cmos5l_antennanp
XFILLER_258_20 VPWR VGND sg13cmos5l_fill_2
XFILLER_258_42 VPWR VGND sg13cmos5l_decap_8
XFILLER_127_9 VPWR VGND sg13cmos5l_fill_2
XANTENNA__1665__X Tile_X0Y0_FrameData_O[5] VPWR VGND sg13cmos5l_antennanp
XANTENNA__2168__A1 AXIL_S_SOC_WDATA27 VPWR VGND sg13cmos5l_antennanp
XFILLER_176_195 VPWR VGND sg13cmos5l_decap_8
X_2819_ _2819_/X Tile_X0Y5_N1END[3] Tile_X0Y5_N4END[3] _2796_/X _0057_/X _1314_/Q
+ _1313_/Q VPWR VGND sg13cmos5l_mux4_1
XANTENNA__0432__D Tile_X0Y1_FrameData[6] VPWR VGND sg13cmos5l_antennanp
XFILLER_11_35 VPWR VGND sg13cmos5l_fill_2
XFILLER_132_210 VPWR VGND sg13cmos5l_decap_4
XFILLER_127_79 VPWR VGND sg13cmos5l_decap_8
XFILLER_274_85 VPWR VGND sg13cmos5l_decap_4
XFILLER_2_8 VPWR VGND sg13cmos5l_fill_1
XANTENNA__1263__D Tile_X0Y4_FrameData[23] VPWR VGND sg13cmos5l_antennanp
XANTENNA__1841__A Tile_X0Y4_FrameData[8] VPWR VGND sg13cmos5l_antennanp
XFILLER_261_114 VPWR VGND sg13cmos5l_decap_8
XFILLER_36_54 VPWR VGND sg13cmos5l_decap_4
XFILLER_36_65 VPWR VGND sg13cmos5l_decap_8
XFILLER_299_60 VPWR VGND sg13cmos5l_decap_8
XANTENNA__0607__D Tile_X0Y2_FrameData[7] VPWR VGND sg13cmos5l_antennanp
XFILLER_159_118 VPWR VGND sg13cmos5l_decap_8
XFILLER_52_97 VPWR VGND sg13cmos5l_fill_2
XANTENNA__1438__D Tile_X0Y5_FrameData[18] VPWR VGND sg13cmos5l_antennanp
XANTENNA__1575__X Tile_X0Y3_FrameData_O[21] VPWR VGND sg13cmos5l_antennanp
XFILLER_167_195 VPWR VGND sg13cmos5l_decap_8
XFILLER_168_97 VPWR VGND sg13cmos5l_decap_8
XFILLER_318_34 VPWR VGND sg13cmos5l_decap_8
XANTENNA__0342__D Tile_X0Y1_FrameData[0] VPWR VGND sg13cmos5l_antennanp
XANTENNA__2159__A1 Tile_X0Y0_WW4END[3] VPWR VGND sg13cmos5l_antennanp
XFILLER_123_210 VPWR VGND sg13cmos5l_fill_2
XFILLER_184_30 VPWR VGND sg13cmos5l_decap_8
XFILLER_184_74 VPWR VGND sg13cmos5l_decap_4
XFILLER_96_105 VPWR VGND sg13cmos5l_decap_8
XFILLER_334_55 VPWR VGND sg13cmos5l_fill_1
XANTENNA__1173__D Tile_X0Y4_FrameData[17] VPWR VGND sg13cmos5l_antennanp
XANTENNA__1751__A Tile_X0Y2_FrameData[11] VPWR VGND sg13cmos5l_antennanp
XFILLER_237_111 VPWR VGND sg13cmos5l_decap_8
X_1150_ _1150_/Q Tile_X0Y4_FrameData[8] VGND VPWR Tile_X0Y5_FrameStrobe[3] latch
X_0101_ _0101_/Q Tile_X0Y0_FrameData[1] VGND VPWR Tile_X0Y5_FrameStrobe[0] latch
XFILLER_350_21 VPWR VGND sg13cmos5l_decap_8
XFILLER_252_136 VPWR VGND sg13cmos5l_fill_1
X_1081_ _1081_/Q Tile_X0Y4_FrameData[13] VGND VPWR Tile_X0Y5_FrameStrobe[1] latch
XFILLER_350_76 VPWR VGND sg13cmos5l_decap_8
XFILLER_252_158 VPWR VGND sg13cmos5l_decap_8
X_0032_ _0032_/X _2803_/X _2804_/X _0392_/Q VPWR VGND sg13cmos5l_mux2_1
XANTENNA__0517__D Tile_X0Y1_FrameData[17] VPWR VGND sg13cmos5l_antennanp
XFILLER_20_105 VPWR VGND sg13cmos5l_decap_4
XFILLER_260_180 VPWR VGND sg13cmos5l_decap_8
XFILLER_20_138 VPWR VGND sg13cmos5l_fill_1
X_1983_ Tile_X0Y5_E2BEGb[4] _2737_/X VPWR VGND sg13cmos5l_buf_1
XFILLER_158_151 VPWR VGND sg13cmos5l_decap_8
XFILLER_20_149 VPWR VGND sg13cmos5l_fill_2
X_0934_ _0934_/Q Tile_X0Y3_FrameData[16] VGND VPWR Tile_X0Y5_FrameStrobe[4] latch
XFILLER_295_29 VPWR VGND sg13cmos5l_decap_4
XFILLER_295_18 VPWR VGND sg13cmos5l_decap_8
XANTENNA__0172__GATE Tile_X0Y5_FrameStrobe[3] VPWR VGND sg13cmos5l_antennanp
XANTENNA__1348__D Tile_X0Y5_FrameData[12] VPWR VGND sg13cmos5l_antennanp
XFILLER_158_195 VPWR VGND sg13cmos5l_fill_1
XFILLER_228_23 VPWR VGND sg13cmos5l_fill_1
X_0865_ _0865_/Q Tile_X0Y3_FrameData[21] VGND VPWR Tile_X0Y5_FrameStrobe[2] latch
XANTENNA__0252__D Tile_X0Y0_FrameData[10] VPWR VGND sg13cmos5l_antennanp
XFILLER_228_45 VPWR VGND sg13cmos5l_decap_8
X_2604_ _2604_/X Tile_X0Y5_W2MID[4] Tile_X0Y5_W2END[4] Tile_X0Y5_W6END[4] _2828_/X
+ _1482_/Q _1481_/Q VPWR VGND sg13cmos5l_mux4_1
X_0796_ _0796_/Q Tile_X0Y3_FrameData[26] VGND VPWR Tile_X0Y5_FrameStrobe[0] latch
XFILLER_54_0 VPWR VGND sg13cmos5l_fill_2
XANTENNA__2570__A1 Tile_X0Y4_W6END[6] VPWR VGND sg13cmos5l_antennanp
X_2535_ _2535_/X AXIL_S_SOC_ARADDR0 AXIL_S_SOC_ARADDR6 _2585_/X _2594_/X _0934_/Q
+ _0933_/Q VPWR VGND sg13cmos5l_mux4_1
XANTENNA__0187__GATE Tile_X0Y5_FrameStrobe[3] VPWR VGND sg13cmos5l_antennanp
XFILLER_244_55 VPWR VGND sg13cmos5l_fill_2
X_2466_ _2466_/X _2464_/X Tile_X0Y5_N4END[15] _2463_/X Tile_X0Y0_S4END[11] _0584_/Q
+ _0583_/Q VPWR VGND sg13cmos5l_mux4_1
XANTENNA__1083__D Tile_X0Y4_FrameData[11] VPWR VGND sg13cmos5l_antennanp
X_1417_ _1417_/Q Tile_X0Y5_FrameData[7] VGND VPWR Tile_X0Y5_FrameStrobe[4] latch
XFILLER_330_195 VPWR VGND sg13cmos5l_fill_2
XANTENNA__1661__A Tile_X0Y0_FrameData[1] VPWR VGND sg13cmos5l_antennanp
XANTENNA__2322__A1 AXIL_S_SOC_WDATA13 VPWR VGND sg13cmos5l_antennanp
X_2397_ _2397_/X _2458_/X _2457_/X AXIL_S_SOC_AWADDR2 AXIL_S_SOC_AWADDR7 _0754_/Q
+ _0753_/Q VPWR VGND sg13cmos5l_mux4_1
XANTENNA__0110__GATE Tile_X0Y5_FrameStrobe[1] VPWR VGND sg13cmos5l_antennanp
XFILLER_228_166 VPWR VGND sg13cmos5l_fill_2
X_1348_ _1348_/Q Tile_X0Y5_FrameData[12] VGND VPWR Tile_X0Y5_FrameStrobe[2] latch
XFILLER_95_160 VPWR VGND sg13cmos5l_decap_8
XANTENNA__0740__GATE Tile_X0Y5_FrameStrobe[5] VPWR VGND sg13cmos5l_antennanp
XFILLER_243_114 VPWR VGND sg13cmos5l_decap_8
X_1279_ _1279_/Q Tile_X0Y5_FrameData[17] VGND VPWR Tile_X0Y5_FrameStrobe[0] latch
XFILLER_243_158 VPWR VGND sg13cmos5l_decap_8
XANTENNA__0125__GATE Tile_X0Y5_FrameStrobe[1] VPWR VGND sg13cmos5l_antennanp
XANTENNA__0427__D Tile_X0Y1_FrameData[11] VPWR VGND sg13cmos5l_antennanp
XANTENNA__0755__GATE Tile_X0Y5_FrameStrobe[6] VPWR VGND sg13cmos5l_antennanp
XFILLER_269_41 VPWR VGND sg13cmos5l_decap_4
XANTENNA__2389__A1 Tile_X0Y0_W2MID[3] VPWR VGND sg13cmos5l_antennanp
XFILLER_149_151 VPWR VGND sg13cmos5l_fill_1
XFILLER_22_12 VPWR VGND sg13cmos5l_fill_2
XANTENNA__1258__D Tile_X0Y4_FrameData[28] VPWR VGND sg13cmos5l_antennanp
XFILLER_138_23 VPWR VGND sg13cmos5l_decap_8
XFILLER_22_56 VPWR VGND sg13cmos5l_decap_4
XANTENNA__0162__D Tile_X0Y0_FrameData[4] VPWR VGND sg13cmos5l_antennanp
XANTENNA__1836__A Tile_X0Y4_FrameData[3] VPWR VGND sg13cmos5l_antennanp
XFILLER_164_143 VPWR VGND sg13cmos5l_decap_8
XFILLER_22_78 VPWR VGND sg13cmos5l_decap_8
XFILLER_22_89 VPWR VGND sg13cmos5l_fill_2
XFILLER_285_62 VPWR VGND sg13cmos5l_decap_4
XFILLER_138_89 VPWR VGND sg13cmos5l_decap_8
XFILLER_313_129 VPWR VGND sg13cmos5l_fill_2
XFILLER_154_44 VPWR VGND sg13cmos5l_decap_8
XFILLER_321_162 VPWR VGND sg13cmos5l_decap_8
XFILLER_154_88 VPWR VGND sg13cmos5l_fill_2
XFILLER_78_149 VPWR VGND sg13cmos5l_decap_4
XANTENNA__1571__A Tile_X0Y3_FrameData[17] VPWR VGND sg13cmos5l_antennanp
XANTENNA__2313__A1 AXIL_S_SOC_WDATA8 VPWR VGND sg13cmos5l_antennanp
XANTENNA__0708__GATE Tile_X0Y5_FrameStrobe[4] VPWR VGND sg13cmos5l_antennanp
XFILLER_234_125 VPWR VGND sg13cmos5l_decap_8
XANTENNA__2616__A2 AXIL_S_SOC_WSTRB1 VPWR VGND sg13cmos5l_antennanp
XFILLER_320_35 VPWR VGND sg13cmos5l_decap_8
XANTENNA__0337__D Tile_X0Y1_FrameData[5] VPWR VGND sg13cmos5l_antennanp
XFILLER_256_0 VPWR VGND sg13cmos5l_decap_8
XFILLER_320_68 VPWR VGND sg13cmos5l_decap_4
XFILLER_320_57 VPWR VGND sg13cmos5l_decap_8
XFILLER_63_85 VPWR VGND sg13cmos5l_decap_8
XFILLER_179_63 VPWR VGND sg13cmos5l_fill_1
XFILLER_63_96 VPWR VGND sg13cmos5l_fill_1
XFILLER_179_96 VPWR VGND sg13cmos5l_decap_8
XFILLER_329_33 VPWR VGND sg13cmos5l_decap_8
XANTENNA__1168__D Tile_X0Y4_FrameData[22] VPWR VGND sg13cmos5l_antennanp
XFILLER_155_132 VPWR VGND sg13cmos5l_decap_8
XFILLER_329_66 VPWR VGND sg13cmos5l_fill_2
XANTENNA__0072__D Tile_X0Y0_FrameData[30] VPWR VGND sg13cmos5l_antennanp
XANTENNA__1746__A Tile_X0Y2_FrameData[6] VPWR VGND sg13cmos5l_antennanp
XFILLER_195_62 VPWR VGND sg13cmos5l_fill_1
XFILLER_195_84 VPWR VGND sg13cmos5l_decap_4
XFILLER_195_95 VPWR VGND sg13cmos5l_decap_8
X_0650_ _0650_/Q Tile_X0Y2_FrameData[28] VGND VPWR Tile_X0Y5_FrameStrobe[3] latch
XFILLER_345_32 VPWR VGND sg13cmos5l_decap_8
XFILLER_345_21 VPWR VGND sg13cmos5l_fill_1
XFILLER_345_10 VPWR VGND sg13cmos5l_decap_8
X_0581_ _0581_/Q Tile_X0Y2_FrameData[1] VGND VPWR Tile_X0Y5_FrameStrobe[0] latch
XANTENNA__0800__D Tile_X0Y3_FrameData[22] VPWR VGND sg13cmos5l_antennanp
X_2320_ _2320_/X AXIL_S_SOC_WDATA7 AXIL_S_SOC_WDATA11 _2371_/X _2377_/X _0452_/Q _0451_/Q
+ VPWR VGND sg13cmos5l_mux4_1
XFILLER_345_76 VPWR VGND sg13cmos5l_decap_8
X_2251_ _2251_/X Tile_X0Y2_W2MID[6] Tile_X0Y2_W2END[6] Tile_X0Y2_W6END[6] _2482_/X
+ _0780_/Q _0779_/Q VPWR VGND sg13cmos5l_mux4_1
XANTENNA__2304__A1 AXIL_S_SOC_WDATA11 VPWR VGND sg13cmos5l_antennanp
X_1202_ _1202_/Q Tile_X0Y4_FrameData[20] VGND VPWR Tile_X0Y5_FrameStrobe[5] latch
XFILLER_272_209 VPWR VGND sg13cmos5l_fill_2
X_2182_ _2182_/X AXIL_S_SOC_WDATA17 AXIL_S_SOC_WDATA29 _2221_/X _2247_/X _0232_/Q
+ _0231_/Q VPWR VGND sg13cmos5l_mux4_1
X_1133_ _1133_/Q Tile_X0Y4_FrameData[25] VGND VPWR Tile_X0Y5_FrameStrobe[3] latch
XFILLER_77_193 VPWR VGND sg13cmos5l_fill_1
XANTENNA__1470__GATE Tile_X0Y5_FrameStrobe[6] VPWR VGND sg13cmos5l_antennanp
X_1064_ _1064_/Q Tile_X0Y4_FrameData[30] VGND VPWR Tile_X0Y5_FrameStrobe[1] latch
XFILLER_92_152 VPWR VGND sg13cmos5l_decap_8
XANTENNA__0247__D Tile_X0Y0_FrameData[15] VPWR VGND sg13cmos5l_antennanp
XANTENNA__2607__A2 Tile_X0Y2_W2END[2] VPWR VGND sg13cmos5l_antennanp
XANTENNA__1485__GATE Tile_X0Y5_FrameStrobe[6] VPWR VGND sg13cmos5l_antennanp
XFILLER_239_22 VPWR VGND sg13cmos5l_decap_8
X_1966_ Tile_X0Y1_E1BEG[3] _2292_/X VPWR VGND sg13cmos5l_buf_1
XANTENNA__1078__D Tile_X0Y4_FrameData[16] VPWR VGND sg13cmos5l_antennanp
XFILLER_146_121 VPWR VGND sg13cmos5l_decap_8
X_0917_ _0917_/Q Tile_X0Y3_FrameData[1] VGND VPWR Tile_X0Y5_FrameStrobe[3] latch
XANTENNA__1656__A Tile_X0Y5_FrameStrobe[16] VPWR VGND sg13cmos5l_antennanp
XANTENNA__2104__X AXIL_S_SOC_BVALID VPWR VGND sg13cmos5l_antennanp
X_1897_ Tile_X0Y1_FrameData_O[10] Tile_X0Y1_FrameData[10] VPWR VGND sg13cmos5l_buf_1
XFILLER_255_10 VPWR VGND sg13cmos5l_decap_8
X_0848_ _0848_/Q Tile_X0Y3_FrameData[6] VGND VPWR Tile_X0Y5_FrameStrobe[1] latch
XANTENNA__1943__X Tile_X0Y1_E6BEG[8] VPWR VGND sg13cmos5l_antennanp
XFILLER_255_32 VPWR VGND sg13cmos5l_decap_8
X_0779_ _0779_/Q Tile_X0Y2_FrameData[27] VGND VPWR Tile_X0Y5_FrameStrobe[7] latch
XANTENNA__0710__D Tile_X0Y2_FrameData[0] VPWR VGND sg13cmos5l_antennanp
XANTENNA__2543__A1 Tile_X0Y0_S4END[14] VPWR VGND sg13cmos5l_antennanp
XFILLER_161_168 VPWR VGND sg13cmos5l_decap_8
X_2518_ _2518_/X AXIL_S_SOC_ARADDR1 AXIL_S_SOC_ARADDR9 _2590_/X _2595_/X _0968_/Q
+ _0967_/Q VPWR VGND sg13cmos5l_mux4_1
XANTENNA__1423__GATE Tile_X0Y5_FrameStrobe[4] VPWR VGND sg13cmos5l_antennanp
XFILLER_248_217 VPWR VGND sg13cmos5l_fill_1
XFILLER_124_36 VPWR VGND sg13cmos5l_decap_4
XFILLER_124_47 VPWR VGND sg13cmos5l_decap_8
X_2449_ _2449_/X Tile_X0Y2_W1END[2] Tile_X0Y2_WW4END[10] Tile_X0Y2_WW4END[14] Tile_X0Y2_W6END[6]
+ _0628_/Q _0627_/Q VPWR VGND sg13cmos5l_mux4_1
XFILLER_68_171 VPWR VGND sg13cmos5l_fill_1
XANTENNA__1438__GATE Tile_X0Y5_FrameStrobe[5] VPWR VGND sg13cmos5l_antennanp
XANTENNA__0157__D Tile_X0Y0_FrameData[9] VPWR VGND sg13cmos5l_antennanp
XANTENNA__0694__GATE Tile_X0Y5_FrameStrobe[4] VPWR VGND sg13cmos5l_antennanp
XFILLER_17_78 VPWR VGND sg13cmos5l_decap_8
XFILLER_17_89 VPWR VGND sg13cmos5l_fill_1
XFILLER_231_106 VPWR VGND sg13cmos5l_decap_8
XFILLER_231_128 VPWR VGND sg13cmos5l_fill_1
XFILLER_347_7 VPWR VGND sg13cmos5l_decap_8
XFILLER_33_33 VPWR VGND sg13cmos5l_fill_1
XANTENNA__0079__GATE Tile_X0Y5_FrameStrobe[0] VPWR VGND sg13cmos5l_antennanp
XFILLER_33_44 VPWR VGND sg13cmos5l_fill_2
XANTENNA__2231__A0 Tile_X0Y4_W1END[3] VPWR VGND sg13cmos5l_antennanp
XFILLER_149_55 VPWR VGND sg13cmos5l_decap_4
XFILLER_33_88 VPWR VGND sg13cmos5l_decap_8
XANTENNA__1566__A Tile_X0Y3_FrameData[12] VPWR VGND sg13cmos5l_antennanp
XFILLER_149_88 VPWR VGND sg13cmos5l_fill_2
XANTENNA__2014__X Tile_X0Y5_EE4BEG[15] VPWR VGND sg13cmos5l_antennanp
XANTENNA__0632__GATE Tile_X0Y5_FrameStrobe[2] VPWR VGND sg13cmos5l_antennanp
XFILLER_152_146 VPWR VGND sg13cmos5l_decap_8
XFILLER_165_54 VPWR VGND sg13cmos5l_fill_1
XFILLER_298_117 VPWR VGND sg13cmos5l_fill_2
XANTENNA__0620__D Tile_X0Y2_FrameData[26] VPWR VGND sg13cmos5l_antennanp
XANTENNA__1853__X Tile_X0Y4_FrameData_O[20] VPWR VGND sg13cmos5l_antennanp
XANTENNA__2534__A1 AXIL_S_SOC_ARADDR9 VPWR VGND sg13cmos5l_antennanp
XFILLER_3_178 VPWR VGND sg13cmos5l_fill_2
XFILLER_315_13 VPWR VGND sg13cmos5l_fill_1
XFILLER_315_57 VPWR VGND sg13cmos5l_decap_8
XANTENNA__0647__GATE Tile_X0Y5_FrameStrobe[3] VPWR VGND sg13cmos5l_antennanp
XANTENNA__2298__A0 AXIL_S_SOC_WDATA5 VPWR VGND sg13cmos5l_antennanp
XFILLER_59_160 VPWR VGND sg13cmos5l_decap_8
XFILLER_58_96 VPWR VGND sg13cmos5l_fill_2
XANTENNA__1451__D Tile_X0Y5_FrameData[5] VPWR VGND sg13cmos5l_antennanp
XFILLER_207_125 VPWR VGND sg13cmos5l_decap_8
XFILLER_331_23 VPWR VGND sg13cmos5l_decap_4
XFILLER_74_40 VPWR VGND sg13cmos5l_decap_8
XFILLER_74_163 VPWR VGND sg13cmos5l_fill_2
XFILLER_331_78 VPWR VGND sg13cmos5l_decap_8
XFILLER_200_16 VPWR VGND sg13cmos5l_decap_4
XFILLER_200_38 VPWR VGND sg13cmos5l_fill_1
X_1820_ Tile_X0Y4_EE4BEG[3] _2636_/X VPWR VGND sg13cmos5l_buf_1
XANTENNA__2773__A1 Tile_X0Y5_W2END[7] VPWR VGND sg13cmos5l_antennanp
X_1751_ Tile_X0Y2_FrameData_O[11] Tile_X0Y2_FrameData[11] VPWR VGND sg13cmos5l_buf_1
XFILLER_209_47 VPWR VGND sg13cmos5l_decap_8
XFILLER_209_58 VPWR VGND sg13cmos5l_fill_1
X_1682_ Tile_X0Y0_FrameData_O[22] Tile_X0Y0_FrameData[22] VPWR VGND sg13cmos5l_buf_1
X_0702_ _0702_/Q Tile_X0Y2_FrameData[8] VGND VPWR Tile_X0Y5_FrameStrobe[4] latch
XFILLER_356_75 VPWR VGND sg13cmos5l_decap_4
XFILLER_356_42 VPWR VGND sg13cmos5l_decap_8
XFILLER_289_128 VPWR VGND sg13cmos5l_decap_8
X_0633_ _0633_/Q Tile_X0Y2_FrameData[13] VGND VPWR Tile_X0Y5_FrameStrobe[2] latch
XFILLER_356_86 VPWR VGND sg13cmos5l_fill_2
XANTENNA__0530__D Tile_X0Y1_FrameData[4] VPWR VGND sg13cmos5l_antennanp
XANTENNA__1763__X Tile_X0Y2_FrameData_O[23] VPWR VGND sg13cmos5l_antennanp
XANTENNA__2525__A1 AXIL_S_SOC_ARADDR2 VPWR VGND sg13cmos5l_antennanp
XFILLER_143_168 VPWR VGND sg13cmos5l_fill_2
XFILLER_225_24 VPWR VGND sg13cmos5l_decap_4
XFILLER_225_35 VPWR VGND sg13cmos5l_decap_8
X_2303_ _2303_/X AXIL_S_SOC_WDATA2 AXIL_S_SOC_WDATA10 _2375_/X _2378_/X _0486_/Q _0485_/Q
+ VPWR VGND sg13cmos5l_mux4_1
X_0564_ _0564_/Q Tile_X0Y2_FrameData[18] VGND VPWR Tile_X0Y5_FrameStrobe[0] latch
XFILLER_225_68 VPWR VGND sg13cmos5l_decap_8
X_0495_ _0495_/Q Tile_X0Y1_FrameData[7] VGND VPWR Tile_X0Y5_FrameStrobe[5] latch
XFILLER_300_143 VPWR VGND sg13cmos5l_fill_2
XFILLER_300_121 VPWR VGND sg13cmos5l_decap_8
X_2234_ _2234_/X _2215_/X _0064_/X Tile_X0Y0_S1END[2] Tile_X0Y0_S4END[2] _0114_/Q
+ _0113_/Q VPWR VGND sg13cmos5l_mux4_1
XFILLER_57_119 VPWR VGND sg13cmos5l_decap_8
XANTENNA__1361__D Tile_X0Y5_FrameData[31] VPWR VGND sg13cmos5l_antennanp
XFILLER_17_0 VPWR VGND sg13cmos5l_fill_1
X_2165_ _2165_/X AXIL_S_SOC_WDATA16 AXIL_S_SOC_WDATA24 _2241_/X _2248_/X _0266_/Q
+ _0265_/Q VPWR VGND sg13cmos5l_mux4_1
XFILLER_65_141 VPWR VGND sg13cmos5l_fill_2
XFILLER_241_45 VPWR VGND sg13cmos5l_decap_4
X_1116_ _1116_/Q Tile_X0Y4_FrameData[10] VGND VPWR Tile_X0Y5_FrameStrobe[2] latch
XFILLER_213_117 VPWR VGND sg13cmos5l_decap_4
XFILLER_241_78 VPWR VGND sg13cmos5l_fill_2
X_2096_ Tile_X0Y3_E2BEGb[0] _2517_/X VPWR VGND sg13cmos5l_buf_1
X_1047_ _1047_/Q Tile_X0Y4_FrameData[15] VGND VPWR Tile_X0Y5_FrameStrobe[0] latch
XFILLER_80_144 VPWR VGND sg13cmos5l_decap_8
XANTENNA__2461__A0 Tile_X0Y1_W1END[2] VPWR VGND sg13cmos5l_antennanp
XFILLER_110_49 VPWR VGND sg13cmos5l_decap_8
XFILLER_206_191 VPWR VGND sg13cmos5l_fill_2
XANTENNA__0705__D Tile_X0Y2_FrameData[5] VPWR VGND sg13cmos5l_antennanp
XANTENNA__1938__X Tile_X0Y1_E6BEG[3] VPWR VGND sg13cmos5l_antennanp
XANTENNA__2213__A0 Tile_X0Y1_W1END[0] VPWR VGND sg13cmos5l_antennanp
X_1949_ Tile_X0Y1_E2BEGb[2] _2303_/X VPWR VGND sg13cmos5l_buf_1
XFILLER_119_69 VPWR VGND sg13cmos5l_decap_8
XANTENNA__0440__D Tile_X0Y1_FrameData[30] VPWR VGND sg13cmos5l_antennanp
XANTENNA__1362__GATE Tile_X0Y5_FrameStrobe[3] VPWR VGND sg13cmos5l_antennanp
XANTENNA__1673__X Tile_X0Y0_FrameData_O[13] VPWR VGND sg13cmos5l_antennanp
XANTENNA__2516__A1 AXIL_S_SOC_ARADDR7 VPWR VGND sg13cmos5l_antennanp
XFILLER_135_35 VPWR VGND sg13cmos5l_decap_8
XFILLER_0_148 VPWR VGND sg13cmos5l_fill_1
XFILLER_142_190 VPWR VGND sg13cmos5l_decap_8
XFILLER_95_28 VPWR VGND sg13cmos5l_decap_8
XFILLER_95_17 VPWR VGND sg13cmos5l_fill_1
XANTENNA__1377__GATE Tile_X0Y5_FrameStrobe[3] VPWR VGND sg13cmos5l_antennanp
XANTENNA__1271__D Tile_X0Y5_FrameData[25] VPWR VGND sg13cmos5l_antennanp
XFILLER_151_45 VPWR VGND sg13cmos5l_decap_8
XFILLER_151_56 VPWR VGND sg13cmos5l_fill_1
XANTENNA__1300__GATE Tile_X0Y5_FrameStrobe[1] VPWR VGND sg13cmos5l_antennanp
XFILLER_151_78 VPWR VGND sg13cmos5l_decap_8
XFILLER_204_106 VPWR VGND sg13cmos5l_decap_8
XANTENNA__2009__X Tile_X0Y5_EE4BEG[10] VPWR VGND sg13cmos5l_antennanp
XANTENNA__0615__D Tile_X0Y2_FrameData[31] VPWR VGND sg13cmos5l_antennanp
XANTENNA__1848__X Tile_X0Y4_FrameData_O[15] VPWR VGND sg13cmos5l_antennanp
XFILLER_12_222 VPWR VGND sg13cmos5l_fill_2
XFILLER_358_143 VPWR VGND sg13cmos5l_decap_4
XANTENNA__1315__GATE Tile_X0Y5_FrameStrobe[1] VPWR VGND sg13cmos5l_antennanp
XANTENNA__2204__A0 AXIL_S_SOC_WDATA23 VPWR VGND sg13cmos5l_antennanp
XFILLER_358_198 VPWR VGND sg13cmos5l_fill_2
XANTENNA__0571__GATE Tile_X0Y5_FrameStrobe[0] VPWR VGND sg13cmos5l_antennanp
XANTENNA__2755__A1 AXIL_S_SOC_RREADY VPWR VGND sg13cmos5l_antennanp
XFILLER_219_0 VPWR VGND sg13cmos5l_fill_1
XANTENNA__1446__D Tile_X0Y5_FrameData[10] VPWR VGND sg13cmos5l_antennanp
XANTENNA__0350__D Tile_X0Y1_FrameData[24] VPWR VGND sg13cmos5l_antennanp
XANTENNA__1583__X Tile_X0Y3_FrameData_O[29] VPWR VGND sg13cmos5l_antennanp
XFILLER_79_200 VPWR VGND sg13cmos5l_decap_8
XFILLER_5_59 VPWR VGND sg13cmos5l_fill_2
XANTENNA__0586__GATE Tile_X0Y5_FrameStrobe[1] VPWR VGND sg13cmos5l_antennanp
XFILLER_227_209 VPWR VGND sg13cmos5l_fill_1
XFILLER_294_153 VPWR VGND sg13cmos5l_decap_8
X_0280_ _0280_/Q Tile_X0Y0_FrameData[14] VGND VPWR Tile_X0Y5_FrameStrobe[6] latch
XANTENNA__1181__D Tile_X0Y4_FrameData[9] VPWR VGND sg13cmos5l_antennanp
XFILLER_294_175 VPWR VGND sg13cmos5l_decap_8
XFILLER_85_50 VPWR VGND sg13cmos5l_fill_2
XFILLER_47_141 VPWR VGND sg13cmos5l_decap_8
XFILLER_211_15 VPWR VGND sg13cmos5l_fill_1
XFILLER_211_26 VPWR VGND sg13cmos5l_fill_1
XFILLER_62_122 VPWR VGND sg13cmos5l_decap_8
XFILLER_211_48 VPWR VGND sg13cmos5l_decap_8
XANTENNA__0524__GATE Tile_X0Y5_FrameStrobe[6] VPWR VGND sg13cmos5l_antennanp
XANTENNA__2443__A0 AXIL_S_SOC_AWADDR2 VPWR VGND sg13cmos5l_antennanp
XANTENNA__0525__D Tile_X0Y1_FrameData[9] VPWR VGND sg13cmos5l_antennanp
XANTENNA__1758__X Tile_X0Y2_FrameData_O[18] VPWR VGND sg13cmos5l_antennanp
XFILLER_148_205 VPWR VGND sg13cmos5l_decap_4
XFILLER_349_165 VPWR VGND sg13cmos5l_fill_1
XFILLER_349_187 VPWR VGND sg13cmos5l_fill_2
X_1803_ Tile_X0Y4_E2BEGb[6] _2631_/X VPWR VGND sg13cmos5l_buf_1
X_2783_ _2783_/X Tile_X0Y5_W1END[1] Tile_X0Y5_WW4END[11] Tile_X0Y5_WW4END[13] Tile_X0Y5_W6END[5]
+ _1337_/Q _1336_/Q VPWR VGND sg13cmos5l_mux4_1
XFILLER_79_2 VPWR VGND sg13cmos5l_fill_1
XANTENNA__0539__GATE Tile_X0Y5_FrameStrobe[7] VPWR VGND sg13cmos5l_antennanp
XANTENNA__2746__A1 AXIL_S_SOC_RREADY VPWR VGND sg13cmos5l_antennanp
X_1734_ Tile_X0Y0_E2BEG[6] _2171_/X VPWR VGND sg13cmos5l_buf_1
XANTENNA__0260__D Tile_X0Y0_FrameData[2] VPWR VGND sg13cmos5l_antennanp
XANTENNA__1356__D Tile_X0Y5_FrameData[4] VPWR VGND sg13cmos5l_antennanp
XFILLER_236_34 VPWR VGND sg13cmos5l_fill_2
X_1665_ Tile_X0Y0_FrameData_O[5] Tile_X0Y0_FrameData[5] VPWR VGND sg13cmos5l_buf_1
XFILLER_236_67 VPWR VGND sg13cmos5l_decap_8
X_1596_ Tile_X0Y2_EE4BEG[9] _2426_/X VPWR VGND sg13cmos5l_buf_1
X_0616_ _0616_/Q Tile_X0Y2_FrameData[30] VGND VPWR Tile_X0Y5_FrameStrobe[2] latch
XFILLER_285_120 VPWR VGND sg13cmos5l_decap_4
X_0547_ _0547_/Q Tile_X0Y1_FrameData[19] VGND VPWR Tile_X0Y5_FrameStrobe[7] latch
XFILLER_105_38 VPWR VGND sg13cmos5l_fill_2
XFILLER_218_209 VPWR VGND sg13cmos5l_decap_8
XANTENNA__1091__D Tile_X0Y4_FrameData[3] VPWR VGND sg13cmos5l_antennanp
X_2217_ _2217_/X _2216_/X _0065_/X Tile_X0Y0_S1END[3] Tile_X0Y0_S4END[3] _0096_/Q
+ _0095_/Q VPWR VGND sg13cmos5l_mux4_1
X_0478_ _0478_/Q Tile_X0Y1_FrameData[24] VGND VPWR Tile_X0Y5_FrameStrobe[5] latch
XANTENNA__2277__A3 Tile_X0Y2_W6END[9] VPWR VGND sg13cmos5l_antennanp
XFILLER_241_201 VPWR VGND sg13cmos5l_decap_4
X_2148_ _2148_/X Tile_X0Y0_W2MID[4] Tile_X0Y0_W2END[4] Tile_X0Y0_W6END[4] _2244_/X
+ _0296_/Q _0295_/Q VPWR VGND sg13cmos5l_mux4_1
XFILLER_38_185 VPWR VGND sg13cmos5l_fill_2
XFILLER_241_223 VPWR VGND sg13cmos5l_fill_1
X_2079_ Tile_X0Y5_S4BEG[12] _2079_/A VPWR VGND sg13cmos5l_buf_1
XANTENNA__2434__A0 Tile_X0Y5_N4END[13] VPWR VGND sg13cmos5l_antennanp
XFILLER_53_177 VPWR VGND sg13cmos5l_fill_1
XANTENNA__0435__D Tile_X0Y1_FrameData[3] VPWR VGND sg13cmos5l_antennanp
XANTENNA__1668__X Tile_X0Y0_FrameData_O[8] VPWR VGND sg13cmos5l_antennanp
XFILLER_14_57 VPWR VGND sg13cmos5l_fill_1
XFILLER_14_68 VPWR VGND sg13cmos5l_decap_8
XFILLER_277_30 VPWR VGND sg13cmos5l_decap_8
XFILLER_355_157 VPWR VGND sg13cmos5l_fill_2
XFILLER_355_135 VPWR VGND sg13cmos5l_decap_8
XANTENNA__2737__A1 AXIL_S_SOC_RREADY VPWR VGND sg13cmos5l_antennanp
XFILLER_355_179 VPWR VGND sg13cmos5l_fill_2
XFILLER_107_135 VPWR VGND sg13cmos5l_decap_8
XANTENNA__0170__D Tile_X0Y0_FrameData[28] VPWR VGND sg13cmos5l_antennanp
XANTENNA__1266__D Tile_X0Y5_FrameData[30] VPWR VGND sg13cmos5l_antennanp
XANTENNA__1844__A Tile_X0Y4_FrameData[11] VPWR VGND sg13cmos5l_antennanp
XFILLER_146_34 VPWR VGND sg13cmos5l_decap_8
XFILLER_268_109 VPWR VGND sg13cmos5l_fill_2
XFILLER_293_84 VPWR VGND sg13cmos5l_decap_4
XFILLER_130_160 VPWR VGND sg13cmos5l_decap_8
XFILLER_162_33 VPWR VGND sg13cmos5l_decap_8
XFILLER_39_65 VPWR VGND sg13cmos5l_fill_1
XFILLER_39_54 VPWR VGND sg13cmos5l_fill_2
XFILLER_276_175 VPWR VGND sg13cmos5l_fill_2
XFILLER_39_98 VPWR VGND sg13cmos5l_decap_8
XFILLER_312_25 VPWR VGND sg13cmos5l_fill_2
XANTENNA__2673__A0 Tile_X0Y3_W1END[0] VPWR VGND sg13cmos5l_antennanp
XFILLER_169_0 VPWR VGND sg13cmos5l_fill_1
XFILLER_189_105 VPWR VGND sg13cmos5l_decap_4
XANTENNA__2425__A0 AXIL_S_SOC_AWADDR4 VPWR VGND sg13cmos5l_antennanp
XANTENNA__0345__D Tile_X0Y1_FrameData[29] VPWR VGND sg13cmos5l_antennanp
XANTENNA__1254__GATE Tile_X0Y5_FrameStrobe[6] VPWR VGND sg13cmos5l_antennanp
XANTENNA__1578__X Tile_X0Y3_FrameData_O[24] VPWR VGND sg13cmos5l_antennanp
XFILLER_111_70 VPWR VGND sg13cmos5l_decap_8
XFILLER_336_0 VPWR VGND sg13cmos5l_fill_1
XFILLER_346_124 VPWR VGND sg13cmos5l_decap_8
XANTENNA__2728__A1 AXIL_S_SOC_ARVALID VPWR VGND sg13cmos5l_antennanp
XFILLER_200_175 VPWR VGND sg13cmos5l_decap_8
XFILLER_346_179 VPWR VGND sg13cmos5l_decap_8
XANTENNA__1269__GATE Tile_X0Y5_FrameStrobe[0] VPWR VGND sg13cmos5l_antennanp
XANTENNA__0080__D Tile_X0Y0_FrameData[22] VPWR VGND sg13cmos5l_antennanp
XANTENNA__1176__D Tile_X0Y4_FrameData[14] VPWR VGND sg13cmos5l_antennanp
XANTENNA__1754__A Tile_X0Y2_FrameData[14] VPWR VGND sg13cmos5l_antennanp
XFILLER_113_105 VPWR VGND sg13cmos5l_decap_8
XFILLER_259_109 VPWR VGND sg13cmos5l_fill_2
X_1450_ _1450_/Q Tile_X0Y5_FrameData[6] VGND VPWR Tile_X0Y5_FrameStrobe[5] latch
XFILLER_206_26 VPWR VGND sg13cmos5l_decap_8
XFILLER_206_48 VPWR VGND sg13cmos5l_fill_1
X_1381_ _1381_/Q Tile_X0Y5_FrameData[11] VGND VPWR Tile_X0Y5_FrameStrobe[3] latch
X_0401_ _0401_/Q Tile_X0Y1_FrameData[5] VGND VPWR Tile_X0Y5_FrameStrobe[2] latch
XFILLER_353_54 VPWR VGND sg13cmos5l_decap_4
XFILLER_267_153 VPWR VGND sg13cmos5l_fill_2
X_0332_ _0332_/Q Tile_X0Y1_FrameData[10] VGND VPWR Tile_X0Y5_FrameStrobe[0] latch
XFILLER_353_76 VPWR VGND sg13cmos5l_decap_8
XANTENNA__1207__GATE Tile_X0Y5_FrameStrobe[5] VPWR VGND sg13cmos5l_antennanp
XFILLER_222_25 VPWR VGND sg13cmos5l_decap_8
X_0263_ _0263_/Q Tile_X0Y0_FrameData[31] VGND VPWR Tile_X0Y5_FrameStrobe[6] latch
XFILLER_82_206 VPWR VGND sg13cmos5l_decap_8
XFILLER_222_69 VPWR VGND sg13cmos5l_fill_2
X_2002_ Tile_X0Y5_EE4BEG[3] _2744_/X VPWR VGND sg13cmos5l_buf_1
X_0194_ _0194_/Q Tile_X0Y0_FrameData[4] VGND VPWR Tile_X0Y5_FrameStrobe[3] latch
XANTENNA__0463__GATE Tile_X0Y5_FrameStrobe[4] VPWR VGND sg13cmos5l_antennanp
XFILLER_223_223 VPWR VGND sg13cmos5l_fill_1
XANTENNA__2416__A0 AXIL_S_SOC_AWADDR1 VPWR VGND sg13cmos5l_antennanp
XFILLER_35_166 VPWR VGND sg13cmos5l_decap_8
XANTENNA__0255__D Tile_X0Y0_FrameData[7] VPWR VGND sg13cmos5l_antennanp
XFILLER_50_147 VPWR VGND sg13cmos5l_fill_2
XANTENNA__0478__GATE Tile_X0Y5_FrameStrobe[5] VPWR VGND sg13cmos5l_antennanp
X_2835_ _2835_/X Tile_X0Y4_W1END[2] Tile_X0Y4_W2MID[1] Tile_X0Y4_W2END[1] _2682_/X
+ _1112_/Q _1111_/Q VPWR VGND sg13cmos5l_mux4_1
XFILLER_84_0 VPWR VGND sg13cmos5l_fill_2
XFILLER_337_135 VPWR VGND sg13cmos5l_decap_8
XANTENNA__2719__A1 Tile_X0Y3_W2MID[1] VPWR VGND sg13cmos5l_antennanp
X_2766_ _2766_/X AXIL_S_SOC_ARPROT1 _2820_/X _2818_/X _2799_/X _1370_/Q _1369_/Q VPWR
+ VGND sg13cmos5l_mux4_1
XANTENNA__0401__GATE Tile_X0Y5_FrameStrobe[2] VPWR VGND sg13cmos5l_antennanp
XANTENNA__1086__D Tile_X0Y4_FrameData[8] VPWR VGND sg13cmos5l_antennanp
XANTENNA__1664__A Tile_X0Y0_FrameData[4] VPWR VGND sg13cmos5l_antennanp
XFILLER_247_77 VPWR VGND sg13cmos5l_decap_4
XFILLER_247_99 VPWR VGND sg13cmos5l_decap_4
X_1717_ Tile_X0Y0_E6BEG[9] _2206_/X VPWR VGND sg13cmos5l_buf_1
X_2697_ _2697_/X _2674_/X Tile_X0Y5_N4END[4] _2673_/X _0039_/X _1070_/Q _1069_/Q VPWR
+ VGND sg13cmos5l_mux4_1
XANTENNA__2112__X AXIL_S_SOC_RDATA6 VPWR VGND sg13cmos5l_antennanp
XFILLER_116_15 VPWR VGND sg13cmos5l_fill_2
X_1648_ Tile_X0Y0_FrameStrobe_O[8] Tile_X0Y5_FrameStrobe[8] VPWR VGND sg13cmos5l_buf_1
XANTENNA__1951__X Tile_X0Y1_E2BEGb[4] VPWR VGND sg13cmos5l_antennanp
XFILLER_263_87 VPWR VGND sg13cmos5l_decap_8
X_1579_ Tile_X0Y3_FrameData_O[25] Tile_X0Y3_FrameData[25] VPWR VGND sg13cmos5l_buf_1
XANTENNA__0416__GATE Tile_X0Y5_FrameStrobe[3] VPWR VGND sg13cmos5l_antennanp
XFILLER_112_193 VPWR VGND sg13cmos5l_decap_8
XANTENNA__2655__A0 AXIL_S_SOC_WSTRB0 VPWR VGND sg13cmos5l_antennanp
XFILLER_273_156 VPWR VGND sg13cmos5l_decap_4
XFILLER_214_223 VPWR VGND sg13cmos5l_fill_1
XANTENNA__2407__A0 AXIL_S_SOC_AWADDR0 VPWR VGND sg13cmos5l_antennanp
XANTENNA__0165__D Tile_X0Y0_FrameData[1] VPWR VGND sg13cmos5l_antennanp
XANTENNA__1839__A Tile_X0Y4_FrameData[6] VPWR VGND sg13cmos5l_antennanp
XFILLER_155_6 VPWR VGND sg13cmos5l_decap_8
XFILLER_179_171 VPWR VGND sg13cmos5l_decap_4
XFILLER_186_119 VPWR VGND sg13cmos5l_fill_2
XFILLER_288_62 VPWR VGND sg13cmos5l_decap_4
XFILLER_41_158 VPWR VGND sg13cmos5l_fill_1
XFILLER_328_102 VPWR VGND sg13cmos5l_fill_2
XFILLER_288_95 VPWR VGND sg13cmos5l_decap_8
XFILLER_157_22 VPWR VGND sg13cmos5l_decap_8
XFILLER_343_105 VPWR VGND sg13cmos5l_decap_8
XFILLER_328_179 VPWR VGND sg13cmos5l_decap_8
XANTENNA__1574__A Tile_X0Y3_FrameData[20] VPWR VGND sg13cmos5l_antennanp
XANTENNA__2022__X Tile_X0Y5_FrameData_O[7] VPWR VGND sg13cmos5l_antennanp
XFILLER_351_182 VPWR VGND sg13cmos5l_decap_8
XANTENNA__1861__X Tile_X0Y4_FrameData_O[28] VPWR VGND sg13cmos5l_antennanp
XFILLER_173_76 VPWR VGND sg13cmos5l_decap_8
XFILLER_323_13 VPWR VGND sg13cmos5l_fill_1
XFILLER_103_171 VPWR VGND sg13cmos5l_fill_1
XFILLER_249_197 VPWR VGND sg13cmos5l_decap_8
XFILLER_286_0 VPWR VGND sg13cmos5l_fill_2
XANTENNA__2646__A0 Tile_X0Y4_WW4END[9] VPWR VGND sg13cmos5l_antennanp
XANTENNA__2110__A2 Tile_X0Y3_W6END[4] VPWR VGND sg13cmos5l_antennanp
XANTENNA__1193__GATE Tile_X0Y5_FrameStrobe[5] VPWR VGND sg13cmos5l_antennanp
XANTENNA__0075__D Tile_X0Y0_FrameData[27] VPWR VGND sg13cmos5l_antennanp
XFILLER_82_73 VPWR VGND sg13cmos5l_decap_8
XANTENNA__1749__A Tile_X0Y2_FrameData[9] VPWR VGND sg13cmos5l_antennanp
XFILLER_198_84 VPWR VGND sg13cmos5l_fill_1
X_0950_ _0950_/Q Tile_X0Y3_FrameData[0] VGND VPWR Tile_X0Y5_FrameStrobe[4] latch
XFILLER_348_10 VPWR VGND sg13cmos5l_decap_8
XANTENNA__0803__D Tile_X0Y3_FrameData[19] VPWR VGND sg13cmos5l_antennanp
XFILLER_118_208 VPWR VGND sg13cmos5l_decap_8
X_2620_ _2620_/X AXIL_S_SOC_WSTRB3 AXIL_S_SOC_BREADY _2711_/X _2712_/X _1214_/Q _1213_/Q
+ VPWR VGND sg13cmos5l_mux4_1
X_0881_ _0881_/Q Tile_X0Y3_FrameData[5] VGND VPWR Tile_X0Y5_FrameStrobe[2] latch
XFILLER_319_157 VPWR VGND sg13cmos5l_fill_1
X_2551_ _2551_/X AXIL_S_SOC_ARADDR2 _2586_/X _2585_/X _2595_/X _0902_/Q _0901_/Q VPWR
+ VGND sg13cmos5l_mux4_1
XFILLER_327_190 VPWR VGND sg13cmos5l_fill_1
XANTENNA__1131__GATE Tile_X0Y5_FrameStrobe[3] VPWR VGND sg13cmos5l_antennanp
X_1502_ _2670_/A3 VPWR VGND sg13cmos5l_tielo
X_2482_ _2482_/X _2384_/X _2492_/X _2491_/X _2383_/X _0572_/Q _0571_/Q VPWR VGND sg13cmos5l_mux4_1
X_1433_ _1433_/Q Tile_X0Y5_FrameData[23] VGND VPWR Tile_X0Y5_FrameStrobe[5] latch
XFILLER_99_147 VPWR VGND sg13cmos5l_decap_4
XANTENNA__1771__X Tile_X0Y2_FrameData_O[31] VPWR VGND sg13cmos5l_antennanp
X_1364_ _1364_/Q Tile_X0Y5_FrameData[28] VGND VPWR Tile_X0Y5_FrameStrobe[3] latch
XANTENNA__1146__GATE Tile_X0Y5_FrameStrobe[3] VPWR VGND sg13cmos5l_antennanp
XFILLER_233_57 VPWR VGND sg13cmos5l_decap_8
X_1295_ _1295_/Q Tile_X0Y5_FrameData[1] VGND VPWR Tile_X0Y5_FrameStrobe[0] latch
X_0315_ _0315_/Q Tile_X0Y1_FrameData[27] VGND VPWR Tile_X0Y5_FrameStrobe[0] latch
XANTENNA__2637__A0 AXIL_S_SOC_WSTRB2 VPWR VGND sg13cmos5l_antennanp
XFILLER_255_167 VPWR VGND sg13cmos5l_decap_8
XFILLER_270_104 VPWR VGND sg13cmos5l_decap_8
X_0246_ _0246_/Q Tile_X0Y0_FrameData[16] VGND VPWR Tile_X0Y5_FrameStrobe[5] latch
XANTENNA__2101__A2 Tile_X0Y4_W6END[1] VPWR VGND sg13cmos5l_antennanp
XFILLER_102_28 VPWR VGND sg13cmos5l_decap_4
XFILLER_270_115 VPWR VGND sg13cmos5l_decap_8
X_0177_ _0177_/Q Tile_X0Y0_FrameData[21] VGND VPWR Tile_X0Y5_FrameStrobe[3] latch
XFILLER_23_147 VPWR VGND sg13cmos5l_fill_2
XANTENNA__1659__A Tile_X0Y5_FrameStrobe[19] VPWR VGND sg13cmos5l_antennanp
XANTENNA__2107__X AXIL_S_SOC_RDATA1 VPWR VGND sg13cmos5l_antennanp
XANTENNA__0713__D Tile_X0Y2_FrameData[29] VPWR VGND sg13cmos5l_antennanp
XANTENNA__1946__X Tile_X0Y1_E6BEG[11] VPWR VGND sg13cmos5l_antennanp
XFILLER_109_208 VPWR VGND sg13cmos5l_fill_1
XFILLER_176_174 VPWR VGND sg13cmos5l_decap_8
XFILLER_325_105 VPWR VGND sg13cmos5l_decap_4
XANTENNA__0340__GATE Tile_X0Y5_FrameStrobe[0] VPWR VGND sg13cmos5l_antennanp
X_2818_ _2818_/X Tile_X0Y5_N1END[2] Tile_X0Y5_N4END[2] _2795_/X _0058_/X _1308_/Q
+ _1307_/Q VPWR VGND sg13cmos5l_mux4_1
XANTENNA__0970__GATE Tile_X0Y5_FrameStrobe[5] VPWR VGND sg13cmos5l_antennanp
XFILLER_274_20 VPWR VGND sg13cmos5l_fill_2
X_2749_ _2749_/X AXIL_S_SOC_ARVALID AXIL_S_SOC_RREADY _2817_/X _2797_/X _1404_/Q _1403_/Q
+ VPWR VGND sg13cmos5l_mux4_1
XFILLER_127_36 VPWR VGND sg13cmos5l_fill_1
XFILLER_191_177 VPWR VGND sg13cmos5l_decap_4
XFILLER_132_222 VPWR VGND sg13cmos5l_fill_2
XANTENNA__0355__GATE Tile_X0Y5_FrameStrobe[1] VPWR VGND sg13cmos5l_antennanp
XANTENNA__1681__X Tile_X0Y0_FrameData_O[21] VPWR VGND sg13cmos5l_antennanp
XANTENNA__0985__GATE Tile_X0Y5_FrameStrobe[6] VPWR VGND sg13cmos5l_antennanp
XFILLER_143_13 VPWR VGND sg13cmos5l_fill_2
XANTENNA__2340__A2 Tile_X0Y1_W6END[3] VPWR VGND sg13cmos5l_antennanp
XANTENNA__2628__A0 AXIL_S_SOC_WSTRB3 VPWR VGND sg13cmos5l_antennanp
XFILLER_100_163 VPWR VGND sg13cmos5l_decap_8
XFILLER_272_6 VPWR VGND sg13cmos5l_decap_4
XFILLER_246_189 VPWR VGND sg13cmos5l_decap_8
XANTENNA__0923__GATE Tile_X0Y5_FrameStrobe[4] VPWR VGND sg13cmos5l_antennanp
XANTENNA__1569__A Tile_X0Y3_FrameData[15] VPWR VGND sg13cmos5l_antennanp
XANTENNA__2017__X Tile_X0Y5_FrameData_O[2] VPWR VGND sg13cmos5l_antennanp
XANTENNA__2800__A0 Tile_X0Y5_N2MID[4] VPWR VGND sg13cmos5l_antennanp
XFILLER_52_76 VPWR VGND sg13cmos5l_fill_2
XANTENNA__0623__D Tile_X0Y2_FrameData[23] VPWR VGND sg13cmos5l_antennanp
XANTENNA__1856__X Tile_X0Y4_FrameData_O[23] VPWR VGND sg13cmos5l_antennanp
XFILLER_167_174 VPWR VGND sg13cmos5l_decap_8
XFILLER_168_43 VPWR VGND sg13cmos5l_decap_8
XANTENNA__0308__GATE Tile_X0Y5_FrameStrobe[7] VPWR VGND sg13cmos5l_antennanp
XFILLER_318_13 VPWR VGND sg13cmos5l_fill_1
XANTENNA__0938__GATE Tile_X0Y5_FrameStrobe[4] VPWR VGND sg13cmos5l_antennanp
XANTENNA__2159__A2 Tile_X0Y0_WW4END[7] VPWR VGND sg13cmos5l_antennanp
XFILLER_331_108 VPWR VGND sg13cmos5l_fill_1
XANTENNA__1454__D Tile_X0Y5_FrameData[2] VPWR VGND sg13cmos5l_antennanp
XANTENNA__1591__X Tile_X0Y2_EE4BEG[4] VPWR VGND sg13cmos5l_antennanp
XFILLER_28_8 VPWR VGND sg13cmos5l_fill_2
XFILLER_89_191 VPWR VGND sg13cmos5l_decap_8
XANTENNA__2619__A0 AXIL_S_SOC_WSTRB2 VPWR VGND sg13cmos5l_antennanp
XFILLER_237_167 VPWR VGND sg13cmos5l_decap_8
X_0100_ _0100_/Q Tile_X0Y0_FrameData[2] VGND VPWR Tile_X0Y5_FrameStrobe[0] latch
XFILLER_237_178 VPWR VGND sg13cmos5l_fill_2
XFILLER_252_115 VPWR VGND sg13cmos5l_decap_8
XFILLER_252_126 VPWR VGND sg13cmos5l_fill_1
X_1080_ _1080_/Q Tile_X0Y4_FrameData[14] VGND VPWR Tile_X0Y5_FrameStrobe[1] latch
XFILLER_350_55 VPWR VGND sg13cmos5l_decap_8
X_0031_ _0031_/X _2355_/X _2356_/X _1467_/Q VPWR VGND sg13cmos5l_mux2_1
XFILLER_350_88 VPWR VGND sg13cmos5l_decap_8
XFILLER_359_42 VPWR VGND sg13cmos5l_fill_2
XFILLER_359_31 VPWR VGND sg13cmos5l_decap_8
XANTENNA__2398__A2 AXIL_S_SOC_AWADDR3 VPWR VGND sg13cmos5l_antennanp
X_1982_ Tile_X0Y5_E2BEGb[3] _2736_/X VPWR VGND sg13cmos5l_buf_1
XFILLER_359_64 VPWR VGND sg13cmos5l_decap_8
XANTENNA__0533__D Tile_X0Y1_FrameData[1] VPWR VGND sg13cmos5l_antennanp
XANTENNA__1766__X Tile_X0Y2_FrameData_O[26] VPWR VGND sg13cmos5l_antennanp
X_0933_ _0933_/Q Tile_X0Y3_FrameData[17] VGND VPWR Tile_X0Y5_FrameStrobe[4] latch
X_0864_ _0864_/Q Tile_X0Y3_FrameData[22] VGND VPWR Tile_X0Y5_FrameStrobe[2] latch
XANTENNA__1070__GATE Tile_X0Y5_FrameStrobe[1] VPWR VGND sg13cmos5l_antennanp
XFILLER_173_144 VPWR VGND sg13cmos5l_decap_8
XFILLER_173_155 VPWR VGND sg13cmos5l_fill_1
X_2603_ _2603_/X Tile_X0Y2_W2MID[4] Tile_X0Y2_W2END[4] Tile_X0Y2_W6END[11] _2484_/X
+ _0644_/Q _0643_/Q VPWR VGND sg13cmos5l_mux4_1
XFILLER_173_177 VPWR VGND sg13cmos5l_decap_8
X_2534_ _2534_/X AXIL_S_SOC_ARADDR5 AXIL_S_SOC_ARADDR9 _2582_/X _2595_/X _0936_/Q
+ _0935_/Q VPWR VGND sg13cmos5l_mux4_1
X_0795_ _0795_/Q Tile_X0Y3_FrameData[27] VGND VPWR Tile_X0Y5_FrameStrobe[0] latch
XFILLER_114_222 VPWR VGND sg13cmos5l_fill_2
XFILLER_244_12 VPWR VGND sg13cmos5l_decap_4
XFILLER_47_0 VPWR VGND sg13cmos5l_fill_2
XFILLER_315_193 VPWR VGND sg13cmos5l_fill_1
XFILLER_315_182 VPWR VGND sg13cmos5l_decap_4
XANTENNA__1364__D Tile_X0Y5_FrameData[28] VPWR VGND sg13cmos5l_antennanp
X_2465_ _2465_/X _2464_/X Tile_X0Y5_N4END[15] _2463_/X Tile_X0Y0_S4END[11] _0576_/Q
+ _0575_/Q VPWR VGND sg13cmos5l_mux4_1
XANTENNA__1085__GATE Tile_X0Y5_FrameStrobe[1] VPWR VGND sg13cmos5l_antennanp
XFILLER_244_78 VPWR VGND sg13cmos5l_decap_8
XFILLER_244_89 VPWR VGND sg13cmos5l_decap_8
X_1416_ _1416_/Q Tile_X0Y5_FrameData[8] VGND VPWR Tile_X0Y5_FrameStrobe[4] latch
X_2396_ _2396_/X Tile_X0Y3_W2MID[0] Tile_X0Y3_W2END[0] Tile_X0Y3_W6END[0] _2596_/X
+ _1008_/Q _1007_/Q VPWR VGND sg13cmos5l_mux4_1
XFILLER_330_174 VPWR VGND sg13cmos5l_decap_8
XFILLER_228_101 VPWR VGND sg13cmos5l_decap_8
X_1347_ _1347_/Q Tile_X0Y5_FrameData[13] VGND VPWR Tile_X0Y5_FrameStrobe[2] latch
XFILLER_228_145 VPWR VGND sg13cmos5l_decap_8
XFILLER_113_49 VPWR VGND sg13cmos5l_decap_8
XFILLER_228_189 VPWR VGND sg13cmos5l_decap_8
XFILLER_260_66 VPWR VGND sg13cmos5l_fill_2
X_1278_ _1278_/Q Tile_X0Y5_FrameData[18] VGND VPWR Tile_X0Y5_FrameStrobe[0] latch
XANTENNA__0708__D Tile_X0Y2_FrameData[2] VPWR VGND sg13cmos5l_antennanp
XFILLER_243_137 VPWR VGND sg13cmos5l_decap_4
X_0229_ _0229_/Q Tile_X0Y0_FrameData[1] VGND VPWR Tile_X0Y5_FrameStrobe[4] latch
XANTENNA__1023__GATE Tile_X0Y5_FrameStrobe[7] VPWR VGND sg13cmos5l_antennanp
XFILLER_251_181 VPWR VGND sg13cmos5l_fill_1
XANTENNA__2389__A2 Tile_X0Y0_W2END[3] VPWR VGND sg13cmos5l_antennanp
XFILLER_269_53 VPWR VGND sg13cmos5l_fill_2
XFILLER_269_86 VPWR VGND sg13cmos5l_decap_8
XANTENNA__0443__D Tile_X0Y1_FrameData[27] VPWR VGND sg13cmos5l_antennanp
XANTENNA__1676__X Tile_X0Y0_FrameData_O[16] VPWR VGND sg13cmos5l_antennanp
XFILLER_138_13 VPWR VGND sg13cmos5l_fill_1
XFILLER_149_196 VPWR VGND sg13cmos5l_fill_2
XFILLER_164_100 VPWR VGND sg13cmos5l_decap_8
XANTENNA__1038__GATE Tile_X0Y5_FrameStrobe[0] VPWR VGND sg13cmos5l_antennanp
XFILLER_138_46 VPWR VGND sg13cmos5l_fill_1
XFILLER_105_200 VPWR VGND sg13cmos5l_fill_2
XFILLER_164_199 VPWR VGND sg13cmos5l_fill_1
XANTENNA__0294__GATE Tile_X0Y5_FrameStrobe[6] VPWR VGND sg13cmos5l_antennanp
XANTENNA__1274__D Tile_X0Y5_FrameData[22] VPWR VGND sg13cmos5l_antennanp
XANTENNA__1852__A Tile_X0Y4_FrameData[19] VPWR VGND sg13cmos5l_antennanp
XANTENNA__2561__A2 Tile_X0Y3_W6END[0] VPWR VGND sg13cmos5l_antennanp
XFILLER_154_23 VPWR VGND sg13cmos5l_decap_8
XFILLER_154_67 VPWR VGND sg13cmos5l_decap_8
XFILLER_266_207 VPWR VGND sg13cmos5l_fill_2
XANTENNA__0618__D Tile_X0Y2_FrameData[28] VPWR VGND sg13cmos5l_antennanp
XFILLER_34_209 VPWR VGND sg13cmos5l_decap_4
XFILLER_320_14 VPWR VGND sg13cmos5l_decap_4
XANTENNA__0232__GATE Tile_X0Y5_FrameStrobe[5] VPWR VGND sg13cmos5l_antennanp
XANTENNA__0862__GATE Tile_X0Y5_FrameStrobe[2] VPWR VGND sg13cmos5l_antennanp
XANTENNA__2616__A3 AXIL_S_SOC_WVALID VPWR VGND sg13cmos5l_antennanp
XFILLER_151_0 VPWR VGND sg13cmos5l_fill_2
XANTENNA__0247__GATE Tile_X0Y5_FrameStrobe[5] VPWR VGND sg13cmos5l_antennanp
XANTENNA__1449__D Tile_X0Y5_FrameData[7] VPWR VGND sg13cmos5l_antennanp
XANTENNA__1586__X Tile_X0Y3_UserCLKo VPWR VGND sg13cmos5l_antennanp
XFILLER_8_37 VPWR VGND sg13cmos5l_fill_1
XFILLER_329_23 VPWR VGND sg13cmos5l_decap_8
XANTENNA__0353__D Tile_X0Y1_FrameData[21] VPWR VGND sg13cmos5l_antennanp
XANTENNA__0877__GATE Tile_X0Y5_FrameStrobe[2] VPWR VGND sg13cmos5l_antennanp
XFILLER_195_30 VPWR VGND sg13cmos5l_fill_2
XFILLER_329_89 VPWR VGND sg13cmos5l_decap_8
XFILLER_155_188 VPWR VGND sg13cmos5l_decap_8
XFILLER_170_125 VPWR VGND sg13cmos5l_fill_1
XANTENNA__0800__GATE Tile_X0Y5_FrameStrobe[0] VPWR VGND sg13cmos5l_antennanp
XFILLER_170_147 VPWR VGND sg13cmos5l_decap_8
XFILLER_170_158 VPWR VGND sg13cmos5l_fill_1
X_0580_ _0580_/Q Tile_X0Y2_FrameData[2] VGND VPWR Tile_X0Y5_FrameStrobe[0] latch
XANTENNA__1184__D Tile_X0Y4_FrameData[6] VPWR VGND sg13cmos5l_antennanp
XANTENNA__1762__A Tile_X0Y2_FrameData[22] VPWR VGND sg13cmos5l_antennanp
X_2250_ _2250_/X Tile_X0Y1_W2MID[7] Tile_X0Y1_W2END[7] Tile_X0Y1_W6END[7] _2373_/X
+ _0542_/Q _0541_/Q VPWR VGND sg13cmos5l_mux4_1
XFILLER_312_163 VPWR VGND sg13cmos5l_decap_8
X_1201_ _1201_/Q Tile_X0Y4_FrameData[21] VGND VPWR Tile_X0Y5_FrameStrobe[5] latch
XANTENNA__0815__GATE Tile_X0Y5_FrameStrobe[0] VPWR VGND sg13cmos5l_antennanp
X_2181_ _2181_/X AXIL_S_SOC_WDATA16 AXIL_S_SOC_WDATA28 _2217_/X _2248_/X _0234_/Q
+ _0233_/Q VPWR VGND sg13cmos5l_mux4_1
XFILLER_77_183 VPWR VGND sg13cmos5l_fill_1
XFILLER_77_172 VPWR VGND sg13cmos5l_decap_8
XFILLER_361_65 VPWR VGND sg13cmos5l_fill_2
X_1132_ _1132_/Q Tile_X0Y4_FrameData[26] VGND VPWR Tile_X0Y5_FrameStrobe[3] latch
XANTENNA__0528__D Tile_X0Y1_FrameData[6] VPWR VGND sg13cmos5l_antennanp
X_1063_ _1063_/Q Tile_X0Y4_FrameData[31] VGND VPWR Tile_X0Y5_FrameStrobe[1] latch
XFILLER_178_203 VPWR VGND sg13cmos5l_fill_2
XFILLER_233_170 VPWR VGND sg13cmos5l_decap_8
XFILLER_310_91 VPWR VGND sg13cmos5l_fill_2
XANTENNA__1359__D Tile_X0Y5_FrameData[1] VPWR VGND sg13cmos5l_antennanp
XFILLER_193_206 VPWR VGND sg13cmos5l_decap_4
X_1965_ Tile_X0Y1_E1BEG[2] _2291_/X VPWR VGND sg13cmos5l_buf_1
XANTENNA__0263__D Tile_X0Y0_FrameData[31] VPWR VGND sg13cmos5l_antennanp
X_0916_ _0916_/Q Tile_X0Y3_FrameData[2] VGND VPWR Tile_X0Y5_FrameStrobe[3] latch
XANTENNA__2791__A2 Tile_X0Y5_W6END[2] VPWR VGND sg13cmos5l_antennanp
X_1896_ Tile_X0Y1_FrameData_O[9] Tile_X0Y1_FrameData[9] VPWR VGND sg13cmos5l_buf_1
X_0847_ _0847_/Q Tile_X0Y3_FrameData[7] VGND VPWR Tile_X0Y5_FrameStrobe[1] latch
XFILLER_350_203 VPWR VGND sg13cmos5l_fill_1
XFILLER_108_38 VPWR VGND sg13cmos5l_fill_1
XFILLER_161_147 VPWR VGND sg13cmos5l_decap_8
X_0778_ _0778_/Q Tile_X0Y2_FrameData[28] VGND VPWR Tile_X0Y5_FrameStrobe[7] latch
XANTENNA__1094__D Tile_X0Y4_FrameData[0] VPWR VGND sg13cmos5l_antennanp
XFILLER_102_203 VPWR VGND sg13cmos5l_fill_2
X_2517_ _2517_/X AXIL_S_SOC_ARADDR0 AXIL_S_SOC_ARADDR8 _2589_/X _2596_/X _0970_/Q
+ _0969_/Q VPWR VGND sg13cmos5l_mux4_1
XANTENNA__1672__A Tile_X0Y0_FrameData[12] VPWR VGND sg13cmos5l_antennanp
XANTENNA__2120__X AXIL_S_SOC_RDATA14 VPWR VGND sg13cmos5l_antennanp
X_2448_ _2448_/X _2478_/X _2477_/X _2470_/X _2469_/X _0631_/Q _0630_/Q VPWR VGND sg13cmos5l_mux4_1
XFILLER_271_10 VPWR VGND sg13cmos5l_fill_2
X_2379_ _2379_/X _2261_/X _2394_/X _2393_/X Tile_X0Y0_S2MID[6] _0322_/Q _0321_/Q VPWR
+ VGND sg13cmos5l_mux4_1
XFILLER_68_150 VPWR VGND sg13cmos5l_decap_8
XFILLER_17_13 VPWR VGND sg13cmos5l_fill_2
XFILLER_187_9 VPWR VGND sg13cmos5l_decap_8
XANTENNA__0438__D Tile_X0Y1_FrameData[0] VPWR VGND sg13cmos5l_antennanp
XFILLER_17_24 VPWR VGND sg13cmos5l_fill_2
XFILLER_216_126 VPWR VGND sg13cmos5l_decap_8
XFILLER_83_153 VPWR VGND sg13cmos5l_decap_8
XFILLER_354_9 VPWR VGND sg13cmos5l_decap_8
XFILLER_169_214 VPWR VGND sg13cmos5l_fill_1
XFILLER_220_91 VPWR VGND sg13cmos5l_decap_8
XFILLER_33_12 VPWR VGND sg13cmos5l_fill_1
XANTENNA__1269__D Tile_X0Y5_FrameData[27] VPWR VGND sg13cmos5l_antennanp
XFILLER_149_34 VPWR VGND sg13cmos5l_decap_8
XFILLER_184_217 VPWR VGND sg13cmos5l_fill_1
XFILLER_33_67 VPWR VGND sg13cmos5l_decap_8
XANTENNA__0173__D Tile_X0Y0_FrameData[25] VPWR VGND sg13cmos5l_antennanp
XANTENNA__1847__A Tile_X0Y4_FrameData[14] VPWR VGND sg13cmos5l_antennanp
XANTENNA__2231__A1 Tile_X0Y4_WW4END[3] VPWR VGND sg13cmos5l_antennanp
XANTENNA__0901__D Tile_X0Y3_FrameData[17] VPWR VGND sg13cmos5l_antennanp
XFILLER_137_188 VPWR VGND sg13cmos5l_decap_8
XFILLER_152_103 VPWR VGND sg13cmos5l_decap_8
XANTENNA__1582__A Tile_X0Y3_FrameData[28] VPWR VGND sg13cmos5l_antennanp
XANTENNA__2030__X Tile_X0Y5_FrameData_O[15] VPWR VGND sg13cmos5l_antennanp
XANTENNA__2298__A1 AXIL_S_SOC_WDATA13 VPWR VGND sg13cmos5l_antennanp
XFILLER_181_65 VPWR VGND sg13cmos5l_decap_8
XFILLER_207_104 VPWR VGND sg13cmos5l_decap_8
XFILLER_59_194 VPWR VGND sg13cmos5l_fill_1
XANTENNA__0171__GATE Tile_X0Y5_FrameStrobe[3] VPWR VGND sg13cmos5l_antennanp
XANTENNA__0348__D Tile_X0Y1_FrameData[26] VPWR VGND sg13cmos5l_antennanp
XFILLER_331_46 VPWR VGND sg13cmos5l_decap_8
XANTENNA__0186__GATE Tile_X0Y5_FrameStrobe[3] VPWR VGND sg13cmos5l_antennanp
XANTENNA__2470__A1 Tile_X0Y5_N4END[13] VPWR VGND sg13cmos5l_antennanp
XFILLER_230_140 VPWR VGND sg13cmos5l_decap_8
XANTENNA__1179__D Tile_X0Y4_FrameData[11] VPWR VGND sg13cmos5l_antennanp
XFILLER_130_91 VPWR VGND sg13cmos5l_fill_1
XFILLER_90_62 VPWR VGND sg13cmos5l_decap_4
XFILLER_30_223 VPWR VGND sg13cmos5l_fill_1
XANTENNA__0083__D Tile_X0Y0_FrameData[19] VPWR VGND sg13cmos5l_antennanp
XANTENNA__1757__A Tile_X0Y2_FrameData[17] VPWR VGND sg13cmos5l_antennanp
X_1750_ Tile_X0Y2_FrameData_O[10] Tile_X0Y2_FrameData[10] VPWR VGND sg13cmos5l_buf_1
XFILLER_90_95 VPWR VGND sg13cmos5l_decap_8
XFILLER_209_26 VPWR VGND sg13cmos5l_decap_8
X_0701_ _0701_/Q Tile_X0Y2_FrameData[9] VGND VPWR Tile_X0Y5_FrameStrobe[4] latch
XANTENNA__0811__D Tile_X0Y3_FrameData[11] VPWR VGND sg13cmos5l_antennanp
XANTENNA__2773__A2 Tile_X0Y5_W6END[8] VPWR VGND sg13cmos5l_antennanp
XFILLER_128_166 VPWR VGND sg13cmos5l_decap_8
XFILLER_128_188 VPWR VGND sg13cmos5l_decap_8
X_1681_ Tile_X0Y0_FrameData_O[21] Tile_X0Y0_FrameData[21] VPWR VGND sg13cmos5l_buf_1
X_0632_ _0632_/Q Tile_X0Y2_FrameData[14] VGND VPWR Tile_X0Y5_FrameStrobe[2] latch
X_0563_ _0563_/Q Tile_X0Y2_FrameData[19] VGND VPWR Tile_X0Y5_FrameStrobe[0] latch
XANTENNA__0124__GATE Tile_X0Y5_FrameStrobe[1] VPWR VGND sg13cmos5l_antennanp
X_2302_ _2302_/X AXIL_S_SOC_WDATA1 AXIL_S_SOC_WDATA9 _2374_/X _2379_/X _0488_/Q _0487_/Q
+ VPWR VGND sg13cmos5l_mux4_1
XFILLER_97_223 VPWR VGND sg13cmos5l_fill_1
XFILLER_300_111 VPWR VGND sg13cmos5l_fill_2
XFILLER_300_100 VPWR VGND sg13cmos5l_fill_1
XANTENNA__0754__GATE Tile_X0Y5_FrameStrobe[6] VPWR VGND sg13cmos5l_antennanp
X_0494_ _0494_/Q Tile_X0Y1_FrameData[8] VGND VPWR Tile_X0Y5_FrameStrobe[5] latch
X_2233_ _2233_/X _2216_/X _0065_/X Tile_X0Y0_S1END[3] Tile_X0Y0_S4END[3] _0112_/Q
+ _0111_/Q VPWR VGND sg13cmos5l_mux4_1
XANTENNA__0139__GATE Tile_X0Y5_FrameStrobe[2] VPWR VGND sg13cmos5l_antennanp
X_2164_ _2164_/X _2216_/X Tile_X0Y0_S1END[3] AXIL_S_SOC_WDATA17 AXIL_S_SOC_WDATA20
+ _0268_/Q _0267_/Q VPWR VGND sg13cmos5l_mux4_1
XANTENNA__0258__D Tile_X0Y0_FrameData[4] VPWR VGND sg13cmos5l_antennanp
XANTENNA__0769__GATE Tile_X0Y5_FrameStrobe[6] VPWR VGND sg13cmos5l_antennanp
X_1115_ _1115_/Q Tile_X0Y4_FrameData[11] VGND VPWR Tile_X0Y5_FrameStrobe[2] latch
XFILLER_65_164 VPWR VGND sg13cmos5l_decap_8
X_2095_ Tile_X0Y3_E2BEG[7] _2516_/X VPWR VGND sg13cmos5l_buf_1
XFILLER_80_123 VPWR VGND sg13cmos5l_decap_8
XFILLER_65_197 VPWR VGND sg13cmos5l_fill_1
XFILLER_206_170 VPWR VGND sg13cmos5l_decap_8
X_1046_ _1046_/Q Tile_X0Y4_FrameData[16] VGND VPWR Tile_X0Y5_FrameStrobe[0] latch
XANTENNA__2461__A1 Tile_X0Y1_W6END[10] VPWR VGND sg13cmos5l_antennanp
XANTENNA__1089__D Tile_X0Y4_FrameData[5] VPWR VGND sg13cmos5l_antennanp
XANTENNA__1667__A Tile_X0Y0_FrameData[7] VPWR VGND sg13cmos5l_antennanp
XANTENNA__2115__X AXIL_S_SOC_RDATA9 VPWR VGND sg13cmos5l_antennanp
XANTENNA__2213__A1 Tile_X0Y1_W6END[4] VPWR VGND sg13cmos5l_antennanp
XFILLER_119_100 VPWR VGND sg13cmos5l_decap_4
XFILLER_119_111 VPWR VGND sg13cmos5l_decap_8
XFILLER_119_133 VPWR VGND sg13cmos5l_decap_4
XFILLER_119_15 VPWR VGND sg13cmos5l_fill_2
XFILLER_119_26 VPWR VGND sg13cmos5l_decap_4
X_1948_ Tile_X0Y1_E2BEGb[1] _2302_/X VPWR VGND sg13cmos5l_buf_1
XANTENNA__0707__GATE Tile_X0Y5_FrameStrobe[4] VPWR VGND sg13cmos5l_antennanp
XANTENNA__1954__X Tile_X0Y1_E2BEGb[7] VPWR VGND sg13cmos5l_antennanp
XFILLER_119_177 VPWR VGND sg13cmos5l_decap_8
XFILLER_119_48 VPWR VGND sg13cmos5l_decap_4
X_1879_ Tile_X0Y2_E6BEG[5] _2438_/X VPWR VGND sg13cmos5l_buf_1
XANTENNA__0721__D Tile_X0Y2_FrameData[21] VPWR VGND sg13cmos5l_antennanp
XFILLER_119_199 VPWR VGND sg13cmos5l_fill_2
XFILLER_134_136 VPWR VGND sg13cmos5l_decap_8
XFILLER_135_14 VPWR VGND sg13cmos5l_decap_8
XFILLER_0_127 VPWR VGND sg13cmos5l_fill_2
XFILLER_192_7 VPWR VGND sg13cmos5l_fill_1
XFILLER_185_6 VPWR VGND sg13cmos5l_decap_8
XANTENNA__0168__D Tile_X0Y0_FrameData[30] VPWR VGND sg13cmos5l_antennanp
XFILLER_28_67 VPWR VGND sg13cmos5l_decap_8
XFILLER_56_164 VPWR VGND sg13cmos5l_decap_4
XFILLER_301_27 VPWR VGND sg13cmos5l_fill_2
XFILLER_71_167 VPWR VGND sg13cmos5l_decap_8
XFILLER_358_133 VPWR VGND sg13cmos5l_fill_1
XANTENNA__1577__A Tile_X0Y3_FrameData[23] VPWR VGND sg13cmos5l_antennanp
XANTENNA__2025__X Tile_X0Y5_FrameData_O[10] VPWR VGND sg13cmos5l_antennanp
XFILLER_358_177 VPWR VGND sg13cmos5l_fill_2
XFILLER_358_166 VPWR VGND sg13cmos5l_decap_8
XFILLER_100_83 VPWR VGND sg13cmos5l_fill_2
XANTENNA__1864__X Tile_X0Y4_FrameData_O[31] VPWR VGND sg13cmos5l_antennanp
XANTENNA__0631__D Tile_X0Y2_FrameData[15] VPWR VGND sg13cmos5l_antennanp
XFILLER_114_0 VPWR VGND sg13cmos5l_fill_1
XFILLER_125_125 VPWR VGND sg13cmos5l_decap_8
XFILLER_176_87 VPWR VGND sg13cmos5l_decap_8
XANTENNA__2507__A2 AXIL_S_SOC_ARADDR0 VPWR VGND sg13cmos5l_antennanp
XFILLER_140_128 VPWR VGND sg13cmos5l_decap_8
XFILLER_79_223 VPWR VGND sg13cmos5l_fill_1
XFILLER_192_86 VPWR VGND sg13cmos5l_fill_2
XFILLER_294_121 VPWR VGND sg13cmos5l_decap_8
XFILLER_69_85 VPWR VGND sg13cmos5l_decap_4
XANTENNA__1462__D Tile_X0Y5_FrameData[26] VPWR VGND sg13cmos5l_antennanp
XANTENNA__1484__GATE Tile_X0Y5_FrameStrobe[6] VPWR VGND sg13cmos5l_antennanp
XFILLER_125_91 VPWR VGND sg13cmos5l_fill_2
XFILLER_342_56 VPWR VGND sg13cmos5l_decap_8
XANTENNA__0078__D Tile_X0Y0_FrameData[24] VPWR VGND sg13cmos5l_antennanp
XANTENNA__2140__A0 Tile_X0Y5_W2MID[3] VPWR VGND sg13cmos5l_antennanp
XFILLER_85_95 VPWR VGND sg13cmos5l_decap_4
XFILLER_62_101 VPWR VGND sg13cmos5l_decap_8
XFILLER_47_197 VPWR VGND sg13cmos5l_fill_2
XANTENNA__0806__D Tile_X0Y3_FrameData[16] VPWR VGND sg13cmos5l_antennanp
XFILLER_349_122 VPWR VGND sg13cmos5l_decap_8
XANTENNA__1422__GATE Tile_X0Y5_FrameStrobe[4] VPWR VGND sg13cmos5l_antennanp
XFILLER_349_133 VPWR VGND sg13cmos5l_fill_2
X_1802_ Tile_X0Y4_E2BEGb[5] _2630_/X VPWR VGND sg13cmos5l_buf_1
X_2782_ _2782_/X _2824_/X _2823_/X _2814_/X _2813_/X _1340_/Q _1339_/Q VPWR VGND sg13cmos5l_mux4_1
XANTENNA__1774__X Tile_X0Y2_E1BEG[1] VPWR VGND sg13cmos5l_antennanp
X_1733_ Tile_X0Y0_E2BEG[5] _2170_/X VPWR VGND sg13cmos5l_buf_1
XANTENNA__0541__D Tile_X0Y1_FrameData[25] VPWR VGND sg13cmos5l_antennanp
XANTENNA__1437__GATE Tile_X0Y5_FrameStrobe[5] VPWR VGND sg13cmos5l_antennanp
XFILLER_236_24 VPWR VGND sg13cmos5l_decap_8
XFILLER_116_169 VPWR VGND sg13cmos5l_decap_8
X_1664_ Tile_X0Y0_FrameData_O[4] Tile_X0Y0_FrameData[4] VPWR VGND sg13cmos5l_buf_1
XANTENNA__0693__GATE Tile_X0Y5_FrameStrobe[4] VPWR VGND sg13cmos5l_antennanp
XFILLER_131_117 VPWR VGND sg13cmos5l_fill_1
XFILLER_131_139 VPWR VGND sg13cmos5l_decap_8
X_1595_ Tile_X0Y2_EE4BEG[8] _2425_/X VPWR VGND sg13cmos5l_buf_1
X_0615_ _0615_/Q Tile_X0Y2_FrameData[31] VGND VPWR Tile_X0Y5_FrameStrobe[2] latch
X_0546_ _0546_/Q Tile_X0Y1_FrameData[20] VGND VPWR Tile_X0Y5_FrameStrobe[7] latch
XANTENNA__1372__D Tile_X0Y5_FrameData[20] VPWR VGND sg13cmos5l_antennanp
X_0477_ _0477_/Q Tile_X0Y1_FrameData[25] VGND VPWR Tile_X0Y5_FrameStrobe[5] latch
XANTENNA__0078__GATE Tile_X0Y5_FrameStrobe[0] VPWR VGND sg13cmos5l_antennanp
X_2216_ _2216_/X Tile_X0Y1_W1END[3] Tile_X0Y1_W6END[7] _2349_/X _2340_/X _0544_/Q
+ _0543_/Q VPWR VGND sg13cmos5l_mux4_1
XANTENNA__2131__A0 Tile_X0Y0_W2MID[1] VPWR VGND sg13cmos5l_antennanp
XANTENNA__2682__A1 Tile_X0Y5_N2MID[6] VPWR VGND sg13cmos5l_antennanp
XFILLER_121_16 VPWR VGND sg13cmos5l_fill_2
X_2147_ _2147_/X Tile_X0Y0_W2MID[5] Tile_X0Y0_W2END[5] Tile_X0Y0_W6END[5] _2243_/X
+ _0298_/Q _0297_/Q VPWR VGND sg13cmos5l_mux4_1
XANTENNA__0631__GATE Tile_X0Y5_FrameStrobe[2] VPWR VGND sg13cmos5l_antennanp
XFILLER_121_49 VPWR VGND sg13cmos5l_decap_8
XFILLER_198_106 VPWR VGND sg13cmos5l_fill_2
X_2078_ Tile_X0Y5_S4BEG[11] _2078_/A VPWR VGND sg13cmos5l_buf_1
XANTENNA__0716__D Tile_X0Y2_FrameData[26] VPWR VGND sg13cmos5l_antennanp
XANTENNA__1949__X Tile_X0Y1_E2BEGb[2] VPWR VGND sg13cmos5l_antennanp
XANTENNA__2434__A1 Tile_X0Y0_S4END[9] VPWR VGND sg13cmos5l_antennanp
X_1029_ _1029_/Q Tile_X0Y3_FrameData[17] VGND VPWR Tile_X0Y5_FrameStrobe[7] latch
XANTENNA__0646__GATE Tile_X0Y5_FrameStrobe[2] VPWR VGND sg13cmos5l_antennanp
XANTENNA__0451__D Tile_X0Y1_FrameData[19] VPWR VGND sg13cmos5l_antennanp
XANTENNA__1684__X Tile_X0Y0_FrameData_O[24] VPWR VGND sg13cmos5l_antennanp
XFILLER_205_7 VPWR VGND sg13cmos5l_decap_4
XFILLER_122_117 VPWR VGND sg13cmos5l_decap_8
XFILLER_293_63 VPWR VGND sg13cmos5l_decap_8
XANTENNA__2021__A Tile_X0Y5_FrameData[6] VPWR VGND sg13cmos5l_antennanp
XANTENNA__1282__D Tile_X0Y5_FrameData[14] VPWR VGND sg13cmos5l_antennanp
XFILLER_162_12 VPWR VGND sg13cmos5l_decap_4
XFILLER_276_132 VPWR VGND sg13cmos5l_fill_1
XANTENNA__1860__A Tile_X0Y4_FrameData[27] VPWR VGND sg13cmos5l_antennanp
XANTENNA__2122__A0 Tile_X0Y1_W2MID[0] VPWR VGND sg13cmos5l_antennanp
XFILLER_217_210 VPWR VGND sg13cmos5l_decap_4
XFILLER_312_37 VPWR VGND sg13cmos5l_fill_1
XFILLER_29_131 VPWR VGND sg13cmos5l_decap_8
XANTENNA__2673__A1 Tile_X0Y3_W6END[8] VPWR VGND sg13cmos5l_antennanp
XFILLER_312_59 VPWR VGND sg13cmos5l_fill_1
XFILLER_55_54 VPWR VGND sg13cmos5l_fill_1
XANTENNA__0626__D Tile_X0Y2_FrameData[20] VPWR VGND sg13cmos5l_antennanp
XANTENNA__1859__X Tile_X0Y4_FrameData_O[26] VPWR VGND sg13cmos5l_antennanp
XANTENNA__2425__A1 AXIL_S_SOC_AWADDR8 VPWR VGND sg13cmos5l_antennanp
XFILLER_189_139 VPWR VGND sg13cmos5l_decap_8
XFILLER_44_178 VPWR VGND sg13cmos5l_decap_8
XFILLER_343_2 VPWR VGND sg13cmos5l_fill_1
XFILLER_231_0 VPWR VGND sg13cmos5l_fill_1
XFILLER_71_64 VPWR VGND sg13cmos5l_fill_2
XFILLER_346_103 VPWR VGND sg13cmos5l_decap_8
XANTENNA__2189__A0 AXIL_S_SOC_WDATA20 VPWR VGND sg13cmos5l_antennanp
XFILLER_329_0 VPWR VGND sg13cmos5l_decap_8
XANTENNA__1457__D Tile_X0Y5_FrameData[31] VPWR VGND sg13cmos5l_antennanp
XANTENNA__0361__D Tile_X0Y1_FrameData[13] VPWR VGND sg13cmos5l_antennanp
XANTENNA__1594__X Tile_X0Y2_EE4BEG[7] VPWR VGND sg13cmos5l_antennanp
XFILLER_337_89 VPWR VGND sg13cmos5l_decap_8
XFILLER_337_78 VPWR VGND sg13cmos5l_decap_4
XFILLER_302_217 VPWR VGND sg13cmos5l_fill_1
X_1380_ _1380_/Q Tile_X0Y5_FrameData[12] VGND VPWR Tile_X0Y5_FrameStrobe[3] latch
X_0400_ _0400_/Q Tile_X0Y1_FrameData[6] VGND VPWR Tile_X0Y5_FrameStrobe[2] latch
XFILLER_353_33 VPWR VGND sg13cmos5l_decap_8
XANTENNA__1192__D Tile_X0Y4_FrameData[30] VPWR VGND sg13cmos5l_antennanp
XFILLER_121_161 VPWR VGND sg13cmos5l_decap_8
X_0331_ _0331_/Q Tile_X0Y1_FrameData[11] VGND VPWR Tile_X0Y5_FrameStrobe[0] latch
XANTENNA__1770__A Tile_X0Y2_FrameData[30] VPWR VGND sg13cmos5l_antennanp
XANTENNA__2113__A0 Tile_X0Y3_W2MID[7] VPWR VGND sg13cmos5l_antennanp
XFILLER_208_210 VPWR VGND sg13cmos5l_decap_4
XFILLER_267_198 VPWR VGND sg13cmos5l_decap_8
X_2001_ Tile_X0Y5_EE4BEG[2] _2743_/X VPWR VGND sg13cmos5l_buf_1
X_0262_ _0262_/Q Tile_X0Y0_FrameData[0] VGND VPWR Tile_X0Y5_FrameStrobe[5] latch
XFILLER_282_179 VPWR VGND sg13cmos5l_fill_2
X_0193_ _0193_/Q Tile_X0Y0_FrameData[5] VGND VPWR Tile_X0Y5_FrameStrobe[3] latch
XANTENNA__0536__D Tile_X0Y1_FrameData[30] VPWR VGND sg13cmos5l_antennanp
XANTENNA__1361__GATE Tile_X0Y5_FrameStrobe[3] VPWR VGND sg13cmos5l_antennanp
XANTENNA__1769__X Tile_X0Y2_FrameData_O[29] VPWR VGND sg13cmos5l_antennanp
XANTENNA__2416__A1 AXIL_S_SOC_AWADDR7 VPWR VGND sg13cmos5l_antennanp
X_2834_ _2834_/X Tile_X0Y4_W1END[1] Tile_X0Y4_W2MID[2] Tile_X0Y4_W2END[2] _2683_/X
+ _1114_/Q _1113_/Q VPWR VGND sg13cmos5l_mux4_1
XANTENNA__1367__D Tile_X0Y5_FrameData[25] VPWR VGND sg13cmos5l_antennanp
XANTENNA__1376__GATE Tile_X0Y5_FrameStrobe[3] VPWR VGND sg13cmos5l_antennanp
XANTENNA__2719__A2 Tile_X0Y3_W2END[1] VPWR VGND sg13cmos5l_antennanp
XANTENNA__0271__D Tile_X0Y0_FrameData[23] VPWR VGND sg13cmos5l_antennanp
XFILLER_247_34 VPWR VGND sg13cmos5l_fill_1
XFILLER_247_56 VPWR VGND sg13cmos5l_decap_8
X_2765_ _2765_/X AXIL_S_SOC_ARPROT0 _2819_/X _2817_/X _2800_/X _1372_/Q _1371_/Q VPWR
+ VGND sg13cmos5l_mux4_1
XFILLER_345_180 VPWR VGND sg13cmos5l_fill_2
X_1716_ Tile_X0Y0_E6BEG[8] _2205_/X VPWR VGND sg13cmos5l_buf_1
X_2696_ _2696_/X _2674_/X Tile_X0Y5_N4END[4] _2673_/X _0039_/X _1062_/Q _1061_/Q VPWR
+ VGND sg13cmos5l_mux4_1
XFILLER_104_128 VPWR VGND sg13cmos5l_decap_4
X_1647_ Tile_X0Y0_FrameStrobe_O[7] Tile_X0Y5_FrameStrobe[7] VPWR VGND sg13cmos5l_buf_1
XFILLER_360_183 VPWR VGND sg13cmos5l_fill_1
XFILLER_258_143 VPWR VGND sg13cmos5l_decap_8
XFILLER_263_77 VPWR VGND sg13cmos5l_fill_2
X_1578_ Tile_X0Y3_FrameData_O[24] Tile_X0Y3_FrameData[24] VPWR VGND sg13cmos5l_buf_1
XANTENNA__1680__A Tile_X0Y0_FrameData[20] VPWR VGND sg13cmos5l_antennanp
X_0529_ _0529_/Q Tile_X0Y1_FrameData[5] VGND VPWR Tile_X0Y5_FrameStrobe[6] latch
XANTENNA__1314__GATE Tile_X0Y5_FrameStrobe[1] VPWR VGND sg13cmos5l_antennanp
XANTENNA__2104__A0 Tile_X0Y4_W2MID[4] VPWR VGND sg13cmos5l_antennanp
XFILLER_273_113 VPWR VGND sg13cmos5l_fill_1
XFILLER_132_48 VPWR VGND sg13cmos5l_decap_4
XFILLER_26_112 VPWR VGND sg13cmos5l_fill_2
XANTENNA__0570__GATE Tile_X0Y5_FrameStrobe[0] VPWR VGND sg13cmos5l_antennanp
XANTENNA__0446__D Tile_X0Y1_FrameData[24] VPWR VGND sg13cmos5l_antennanp
XANTENNA__1329__GATE Tile_X0Y5_FrameStrobe[2] VPWR VGND sg13cmos5l_antennanp
XANTENNA__1679__X Tile_X0Y0_FrameData_O[19] VPWR VGND sg13cmos5l_antennanp
XFILLER_212_70 VPWR VGND sg13cmos5l_fill_2
XANTENNA__2407__A1 AXIL_S_SOC_AWADDR6 VPWR VGND sg13cmos5l_antennanp
XFILLER_25_79 VPWR VGND sg13cmos5l_decap_4
XFILLER_288_41 VPWR VGND sg13cmos5l_decap_4
XFILLER_41_115 VPWR VGND sg13cmos5l_decap_8
XANTENNA__0585__GATE Tile_X0Y5_FrameStrobe[1] VPWR VGND sg13cmos5l_antennanp
XFILLER_288_74 VPWR VGND sg13cmos5l_decap_8
XANTENNA__2016__A Tile_X0Y5_FrameData[1] VPWR VGND sg13cmos5l_antennanp
XFILLER_328_147 VPWR VGND sg13cmos5l_decap_8
XFILLER_328_125 VPWR VGND sg13cmos5l_fill_1
XANTENNA__0181__D Tile_X0Y0_FrameData[17] VPWR VGND sg13cmos5l_antennanp
XANTENNA__1277__D Tile_X0Y5_FrameData[19] VPWR VGND sg13cmos5l_antennanp
XANTENNA__1855__A Tile_X0Y4_FrameData[22] VPWR VGND sg13cmos5l_antennanp
XFILLER_41_89 VPWR VGND sg13cmos5l_fill_1
XFILLER_336_191 VPWR VGND sg13cmos5l_fill_1
XFILLER_307_26 VPWR VGND sg13cmos5l_fill_1
XFILLER_351_172 VPWR VGND sg13cmos5l_fill_1
XFILLER_307_37 VPWR VGND sg13cmos5l_decap_8
XFILLER_150_223 VPWR VGND sg13cmos5l_fill_1
XFILLER_173_44 VPWR VGND sg13cmos5l_fill_1
XANTENNA__0523__GATE Tile_X0Y5_FrameStrobe[6] VPWR VGND sg13cmos5l_antennanp
XANTENNA__2343__A0 Tile_X0Y0_W1END[1] VPWR VGND sg13cmos5l_antennanp
XFILLER_173_55 VPWR VGND sg13cmos5l_decap_8
XFILLER_249_132 VPWR VGND sg13cmos5l_decap_8
XFILLER_249_176 VPWR VGND sg13cmos5l_decap_8
XFILLER_181_0 VPWR VGND sg13cmos5l_fill_2
XFILLER_66_31 VPWR VGND sg13cmos5l_fill_1
XANTENNA__0538__GATE Tile_X0Y5_FrameStrobe[7] VPWR VGND sg13cmos5l_antennanp
XANTENNA__2646__A1 AXIL_S_SOC_WSTRB1 VPWR VGND sg13cmos5l_antennanp
XFILLER_17_101 VPWR VGND sg13cmos5l_fill_1
XFILLER_17_123 VPWR VGND sg13cmos5l_fill_2
XANTENNA__0356__D Tile_X0Y1_FrameData[18] VPWR VGND sg13cmos5l_antennanp
XANTENNA__1589__X Tile_X0Y2_EE4BEG[2] VPWR VGND sg13cmos5l_antennanp
XFILLER_198_63 VPWR VGND sg13cmos5l_decap_8
XFILLER_185_153 VPWR VGND sg13cmos5l_fill_1
X_0880_ _0880_/Q Tile_X0Y3_FrameData[6] VGND VPWR Tile_X0Y5_FrameStrobe[2] latch
XFILLER_319_169 VPWR VGND sg13cmos5l_fill_1
XANTENNA__0091__D Tile_X0Y0_FrameData[11] VPWR VGND sg13cmos5l_antennanp
XANTENNA__1187__D Tile_X0Y4_FrameData[3] VPWR VGND sg13cmos5l_antennanp
XANTENNA__1765__A Tile_X0Y2_FrameData[25] VPWR VGND sg13cmos5l_antennanp
XFILLER_348_88 VPWR VGND sg13cmos5l_decap_8
X_2550_ _2550_/X AXIL_S_SOC_ARADDR1 _2584_/X _2582_/X _2594_/X _0904_/Q _0903_/Q VPWR
+ VGND sg13cmos5l_mux4_1
XFILLER_327_180 VPWR VGND sg13cmos5l_fill_1
XFILLER_141_212 VPWR VGND sg13cmos5l_decap_4
XFILLER_217_59 VPWR VGND sg13cmos5l_decap_8
X_1501_ _2562_/A3 VPWR VGND sg13cmos5l_tielo
X_2481_ _2481_/X _2382_/X _2490_/X _2489_/X _2381_/X _0574_/Q _0573_/Q VPWR VGND sg13cmos5l_mux4_1
XFILLER_99_104 VPWR VGND sg13cmos5l_fill_1
XFILLER_141_223 VPWR VGND sg13cmos5l_fill_1
X_1432_ _1432_/Q Tile_X0Y5_FrameData[24] VGND VPWR Tile_X0Y5_FrameStrobe[5] latch
XFILLER_99_159 VPWR VGND sg13cmos5l_decap_8
XFILLER_342_194 VPWR VGND sg13cmos5l_fill_1
XANTENNA__2334__A0 AXIL_S_SOC_WDATA1 VPWR VGND sg13cmos5l_antennanp
X_1363_ _1363_/Q Tile_X0Y5_FrameData[29] VGND VPWR Tile_X0Y5_FrameStrobe[3] latch
XFILLER_255_113 VPWR VGND sg13cmos5l_decap_4
X_1294_ _1294_/Q Tile_X0Y5_FrameData[2] VGND VPWR Tile_X0Y5_FrameStrobe[0] latch
X_0314_ _0314_/Q Tile_X0Y1_FrameData[28] VGND VPWR Tile_X0Y5_FrameStrobe[0] latch
XANTENNA__2637__A1 AXIL_S_SOC_WVALID VPWR VGND sg13cmos5l_antennanp
XFILLER_255_146 VPWR VGND sg13cmos5l_fill_2
X_0245_ _0245_/Q Tile_X0Y0_FrameData[17] VGND VPWR Tile_X0Y5_FrameStrobe[5] latch
XANTENNA__0266__D Tile_X0Y0_FrameData[28] VPWR VGND sg13cmos5l_antennanp
X_0176_ _0176_/Q Tile_X0Y0_FrameData[22] VGND VPWR Tile_X0Y5_FrameStrobe[3] latch
XFILLER_258_11 VPWR VGND sg13cmos5l_fill_2
XANTENNA__1097__D Tile_X0Y4_FrameData[29] VPWR VGND sg13cmos5l_antennanp
XANTENNA__1675__A Tile_X0Y0_FrameData[15] VPWR VGND sg13cmos5l_antennanp
X_2817_ _2817_/X Tile_X0Y5_N1END[3] Tile_X0Y5_N4END[3] _2796_/X _0057_/X _1306_/Q
+ _1305_/Q VPWR VGND sg13cmos5l_mux4_1
XANTENNA__2123__X AXIL_S_SOC_RDATA17 VPWR VGND sg13cmos5l_antennanp
XFILLER_11_48 VPWR VGND sg13cmos5l_fill_2
XFILLER_191_167 VPWR VGND sg13cmos5l_fill_2
X_2748_ _2748_/X AXIL_S_SOC_ARPROT1 AXIL_S_SOC_ARPROT2 _2814_/X _2825_/X _1406_/Q
+ _1405_/Q VPWR VGND sg13cmos5l_mux4_1
XANTENNA__1962__X Tile_X0Y1_E2BEG[7] VPWR VGND sg13cmos5l_antennanp
XFILLER_278_216 VPWR VGND sg13cmos5l_fill_1
X_2679_ _2679_/X Tile_X0Y3_W1END[3] Tile_X0Y3_W6END[11] _2573_/X _2564_/X _0892_/Q
+ _0891_/Q VPWR VGND sg13cmos5l_mux4_1
XANTENNA__1253__GATE Tile_X0Y5_FrameStrobe[6] VPWR VGND sg13cmos5l_antennanp
XFILLER_143_36 VPWR VGND sg13cmos5l_decap_8
XFILLER_100_120 VPWR VGND sg13cmos5l_decap_8
XFILLER_246_113 VPWR VGND sg13cmos5l_decap_8
XFILLER_290_64 VPWR VGND sg13cmos5l_decap_8
XANTENNA__2628__A1 AXIL_S_SOC_BREADY VPWR VGND sg13cmos5l_antennanp
XANTENNA__1268__GATE Tile_X0Y5_FrameStrobe[0] VPWR VGND sg13cmos5l_antennanp
XFILLER_223_91 VPWR VGND sg13cmos5l_decap_8
XANTENNA__0176__D Tile_X0Y0_FrameData[22] VPWR VGND sg13cmos5l_antennanp
XFILLER_199_223 VPWR VGND sg13cmos5l_fill_1
XFILLER_299_40 VPWR VGND sg13cmos5l_decap_8
XFILLER_299_73 VPWR VGND sg13cmos5l_fill_2
XANTENNA__0904__D Tile_X0Y3_FrameData[14] VPWR VGND sg13cmos5l_antennanp
XFILLER_52_66 VPWR VGND sg13cmos5l_fill_1
XANTENNA__2800__A1 Tile_X0Y5_N2END[4] VPWR VGND sg13cmos5l_antennanp
XFILLER_167_153 VPWR VGND sg13cmos5l_decap_8
XANTENNA__1585__A Tile_X0Y3_FrameData[31] VPWR VGND sg13cmos5l_antennanp
XANTENNA__1206__GATE Tile_X0Y5_FrameStrobe[5] VPWR VGND sg13cmos5l_antennanp
XANTENNA__2033__X Tile_X0Y5_FrameData_O[18] VPWR VGND sg13cmos5l_antennanp
XANTENNA__2159__A3 Tile_X0Y0_W6END[11] VPWR VGND sg13cmos5l_antennanp
XFILLER_182_167 VPWR VGND sg13cmos5l_decap_8
XFILLER_184_10 VPWR VGND sg13cmos5l_decap_8
XFILLER_309_180 VPWR VGND sg13cmos5l_fill_1
XFILLER_123_212 VPWR VGND sg13cmos5l_fill_1
XFILLER_182_178 VPWR VGND sg13cmos5l_decap_4
XANTENNA__0462__GATE Tile_X0Y5_FrameStrobe[4] VPWR VGND sg13cmos5l_antennanp
XANTENNA__1872__X Tile_X0Y2_E2BEGb[6] VPWR VGND sg13cmos5l_antennanp
XFILLER_324_172 VPWR VGND sg13cmos5l_decap_8
XANTENNA__2316__A0 AXIL_S_SOC_WDATA7 VPWR VGND sg13cmos5l_antennanp
XFILLER_334_35 VPWR VGND sg13cmos5l_fill_2
XFILLER_334_24 VPWR VGND sg13cmos5l_fill_1
XFILLER_117_92 VPWR VGND sg13cmos5l_fill_1
XFILLER_77_63 VPWR VGND sg13cmos5l_decap_8
XANTENNA__0477__GATE Tile_X0Y5_FrameStrobe[5] VPWR VGND sg13cmos5l_antennanp
XANTENNA__1470__D Tile_X0Y5_FrameData[18] VPWR VGND sg13cmos5l_antennanp
XANTENNA__2619__A1 AXIL_S_SOC_WVALID VPWR VGND sg13cmos5l_antennanp
X_0030_ _0030_/X _2359_/X _2360_/X _1464_/Q VPWR VGND sg13cmos5l_mux2_1
XANTENNA__0086__D Tile_X0Y0_FrameData[16] VPWR VGND sg13cmos5l_antennanp
XANTENNA__0400__GATE Tile_X0Y5_FrameStrobe[2] VPWR VGND sg13cmos5l_antennanp
XANTENNA__0814__D Tile_X0Y3_FrameData[8] VPWR VGND sg13cmos5l_antennanp
XFILLER_20_129 VPWR VGND sg13cmos5l_decap_8
X_1981_ Tile_X0Y5_E2BEGb[2] _2735_/X VPWR VGND sg13cmos5l_buf_1
XANTENNA__0415__GATE Tile_X0Y5_FrameStrobe[3] VPWR VGND sg13cmos5l_antennanp
XANTENNA__2398__A3 AXIL_S_SOC_AWADDR6 VPWR VGND sg13cmos5l_antennanp
XFILLER_158_142 VPWR VGND sg13cmos5l_fill_2
X_0932_ _0932_/Q Tile_X0Y3_FrameData[18] VGND VPWR Tile_X0Y5_FrameStrobe[4] latch
XFILLER_158_186 VPWR VGND sg13cmos5l_decap_8
XFILLER_173_123 VPWR VGND sg13cmos5l_decap_8
X_0863_ _0863_/Q Tile_X0Y3_FrameData[23] VGND VPWR Tile_X0Y5_FrameStrobe[2] latch
XFILLER_362_201 VPWR VGND sg13cmos5l_fill_2
X_2602_ _2602_/X Tile_X0Y5_W2MID[5] Tile_X0Y5_W2END[5] Tile_X0Y5_W6END[5] _2827_/X
+ _1484_/Q _1483_/Q VPWR VGND sg13cmos5l_mux4_1
XANTENNA__2555__A0 Tile_X0Y3_W1END[1] VPWR VGND sg13cmos5l_antennanp
X_2533_ _2533_/X AXIL_S_SOC_ARADDR4 AXIL_S_SOC_ARADDR8 _2581_/X _2596_/X _0938_/Q
+ _0937_/Q VPWR VGND sg13cmos5l_mux4_1
X_0794_ _0794_/Q Tile_X0Y3_FrameData[28] VGND VPWR Tile_X0Y5_FrameStrobe[0] latch
XANTENNA__1782__X Tile_X0Y2_E2BEG[5] VPWR VGND sg13cmos5l_antennanp
XFILLER_308_91 VPWR VGND sg13cmos5l_fill_2
XANTENNA__2307__A0 AXIL_S_SOC_WDATA6 VPWR VGND sg13cmos5l_antennanp
XFILLER_244_24 VPWR VGND sg13cmos5l_decap_4
X_2464_ _2464_/X Tile_X0Y3_W1END[3] Tile_X0Y3_W6END[7] _2573_/X _2564_/X _1024_/Q
+ _1023_/Q VPWR VGND sg13cmos5l_mux4_1
XFILLER_330_153 VPWR VGND sg13cmos5l_decap_8
XFILLER_244_57 VPWR VGND sg13cmos5l_fill_1
XFILLER_244_68 VPWR VGND sg13cmos5l_decap_8
X_1415_ _1415_/Q Tile_X0Y5_FrameData[9] VGND VPWR Tile_X0Y5_FrameStrobe[4] latch
X_2395_ _2395_/X Tile_X0Y0_W1END[3] Tile_X0Y0_W2MID[0] Tile_X0Y0_W2END[0] _2248_/X
+ _0156_/Q _0155_/Q VPWR VGND sg13cmos5l_mux4_1
XFILLER_87_129 VPWR VGND sg13cmos5l_decap_8
XFILLER_330_197 VPWR VGND sg13cmos5l_fill_1
X_1346_ _1346_/Q Tile_X0Y5_FrameData[14] VGND VPWR Tile_X0Y5_FrameStrobe[2] latch
XANTENNA__1380__D Tile_X0Y5_FrameData[12] VPWR VGND sg13cmos5l_antennanp
XFILLER_324_90 VPWR VGND sg13cmos5l_decap_4
X_1277_ _1277_/Q Tile_X0Y5_FrameData[19] VGND VPWR Tile_X0Y5_FrameStrobe[0] latch
XFILLER_260_89 VPWR VGND sg13cmos5l_decap_8
X_0228_ _0228_/Q Tile_X0Y0_FrameData[2] VGND VPWR Tile_X0Y5_FrameStrobe[4] latch
XANTENNA__2118__X AXIL_S_SOC_RDATA12 VPWR VGND sg13cmos5l_antennanp
X_0159_ _0159_/Q Tile_X0Y0_FrameData[7] VGND VPWR Tile_X0Y5_FrameStrobe[2] latch
XANTENNA__0724__D Tile_X0Y2_FrameData[18] VPWR VGND sg13cmos5l_antennanp
XANTENNA__1957__X Tile_X0Y1_E2BEG[2] VPWR VGND sg13cmos5l_antennanp
XFILLER_11_118 VPWR VGND sg13cmos5l_decap_4
XFILLER_269_65 VPWR VGND sg13cmos5l_decap_8
XANTENNA__2794__A0 Tile_X0Y4_W1END[1] VPWR VGND sg13cmos5l_antennanp
XANTENNA__2546__A0 AXIL_S_SOC_ARADDR5 VPWR VGND sg13cmos5l_antennanp
XFILLER_164_178 VPWR VGND sg13cmos5l_decap_8
XFILLER_285_75 VPWR VGND sg13cmos5l_fill_2
XFILLER_98_18 VPWR VGND sg13cmos5l_fill_2
XANTENNA__1692__X Tile_X0Y0_EE4BEG[0] VPWR VGND sg13cmos5l_antennanp
XANTENNA__1192__GATE Tile_X0Y5_FrameStrobe[5] VPWR VGND sg13cmos5l_antennanp
XFILLER_154_13 VPWR VGND sg13cmos5l_fill_2
XFILLER_304_16 VPWR VGND sg13cmos5l_decap_8
XFILLER_219_135 VPWR VGND sg13cmos5l_decap_8
XFILLER_219_157 VPWR VGND sg13cmos5l_fill_1
XFILLER_47_55 VPWR VGND sg13cmos5l_fill_1
XFILLER_47_33 VPWR VGND sg13cmos5l_fill_1
XANTENNA__1290__D Tile_X0Y5_FrameData[6] VPWR VGND sg13cmos5l_antennanp
XFILLER_219_179 VPWR VGND sg13cmos5l_decap_8
XFILLER_170_67 VPWR VGND sg13cmos5l_decap_8
XANTENNA__1130__GATE Tile_X0Y5_FrameStrobe[3] VPWR VGND sg13cmos5l_antennanp
XANTENNA__2028__X Tile_X0Y5_FrameData_O[13] VPWR VGND sg13cmos5l_antennanp
XFILLER_103_83 VPWR VGND sg13cmos5l_decap_8
XFILLER_42_210 VPWR VGND sg13cmos5l_fill_1
XFILLER_179_32 VPWR VGND sg13cmos5l_decap_4
XFILLER_242_182 VPWR VGND sg13cmos5l_decap_8
XFILLER_63_65 VPWR VGND sg13cmos5l_decap_4
XFILLER_63_54 VPWR VGND sg13cmos5l_fill_1
XANTENNA__0634__D Tile_X0Y2_FrameData[12] VPWR VGND sg13cmos5l_antennanp
XANTENNA__1867__X Tile_X0Y2_E2BEGb[1] VPWR VGND sg13cmos5l_antennanp
XFILLER_144_0 VPWR VGND sg13cmos5l_decap_8
XANTENNA__2785__A0 Tile_X0Y5_W1END[2] VPWR VGND sg13cmos5l_antennanp
XANTENNA__1145__GATE Tile_X0Y5_FrameStrobe[3] VPWR VGND sg13cmos5l_antennanp
XFILLER_329_57 VPWR VGND sg13cmos5l_fill_2
XFILLER_311_0 VPWR VGND sg13cmos5l_fill_1
XANTENNA__2537__A0 AXIL_S_SOC_ARADDR0 VPWR VGND sg13cmos5l_antennanp
XFILLER_155_167 VPWR VGND sg13cmos5l_decap_8
XANTENNA__1465__D Tile_X0Y5_FrameData[23] VPWR VGND sg13cmos5l_antennanp
XFILLER_88_40 VPWR VGND sg13cmos5l_decap_8
XFILLER_312_142 VPWR VGND sg13cmos5l_fill_2
XFILLER_111_204 VPWR VGND sg13cmos5l_fill_1
XFILLER_88_84 VPWR VGND sg13cmos5l_decap_8
XFILLER_69_129 VPWR VGND sg13cmos5l_decap_8
X_2180_ _2180_/X AXIL_S_SOC_WDATA23 AXIL_S_SOC_WDATA31 _2241_/X _2248_/X _0236_/Q
+ _0235_/Q VPWR VGND sg13cmos5l_mux4_1
X_1200_ _1200_/Q Tile_X0Y4_FrameData[22] VGND VPWR Tile_X0Y5_FrameStrobe[5] latch
XANTENNA__0809__D Tile_X0Y3_FrameData[13] VPWR VGND sg13cmos5l_antennanp
XFILLER_214_49 VPWR VGND sg13cmos5l_decap_8
X_1131_ _1131_/Q Tile_X0Y4_FrameData[27] VGND VPWR Tile_X0Y5_FrameStrobe[3] latch
XFILLER_92_132 VPWR VGND sg13cmos5l_decap_4
XFILLER_225_127 VPWR VGND sg13cmos5l_fill_1
XFILLER_230_15 VPWR VGND sg13cmos5l_decap_4
X_1062_ _1062_/Q Tile_X0Y4_FrameData[0] VGND VPWR Tile_X0Y5_FrameStrobe[0] latch
XFILLER_230_26 VPWR VGND sg13cmos5l_fill_1
XFILLER_92_187 VPWR VGND sg13cmos5l_decap_8
XANTENNA__0354__GATE Tile_X0Y5_FrameStrobe[1] VPWR VGND sg13cmos5l_antennanp
XANTENNA__0544__D Tile_X0Y1_FrameData[22] VPWR VGND sg13cmos5l_antennanp
XANTENNA__1777__X Tile_X0Y2_E2BEG[0] VPWR VGND sg13cmos5l_antennanp
XANTENNA__0984__GATE Tile_X0Y5_FrameStrobe[6] VPWR VGND sg13cmos5l_antennanp
XANTENNA__2776__A0 Tile_X0Y5_W2MID[4] VPWR VGND sg13cmos5l_antennanp
X_1964_ Tile_X0Y1_E1BEG[1] _2290_/X VPWR VGND sg13cmos5l_buf_1
XANTENNA__2240__A2 Tile_X0Y0_S1END[0] VPWR VGND sg13cmos5l_antennanp
XFILLER_239_68 VPWR VGND sg13cmos5l_decap_8
X_0915_ _0915_/Q Tile_X0Y3_FrameData[3] VGND VPWR Tile_X0Y5_FrameStrobe[3] latch
XFILLER_239_79 VPWR VGND sg13cmos5l_fill_1
X_1895_ Tile_X0Y1_FrameData_O[8] Tile_X0Y1_FrameData[8] VPWR VGND sg13cmos5l_buf_1
XANTENNA__0369__GATE Tile_X0Y5_FrameStrobe[1] VPWR VGND sg13cmos5l_antennanp
XANTENNA__2528__A0 AXIL_S_SOC_ARADDR3 VPWR VGND sg13cmos5l_antennanp
X_0846_ _0846_/Q Tile_X0Y3_FrameData[8] VGND VPWR Tile_X0Y5_FrameStrobe[1] latch
XANTENNA__0999__GATE Tile_X0Y5_FrameStrobe[6] VPWR VGND sg13cmos5l_antennanp
XANTENNA__1375__D Tile_X0Y5_FrameData[17] VPWR VGND sg13cmos5l_antennanp
XFILLER_108_28 VPWR VGND sg13cmos5l_fill_1
XFILLER_255_45 VPWR VGND sg13cmos5l_fill_1
XFILLER_255_56 VPWR VGND sg13cmos5l_fill_2
X_0777_ _0777_/Q Tile_X0Y2_FrameData[29] VGND VPWR Tile_X0Y5_FrameStrobe[7] latch
X_2516_ _2516_/X AXIL_S_SOC_ARADDR5 AXIL_S_SOC_ARADDR7 _2589_/X _2596_/X _0972_/Q
+ _0971_/Q VPWR VGND sg13cmos5l_mux4_1
XFILLER_303_120 VPWR VGND sg13cmos5l_decap_8
X_2447_ _2447_/X Tile_X0Y2_W1END[1] Tile_X0Y2_WW4END[9] Tile_X0Y2_WW4END[13] Tile_X0Y2_W6END[5]
+ _0631_/Q _0630_/Q VPWR VGND sg13cmos5l_mux4_1
XFILLER_303_164 VPWR VGND sg13cmos5l_decap_8
XANTENNA__0922__GATE Tile_X0Y5_FrameStrobe[4] VPWR VGND sg13cmos5l_antennanp
XANTENNA__0719__D Tile_X0Y2_FrameData[23] VPWR VGND sg13cmos5l_antennanp
X_2378_ _2378_/X _2259_/X _2392_/X _2391_/X Tile_X0Y0_S2MID[5] _0324_/Q _0323_/Q VPWR
+ VGND sg13cmos5l_mux4_1
XANTENNA__0307__GATE Tile_X0Y5_FrameStrobe[7] VPWR VGND sg13cmos5l_antennanp
X_1329_ _1329_/Q Tile_X0Y5_FrameData[31] VGND VPWR Tile_X0Y5_FrameStrobe[2] latch
XFILLER_83_132 VPWR VGND sg13cmos5l_decap_8
XANTENNA__0937__GATE Tile_X0Y5_FrameStrobe[4] VPWR VGND sg13cmos5l_antennanp
XFILLER_204_71 VPWR VGND sg13cmos5l_decap_8
XFILLER_216_149 VPWR VGND sg13cmos5l_decap_8
XFILLER_17_69 VPWR VGND sg13cmos5l_fill_2
XFILLER_83_176 VPWR VGND sg13cmos5l_fill_2
XANTENNA__0454__D Tile_X0Y1_FrameData[16] VPWR VGND sg13cmos5l_antennanp
XANTENNA__1687__X Tile_X0Y0_FrameData_O[27] VPWR VGND sg13cmos5l_antennanp
XANTENNA__2767__A0 AXIL_S_SOC_ARPROT2 VPWR VGND sg13cmos5l_antennanp
XFILLER_149_13 VPWR VGND sg13cmos5l_decap_8
XANTENNA__2231__A2 Tile_X0Y4_W6END[11] VPWR VGND sg13cmos5l_antennanp
XFILLER_296_63 VPWR VGND sg13cmos5l_decap_4
XANTENNA__2024__A Tile_X0Y5_FrameData[9] VPWR VGND sg13cmos5l_antennanp
XFILLER_137_123 VPWR VGND sg13cmos5l_decap_8
XANTENNA__2519__A0 AXIL_S_SOC_ARADDR0 VPWR VGND sg13cmos5l_antennanp
XANTENNA__1285__D Tile_X0Y5_FrameData[11] VPWR VGND sg13cmos5l_antennanp
XANTENNA__1863__A Tile_X0Y4_FrameData[30] VPWR VGND sg13cmos5l_antennanp
XFILLER_165_45 VPWR VGND sg13cmos5l_decap_8
XFILLER_3_125 VPWR VGND sg13cmos5l_fill_1
XFILLER_58_10 VPWR VGND sg13cmos5l_fill_2
XFILLER_181_44 VPWR VGND sg13cmos5l_decap_8
XANTENNA__0629__D Tile_X0Y2_FrameData[17] VPWR VGND sg13cmos5l_antennanp
XFILLER_181_77 VPWR VGND sg13cmos5l_decap_8
XFILLER_74_110 VPWR VGND sg13cmos5l_decap_4
XFILLER_114_82 VPWR VGND sg13cmos5l_fill_2
XFILLER_74_165 VPWR VGND sg13cmos5l_fill_1
XFILLER_74_143 VPWR VGND sg13cmos5l_decap_4
XFILLER_261_0 VPWR VGND sg13cmos5l_decap_8
XFILLER_359_0 VPWR VGND sg13cmos5l_fill_2
XFILLER_74_97 VPWR VGND sg13cmos5l_decap_4
XANTENNA__0364__D Tile_X0Y1_FrameData[10] VPWR VGND sg13cmos5l_antennanp
XANTENNA__1597__X Tile_X0Y2_EE4BEG[10] VPWR VGND sg13cmos5l_antennanp
XFILLER_30_202 VPWR VGND sg13cmos5l_decap_8
XANTENNA__1084__GATE Tile_X0Y5_FrameStrobe[1] VPWR VGND sg13cmos5l_antennanp
XFILLER_90_41 VPWR VGND sg13cmos5l_decap_8
XANTENNA__2758__A0 Tile_X0Y5_N4END[1] VPWR VGND sg13cmos5l_antennanp
XFILLER_230_196 VPWR VGND sg13cmos5l_decap_8
XFILLER_90_74 VPWR VGND sg13cmos5l_decap_8
XANTENNA__2222__A2 Tile_X0Y0_S1END[2] VPWR VGND sg13cmos5l_antennanp
X_0700_ _0700_/Q Tile_X0Y2_FrameData[10] VGND VPWR Tile_X0Y5_FrameStrobe[4] latch
XFILLER_317_223 VPWR VGND sg13cmos5l_fill_1
XFILLER_128_156 VPWR VGND sg13cmos5l_fill_2
X_1680_ Tile_X0Y0_FrameData_O[20] Tile_X0Y0_FrameData[20] VPWR VGND sg13cmos5l_buf_1
XANTENNA__1099__GATE Tile_X0Y5_FrameStrobe[2] VPWR VGND sg13cmos5l_antennanp
XANTENNA__1195__D Tile_X0Y4_FrameData[27] VPWR VGND sg13cmos5l_antennanp
X_0631_ _0631_/Q Tile_X0Y2_FrameData[15] VGND VPWR Tile_X0Y5_FrameStrobe[2] latch
XFILLER_99_83 VPWR VGND sg13cmos5l_decap_8
XFILLER_332_215 VPWR VGND sg13cmos5l_fill_1
X_0562_ _0562_/Q Tile_X0Y2_FrameData[20] VGND VPWR Tile_X0Y5_FrameStrobe[0] latch
X_2301_ _2301_/X AXIL_S_SOC_WDATA0 AXIL_S_SOC_WDATA8 _2373_/X _2380_/X _0490_/Q _0489_/Q
+ VPWR VGND sg13cmos5l_mux4_1
XFILLER_97_213 VPWR VGND sg13cmos5l_decap_4
XFILLER_297_163 VPWR VGND sg13cmos5l_fill_2
XFILLER_297_130 VPWR VGND sg13cmos5l_decap_4
XANTENNA__1022__GATE Tile_X0Y5_FrameStrobe[7] VPWR VGND sg13cmos5l_antennanp
X_0493_ _0493_/Q Tile_X0Y1_FrameData[9] VGND VPWR Tile_X0Y5_FrameStrobe[5] latch
XANTENNA__2289__A2 AXIL_S_SOC_WDATA2 VPWR VGND sg13cmos5l_antennanp
X_2232_ _2232_/X _2700_/X _2685_/X _2684_/X _2711_/X _1231_/Q _1230_/Q VPWR VGND sg13cmos5l_mux4_1
XANTENNA__0539__D Tile_X0Y1_FrameData[27] VPWR VGND sg13cmos5l_antennanp
X_2163_ _2163_/X _2215_/X Tile_X0Y0_S1END[2] AXIL_S_SOC_WDATA16 AXIL_S_SOC_WDATA21
+ _0270_/Q _0269_/Q VPWR VGND sg13cmos5l_mux4_1
XANTENNA__1037__GATE Tile_X0Y5_FrameStrobe[0] VPWR VGND sg13cmos5l_antennanp
XFILLER_253_222 VPWR VGND sg13cmos5l_fill_2
X_1114_ _1114_/Q Tile_X0Y4_FrameData[12] VGND VPWR Tile_X0Y5_FrameStrobe[2] latch
X_2094_ Tile_X0Y3_E2BEG[6] _2515_/X VPWR VGND sg13cmos5l_buf_1
X_1045_ _1045_/Q Tile_X0Y4_FrameData[17] VGND VPWR Tile_X0Y5_FrameStrobe[0] latch
XANTENNA__0293__GATE Tile_X0Y5_FrameStrobe[6] VPWR VGND sg13cmos5l_antennanp
XFILLER_206_193 VPWR VGND sg13cmos5l_fill_1
XANTENNA__0274__D Tile_X0Y0_FrameData[20] VPWR VGND sg13cmos5l_antennanp
XANTENNA__2749__A0 AXIL_S_SOC_ARVALID VPWR VGND sg13cmos5l_antennanp
XFILLER_221_185 VPWR VGND sg13cmos5l_decap_8
X_1947_ Tile_X0Y1_E2BEGb[0] _2301_/X VPWR VGND sg13cmos5l_buf_1
XFILLER_119_167 VPWR VGND sg13cmos5l_fill_2
X_1878_ Tile_X0Y2_E6BEG[4] _2437_/X VPWR VGND sg13cmos5l_buf_1
XFILLER_266_66 VPWR VGND sg13cmos5l_fill_1
XFILLER_266_99 VPWR VGND sg13cmos5l_fill_1
X_0829_ _0829_/Q Tile_X0Y3_FrameData[25] VGND VPWR Tile_X0Y5_FrameStrobe[1] latch
XANTENNA__0231__GATE Tile_X0Y5_FrameStrobe[5] VPWR VGND sg13cmos5l_antennanp
XANTENNA__1683__A Tile_X0Y0_FrameData[23] VPWR VGND sg13cmos5l_antennanp
XANTENNA__2131__X AXIL_S_SOC_RDATA25 VPWR VGND sg13cmos5l_antennanp
XANTENNA__0861__GATE Tile_X0Y5_FrameStrobe[2] VPWR VGND sg13cmos5l_antennanp
XFILLER_282_21 VPWR VGND sg13cmos5l_decap_4
XFILLER_282_43 VPWR VGND sg13cmos5l_decap_8
XANTENNA__1970__X Tile_X0Y5_E1BEG[3] VPWR VGND sg13cmos5l_antennanp
XFILLER_288_174 VPWR VGND sg13cmos5l_fill_1
XFILLER_288_185 VPWR VGND sg13cmos5l_fill_2
XANTENNA__0246__GATE Tile_X0Y5_FrameStrobe[5] VPWR VGND sg13cmos5l_antennanp
XANTENNA__0449__D Tile_X0Y1_FrameData[21] VPWR VGND sg13cmos5l_antennanp
XFILLER_215_92 VPWR VGND sg13cmos5l_decap_8
XFILLER_28_57 VPWR VGND sg13cmos5l_fill_2
XANTENNA__0876__GATE Tile_X0Y5_FrameStrobe[2] VPWR VGND sg13cmos5l_antennanp
XFILLER_56_143 VPWR VGND sg13cmos5l_decap_8
XFILLER_56_187 VPWR VGND sg13cmos5l_decap_8
XANTENNA__2019__A Tile_X0Y5_FrameData[4] VPWR VGND sg13cmos5l_antennanp
XFILLER_71_146 VPWR VGND sg13cmos5l_decap_8
XFILLER_301_39 VPWR VGND sg13cmos5l_fill_2
XFILLER_44_56 VPWR VGND sg13cmos5l_fill_2
XFILLER_358_112 VPWR VGND sg13cmos5l_decap_8
XANTENNA__0184__D Tile_X0Y0_FrameData[14] VPWR VGND sg13cmos5l_antennanp
XANTENNA__1858__A Tile_X0Y4_FrameData[25] VPWR VGND sg13cmos5l_antennanp
XFILLER_157_207 VPWR VGND sg13cmos5l_decap_8
XFILLER_100_62 VPWR VGND sg13cmos5l_decap_8
XANTENNA__0814__GATE Tile_X0Y5_FrameStrobe[0] VPWR VGND sg13cmos5l_antennanp
XANTENNA__0912__D Tile_X0Y3_FrameData[6] VPWR VGND sg13cmos5l_antennanp
XFILLER_176_11 VPWR VGND sg13cmos5l_fill_1
XFILLER_125_104 VPWR VGND sg13cmos5l_decap_8
XFILLER_176_66 VPWR VGND sg13cmos5l_decap_8
XFILLER_326_14 VPWR VGND sg13cmos5l_decap_8
XANTENNA__2041__X Tile_X0Y5_FrameData_O[26] VPWR VGND sg13cmos5l_antennanp
XANTENNA__2507__A3 AXIL_S_SOC_ARADDR5 VPWR VGND sg13cmos5l_antennanp
XFILLER_107_0 VPWR VGND sg13cmos5l_fill_1
XFILLER_109_82 VPWR VGND sg13cmos5l_decap_4
XFILLER_326_25 VPWR VGND sg13cmos5l_fill_2
XANTENNA__0829__GATE Tile_X0Y5_FrameStrobe[1] VPWR VGND sg13cmos5l_antennanp
XFILLER_140_118 VPWR VGND sg13cmos5l_fill_2
XANTENNA__1880__X Tile_X0Y2_E6BEG[6] VPWR VGND sg13cmos5l_antennanp
XFILLER_192_54 VPWR VGND sg13cmos5l_decap_8
XFILLER_294_100 VPWR VGND sg13cmos5l_decap_8
XFILLER_342_35 VPWR VGND sg13cmos5l_decap_8
XANTENNA__0359__D Tile_X0Y1_FrameData[15] VPWR VGND sg13cmos5l_antennanp
XFILLER_85_52 VPWR VGND sg13cmos5l_fill_1
XANTENNA__2140__A1 Tile_X0Y5_W2END[3] VPWR VGND sg13cmos5l_antennanp
XFILLER_342_79 VPWR VGND sg13cmos5l_decap_8
XFILLER_141_80 VPWR VGND sg13cmos5l_fill_2
XFILLER_62_168 VPWR VGND sg13cmos5l_decap_8
XFILLER_349_101 VPWR VGND sg13cmos5l_decap_8
XANTENNA__0094__D Tile_X0Y0_FrameData[8] VPWR VGND sg13cmos5l_antennanp
XANTENNA__1768__A Tile_X0Y2_FrameData[28] VPWR VGND sg13cmos5l_antennanp
XFILLER_93_6 VPWR VGND sg13cmos5l_decap_4
XFILLER_203_185 VPWR VGND sg13cmos5l_decap_8
X_1801_ Tile_X0Y4_E2BEGb[4] _2629_/X VPWR VGND sg13cmos5l_buf_1
XANTENNA__0822__D Tile_X0Y3_FrameData[0] VPWR VGND sg13cmos5l_antennanp
X_2781_ _2781_/X Tile_X0Y5_W1END[0] Tile_X0Y5_WW4END[10] Tile_X0Y5_WW4END[12] Tile_X0Y5_W6END[4]
+ _1340_/Q _1339_/Q VPWR VGND sg13cmos5l_mux4_1
X_1732_ Tile_X0Y0_E2BEG[4] _2169_/X VPWR VGND sg13cmos5l_buf_1
XFILLER_236_14 VPWR VGND sg13cmos5l_fill_2
X_1663_ Tile_X0Y0_FrameData_O[3] Tile_X0Y0_FrameData[3] VPWR VGND sg13cmos5l_buf_1
XFILLER_116_148 VPWR VGND sg13cmos5l_decap_8
XFILLER_236_36 VPWR VGND sg13cmos5l_fill_1
X_0614_ _0614_/Q Tile_X0Y2_FrameData[0] VGND VPWR Tile_X0Y5_FrameStrobe[1] latch
X_1594_ Tile_X0Y2_EE4BEG[7] _2424_/X VPWR VGND sg13cmos5l_buf_1
XANTENNA__1790__X Tile_X0Y4_E2BEG[1] VPWR VGND sg13cmos5l_antennanp
X_0545_ _0545_/Q Tile_X0Y1_FrameData[21] VGND VPWR Tile_X0Y5_FrameStrobe[7] latch
XFILLER_252_24 VPWR VGND sg13cmos5l_decap_8
X_0476_ _0476_/Q Tile_X0Y1_FrameData[26] VGND VPWR Tile_X0Y5_FrameStrobe[5] latch
XFILLER_85_216 VPWR VGND sg13cmos5l_fill_1
XFILLER_85_205 VPWR VGND sg13cmos5l_decap_8
XANTENNA__0269__D Tile_X0Y0_FrameData[25] VPWR VGND sg13cmos5l_antennanp
X_2215_ _2215_/X Tile_X0Y1_W1END[2] Tile_X0Y1_W6END[6] _2353_/X _2339_/X _0546_/Q
+ _0545_/Q VPWR VGND sg13cmos5l_mux4_1
XANTENNA__2131__A1 Tile_X0Y0_W2END[1] VPWR VGND sg13cmos5l_antennanp
XFILLER_285_199 VPWR VGND sg13cmos5l_fill_1
X_2146_ _2146_/X Tile_X0Y0_W2MID[6] Tile_X0Y0_W2END[6] Tile_X0Y0_W6END[6] _2242_/X
+ _0300_/Q _0299_/Q VPWR VGND sg13cmos5l_mux4_1
XFILLER_121_28 VPWR VGND sg13cmos5l_decap_8
X_2077_ Tile_X0Y5_S4BEG[10] _2077_/A VPWR VGND sg13cmos5l_buf_1
XFILLER_198_129 VPWR VGND sg13cmos5l_decap_8
X_1028_ _1028_/Q Tile_X0Y3_FrameData[18] VGND VPWR Tile_X0Y5_FrameStrobe[7] latch
XANTENNA__1678__A Tile_X0Y0_FrameData[18] VPWR VGND sg13cmos5l_antennanp
XANTENNA__2126__X AXIL_S_SOC_RDATA20 VPWR VGND sg13cmos5l_antennanp
XANTENNA__0732__D Tile_X0Y2_FrameData[10] VPWR VGND sg13cmos5l_antennanp
XANTENNA__1965__X Tile_X0Y1_E1BEG[2] VPWR VGND sg13cmos5l_antennanp
XANTENNA__2198__A1 Tile_X0Y0_S4END[1] VPWR VGND sg13cmos5l_antennanp
XFILLER_277_65 VPWR VGND sg13cmos5l_decap_8
XFILLER_277_87 VPWR VGND sg13cmos5l_decap_4
XFILLER_5_209 VPWR VGND sg13cmos5l_fill_2
XANTENNA__0170__GATE Tile_X0Y5_FrameStrobe[3] VPWR VGND sg13cmos5l_antennanp
XFILLER_146_14 VPWR VGND sg13cmos5l_fill_2
XFILLER_30_25 VPWR VGND sg13cmos5l_fill_1
XFILLER_30_69 VPWR VGND sg13cmos5l_decap_8
XFILLER_146_69 VPWR VGND sg13cmos5l_decap_8
XFILLER_276_111 VPWR VGND sg13cmos5l_decap_8
XANTENNA__0185__GATE Tile_X0Y5_FrameStrobe[3] VPWR VGND sg13cmos5l_antennanp
XFILLER_276_144 VPWR VGND sg13cmos5l_fill_1
XANTENNA__0179__D Tile_X0Y0_FrameData[19] VPWR VGND sg13cmos5l_antennanp
XFILLER_276_177 VPWR VGND sg13cmos5l_fill_1
XANTENNA__2122__A1 Tile_X0Y1_W2END[0] VPWR VGND sg13cmos5l_antennanp
XFILLER_291_114 VPWR VGND sg13cmos5l_decap_8
XFILLER_91_208 VPWR VGND sg13cmos5l_fill_2
XFILLER_312_27 VPWR VGND sg13cmos5l_fill_1
XFILLER_312_16 VPWR VGND sg13cmos5l_decap_4
XFILLER_29_154 VPWR VGND sg13cmos5l_fill_2
XFILLER_291_158 VPWR VGND sg13cmos5l_decap_8
XANTENNA__0907__D Tile_X0Y3_FrameData[11] VPWR VGND sg13cmos5l_antennanp
XFILLER_55_77 VPWR VGND sg13cmos5l_fill_2
XFILLER_44_146 VPWR VGND sg13cmos5l_decap_8
XFILLER_55_88 VPWR VGND sg13cmos5l_fill_1
XANTENNA__0123__GATE Tile_X0Y5_FrameStrobe[1] VPWR VGND sg13cmos5l_antennanp
XANTENNA__2036__X Tile_X0Y5_FrameData_O[21] VPWR VGND sg13cmos5l_antennanp
XANTENNA__0753__GATE Tile_X0Y5_FrameStrobe[6] VPWR VGND sg13cmos5l_antennanp
XFILLER_197_151 VPWR VGND sg13cmos5l_fill_2
XFILLER_71_43 VPWR VGND sg13cmos5l_decap_8
XANTENNA__0642__D Tile_X0Y2_FrameData[4] VPWR VGND sg13cmos5l_antennanp
XANTENNA__1875__X Tile_X0Y2_E6BEG[1] VPWR VGND sg13cmos5l_antennanp
XANTENNA__2189__A1 AXIL_S_SOC_WDATA24 VPWR VGND sg13cmos5l_antennanp
XFILLER_361_107 VPWR VGND sg13cmos5l_decap_8
XANTENNA__0138__GATE Tile_X0Y5_FrameStrobe[2] VPWR VGND sg13cmos5l_antennanp
XFILLER_153_221 VPWR VGND sg13cmos5l_fill_2
XFILLER_361_118 VPWR VGND sg13cmos5l_decap_4
XFILLER_337_57 VPWR VGND sg13cmos5l_decap_8
XFILLER_337_46 VPWR VGND sg13cmos5l_fill_1
XFILLER_337_35 VPWR VGND sg13cmos5l_decap_8
XANTENNA__0768__GATE Tile_X0Y5_FrameStrobe[6] VPWR VGND sg13cmos5l_antennanp
XFILLER_354_192 VPWR VGND sg13cmos5l_decap_8
XANTENNA__1473__D Tile_X0Y5_FrameData[15] VPWR VGND sg13cmos5l_antennanp
XFILLER_267_111 VPWR VGND sg13cmos5l_decap_8
XFILLER_121_140 VPWR VGND sg13cmos5l_decap_8
X_0330_ _0330_/Q Tile_X0Y1_FrameData[12] VGND VPWR Tile_X0Y5_FrameStrobe[0] latch
XANTENNA__0089__D Tile_X0Y0_FrameData[13] VPWR VGND sg13cmos5l_antennanp
XFILLER_267_155 VPWR VGND sg13cmos5l_fill_1
XFILLER_267_177 VPWR VGND sg13cmos5l_decap_8
XANTENNA__2113__A1 Tile_X0Y3_W2END[7] VPWR VGND sg13cmos5l_antennanp
XFILLER_282_125 VPWR VGND sg13cmos5l_decap_8
X_2000_ Tile_X0Y5_EE4BEG[1] _2742_/X VPWR VGND sg13cmos5l_buf_1
X_0261_ _0261_/Q Tile_X0Y0_FrameData[1] VGND VPWR Tile_X0Y5_FrameStrobe[5] latch
XANTENNA__0706__GATE Tile_X0Y5_FrameStrobe[4] VPWR VGND sg13cmos5l_antennanp
X_0192_ _0192_/Q Tile_X0Y0_FrameData[6] VGND VPWR Tile_X0Y5_FrameStrobe[3] latch
XANTENNA__0817__D Tile_X0Y3_FrameData[5] VPWR VGND sg13cmos5l_antennanp
XFILLER_35_124 VPWR VGND sg13cmos5l_decap_8
XFILLER_50_149 VPWR VGND sg13cmos5l_fill_1
XFILLER_43_190 VPWR VGND sg13cmos5l_decap_8
XANTENNA__1785__X Tile_X0Y4_E1BEG[0] VPWR VGND sg13cmos5l_antennanp
XFILLER_188_184 VPWR VGND sg13cmos5l_decap_8
X_2833_ _2833_/X Tile_X0Y4_W1END[0] Tile_X0Y4_W2MID[3] Tile_X0Y4_W2END[3] _2712_/X
+ _1116_/Q _1115_/Q VPWR VGND sg13cmos5l_mux4_1
XFILLER_84_2 VPWR VGND sg13cmos5l_fill_1
XFILLER_337_126 VPWR VGND sg13cmos5l_fill_2
XANTENNA__0552__D Tile_X0Y2_FrameData[30] VPWR VGND sg13cmos5l_antennanp
X_2764_ _2764_/X AXIL_S_SOC_ARPROT2 _2823_/X _2814_/X _2828_/X _1374_/Q _1373_/Q VPWR
+ VGND sg13cmos5l_mux4_1
XFILLER_144_221 VPWR VGND sg13cmos5l_fill_2
X_1715_ Tile_X0Y0_E6BEG[7] _2204_/X VPWR VGND sg13cmos5l_buf_1
XFILLER_352_129 VPWR VGND sg13cmos5l_decap_8
X_2695_ _2695_/X _2236_/X _2234_/X _2222_/X _2221_/X _0148_/Q _0147_/Q VPWR VGND sg13cmos5l_mux4_1
XFILLER_345_192 VPWR VGND sg13cmos5l_decap_8
XFILLER_104_107 VPWR VGND sg13cmos5l_decap_8
X_1646_ Tile_X0Y0_FrameStrobe_O[6] Tile_X0Y5_FrameStrobe[6] VPWR VGND sg13cmos5l_buf_1
XFILLER_6_82 VPWR VGND sg13cmos5l_fill_2
XANTENNA__1383__D Tile_X0Y5_FrameData[9] VPWR VGND sg13cmos5l_antennanp
XFILLER_116_39 VPWR VGND sg13cmos5l_fill_2
X_1577_ Tile_X0Y3_FrameData_O[23] Tile_X0Y3_FrameData[23] VPWR VGND sg13cmos5l_buf_1
XFILLER_360_195 VPWR VGND sg13cmos5l_decap_8
XFILLER_258_111 VPWR VGND sg13cmos5l_decap_8
XFILLER_263_56 VPWR VGND sg13cmos5l_decap_8
X_0528_ _0528_/Q Tile_X0Y1_FrameData[6] VGND VPWR Tile_X0Y5_FrameStrobe[6] latch
XANTENNA__2104__A1 Tile_X0Y4_W2END[4] VPWR VGND sg13cmos5l_antennanp
XFILLER_132_27 VPWR VGND sg13cmos5l_decap_8
X_0459_ _0459_/Q Tile_X0Y1_FrameData[11] VGND VPWR Tile_X0Y5_FrameStrobe[4] latch
XFILLER_273_169 VPWR VGND sg13cmos5l_decap_8
XANTENNA__0727__D Tile_X0Y2_FrameData[15] VPWR VGND sg13cmos5l_antennanp
XFILLER_214_214 VPWR VGND sg13cmos5l_fill_1
XFILLER_26_135 VPWR VGND sg13cmos5l_decap_8
X_2129_ AXIL_S_SOC_RDATA23 Tile_X0Y1_W2MID[7] Tile_X0Y1_W2END[7] Tile_X0Y1_W6END[7]
+ _2380_/X _0368_/Q _0367_/Q VPWR VGND sg13cmos5l_mux4_1
XFILLER_288_20 VPWR VGND sg13cmos5l_decap_8
XFILLER_41_149 VPWR VGND sg13cmos5l_decap_8
XANTENNA__1483__GATE Tile_X0Y5_FrameStrobe[6] VPWR VGND sg13cmos5l_antennanp
XANTENNA__1695__X Tile_X0Y0_EE4BEG[3] VPWR VGND sg13cmos5l_antennanp
XFILLER_179_184 VPWR VGND sg13cmos5l_fill_2
XANTENNA__0462__D Tile_X0Y1_FrameData[8] VPWR VGND sg13cmos5l_antennanp
XFILLER_157_68 VPWR VGND sg13cmos5l_decap_8
XANTENNA__2032__A Tile_X0Y5_FrameData[17] VPWR VGND sg13cmos5l_antennanp
XFILLER_1_201 VPWR VGND sg13cmos5l_fill_1
XFILLER_237_90 VPWR VGND sg13cmos5l_decap_8
XFILLER_351_151 VPWR VGND sg13cmos5l_decap_8
XFILLER_307_49 VPWR VGND sg13cmos5l_decap_8
XANTENNA__1293__D Tile_X0Y5_FrameData[3] VPWR VGND sg13cmos5l_antennanp
XANTENNA__2343__A1 Tile_X0Y0_W6END[9] VPWR VGND sg13cmos5l_antennanp
XFILLER_249_111 VPWR VGND sg13cmos5l_fill_2
XANTENNA__1421__GATE Tile_X0Y5_FrameStrobe[4] VPWR VGND sg13cmos5l_antennanp
XFILLER_249_155 VPWR VGND sg13cmos5l_decap_8
XFILLER_106_94 VPWR VGND sg13cmos5l_decap_8
XFILLER_264_147 VPWR VGND sg13cmos5l_decap_8
XANTENNA__0637__D Tile_X0Y2_FrameData[9] VPWR VGND sg13cmos5l_antennanp
XANTENNA__1436__GATE Tile_X0Y5_FrameStrobe[5] VPWR VGND sg13cmos5l_antennanp
XFILLER_174_0 VPWR VGND sg13cmos5l_fill_1
XFILLER_205_203 VPWR VGND sg13cmos5l_decap_4
XFILLER_122_82 VPWR VGND sg13cmos5l_decap_8
XFILLER_17_168 VPWR VGND sg13cmos5l_decap_4
XFILLER_341_0 VPWR VGND sg13cmos5l_decap_8
XANTENNA__0692__GATE Tile_X0Y5_FrameStrobe[4] VPWR VGND sg13cmos5l_antennanp
XFILLER_198_42 VPWR VGND sg13cmos5l_decap_8
XFILLER_319_104 VPWR VGND sg13cmos5l_decap_8
XANTENNA__1468__D Tile_X0Y5_FrameData[20] VPWR VGND sg13cmos5l_antennanp
XANTENNA__0077__GATE Tile_X0Y5_FrameStrobe[0] VPWR VGND sg13cmos5l_antennanp
XANTENNA__0372__D Tile_X0Y1_FrameData[2] VPWR VGND sg13cmos5l_antennanp
XFILLER_40_182 VPWR VGND sg13cmos5l_decap_8
XFILLER_348_67 VPWR VGND sg13cmos5l_decap_8
XFILLER_334_107 VPWR VGND sg13cmos5l_fill_1
XANTENNA__2582__A1 Tile_X0Y5_N4END[10] VPWR VGND sg13cmos5l_antennanp
XFILLER_217_38 VPWR VGND sg13cmos5l_decap_8
X_1500_ _2563_/A3 VPWR VGND sg13cmos5l_tielo
X_2480_ _2480_/X _2458_/X Tile_X0Y5_N4END[12] _2457_/X Tile_X0Y0_S4END[8] _0606_/Q
+ _0605_/Q VPWR VGND sg13cmos5l_mux4_1
XANTENNA__0630__GATE Tile_X0Y5_FrameStrobe[2] VPWR VGND sg13cmos5l_antennanp
X_1431_ _1431_/Q Tile_X0Y5_FrameData[25] VGND VPWR Tile_X0Y5_FrameStrobe[5] latch
XFILLER_342_184 VPWR VGND sg13cmos5l_decap_4
XFILLER_233_15 VPWR VGND sg13cmos5l_fill_2
XFILLER_233_26 VPWR VGND sg13cmos5l_fill_2
X_1362_ _1362_/Q Tile_X0Y5_FrameData[30] VGND VPWR Tile_X0Y5_FrameStrobe[3] latch
X_1293_ _1293_/Q Tile_X0Y5_FrameData[3] VGND VPWR Tile_X0Y5_FrameStrobe[0] latch
X_0313_ _0313_/Q Tile_X0Y1_FrameData[29] VGND VPWR Tile_X0Y5_FrameStrobe[0] latch
XANTENNA__0645__GATE Tile_X0Y5_FrameStrobe[2] VPWR VGND sg13cmos5l_antennanp
X_0244_ _0244_/Q Tile_X0Y0_FrameData[18] VGND VPWR Tile_X0Y5_FrameStrobe[5] latch
XANTENNA__0547__D Tile_X0Y1_FrameData[19] VPWR VGND sg13cmos5l_antennanp
X_0175_ _0175_/Q Tile_X0Y0_FrameData[23] VGND VPWR Tile_X0Y5_FrameStrobe[3] latch
XANTENNA__1378__D Tile_X0Y5_FrameData[14] VPWR VGND sg13cmos5l_antennanp
XANTENNA__0282__D Tile_X0Y0_FrameData[12] VPWR VGND sg13cmos5l_antennanp
XFILLER_176_154 VPWR VGND sg13cmos5l_decap_4
X_2816_ _2816_/X _2367_/X _2365_/X _2350_/X _2349_/X _0385_/Q _0384_/Q VPWR VGND sg13cmos5l_mux4_1
XFILLER_31_182 VPWR VGND sg13cmos5l_fill_2
XFILLER_325_118 VPWR VGND sg13cmos5l_fill_1
X_2747_ _2747_/X AXIL_S_SOC_ARPROT0 AXIL_S_SOC_ARPROT1 _2810_/X _2826_/X _1408_/Q
+ _1407_/Q VPWR VGND sg13cmos5l_mux4_1
XANTENNA__2573__A1 Tile_X0Y5_N4END[11] VPWR VGND sg13cmos5l_antennanp
XFILLER_274_22 VPWR VGND sg13cmos5l_fill_1
X_2678_ _2678_/X Tile_X0Y5_W1END[2] Tile_X0Y5_W6END[6] _2805_/X _2791_/X _1492_/Q
+ _1491_/Q VPWR VGND sg13cmos5l_mux4_1
X_1629_ Tile_X0Y0_N2BEG[1] _2146_/X VPWR VGND sg13cmos5l_buf_1
XANTENNA__1691__A Tile_X0Y0_FrameData[31] VPWR VGND sg13cmos5l_antennanp
XANTENNA__2325__A1 Tile_X0Y0_S4END[4] VPWR VGND sg13cmos5l_antennanp
XFILLER_98_182 VPWR VGND sg13cmos5l_decap_8
XFILLER_246_103 VPWR VGND sg13cmos5l_decap_4
XFILLER_46_208 VPWR VGND sg13cmos5l_fill_2
XANTENNA__0457__D Tile_X0Y1_FrameData[13] VPWR VGND sg13cmos5l_antennanp
XFILLER_223_70 VPWR VGND sg13cmos5l_decap_8
XFILLER_261_128 VPWR VGND sg13cmos5l_decap_4
XFILLER_265_7 VPWR VGND sg13cmos5l_decap_8
XFILLER_36_79 VPWR VGND sg13cmos5l_fill_2
XFILLER_202_206 VPWR VGND sg13cmos5l_decap_8
XANTENNA__2027__A Tile_X0Y5_FrameData[12] VPWR VGND sg13cmos5l_antennanp
XANTENNA__1288__D Tile_X0Y5_FrameData[8] VPWR VGND sg13cmos5l_antennanp
XANTENNA__2261__A0 Tile_X0Y2_W2MID[1] VPWR VGND sg13cmos5l_antennanp
XFILLER_167_110 VPWR VGND sg13cmos5l_fill_1
XFILLER_168_23 VPWR VGND sg13cmos5l_decap_8
XFILLER_356_221 VPWR VGND sg13cmos5l_fill_2
XANTENNA__0192__D Tile_X0Y0_FrameData[6] VPWR VGND sg13cmos5l_antennanp
XFILLER_22_171 VPWR VGND sg13cmos5l_fill_1
XFILLER_168_78 VPWR VGND sg13cmos5l_decap_4
XFILLER_316_129 VPWR VGND sg13cmos5l_fill_2
XFILLER_182_157 VPWR VGND sg13cmos5l_fill_1
XFILLER_318_48 VPWR VGND sg13cmos5l_fill_2
XANTENNA__0920__D Tile_X0Y3_FrameData[30] VPWR VGND sg13cmos5l_antennanp
XFILLER_324_151 VPWR VGND sg13cmos5l_fill_2
XFILLER_269_206 VPWR VGND sg13cmos5l_decap_8
XANTENNA__1360__GATE Tile_X0Y5_FrameStrobe[2] VPWR VGND sg13cmos5l_antennanp
XANTENNA__2316__A1 AXIL_S_SOC_WDATA11 VPWR VGND sg13cmos5l_antennanp
XFILLER_184_99 VPWR VGND sg13cmos5l_fill_2
XFILLER_334_14 VPWR VGND sg13cmos5l_decap_8
XFILLER_284_209 VPWR VGND sg13cmos5l_fill_2
XFILLER_291_0 VPWR VGND sg13cmos5l_fill_1
XFILLER_89_182 VPWR VGND sg13cmos5l_fill_2
XFILLER_89_171 VPWR VGND sg13cmos5l_decap_8
XFILLER_237_125 VPWR VGND sg13cmos5l_decap_8
XFILLER_203_29 VPWR VGND sg13cmos5l_decap_8
XANTENNA__0367__D Tile_X0Y1_FrameData[7] VPWR VGND sg13cmos5l_antennanp
XANTENNA__1375__GATE Tile_X0Y5_FrameStrobe[3] VPWR VGND sg13cmos5l_antennanp
XFILLER_350_35 VPWR VGND sg13cmos5l_fill_2
XFILLER_93_74 VPWR VGND sg13cmos5l_decap_4
XFILLER_260_161 VPWR VGND sg13cmos5l_decap_4
X_1980_ Tile_X0Y5_E2BEGb[1] _2734_/X VPWR VGND sg13cmos5l_buf_1
XANTENNA__2252__A0 Tile_X0Y1_W2MID[6] VPWR VGND sg13cmos5l_antennanp
XFILLER_158_110 VPWR VGND sg13cmos5l_decap_4
XFILLER_158_121 VPWR VGND sg13cmos5l_decap_8
X_0931_ _0931_/Q Tile_X0Y3_FrameData[19] VGND VPWR Tile_X0Y5_FrameStrobe[4] latch
XANTENNA__1198__D Tile_X0Y4_FrameData[24] VPWR VGND sg13cmos5l_antennanp
XANTENNA__1313__GATE Tile_X0Y5_FrameStrobe[1] VPWR VGND sg13cmos5l_antennanp
XFILLER_158_165 VPWR VGND sg13cmos5l_decap_8
XFILLER_173_102 VPWR VGND sg13cmos5l_decap_8
XFILLER_228_15 VPWR VGND sg13cmos5l_fill_1
X_0862_ _0862_/Q Tile_X0Y3_FrameData[24] VGND VPWR Tile_X0Y5_FrameStrobe[2] latch
XFILLER_228_59 VPWR VGND sg13cmos5l_decap_8
X_2601_ _2601_/X Tile_X0Y2_W2MID[5] Tile_X0Y2_W2END[5] Tile_X0Y2_W6END[10] _2483_/X
+ _0646_/Q _0645_/Q VPWR VGND sg13cmos5l_mux4_1
X_0793_ _0793_/Q Tile_X0Y3_FrameData[29] VGND VPWR Tile_X0Y5_FrameStrobe[0] latch
XANTENNA__0830__D Tile_X0Y3_FrameData[24] VPWR VGND sg13cmos5l_antennanp
XANTENNA__2555__A1 Tile_X0Y3_WW4END[9] VPWR VGND sg13cmos5l_antennanp
X_2532_ _2532_/X AXIL_S_SOC_ARADDR1 AXIL_S_SOC_ARADDR7 _2580_/X _2589_/X _0940_/Q
+ _0939_/Q VPWR VGND sg13cmos5l_mux4_1
XANTENNA__1328__GATE Tile_X0Y5_FrameStrobe[1] VPWR VGND sg13cmos5l_antennanp
XANTENNA__2307__A1 AXIL_S_SOC_WDATA14 VPWR VGND sg13cmos5l_antennanp
XFILLER_244_36 VPWR VGND sg13cmos5l_decap_8
X_2463_ _2463_/X Tile_X0Y1_W1END[3] Tile_X0Y1_W6END[11] _2349_/X _2340_/X _0412_/Q
+ _0411_/Q VPWR VGND sg13cmos5l_mux4_1
X_1414_ _1414_/Q Tile_X0Y5_FrameData[10] VGND VPWR Tile_X0Y5_FrameStrobe[4] latch
X_2394_ _2394_/X Tile_X0Y3_W2MID[1] Tile_X0Y3_W2END[1] Tile_X0Y3_W6END[1] _2595_/X
+ _1010_/Q _1009_/Q VPWR VGND sg13cmos5l_mux4_1
XANTENNA__0584__GATE Tile_X0Y5_FrameStrobe[1] VPWR VGND sg13cmos5l_antennanp
X_1345_ _1345_/Q Tile_X0Y5_FrameData[15] VGND VPWR Tile_X0Y5_FrameStrobe[2] latch
XFILLER_3_94 VPWR VGND sg13cmos5l_fill_1
XANTENNA__0277__D Tile_X0Y0_FrameData[17] VPWR VGND sg13cmos5l_antennanp
XFILLER_260_46 VPWR VGND sg13cmos5l_decap_4
X_1276_ _1276_/Q Tile_X0Y5_FrameData[20] VGND VPWR Tile_X0Y5_FrameStrobe[0] latch
XFILLER_95_185 VPWR VGND sg13cmos5l_decap_8
XANTENNA__0599__GATE Tile_X0Y5_FrameStrobe[1] VPWR VGND sg13cmos5l_antennanp
XFILLER_236_180 VPWR VGND sg13cmos5l_decap_8
XFILLER_243_128 VPWR VGND sg13cmos5l_decap_4
X_0227_ _0227_/Q Tile_X0Y0_FrameData[3] VGND VPWR Tile_X0Y5_FrameStrobe[4] latch
XANTENNA__2491__A0 Tile_X0Y1_W2MID[6] VPWR VGND sg13cmos5l_antennanp
X_0158_ _0158_/Q Tile_X0Y0_FrameData[8] VGND VPWR Tile_X0Y5_FrameStrobe[2] latch
XFILLER_269_22 VPWR VGND sg13cmos5l_fill_2
XANTENNA__0522__GATE Tile_X0Y5_FrameStrobe[6] VPWR VGND sg13cmos5l_antennanp
X_0089_ _0089_/Q Tile_X0Y0_FrameData[13] VGND VPWR Tile_X0Y5_FrameStrobe[0] latch
XANTENNA__1686__A Tile_X0Y0_FrameData[26] VPWR VGND sg13cmos5l_antennanp
XANTENNA__2794__A1 Tile_X0Y4_W6END[9] VPWR VGND sg13cmos5l_antennanp
XANTENNA__2134__X AXIL_S_SOC_RDATA28 VPWR VGND sg13cmos5l_antennanp
XFILLER_149_187 VPWR VGND sg13cmos5l_fill_1
XFILLER_353_202 VPWR VGND sg13cmos5l_decap_8
XFILLER_138_37 VPWR VGND sg13cmos5l_decap_8
XFILLER_164_157 VPWR VGND sg13cmos5l_decap_8
XANTENNA__0537__GATE Tile_X0Y5_FrameStrobe[7] VPWR VGND sg13cmos5l_antennanp
XANTENNA__0740__D Tile_X0Y2_FrameData[2] VPWR VGND sg13cmos5l_antennanp
XANTENNA__1973__X Tile_X0Y5_E2BEG[2] VPWR VGND sg13cmos5l_antennanp
XFILLER_105_202 VPWR VGND sg13cmos5l_fill_1
XFILLER_306_151 VPWR VGND sg13cmos5l_fill_1
XFILLER_306_184 VPWR VGND sg13cmos5l_fill_2
XFILLER_219_103 VPWR VGND sg13cmos5l_decap_4
XFILLER_86_141 VPWR VGND sg13cmos5l_decap_8
XFILLER_234_80 VPWR VGND sg13cmos5l_decap_8
XANTENNA__0187__D Tile_X0Y0_FrameData[11] VPWR VGND sg13cmos5l_antennanp
XFILLER_170_46 VPWR VGND sg13cmos5l_decap_8
XFILLER_86_185 VPWR VGND sg13cmos5l_decap_8
XFILLER_103_62 VPWR VGND sg13cmos5l_decap_8
XFILLER_63_22 VPWR VGND sg13cmos5l_fill_2
XFILLER_63_11 VPWR VGND sg13cmos5l_fill_2
XFILLER_320_49 VPWR VGND sg13cmos5l_fill_1
XANTENNA__0915__D Tile_X0Y3_FrameData[3] VPWR VGND sg13cmos5l_antennanp
XFILLER_151_2 VPWR VGND sg13cmos5l_fill_1
XFILLER_187_205 VPWR VGND sg13cmos5l_fill_2
XFILLER_242_161 VPWR VGND sg13cmos5l_decap_8
XANTENNA__2785__A1 Tile_X0Y5_WW4END[14] VPWR VGND sg13cmos5l_antennanp
XFILLER_137_0 VPWR VGND sg13cmos5l_decap_8
XFILLER_329_14 VPWR VGND sg13cmos5l_decap_4
XANTENNA__2044__X Tile_X0Y5_FrameData_O[29] VPWR VGND sg13cmos5l_antennanp
XFILLER_6_101 VPWR VGND sg13cmos5l_fill_1
XFILLER_329_47 VPWR VGND sg13cmos5l_decap_8
XFILLER_155_146 VPWR VGND sg13cmos5l_decap_8
XANTENNA__0650__D Tile_X0Y2_FrameData[28] VPWR VGND sg13cmos5l_antennanp
XANTENNA__1883__X Tile_X0Y2_E6BEG[9] VPWR VGND sg13cmos5l_antennanp
XANTENNA__2537__A1 AXIL_S_SOC_ARADDR2 VPWR VGND sg13cmos5l_antennanp
XFILLER_6_178 VPWR VGND sg13cmos5l_fill_2
XFILLER_345_46 VPWR VGND sg13cmos5l_decap_8
XANTENNA__1481__D Tile_X0Y5_FrameData[7] VPWR VGND sg13cmos5l_antennanp
X_1130_ _1130_/Q Tile_X0Y4_FrameData[28] VGND VPWR Tile_X0Y5_FrameStrobe[3] latch
XFILLER_361_56 VPWR VGND sg13cmos5l_fill_1
XANTENNA__0097__D Tile_X0Y0_FrameData[5] VPWR VGND sg13cmos5l_antennanp
XFILLER_280_212 VPWR VGND sg13cmos5l_fill_2
XFILLER_280_223 VPWR VGND sg13cmos5l_fill_1
X_1061_ _1061_/Q Tile_X0Y4_FrameData[1] VGND VPWR Tile_X0Y5_FrameStrobe[0] latch
XFILLER_92_166 VPWR VGND sg13cmos5l_decap_8
XANTENNA__0825__D Tile_X0Y3_FrameData[29] VPWR VGND sg13cmos5l_antennanp
XFILLER_178_205 VPWR VGND sg13cmos5l_fill_1
XFILLER_310_60 VPWR VGND sg13cmos5l_decap_8
XANTENNA__1252__GATE Tile_X0Y5_FrameStrobe[6] VPWR VGND sg13cmos5l_antennanp
X_1963_ Tile_X0Y1_E1BEG[0] _2289_/X VPWR VGND sg13cmos5l_buf_1
XANTENNA__2776__A1 Tile_X0Y5_W2END[4] VPWR VGND sg13cmos5l_antennanp
XFILLER_239_47 VPWR VGND sg13cmos5l_fill_2
X_1894_ Tile_X0Y1_FrameData_O[7] Tile_X0Y1_FrameData[7] VPWR VGND sg13cmos5l_buf_1
X_0914_ _0914_/Q Tile_X0Y3_FrameData[4] VGND VPWR Tile_X0Y5_FrameStrobe[3] latch
XANTENNA__2240__A3 Tile_X0Y0_S4END[0] VPWR VGND sg13cmos5l_antennanp
X_0845_ _0845_/Q Tile_X0Y3_FrameData[9] VGND VPWR Tile_X0Y5_FrameStrobe[1] latch
XANTENNA__0560__D Tile_X0Y2_FrameData[22] VPWR VGND sg13cmos5l_antennanp
XANTENNA__1793__X Tile_X0Y4_E2BEG[4] VPWR VGND sg13cmos5l_antennanp
XANTENNA__2528__A1 AXIL_S_SOC_ARADDR5 VPWR VGND sg13cmos5l_antennanp
XANTENNA__1267__GATE Tile_X0Y5_FrameStrobe[0] VPWR VGND sg13cmos5l_antennanp
XFILLER_255_24 VPWR VGND sg13cmos5l_decap_4
X_0776_ _0776_/Q Tile_X0Y2_FrameData[30] VGND VPWR Tile_X0Y5_FrameStrobe[7] latch
XFILLER_255_79 VPWR VGND sg13cmos5l_decap_4
X_2515_ _2515_/X AXIL_S_SOC_ARADDR4 AXIL_S_SOC_ARADDR6 _2590_/X _2595_/X _0974_/Q
+ _0973_/Q VPWR VGND sg13cmos5l_mux4_1
X_2446_ _2446_/X _2480_/X _2479_/X _2472_/X _2471_/X _0634_/Q _0633_/Q VPWR VGND sg13cmos5l_mux4_1
XANTENNA__1391__D Tile_X0Y5_FrameData[1] VPWR VGND sg13cmos5l_antennanp
XFILLER_124_17 VPWR VGND sg13cmos5l_fill_2
XANTENNA__2700__A1 Tile_X0Y5_N4END[7] VPWR VGND sg13cmos5l_antennanp
X_2377_ _2377_/X _2257_/X _2390_/X _2389_/X Tile_X0Y0_S2MID[4] _0326_/Q _0325_/Q VPWR
+ VGND sg13cmos5l_mux4_1
X_1328_ _1328_/Q Tile_X0Y5_FrameData[0] VGND VPWR Tile_X0Y5_FrameStrobe[1] latch
XFILLER_83_111 VPWR VGND sg13cmos5l_decap_8
XANTENNA__1205__GATE Tile_X0Y5_FrameStrobe[5] VPWR VGND sg13cmos5l_antennanp
XANTENNA__2129__X AXIL_S_SOC_RDATA23 VPWR VGND sg13cmos5l_antennanp
XFILLER_271_223 VPWR VGND sg13cmos5l_fill_1
X_1259_ _1259_/Q Tile_X0Y4_FrameData[27] VGND VPWR Tile_X0Y5_FrameStrobe[7] latch
XANTENNA__2464__A0 Tile_X0Y3_W1END[3] VPWR VGND sg13cmos5l_antennanp
XFILLER_209_191 VPWR VGND sg13cmos5l_decap_8
XANTENNA__0735__D Tile_X0Y2_FrameData[7] VPWR VGND sg13cmos5l_antennanp
XANTENNA__1968__X Tile_X0Y5_E1BEG[1] VPWR VGND sg13cmos5l_antennanp
XFILLER_169_205 VPWR VGND sg13cmos5l_decap_8
XANTENNA__0461__GATE Tile_X0Y5_FrameStrobe[4] VPWR VGND sg13cmos5l_antennanp
XANTENNA__2216__A0 Tile_X0Y1_W1END[3] VPWR VGND sg13cmos5l_antennanp
XFILLER_220_60 VPWR VGND sg13cmos5l_decap_8
XFILLER_224_183 VPWR VGND sg13cmos5l_decap_8
XFILLER_137_102 VPWR VGND sg13cmos5l_decap_8
XFILLER_296_42 VPWR VGND sg13cmos5l_decap_8
XANTENNA__0476__GATE Tile_X0Y5_FrameStrobe[5] VPWR VGND sg13cmos5l_antennanp
XFILLER_137_135 VPWR VGND sg13cmos5l_decap_4
XANTENNA__0470__D Tile_X0Y1_FrameData[0] VPWR VGND sg13cmos5l_antennanp
XANTENNA__2519__A1 AXIL_S_SOC_ARADDR2 VPWR VGND sg13cmos5l_antennanp
XFILLER_152_138 VPWR VGND sg13cmos5l_fill_1
XFILLER_165_24 VPWR VGND sg13cmos5l_decap_8
XFILLER_341_216 VPWR VGND sg13cmos5l_fill_2
XANTENNA__2040__A Tile_X0Y5_FrameData[25] VPWR VGND sg13cmos5l_antennanp
XFILLER_315_27 VPWR VGND sg13cmos5l_fill_2
XANTENNA__0414__GATE Tile_X0Y5_FrameStrobe[3] VPWR VGND sg13cmos5l_antennanp
XFILLER_59_174 VPWR VGND sg13cmos5l_decap_8
XANTENNA__2039__X Tile_X0Y5_FrameData_O[24] VPWR VGND sg13cmos5l_antennanp
XFILLER_222_109 VPWR VGND sg13cmos5l_decap_4
XFILLER_74_76 VPWR VGND sg13cmos5l_decap_8
XFILLER_74_54 VPWR VGND sg13cmos5l_fill_1
XANTENNA__0429__GATE Tile_X0Y5_FrameStrobe[3] VPWR VGND sg13cmos5l_antennanp
XANTENNA__0645__D Tile_X0Y2_FrameData[1] VPWR VGND sg13cmos5l_antennanp
XANTENNA__1878__X Tile_X0Y2_E6BEG[4] VPWR VGND sg13cmos5l_antennanp
XFILLER_254_0 VPWR VGND sg13cmos5l_fill_2
XANTENNA__2470__A3 Tile_X0Y0_S4END[9] VPWR VGND sg13cmos5l_antennanp
XFILLER_90_20 VPWR VGND sg13cmos5l_decap_8
XANTENNA__2207__A0 AXIL_S_SOC_WDATA18 VPWR VGND sg13cmos5l_antennanp
XFILLER_130_82 VPWR VGND sg13cmos5l_decap_8
XFILLER_175_208 VPWR VGND sg13cmos5l_fill_2
XFILLER_230_175 VPWR VGND sg13cmos5l_decap_8
XFILLER_88_9 VPWR VGND sg13cmos5l_fill_2
XANTENNA__2222__A3 Tile_X0Y0_S4END[2] VPWR VGND sg13cmos5l_antennanp
XFILLER_128_135 VPWR VGND sg13cmos5l_decap_8
XANTENNA__0380__D Tile_X0Y1_FrameData[26] VPWR VGND sg13cmos5l_antennanp
XANTENNA__1476__D Tile_X0Y5_FrameData[12] VPWR VGND sg13cmos5l_antennanp
XFILLER_143_105 VPWR VGND sg13cmos5l_decap_8
XFILLER_356_56 VPWR VGND sg13cmos5l_decap_8
XFILLER_143_127 VPWR VGND sg13cmos5l_decap_4
XFILLER_289_109 VPWR VGND sg13cmos5l_decap_8
X_0630_ _0630_/Q Tile_X0Y2_FrameData[16] VGND VPWR Tile_X0Y5_FrameStrobe[2] latch
XFILLER_99_62 VPWR VGND sg13cmos5l_decap_8
XFILLER_356_67 VPWR VGND sg13cmos5l_fill_2
XFILLER_136_190 VPWR VGND sg13cmos5l_decap_8
X_0561_ _0561_/Q Tile_X0Y2_FrameData[21] VGND VPWR Tile_X0Y5_FrameStrobe[0] latch
X_2300_ _2300_/X AXIL_S_SOC_WDATA7 AXIL_S_SOC_WDATA15 _2373_/X _2380_/X _0492_/Q _0491_/Q
+ VPWR VGND sg13cmos5l_mux4_1
XFILLER_155_90 VPWR VGND sg13cmos5l_decap_8
X_2231_ _2231_/X Tile_X0Y4_W1END[3] Tile_X0Y4_WW4END[3] Tile_X0Y4_W6END[11] _2702_/X
+ _1231_/Q _1230_/Q VPWR VGND sg13cmos5l_mux4_1
X_0492_ _0492_/Q Tile_X0Y1_FrameData[10] VGND VPWR Tile_X0Y5_FrameStrobe[5] latch
XANTENNA__2289__A3 AXIL_S_SOC_WDATA7 VPWR VGND sg13cmos5l_antennanp
XANTENNA__2694__A0 Tile_X0Y0_W1END[2] VPWR VGND sg13cmos5l_antennanp
X_2162_ _2162_/X _2214_/X Tile_X0Y0_S1END[1] AXIL_S_SOC_WDATA19 AXIL_S_SOC_WDATA22
+ _0272_/Q _0271_/Q VPWR VGND sg13cmos5l_mux4_1
XFILLER_241_59 VPWR VGND sg13cmos5l_decap_8
XFILLER_253_212 VPWR VGND sg13cmos5l_fill_2
X_2093_ Tile_X0Y3_E2BEG[5] _2514_/X VPWR VGND sg13cmos5l_buf_1
X_1113_ _1113_/Q Tile_X0Y4_FrameData[13] VGND VPWR Tile_X0Y5_FrameStrobe[2] latch
X_1044_ _1044_/Q Tile_X0Y4_FrameData[18] VGND VPWR Tile_X0Y5_FrameStrobe[0] latch
XANTENNA__0555__D Tile_X0Y2_FrameData[27] VPWR VGND sg13cmos5l_antennanp
XANTENNA__1788__X Tile_X0Y4_E1BEG[3] VPWR VGND sg13cmos5l_antennanp
XFILLER_80_158 VPWR VGND sg13cmos5l_decap_8
XFILLER_221_131 VPWR VGND sg13cmos5l_decap_8
XANTENNA__1191__GATE Tile_X0Y5_FrameStrobe[5] VPWR VGND sg13cmos5l_antennanp
XANTENNA__2749__A1 AXIL_S_SOC_RREADY VPWR VGND sg13cmos5l_antennanp
X_1946_ Tile_X0Y1_E6BEG[11] _2336_/X VPWR VGND sg13cmos5l_buf_1
XANTENNA__0290__D Tile_X0Y0_FrameData[4] VPWR VGND sg13cmos5l_antennanp
XANTENNA__1386__D Tile_X0Y5_FrameData[6] VPWR VGND sg13cmos5l_antennanp
XFILLER_119_146 VPWR VGND sg13cmos5l_decap_8
X_1877_ Tile_X0Y2_E6BEG[3] _2436_/X VPWR VGND sg13cmos5l_buf_1
XFILLER_266_78 VPWR VGND sg13cmos5l_decap_8
X_0828_ _0828_/Q Tile_X0Y3_FrameData[26] VGND VPWR Tile_X0Y5_FrameStrobe[1] latch
X_0759_ _0759_/Q Tile_X0Y2_FrameData[15] VGND VPWR Tile_X0Y5_FrameStrobe[6] latch
XFILLER_288_131 VPWR VGND sg13cmos5l_decap_8
XFILLER_88_203 VPWR VGND sg13cmos5l_fill_2
XFILLER_282_77 VPWR VGND sg13cmos5l_decap_4
XFILLER_215_71 VPWR VGND sg13cmos5l_decap_8
X_2429_ _2429_/X AXIL_S_SOC_AWADDR0 AXIL_S_SOC_AWPROT2 _2475_/X _2484_/X _0690_/Q
+ _0689_/Q VPWR VGND sg13cmos5l_mux4_1
XFILLER_56_122 VPWR VGND sg13cmos5l_decap_8
XANTENNA__1144__GATE Tile_X0Y5_FrameStrobe[3] VPWR VGND sg13cmos5l_antennanp
XFILLER_244_212 VPWR VGND sg13cmos5l_fill_2
XANTENNA__2437__A0 AXIL_S_SOC_AWADDR4 VPWR VGND sg13cmos5l_antennanp
XFILLER_301_18 VPWR VGND sg13cmos5l_fill_2
XANTENNA__0465__D Tile_X0Y1_FrameData[5] VPWR VGND sg13cmos5l_antennanp
XANTENNA__1698__X Tile_X0Y0_EE4BEG[6] VPWR VGND sg13cmos5l_antennanp
XFILLER_44_13 VPWR VGND sg13cmos5l_fill_1
XANTENNA__1159__GATE Tile_X0Y5_FrameStrobe[4] VPWR VGND sg13cmos5l_antennanp
XFILLER_231_92 VPWR VGND sg13cmos5l_decap_8
XFILLER_358_124 VPWR VGND sg13cmos5l_decap_8
XFILLER_338_6 VPWR VGND sg13cmos5l_decap_8
XANTENNA__2035__A Tile_X0Y5_FrameData[20] VPWR VGND sg13cmos5l_antennanp
XFILLER_100_41 VPWR VGND sg13cmos5l_decap_8
XANTENNA__1296__D Tile_X0Y5_FrameData[0] VPWR VGND sg13cmos5l_antennanp
XFILLER_60_78 VPWR VGND sg13cmos5l_fill_1
XFILLER_60_67 VPWR VGND sg13cmos5l_fill_2
XFILLER_180_211 VPWR VGND sg13cmos5l_fill_1
XFILLER_326_48 VPWR VGND sg13cmos5l_fill_1
XFILLER_326_37 VPWR VGND sg13cmos5l_decap_4
XFILLER_192_11 VPWR VGND sg13cmos5l_decap_8
XFILLER_79_214 VPWR VGND sg13cmos5l_fill_1
XFILLER_69_43 VPWR VGND sg13cmos5l_decap_8
XFILLER_133_193 VPWR VGND sg13cmos5l_decap_8
XFILLER_279_175 VPWR VGND sg13cmos5l_decap_4
XANTENNA__0353__GATE Tile_X0Y5_FrameStrobe[1] VPWR VGND sg13cmos5l_antennanp
XFILLER_342_14 VPWR VGND sg13cmos5l_decap_8
XANTENNA__0983__GATE Tile_X0Y5_FrameStrobe[6] VPWR VGND sg13cmos5l_antennanp
XANTENNA__2676__A0 Tile_X0Y5_W1END[1] VPWR VGND sg13cmos5l_antennanp
XFILLER_294_167 VPWR VGND sg13cmos5l_fill_1
XANTENNA__2140__A2 Tile_X0Y5_W6END[3] VPWR VGND sg13cmos5l_antennanp
XFILLER_294_189 VPWR VGND sg13cmos5l_decap_8
XANTENNA__0368__GATE Tile_X0Y5_FrameStrobe[1] VPWR VGND sg13cmos5l_antennanp
XANTENNA__2428__A0 AXIL_S_SOC_AWADDR7 VPWR VGND sg13cmos5l_antennanp
XANTENNA__0375__D Tile_X0Y1_FrameData[31] VPWR VGND sg13cmos5l_antennanp
XANTENNA__0998__GATE Tile_X0Y5_FrameStrobe[6] VPWR VGND sg13cmos5l_antennanp
XFILLER_62_136 VPWR VGND sg13cmos5l_decap_8
XFILLER_47_199 VPWR VGND sg13cmos5l_fill_1
XFILLER_70_180 VPWR VGND sg13cmos5l_decap_4
XANTENNA__0921__GATE Tile_X0Y5_FrameStrobe[4] VPWR VGND sg13cmos5l_antennanp
X_1800_ Tile_X0Y4_E2BEGb[3] _2628_/X VPWR VGND sg13cmos5l_buf_1
X_2780_ _2780_/X Tile_X0Y5_W1END[3] Tile_X0Y5_W2MID[0] Tile_X0Y5_W2END[0] _2797_/X
+ _1342_/Q _1341_/Q VPWR VGND sg13cmos5l_mux4_1
XANTENNA__2600__A0 Tile_X0Y5_W2MID[6] VPWR VGND sg13cmos5l_antennanp
X_1731_ Tile_X0Y0_E2BEG[3] _2168_/X VPWR VGND sg13cmos5l_buf_1
XANTENNA__0306__GATE Tile_X0Y5_FrameStrobe[7] VPWR VGND sg13cmos5l_antennanp
XFILLER_116_105 VPWR VGND sg13cmos5l_decap_8
XFILLER_116_127 VPWR VGND sg13cmos5l_decap_8
X_1662_ Tile_X0Y0_FrameData_O[2] Tile_X0Y0_FrameData[2] VPWR VGND sg13cmos5l_buf_1
XANTENNA__0936__GATE Tile_X0Y5_FrameStrobe[4] VPWR VGND sg13cmos5l_antennanp
XFILLER_109_190 VPWR VGND sg13cmos5l_decap_8
X_0613_ _0613_/Q Tile_X0Y2_FrameData[1] VGND VPWR Tile_X0Y5_FrameStrobe[1] latch
XFILLER_131_108 VPWR VGND sg13cmos5l_decap_8
X_1593_ Tile_X0Y2_EE4BEG[6] _2423_/X VPWR VGND sg13cmos5l_buf_1
XFILLER_320_208 VPWR VGND sg13cmos5l_fill_1
X_0544_ _0544_/Q Tile_X0Y1_FrameData[22] VGND VPWR Tile_X0Y5_FrameStrobe[7] latch
XFILLER_316_70 VPWR VGND sg13cmos5l_fill_2
XFILLER_252_14 VPWR VGND sg13cmos5l_decap_8
XFILLER_285_145 VPWR VGND sg13cmos5l_decap_8
X_0475_ _0475_/Q Tile_X0Y1_FrameData[27] VGND VPWR Tile_X0Y5_FrameStrobe[5] latch
XANTENNA__2667__A0 Tile_X0Y4_W1END[3] VPWR VGND sg13cmos5l_antennanp
XFILLER_285_156 VPWR VGND sg13cmos5l_fill_1
X_2214_ _2214_/X Tile_X0Y1_W1END[1] Tile_X0Y1_W6END[5] _2357_/X _2338_/X _0548_/Q
+ _0547_/Q VPWR VGND sg13cmos5l_mux4_1
XANTENNA__2131__A2 Tile_X0Y0_W6END[1] VPWR VGND sg13cmos5l_antennanp
XFILLER_15_0 VPWR VGND sg13cmos5l_fill_1
XFILLER_226_223 VPWR VGND sg13cmos5l_fill_1
XFILLER_285_189 VPWR VGND sg13cmos5l_fill_1
X_2145_ _2145_/X Tile_X0Y0_W2MID[7] Tile_X0Y0_W2END[7] Tile_X0Y0_W6END[7] _2241_/X
+ _0302_/Q _0301_/Q VPWR VGND sg13cmos5l_mux4_1
XFILLER_38_155 VPWR VGND sg13cmos5l_fill_2
XANTENNA__2419__A0 AXIL_S_SOC_AWADDR0 VPWR VGND sg13cmos5l_antennanp
XFILLER_332_80 VPWR VGND sg13cmos5l_fill_1
XANTENNA__0285__D Tile_X0Y0_FrameData[9] VPWR VGND sg13cmos5l_antennanp
X_2076_ Tile_X0Y5_S4BEG[9] _2076_/A VPWR VGND sg13cmos5l_buf_1
X_1027_ _1027_/Q Tile_X0Y3_FrameData[19] VGND VPWR Tile_X0Y5_FrameStrobe[7] latch
XFILLER_201_95 VPWR VGND sg13cmos5l_fill_2
XFILLER_355_105 VPWR VGND sg13cmos5l_decap_8
XFILLER_277_44 VPWR VGND sg13cmos5l_decap_8
XFILLER_355_116 VPWR VGND sg13cmos5l_fill_2
XFILLER_277_99 VPWR VGND sg13cmos5l_decap_4
X_1929_ Tile_X0Y1_EE4BEG[10] _2319_/X VPWR VGND sg13cmos5l_buf_1
XFILLER_355_149 VPWR VGND sg13cmos5l_decap_4
XFILLER_162_222 VPWR VGND sg13cmos5l_fill_2
XFILLER_30_15 VPWR VGND sg13cmos5l_fill_1
XFILLER_107_149 VPWR VGND sg13cmos5l_decap_8
XFILLER_146_48 VPWR VGND sg13cmos5l_decap_8
XFILLER_293_21 VPWR VGND sg13cmos5l_decap_8
XFILLER_293_32 VPWR VGND sg13cmos5l_fill_1
XANTENNA__1981__X Tile_X0Y5_E2BEGb[2] VPWR VGND sg13cmos5l_antennanp
XFILLER_115_182 VPWR VGND sg13cmos5l_fill_1
XFILLER_115_193 VPWR VGND sg13cmos5l_decap_8
XFILLER_226_81 VPWR VGND sg13cmos5l_decap_4
XANTENNA__1083__GATE Tile_X0Y5_FrameStrobe[1] VPWR VGND sg13cmos5l_antennanp
XANTENNA__2658__A0 AXIL_S_SOC_WSTRB1 VPWR VGND sg13cmos5l_antennanp
XFILLER_162_47 VPWR VGND sg13cmos5l_decap_8
XFILLER_190_6 VPWR VGND sg13cmos5l_decap_8
XFILLER_276_156 VPWR VGND sg13cmos5l_fill_1
XANTENNA__2122__A2 Tile_X0Y1_W6END[0] VPWR VGND sg13cmos5l_antennanp
XFILLER_44_103 VPWR VGND sg13cmos5l_fill_2
XANTENNA__0195__D Tile_X0Y0_FrameData[3] VPWR VGND sg13cmos5l_antennanp
XANTENNA__1098__GATE Tile_X0Y5_FrameStrobe[2] VPWR VGND sg13cmos5l_antennanp
XFILLER_232_204 VPWR VGND sg13cmos5l_fill_1
XFILLER_55_67 VPWR VGND sg13cmos5l_fill_1
XFILLER_55_45 VPWR VGND sg13cmos5l_fill_1
XFILLER_44_169 VPWR VGND sg13cmos5l_fill_2
XANTENNA__2830__A0 Tile_X0Y4_W2MID[6] VPWR VGND sg13cmos5l_antennanp
XANTENNA__0923__D Tile_X0Y3_FrameData[27] VPWR VGND sg13cmos5l_antennanp
XANTENNA__1021__GATE Tile_X0Y5_FrameStrobe[7] VPWR VGND sg13cmos5l_antennanp
XFILLER_111_84 VPWR VGND sg13cmos5l_decap_8
XFILLER_52_191 VPWR VGND sg13cmos5l_fill_1
XFILLER_187_33 VPWR VGND sg13cmos5l_fill_1
XFILLER_197_185 VPWR VGND sg13cmos5l_fill_1
XFILLER_71_77 VPWR VGND sg13cmos5l_fill_2
XFILLER_346_138 VPWR VGND sg13cmos5l_decap_8
XFILLER_200_189 VPWR VGND sg13cmos5l_decap_4
XFILLER_337_14 VPWR VGND sg13cmos5l_decap_8
XANTENNA__2052__X Tile_X0Y5_S2BEG[1] VPWR VGND sg13cmos5l_antennanp
XFILLER_217_0 VPWR VGND sg13cmos5l_fill_2
XFILLER_354_171 VPWR VGND sg13cmos5l_decap_8
XFILLER_299_204 VPWR VGND sg13cmos5l_fill_2
XANTENNA__1036__GATE Tile_X0Y5_FrameStrobe[0] VPWR VGND sg13cmos5l_antennanp
XANTENNA__1891__X Tile_X0Y1_FrameData_O[4] VPWR VGND sg13cmos5l_antennanp
XANTENNA__0292__GATE Tile_X0Y5_FrameStrobe[6] VPWR VGND sg13cmos5l_antennanp
XFILLER_20_81 VPWR VGND sg13cmos5l_fill_1
XANTENNA__2649__A0 Tile_X0Y5_N4END[4] VPWR VGND sg13cmos5l_antennanp
X_0260_ _0260_/Q Tile_X0Y0_FrameData[2] VGND VPWR Tile_X0Y5_FrameStrobe[5] latch
XFILLER_96_63 VPWR VGND sg13cmos5l_decap_8
XANTENNA__2113__A2 Tile_X0Y3_W6END[7] VPWR VGND sg13cmos5l_antennanp
XFILLER_282_104 VPWR VGND sg13cmos5l_decap_8
XFILLER_222_39 VPWR VGND sg13cmos5l_decap_8
X_0191_ _0191_/Q Tile_X0Y0_FrameData[7] VGND VPWR Tile_X0Y5_FrameStrobe[3] latch
XFILLER_35_103 VPWR VGND sg13cmos5l_decap_8
XFILLER_223_204 VPWR VGND sg13cmos5l_decap_8
XFILLER_35_158 VPWR VGND sg13cmos5l_fill_1
XFILLER_302_83 VPWR VGND sg13cmos5l_fill_2
XFILLER_302_61 VPWR VGND sg13cmos5l_decap_4
XANTENNA__0230__GATE Tile_X0Y5_FrameStrobe[4] VPWR VGND sg13cmos5l_antennanp
XANTENNA__2821__A0 Tile_X0Y5_N1END[1] VPWR VGND sg13cmos5l_antennanp
XFILLER_188_141 VPWR VGND sg13cmos5l_fill_1
XANTENNA__0833__D Tile_X0Y3_FrameData[21] VPWR VGND sg13cmos5l_antennanp
XANTENNA__0860__GATE Tile_X0Y5_FrameStrobe[2] VPWR VGND sg13cmos5l_antennanp
X_2832_ _2832_/X Tile_X0Y4_W2MID[4] Tile_X0Y4_W2END[4] Tile_X0Y4_W6END[11] _2711_/X
+ _1118_/Q _1117_/Q VPWR VGND sg13cmos5l_mux4_1
XANTENNA__0245__GATE Tile_X0Y5_FrameStrobe[5] VPWR VGND sg13cmos5l_antennanp
X_2763_ _2763_/X AXIL_S_SOC_ARPROT1 _2821_/X _2810_/X _2827_/X _1376_/Q _1375_/Q VPWR
+ VGND sg13cmos5l_mux4_1
XANTENNA__0875__GATE Tile_X0Y5_FrameStrobe[2] VPWR VGND sg13cmos5l_antennanp
XFILLER_247_25 VPWR VGND sg13cmos5l_decap_8
X_1714_ Tile_X0Y0_E6BEG[6] _2203_/X VPWR VGND sg13cmos5l_buf_1
XFILLER_352_108 VPWR VGND sg13cmos5l_decap_8
X_2694_ _2694_/X Tile_X0Y0_W1END[2] Tile_X0Y0_WW4END[10] Tile_X0Y0_WW4END[14] Tile_X0Y0_W6END[6]
+ _0148_/Q _0147_/Q VPWR VGND sg13cmos5l_mux4_1
X_1645_ Tile_X0Y0_FrameStrobe_O[5] Tile_X0Y5_FrameStrobe[5] VPWR VGND sg13cmos5l_buf_1
XFILLER_116_29 VPWR VGND sg13cmos5l_fill_1
X_1576_ Tile_X0Y3_FrameData_O[22] Tile_X0Y3_FrameData[22] VPWR VGND sg13cmos5l_buf_1
X_0527_ _0527_/Q Tile_X0Y1_FrameData[7] VGND VPWR Tile_X0Y5_FrameStrobe[6] latch
XFILLER_263_79 VPWR VGND sg13cmos5l_fill_1
XANTENNA__2104__A2 Tile_X0Y4_W6END[4] VPWR VGND sg13cmos5l_antennanp
XFILLER_258_178 VPWR VGND sg13cmos5l_decap_4
XFILLER_273_104 VPWR VGND sg13cmos5l_decap_8
X_0458_ _0458_/Q Tile_X0Y1_FrameData[12] VGND VPWR Tile_X0Y5_FrameStrobe[4] latch
XANTENNA__0813__GATE Tile_X0Y5_FrameStrobe[0] VPWR VGND sg13cmos5l_antennanp
X_0389_ _0389_/Q Tile_X0Y1_FrameData[17] VGND VPWR Tile_X0Y5_FrameStrobe[2] latch
XFILLER_73_209 VPWR VGND sg13cmos5l_fill_2
X_2128_ AXIL_S_SOC_RDATA22 Tile_X0Y1_W2MID[6] Tile_X0Y1_W2END[6] Tile_X0Y1_W6END[6]
+ _2379_/X _0370_/Q _0369_/Q VPWR VGND sg13cmos5l_mux4_1
XFILLER_81_220 VPWR VGND sg13cmos5l_decap_4
XANTENNA__1689__A Tile_X0Y0_FrameData[29] VPWR VGND sg13cmos5l_antennanp
XANTENNA__2137__X AXIL_S_SOC_RDATA31 VPWR VGND sg13cmos5l_antennanp
XFILLER_25_15 VPWR VGND sg13cmos5l_fill_2
X_2059_ Tile_X0Y5_S2BEGb[0] _2829_/X VPWR VGND sg13cmos5l_buf_1
XANTENNA__0828__GATE Tile_X0Y5_FrameStrobe[1] VPWR VGND sg13cmos5l_antennanp
XFILLER_288_10 VPWR VGND sg13cmos5l_fill_1
XANTENNA__0743__D Tile_X0Y2_FrameData[31] VPWR VGND sg13cmos5l_antennanp
XANTENNA__1976__X Tile_X0Y5_E2BEG[5] VPWR VGND sg13cmos5l_antennanp
XFILLER_179_163 VPWR VGND sg13cmos5l_fill_1
XFILLER_194_100 VPWR VGND sg13cmos5l_fill_1
XFILLER_194_133 VPWR VGND sg13cmos5l_decap_8
XFILLER_194_155 VPWR VGND sg13cmos5l_decap_4
XFILLER_194_166 VPWR VGND sg13cmos5l_decap_8
XFILLER_157_36 VPWR VGND sg13cmos5l_decap_8
XFILLER_336_182 VPWR VGND sg13cmos5l_decap_8
XFILLER_351_163 VPWR VGND sg13cmos5l_decap_8
XFILLER_351_141 VPWR VGND sg13cmos5l_decap_4
XFILLER_351_196 VPWR VGND sg13cmos5l_decap_8
XFILLER_106_40 VPWR VGND sg13cmos5l_decap_8
XFILLER_49_217 VPWR VGND sg13cmos5l_fill_1
XANTENNA__0918__D Tile_X0Y3_FrameData[0] VPWR VGND sg13cmos5l_antennanp
XFILLER_323_49 VPWR VGND sg13cmos5l_decap_4
XFILLER_323_38 VPWR VGND sg13cmos5l_fill_1
XFILLER_181_2 VPWR VGND sg13cmos5l_fill_1
XFILLER_66_88 VPWR VGND sg13cmos5l_fill_1
XFILLER_122_50 VPWR VGND sg13cmos5l_decap_4
XFILLER_17_125 VPWR VGND sg13cmos5l_fill_1
XANTENNA__2047__X Tile_X0Y5_S1BEG[0] VPWR VGND sg13cmos5l_antennanp
XFILLER_167_0 VPWR VGND sg13cmos5l_fill_1
XFILLER_17_158 VPWR VGND sg13cmos5l_fill_2
XFILLER_272_181 VPWR VGND sg13cmos5l_decap_8
XFILLER_82_43 VPWR VGND sg13cmos5l_fill_2
XANTENNA__0653__D Tile_X0Y2_FrameData[25] VPWR VGND sg13cmos5l_antennanp
XANTENNA__1886__X Tile_X0Y1_UserCLKo VPWR VGND sg13cmos5l_antennanp
XANTENNA__2803__A0 Tile_X0Y1_W1END[0] VPWR VGND sg13cmos5l_antennanp
XFILLER_82_98 VPWR VGND sg13cmos5l_fill_2
XFILLER_82_87 VPWR VGND sg13cmos5l_decap_8
XFILLER_334_0 VPWR VGND sg13cmos5l_decap_8
XFILLER_40_161 VPWR VGND sg13cmos5l_decap_8
XFILLER_348_24 VPWR VGND sg13cmos5l_decap_8
XFILLER_185_133 VPWR VGND sg13cmos5l_fill_1
XFILLER_185_144 VPWR VGND sg13cmos5l_decap_8
XFILLER_348_46 VPWR VGND sg13cmos5l_decap_8
XANTENNA__1484__D Tile_X0Y5_FrameData[4] VPWR VGND sg13cmos5l_antennanp
XFILLER_217_17 VPWR VGND sg13cmos5l_decap_8
X_1430_ _1430_/Q Tile_X0Y5_FrameData[26] VGND VPWR Tile_X0Y5_FrameStrobe[5] latch
X_1361_ _1361_/Q Tile_X0Y5_FrameData[31] VGND VPWR Tile_X0Y5_FrameStrobe[3] latch
X_0312_ _0312_/Q Tile_X0Y1_FrameData[30] VGND VPWR Tile_X0Y5_FrameStrobe[0] latch
X_1292_ _1292_/Q Tile_X0Y5_FrameData[4] VGND VPWR Tile_X0Y5_FrameStrobe[0] latch
XANTENNA__0828__D Tile_X0Y3_FrameData[26] VPWR VGND sg13cmos5l_antennanp
XFILLER_255_148 VPWR VGND sg13cmos5l_fill_1
X_0243_ _0243_/Q Tile_X0Y0_FrameData[19] VGND VPWR Tile_X0Y5_FrameStrobe[5] latch
X_0174_ _0174_/Q Tile_X0Y0_FrameData[24] VGND VPWR Tile_X0Y5_FrameStrobe[3] latch
XFILLER_313_93 VPWR VGND sg13cmos5l_fill_1
XFILLER_313_82 VPWR VGND sg13cmos5l_decap_8
XFILLER_263_181 VPWR VGND sg13cmos5l_decap_4
XFILLER_270_129 VPWR VGND sg13cmos5l_decap_8
XFILLER_23_117 VPWR VGND sg13cmos5l_decap_4
XANTENNA__0563__D Tile_X0Y2_FrameData[19] VPWR VGND sg13cmos5l_antennanp
XANTENNA__1796__X Tile_X0Y4_E2BEG[7] VPWR VGND sg13cmos5l_antennanp
XANTENNA__0184__GATE Tile_X0Y5_FrameStrobe[3] VPWR VGND sg13cmos5l_antennanp
XFILLER_176_111 VPWR VGND sg13cmos5l_decap_8
XFILLER_258_35 VPWR VGND sg13cmos5l_decap_8
X_2815_ _2815_/X Tile_X0Y1_W1END[3] Tile_X0Y1_WW4END[11] Tile_X0Y1_WW4END[15] Tile_X0Y1_W6END[7]
+ _0385_/Q _0384_/Q VPWR VGND sg13cmos5l_mux4_1
XFILLER_176_188 VPWR VGND sg13cmos5l_decap_8
XFILLER_258_79 VPWR VGND sg13cmos5l_decap_4
X_2746_ _2746_/X AXIL_S_SOC_ARPROT0 AXIL_S_SOC_RREADY _2806_/X _2827_/X _1410_/Q _1409_/Q
+ VPWR VGND sg13cmos5l_mux4_1
XANTENNA__0199__GATE Tile_X0Y5_FrameStrobe[4] VPWR VGND sg13cmos5l_antennanp
XANTENNA__1394__D Tile_X0Y5_FrameData[30] VPWR VGND sg13cmos5l_antennanp
XFILLER_191_169 VPWR VGND sg13cmos5l_fill_1
X_2677_ _2677_/X Tile_X0Y3_W1END[2] Tile_X0Y3_W6END[10] _2575_/X _2563_/X _0894_/Q
+ _0893_/Q VPWR VGND sg13cmos5l_mux4_1
X_1628_ Tile_X0Y0_N2BEG[0] _2145_/X VPWR VGND sg13cmos5l_buf_1
XFILLER_333_163 VPWR VGND sg13cmos5l_fill_2
XANTENNA__0122__GATE Tile_X0Y5_FrameStrobe[1] VPWR VGND sg13cmos5l_antennanp
X_1559_ Tile_X0Y3_FrameData_O[5] Tile_X0Y3_FrameData[5] VPWR VGND sg13cmos5l_buf_1
XANTENNA__0752__GATE Tile_X0Y5_FrameStrobe[6] VPWR VGND sg13cmos5l_antennanp
XFILLER_290_33 VPWR VGND sg13cmos5l_fill_1
XFILLER_290_44 VPWR VGND sg13cmos5l_fill_2
XANTENNA__0738__D Tile_X0Y2_FrameData[4] VPWR VGND sg13cmos5l_antennanp
XFILLER_246_148 VPWR VGND sg13cmos5l_fill_2
XFILLER_261_107 VPWR VGND sg13cmos5l_decap_8
XANTENNA__0137__GATE Tile_X0Y5_FrameStrobe[2] VPWR VGND sg13cmos5l_antennanp
XANTENNA__0767__GATE Tile_X0Y5_FrameStrobe[6] VPWR VGND sg13cmos5l_antennanp
XFILLER_36_47 VPWR VGND sg13cmos5l_decap_8
XFILLER_258_7 VPWR VGND sg13cmos5l_decap_4
XFILLER_299_75 VPWR VGND sg13cmos5l_fill_1
XFILLER_299_86 VPWR VGND sg13cmos5l_decap_4
XANTENNA__0473__D Tile_X0Y1_FrameData[29] VPWR VGND sg13cmos5l_antennanp
XANTENNA__2261__A1 Tile_X0Y2_W2END[1] VPWR VGND sg13cmos5l_antennanp
XFILLER_168_57 VPWR VGND sg13cmos5l_fill_1
XFILLER_167_188 VPWR VGND sg13cmos5l_decap_8
XFILLER_316_108 VPWR VGND sg13cmos5l_decap_8
XANTENNA__2043__A Tile_X0Y5_FrameData[28] VPWR VGND sg13cmos5l_antennanp
XFILLER_318_27 VPWR VGND sg13cmos5l_fill_1
XFILLER_309_171 VPWR VGND sg13cmos5l_decap_8
XANTENNA__0705__GATE Tile_X0Y5_FrameStrobe[4] VPWR VGND sg13cmos5l_antennanp
XANTENNA__2564__A2 Tile_X0Y3_W6END[3] VPWR VGND sg13cmos5l_antennanp
XFILLER_123_203 VPWR VGND sg13cmos5l_decap_8
XFILLER_184_23 VPWR VGND sg13cmos5l_decap_8
XFILLER_184_78 VPWR VGND sg13cmos5l_fill_2
XFILLER_117_50 VPWR VGND sg13cmos5l_decap_8
XFILLER_334_37 VPWR VGND sg13cmos5l_fill_1
XFILLER_334_59 VPWR VGND sg13cmos5l_fill_2
XFILLER_334_48 VPWR VGND sg13cmos5l_decap_8
XFILLER_237_104 VPWR VGND sg13cmos5l_decap_8
XANTENNA__0648__D Tile_X0Y2_FrameData[30] VPWR VGND sg13cmos5l_antennanp
XFILLER_237_148 VPWR VGND sg13cmos5l_decap_4
XFILLER_284_0 VPWR VGND sg13cmos5l_fill_2
XFILLER_77_98 VPWR VGND sg13cmos5l_fill_2
XFILLER_37_209 VPWR VGND sg13cmos5l_fill_2
XFILLER_350_14 VPWR VGND sg13cmos5l_decap_8
XFILLER_93_42 VPWR VGND sg13cmos5l_decap_8
XFILLER_245_170 VPWR VGND sg13cmos5l_decap_8
XFILLER_245_181 VPWR VGND sg13cmos5l_fill_1
XFILLER_350_69 VPWR VGND sg13cmos5l_decap_8
XANTENNA__1479__D Tile_X0Y5_FrameData[9] VPWR VGND sg13cmos5l_antennanp
XFILLER_260_173 VPWR VGND sg13cmos5l_decap_8
XANTENNA__0383__D Tile_X0Y1_FrameData[23] VPWR VGND sg13cmos5l_antennanp
XANTENNA__2252__A1 Tile_X0Y1_W2END[6] VPWR VGND sg13cmos5l_antennanp
XFILLER_20_109 VPWR VGND sg13cmos5l_fill_2
X_0930_ _0930_/Q Tile_X0Y3_FrameData[20] VGND VPWR Tile_X0Y5_FrameStrobe[4] latch
XFILLER_9_121 VPWR VGND sg13cmos5l_fill_2
X_0861_ _0861_/Q Tile_X0Y3_FrameData[25] VGND VPWR Tile_X0Y5_FrameStrobe[2] latch
XFILLER_158_199 VPWR VGND sg13cmos5l_decap_8
XFILLER_228_38 VPWR VGND sg13cmos5l_decap_8
X_2600_ _2600_/X Tile_X0Y5_W2MID[6] Tile_X0Y5_W2END[6] Tile_X0Y5_W6END[6] _2826_/X
+ _1486_/Q _1485_/Q VPWR VGND sg13cmos5l_mux4_1
X_0792_ _0792_/Q Tile_X0Y3_FrameData[30] VGND VPWR Tile_X0Y5_FrameStrobe[0] latch
XANTENNA__2555__A2 Tile_X0Y3_WW4END[13] VPWR VGND sg13cmos5l_antennanp
X_2531_ _2531_/X AXIL_S_SOC_ARADDR0 AXIL_S_SOC_ARADDR6 _2578_/X _2590_/X _0942_/Q
+ _0941_/Q VPWR VGND sg13cmos5l_mux4_1
XFILLER_315_163 VPWR VGND sg13cmos5l_decap_4
XFILLER_181_191 VPWR VGND sg13cmos5l_decap_8
X_2462_ _2462_/X Tile_X0Y3_W1END[2] Tile_X0Y3_W6END[6] _2575_/X _2563_/X _1026_/Q
+ _1025_/Q VPWR VGND sg13cmos5l_mux4_1
XFILLER_308_93 VPWR VGND sg13cmos5l_fill_1
XFILLER_244_48 VPWR VGND sg13cmos5l_decap_8
X_1413_ _1413_/Q Tile_X0Y5_FrameData[11] VGND VPWR Tile_X0Y5_FrameStrobe[4] latch
X_2393_ _2393_/X Tile_X0Y0_W1END[2] Tile_X0Y0_W2MID[1] Tile_X0Y0_W2END[1] _2247_/X
+ _0158_/Q _0157_/Q VPWR VGND sg13cmos5l_mux4_1
XFILLER_330_188 VPWR VGND sg13cmos5l_decap_4
XFILLER_228_115 VPWR VGND sg13cmos5l_fill_2
X_1344_ _1344_/Q Tile_X0Y5_FrameData[16] VGND VPWR Tile_X0Y5_FrameStrobe[2] latch
XFILLER_3_51 VPWR VGND sg13cmos5l_fill_2
XANTENNA__0558__D Tile_X0Y2_FrameData[24] VPWR VGND sg13cmos5l_antennanp
XANTENNA__1482__GATE Tile_X0Y5_FrameStrobe[6] VPWR VGND sg13cmos5l_antennanp
XFILLER_228_159 VPWR VGND sg13cmos5l_decap_8
X_1275_ _1275_/Q Tile_X0Y5_FrameData[21] VGND VPWR Tile_X0Y5_FrameStrobe[0] latch
XFILLER_95_153 VPWR VGND sg13cmos5l_decap_8
XFILLER_243_107 VPWR VGND sg13cmos5l_decap_8
XFILLER_260_25 VPWR VGND sg13cmos5l_fill_2
X_0226_ _0226_/Q Tile_X0Y0_FrameData[4] VGND VPWR Tile_X0Y5_FrameStrobe[4] latch
XANTENNA__1497__GATE Tile_X0Y5_FrameStrobe[0] VPWR VGND sg13cmos5l_antennanp
XANTENNA__2491__A1 Tile_X0Y1_W2END[6] VPWR VGND sg13cmos5l_antennanp
XFILLER_251_140 VPWR VGND sg13cmos5l_fill_1
X_0157_ _0157_/Q Tile_X0Y0_FrameData[9] VGND VPWR Tile_X0Y5_FrameStrobe[2] latch
XANTENNA__1389__D Tile_X0Y5_FrameData[3] VPWR VGND sg13cmos5l_antennanp
XFILLER_196_217 VPWR VGND sg13cmos5l_fill_1
X_0088_ _0088_/Q Tile_X0Y0_FrameData[14] VGND VPWR Tile_X0Y5_FrameStrobe[0] latch
XANTENNA__0293__D Tile_X0Y0_FrameData[1] VPWR VGND sg13cmos5l_antennanp
XFILLER_269_45 VPWR VGND sg13cmos5l_fill_1
XANTENNA__1420__GATE Tile_X0Y5_FrameStrobe[4] VPWR VGND sg13cmos5l_antennanp
XFILLER_22_49 VPWR VGND sg13cmos5l_decap_8
XFILLER_164_136 VPWR VGND sg13cmos5l_decap_8
XFILLER_285_55 VPWR VGND sg13cmos5l_decap_8
XFILLER_353_214 VPWR VGND sg13cmos5l_fill_1
XFILLER_285_66 VPWR VGND sg13cmos5l_fill_2
XFILLER_285_77 VPWR VGND sg13cmos5l_fill_1
X_2729_ _2729_/X AXIL_S_SOC_ARPROT2 AXIL_S_SOC_RREADY _2828_/X _2800_/X _1444_/Q _1443_/Q
+ VPWR VGND sg13cmos5l_mux4_1
XANTENNA__1435__GATE Tile_X0Y5_FrameStrobe[5] VPWR VGND sg13cmos5l_antennanp
XFILLER_172_180 VPWR VGND sg13cmos5l_decap_8
XFILLER_218_71 VPWR VGND sg13cmos5l_decap_4
XFILLER_154_15 VPWR VGND sg13cmos5l_fill_1
XFILLER_154_37 VPWR VGND sg13cmos5l_decap_8
XANTENNA__0691__GATE Tile_X0Y5_FrameStrobe[4] VPWR VGND sg13cmos5l_antennanp
XFILLER_120_217 VPWR VGND sg13cmos5l_fill_1
XFILLER_304_29 VPWR VGND sg13cmos5l_fill_1
XANTENNA__0468__D Tile_X0Y1_FrameData[2] VPWR VGND sg13cmos5l_antennanp
XFILLER_170_14 VPWR VGND sg13cmos5l_fill_1
XANTENNA__0076__GATE Tile_X0Y5_FrameStrobe[0] VPWR VGND sg13cmos5l_antennanp
XFILLER_47_68 VPWR VGND sg13cmos5l_fill_2
XFILLER_103_41 VPWR VGND sg13cmos5l_decap_8
XFILLER_234_118 VPWR VGND sg13cmos5l_decap_8
XANTENNA__2038__A Tile_X0Y5_FrameData[23] VPWR VGND sg13cmos5l_antennanp
XFILLER_227_192 VPWR VGND sg13cmos5l_decap_8
XANTENNA__1299__D Tile_X0Y5_FrameData[29] VPWR VGND sg13cmos5l_antennanp
XFILLER_42_223 VPWR VGND sg13cmos5l_fill_1
XFILLER_179_45 VPWR VGND sg13cmos5l_fill_1
XFILLER_179_56 VPWR VGND sg13cmos5l_decap_4
XFILLER_63_78 VPWR VGND sg13cmos5l_decap_8
XFILLER_179_89 VPWR VGND sg13cmos5l_fill_1
XANTENNA__0931__D Tile_X0Y3_FrameData[19] VPWR VGND sg13cmos5l_antennanp
XANTENNA__2785__A2 Tile_X0Y5_W6END[6] VPWR VGND sg13cmos5l_antennanp
XFILLER_10_142 VPWR VGND sg13cmos5l_fill_1
XANTENNA__0644__GATE Tile_X0Y5_FrameStrobe[2] VPWR VGND sg13cmos5l_antennanp
XFILLER_10_175 VPWR VGND sg13cmos5l_fill_1
XFILLER_10_186 VPWR VGND sg13cmos5l_fill_2
XFILLER_195_22 VPWR VGND sg13cmos5l_fill_2
XANTENNA__2060__X Tile_X0Y5_S2BEGb[1] VPWR VGND sg13cmos5l_antennanp
XFILLER_345_25 VPWR VGND sg13cmos5l_decap_8
XFILLER_345_69 VPWR VGND sg13cmos5l_decap_8
XFILLER_312_144 VPWR VGND sg13cmos5l_fill_1
XANTENNA__0659__GATE Tile_X0Y5_FrameStrobe[3] VPWR VGND sg13cmos5l_antennanp
XFILLER_111_217 VPWR VGND sg13cmos5l_fill_1
XANTENNA__0378__D Tile_X0Y1_FrameData[28] VPWR VGND sg13cmos5l_antennanp
XANTENNA__2170__A0 AXIL_S_SOC_WDATA21 VPWR VGND sg13cmos5l_antennanp
XFILLER_144_70 VPWR VGND sg13cmos5l_decap_8
X_1060_ _1060_/Q Tile_X0Y4_FrameData[2] VGND VPWR Tile_X0Y5_FrameStrobe[0] latch
XFILLER_92_145 VPWR VGND sg13cmos5l_decap_8
XANTENNA__2473__A1 Tile_X0Y5_N4END[15] VPWR VGND sg13cmos5l_antennanp
XFILLER_33_201 VPWR VGND sg13cmos5l_decap_8
XFILLER_233_184 VPWR VGND sg13cmos5l_decap_4
XANTENNA__1002__D Tile_X0Y3_FrameData[12] VPWR VGND sg13cmos5l_antennanp
X_1962_ Tile_X0Y1_E2BEG[7] _2300_/X VPWR VGND sg13cmos5l_buf_1
XANTENNA__2776__A2 Tile_X0Y5_W6END[11] VPWR VGND sg13cmos5l_antennanp
XFILLER_239_37 VPWR VGND sg13cmos5l_fill_2
XFILLER_239_59 VPWR VGND sg13cmos5l_decap_4
X_1893_ Tile_X0Y1_FrameData_O[6] Tile_X0Y1_FrameData[6] VPWR VGND sg13cmos5l_buf_1
X_0913_ _0913_/Q Tile_X0Y3_FrameData[5] VGND VPWR Tile_X0Y5_FrameStrobe[3] latch
XANTENNA__0841__D Tile_X0Y3_FrameData[13] VPWR VGND sg13cmos5l_antennanp
XFILLER_146_114 VPWR VGND sg13cmos5l_decap_8
X_0844_ _0844_/Q Tile_X0Y3_FrameData[10] VGND VPWR Tile_X0Y5_FrameStrobe[1] latch
XFILLER_335_214 VPWR VGND sg13cmos5l_fill_1
X_0775_ _0775_/Q Tile_X0Y2_FrameData[31] VGND VPWR Tile_X0Y5_FrameStrobe[7] latch
X_2514_ _2514_/X AXIL_S_SOC_ARADDR3 AXIL_S_SOC_ARADDR5 _2591_/X _2594_/X _0976_/Q
+ _0975_/Q VPWR VGND sg13cmos5l_mux4_1
X_2445_ _2445_/X Tile_X0Y2_W1END[0] Tile_X0Y2_WW4END[8] Tile_X0Y2_WW4END[12] Tile_X0Y2_W6END[4]
+ _0634_/Q _0633_/Q VPWR VGND sg13cmos5l_mux4_1
XFILLER_124_29 VPWR VGND sg13cmos5l_decap_8
XANTENNA__0288__D Tile_X0Y0_FrameData[6] VPWR VGND sg13cmos5l_antennanp
X_2376_ _2376_/X _2255_/X _2388_/X _2387_/X Tile_X0Y0_S2MID[3] _0328_/Q _0327_/Q VPWR
+ VGND sg13cmos5l_mux4_1
XFILLER_68_164 VPWR VGND sg13cmos5l_decap_8
XFILLER_271_79 VPWR VGND sg13cmos5l_fill_2
X_1327_ _1327_/Q Tile_X0Y5_FrameData[1] VGND VPWR Tile_X0Y5_FrameStrobe[1] latch
X_1258_ _1258_/Q Tile_X0Y4_FrameData[28] VGND VPWR Tile_X0Y5_FrameStrobe[7] latch
XANTENNA__2464__A1 Tile_X0Y3_W6END[7] VPWR VGND sg13cmos5l_antennanp
XFILLER_140_39 VPWR VGND sg13cmos5l_decap_8
XFILLER_17_49 VPWR VGND sg13cmos5l_fill_2
X_1189_ _1189_/Q Tile_X0Y4_FrameData[1] VGND VPWR Tile_X0Y5_FrameStrobe[4] latch
X_0209_ _0209_/Q Tile_X0Y0_FrameData[21] VGND VPWR Tile_X0Y5_FrameStrobe[4] latch
XFILLER_24_223 VPWR VGND sg13cmos5l_fill_1
XANTENNA__2216__A1 Tile_X0Y1_W6END[7] VPWR VGND sg13cmos5l_antennanp
XFILLER_33_37 VPWR VGND sg13cmos5l_decap_8
XANTENNA__1984__X Tile_X0Y5_E2BEGb[5] VPWR VGND sg13cmos5l_antennanp
XFILLER_149_48 VPWR VGND sg13cmos5l_decap_8
XFILLER_149_59 VPWR VGND sg13cmos5l_fill_1
XFILLER_184_209 VPWR VGND sg13cmos5l_decap_4
XANTENNA__0751__D Tile_X0Y2_FrameData[23] VPWR VGND sg13cmos5l_antennanp
XFILLER_296_98 VPWR VGND sg13cmos5l_decap_8
XANTENNA__1374__GATE Tile_X0Y5_FrameStrobe[3] VPWR VGND sg13cmos5l_antennanp
XFILLER_137_147 VPWR VGND sg13cmos5l_decap_4
XANTENNA__1389__GATE Tile_X0Y5_FrameStrobe[3] VPWR VGND sg13cmos5l_antennanp
XFILLER_181_24 VPWR VGND sg13cmos5l_fill_1
XANTENNA__0198__D Tile_X0Y0_FrameData[0] VPWR VGND sg13cmos5l_antennanp
XANTENNA__2152__A0 Tile_X0Y0_W2MID[0] VPWR VGND sg13cmos5l_antennanp
XFILLER_59_153 VPWR VGND sg13cmos5l_decap_8
XFILLER_58_78 VPWR VGND sg13cmos5l_fill_2
XFILLER_74_101 VPWR VGND sg13cmos5l_fill_2
XFILLER_331_16 VPWR VGND sg13cmos5l_decap_8
XANTENNA__1312__GATE Tile_X0Y5_FrameStrobe[1] VPWR VGND sg13cmos5l_antennanp
XFILLER_114_84 VPWR VGND sg13cmos5l_fill_1
XFILLER_207_118 VPWR VGND sg13cmos5l_decap_8
XFILLER_74_33 VPWR VGND sg13cmos5l_decap_8
XFILLER_74_156 VPWR VGND sg13cmos5l_decap_8
XFILLER_331_27 VPWR VGND sg13cmos5l_fill_2
XANTENNA__0926__D Tile_X0Y3_FrameData[24] VPWR VGND sg13cmos5l_antennanp
XFILLER_15_223 VPWR VGND sg13cmos5l_fill_1
XANTENNA__1327__GATE Tile_X0Y5_FrameStrobe[1] VPWR VGND sg13cmos5l_antennanp
XFILLER_130_61 VPWR VGND sg13cmos5l_decap_8
XFILLER_247_0 VPWR VGND sg13cmos5l_fill_2
XANTENNA__2055__X Tile_X0Y5_S2BEG[4] VPWR VGND sg13cmos5l_antennanp
XFILLER_230_165 VPWR VGND sg13cmos5l_fill_2
XANTENNA__0583__GATE Tile_X0Y5_FrameStrobe[1] VPWR VGND sg13cmos5l_antennanp
XANTENNA__0661__D Tile_X0Y2_FrameData[17] VPWR VGND sg13cmos5l_antennanp
XANTENNA__1894__X Tile_X0Y1_FrameData_O[7] VPWR VGND sg13cmos5l_antennanp
XFILLER_356_13 VPWR VGND sg13cmos5l_decap_4
XFILLER_128_158 VPWR VGND sg13cmos5l_fill_1
XANTENNA__0598__GATE Tile_X0Y5_FrameStrobe[1] VPWR VGND sg13cmos5l_antennanp
XANTENNA__2391__A0 Tile_X0Y0_W1END[1] VPWR VGND sg13cmos5l_antennanp
X_0560_ _0560_/Q Tile_X0Y2_FrameData[22] VGND VPWR Tile_X0Y5_FrameStrobe[0] latch
XANTENNA__1492__D Tile_X0Y5_FrameData[28] VPWR VGND sg13cmos5l_antennanp
XFILLER_225_17 VPWR VGND sg13cmos5l_decap_8
X_0491_ _0491_/Q Tile_X0Y1_FrameData[11] VGND VPWR Tile_X0Y5_FrameStrobe[5] latch
X_2230_ _2230_/X _2213_/X _0049_/X Tile_X0Y0_S1END[0] Tile_X0Y0_S4END[0] _0110_/Q
+ _0109_/Q VPWR VGND sg13cmos5l_mux4_1
XFILLER_2_171 VPWR VGND sg13cmos5l_fill_2
XFILLER_297_165 VPWR VGND sg13cmos5l_fill_1
XANTENNA__0521__GATE Tile_X0Y5_FrameStrobe[6] VPWR VGND sg13cmos5l_antennanp
XANTENNA__2143__A0 Tile_X0Y0_W1END[2] VPWR VGND sg13cmos5l_antennanp
XANTENNA__2694__A1 Tile_X0Y0_WW4END[10] VPWR VGND sg13cmos5l_antennanp
X_2161_ _2161_/X _2213_/X Tile_X0Y0_S1END[0] AXIL_S_SOC_WDATA18 AXIL_S_SOC_WDATA23
+ _0274_/Q _0273_/Q VPWR VGND sg13cmos5l_mux4_1
XFILLER_241_38 VPWR VGND sg13cmos5l_decap_8
XFILLER_241_49 VPWR VGND sg13cmos5l_fill_2
X_2092_ Tile_X0Y3_E2BEG[4] _2513_/X VPWR VGND sg13cmos5l_buf_1
X_1112_ _1112_/Q Tile_X0Y4_FrameData[14] VGND VPWR Tile_X0Y5_FrameStrobe[2] latch
XFILLER_65_134 VPWR VGND sg13cmos5l_decap_8
XANTENNA__0836__D Tile_X0Y3_FrameData[18] VPWR VGND sg13cmos5l_antennanp
X_1043_ _1043_/Q Tile_X0Y4_FrameData[19] VGND VPWR Tile_X0Y5_FrameStrobe[0] latch
XFILLER_65_178 VPWR VGND sg13cmos5l_decap_4
XANTENNA__0536__GATE Tile_X0Y5_FrameStrobe[7] VPWR VGND sg13cmos5l_antennanp
XFILLER_80_137 VPWR VGND sg13cmos5l_decap_8
XFILLER_206_184 VPWR VGND sg13cmos5l_decap_8
XFILLER_221_110 VPWR VGND sg13cmos5l_decap_8
X_1945_ Tile_X0Y1_E6BEG[10] _2335_/X VPWR VGND sg13cmos5l_buf_1
XANTENNA__0571__D Tile_X0Y2_FrameData[11] VPWR VGND sg13cmos5l_antennanp
XFILLER_119_169 VPWR VGND sg13cmos5l_fill_1
XFILLER_266_24 VPWR VGND sg13cmos5l_decap_4
X_1876_ Tile_X0Y2_E6BEG[2] _2435_/X VPWR VGND sg13cmos5l_buf_1
XFILLER_134_106 VPWR VGND sg13cmos5l_fill_2
X_0827_ _0827_/Q Tile_X0Y3_FrameData[27] VGND VPWR Tile_X0Y5_FrameStrobe[1] latch
XANTENNA__2382__A0 Tile_X0Y3_W2MID[7] VPWR VGND sg13cmos5l_antennanp
XFILLER_127_180 VPWR VGND sg13cmos5l_fill_2
X_0758_ _0758_/Q Tile_X0Y2_FrameData[16] VGND VPWR Tile_X0Y5_FrameStrobe[6] latch
XFILLER_135_28 VPWR VGND sg13cmos5l_decap_8
XFILLER_142_183 VPWR VGND sg13cmos5l_decap_8
XFILLER_288_187 VPWR VGND sg13cmos5l_fill_1
X_0689_ _0689_/Q Tile_X0Y2_FrameData[21] VGND VPWR Tile_X0Y5_FrameStrobe[4] latch
XANTENNA__2134__A0 Tile_X0Y0_W2MID[4] VPWR VGND sg13cmos5l_antennanp
X_2428_ _2428_/X AXIL_S_SOC_AWADDR7 AXIL_S_SOC_AWPROT1 _2479_/X _2485_/X _0692_/Q
+ _0691_/Q VPWR VGND sg13cmos5l_mux4_1
XANTENNA__2685__A1 Tile_X0Y5_N4END[7] VPWR VGND sg13cmos5l_antennanp
X_2359_ _2359_/X Tile_X0Y5_W1END[2] Tile_X0Y5_WW4END[2] Tile_X0Y5_WW4END[8] Tile_X0Y5_W6END[10]
+ _1466_/Q _1465_/Q VPWR VGND sg13cmos5l_mux4_1
XFILLER_151_38 VPWR VGND sg13cmos5l_decap_8
XANTENNA__0746__D Tile_X0Y2_FrameData[28] VPWR VGND sg13cmos5l_antennanp
XANTENNA__1979__X Tile_X0Y5_E2BEGb[0] VPWR VGND sg13cmos5l_antennanp
XFILLER_231_71 VPWR VGND sg13cmos5l_decap_8
XANTENNA__0481__D Tile_X0Y1_FrameData[21] VPWR VGND sg13cmos5l_antennanp
XFILLER_60_35 VPWR VGND sg13cmos5l_fill_1
XFILLER_176_24 VPWR VGND sg13cmos5l_fill_2
XFILLER_60_57 VPWR VGND sg13cmos5l_fill_1
XFILLER_176_57 VPWR VGND sg13cmos5l_fill_2
XFILLER_180_223 VPWR VGND sg13cmos5l_fill_1
XFILLER_109_51 VPWR VGND sg13cmos5l_fill_2
XFILLER_69_22 VPWR VGND sg13cmos5l_decap_8
XFILLER_109_95 VPWR VGND sg13cmos5l_fill_2
XFILLER_256_90 VPWR VGND sg13cmos5l_fill_1
XANTENNA__1890__A Tile_X0Y1_FrameData[3] VPWR VGND sg13cmos5l_antennanp
XFILLER_133_172 VPWR VGND sg13cmos5l_decap_8
XANTENNA__2125__A0 Tile_X0Y1_W2MID[3] VPWR VGND sg13cmos5l_antennanp
XFILLER_294_146 VPWR VGND sg13cmos5l_decap_8
XANTENNA__1251__GATE Tile_X0Y5_FrameStrobe[6] VPWR VGND sg13cmos5l_antennanp
XANTENNA__2676__A1 Tile_X0Y5_W6END[5] VPWR VGND sg13cmos5l_antennanp
XFILLER_125_72 VPWR VGND sg13cmos5l_decap_8
XFILLER_197_0 VPWR VGND sg13cmos5l_fill_2
XFILLER_85_43 VPWR VGND sg13cmos5l_decap_8
XFILLER_235_202 VPWR VGND sg13cmos5l_fill_2
XFILLER_47_134 VPWR VGND sg13cmos5l_decap_8
XANTENNA__0656__D Tile_X0Y2_FrameData[22] VPWR VGND sg13cmos5l_antennanp
XANTENNA__1889__X Tile_X0Y1_FrameData_O[2] VPWR VGND sg13cmos5l_antennanp
XANTENNA__1266__GATE Tile_X0Y5_FrameStrobe[0] VPWR VGND sg13cmos5l_antennanp
XANTENNA__2428__A1 AXIL_S_SOC_AWPROT1 VPWR VGND sg13cmos5l_antennanp
XFILLER_141_60 VPWR VGND sg13cmos5l_fill_2
XFILLER_211_19 VPWR VGND sg13cmos5l_decap_8
XFILLER_62_115 VPWR VGND sg13cmos5l_decap_8
XFILLER_70_170 VPWR VGND sg13cmos5l_fill_2
XFILLER_203_165 VPWR VGND sg13cmos5l_decap_4
XFILLER_349_158 VPWR VGND sg13cmos5l_decap_8
XANTENNA__0391__D Tile_X0Y1_FrameData[15] VPWR VGND sg13cmos5l_antennanp
XANTENNA__1487__D Tile_X0Y5_FrameData[1] VPWR VGND sg13cmos5l_antennanp
XANTENNA__2600__A1 Tile_X0Y5_W2END[6] VPWR VGND sg13cmos5l_antennanp
X_1730_ Tile_X0Y0_E2BEG[2] _2167_/X VPWR VGND sg13cmos5l_buf_1
XFILLER_79_6 VPWR VGND sg13cmos5l_decap_8
X_1661_ Tile_X0Y0_FrameData_O[1] Tile_X0Y0_FrameData[1] VPWR VGND sg13cmos5l_buf_1
XANTENNA__1204__GATE Tile_X0Y5_FrameStrobe[5] VPWR VGND sg13cmos5l_antennanp
X_0612_ _0612_/Q Tile_X0Y2_FrameData[2] VGND VPWR Tile_X0Y5_FrameStrobe[1] latch
X_1592_ Tile_X0Y2_EE4BEG[5] _2422_/X VPWR VGND sg13cmos5l_buf_1
XANTENNA__0460__GATE Tile_X0Y5_FrameStrobe[4] VPWR VGND sg13cmos5l_antennanp
XFILLER_124_172 VPWR VGND sg13cmos5l_decap_4
X_0543_ _0543_/Q Tile_X0Y1_FrameData[23] VGND VPWR Tile_X0Y5_FrameStrobe[7] latch
XANTENNA__2116__A0 Tile_X0Y2_W2MID[2] VPWR VGND sg13cmos5l_antennanp
XFILLER_285_113 VPWR VGND sg13cmos5l_decap_8
X_0474_ _0474_/Q Tile_X0Y1_FrameData[28] VGND VPWR Tile_X0Y5_FrameStrobe[5] latch
XFILLER_316_82 VPWR VGND sg13cmos5l_decap_8
XANTENNA__1219__GATE Tile_X0Y5_FrameStrobe[5] VPWR VGND sg13cmos5l_antennanp
XANTENNA__2667__A1 Tile_X0Y4_WW4END[15] VPWR VGND sg13cmos5l_antennanp
XFILLER_252_59 VPWR VGND sg13cmos5l_decap_4
X_2213_ _2213_/X Tile_X0Y1_W1END[0] Tile_X0Y1_W6END[4] _2361_/X _2337_/X _0550_/Q
+ _0549_/Q VPWR VGND sg13cmos5l_mux4_1
XFILLER_226_202 VPWR VGND sg13cmos5l_decap_4
X_2144_ _2144_/X Tile_X0Y0_W1END[3] Tile_X0Y0_W6END[7] _2217_/X _2212_/X _0304_/Q
+ _0303_/Q VPWR VGND sg13cmos5l_mux4_1
XANTENNA__0475__GATE Tile_X0Y5_FrameStrobe[5] VPWR VGND sg13cmos5l_antennanp
XANTENNA__0566__D Tile_X0Y2_FrameData[16] VPWR VGND sg13cmos5l_antennanp
XANTENNA__1799__X Tile_X0Y4_E2BEGb[2] VPWR VGND sg13cmos5l_antennanp
XFILLER_38_178 VPWR VGND sg13cmos5l_decap_8
XFILLER_332_92 VPWR VGND sg13cmos5l_fill_1
XANTENNA__2419__A1 AXIL_S_SOC_AWADDR2 VPWR VGND sg13cmos5l_antennanp
X_2075_ Tile_X0Y5_S4BEG[8] _2075_/A VPWR VGND sg13cmos5l_buf_1
X_1026_ _1026_/Q Tile_X0Y3_FrameData[20] VGND VPWR Tile_X0Y5_FrameStrobe[7] latch
XFILLER_14_17 VPWR VGND sg13cmos5l_fill_1
XFILLER_201_52 VPWR VGND sg13cmos5l_decap_8
XFILLER_14_39 VPWR VGND sg13cmos5l_fill_2
XFILLER_277_23 VPWR VGND sg13cmos5l_decap_8
XANTENNA__1397__D Tile_X0Y5_FrameData[27] VPWR VGND sg13cmos5l_antennanp
XFILLER_355_128 VPWR VGND sg13cmos5l_decap_8
XANTENNA__0413__GATE Tile_X0Y5_FrameStrobe[3] VPWR VGND sg13cmos5l_antennanp
X_1928_ Tile_X0Y1_EE4BEG[9] _2318_/X VPWR VGND sg13cmos5l_buf_1
XFILLER_107_128 VPWR VGND sg13cmos5l_decap_8
XFILLER_162_201 VPWR VGND sg13cmos5l_decap_8
X_1859_ Tile_X0Y4_FrameData_O[26] Tile_X0Y4_FrameData[26] VPWR VGND sg13cmos5l_buf_1
XFILLER_146_16 VPWR VGND sg13cmos5l_fill_1
XFILLER_146_27 VPWR VGND sg13cmos5l_decap_8
XFILLER_293_11 VPWR VGND sg13cmos5l_fill_2
XANTENNA__2355__A0 Tile_X0Y5_W1END[1] VPWR VGND sg13cmos5l_antennanp
XFILLER_100_9 VPWR VGND sg13cmos5l_fill_2
XFILLER_293_77 VPWR VGND sg13cmos5l_decap_8
XANTENNA__0428__GATE Tile_X0Y5_FrameStrobe[3] VPWR VGND sg13cmos5l_antennanp
XFILLER_115_161 VPWR VGND sg13cmos5l_decap_8
XFILLER_276_102 VPWR VGND sg13cmos5l_fill_2
XANTENNA__2107__A0 Tile_X0Y3_W2MID[1] VPWR VGND sg13cmos5l_antennanp
XANTENNA__2370__A3 Tile_X0Y0_S4END[5] VPWR VGND sg13cmos5l_antennanp
XFILLER_130_153 VPWR VGND sg13cmos5l_decap_8
XFILLER_162_26 VPWR VGND sg13cmos5l_decap_8
XFILLER_226_93 VPWR VGND sg13cmos5l_decap_8
XFILLER_276_168 VPWR VGND sg13cmos5l_decap_8
XFILLER_183_6 VPWR VGND sg13cmos5l_fill_2
XFILLER_29_123 VPWR VGND sg13cmos5l_fill_1
XANTENNA__0476__D Tile_X0Y1_FrameData[26] VPWR VGND sg13cmos5l_antennanp
XFILLER_242_92 VPWR VGND sg13cmos5l_decap_4
XFILLER_29_156 VPWR VGND sg13cmos5l_fill_1
XFILLER_189_109 VPWR VGND sg13cmos5l_fill_2
XFILLER_111_30 VPWR VGND sg13cmos5l_decap_8
XANTENNA__2046__A Tile_X0Y5_FrameData[31] VPWR VGND sg13cmos5l_antennanp
XFILLER_111_63 VPWR VGND sg13cmos5l_decap_8
XANTENNA__2830__A1 Tile_X0Y4_W2END[6] VPWR VGND sg13cmos5l_antennanp
XFILLER_197_153 VPWR VGND sg13cmos5l_fill_1
XFILLER_197_175 VPWR VGND sg13cmos5l_fill_2
XFILLER_346_117 VPWR VGND sg13cmos5l_decap_8
XANTENNA__1100__D Tile_X0Y4_FrameData[26] VPWR VGND sg13cmos5l_antennanp
XFILLER_200_157 VPWR VGND sg13cmos5l_decap_4
XFILLER_200_168 VPWR VGND sg13cmos5l_decap_8
XFILLER_354_150 VPWR VGND sg13cmos5l_decap_8
XFILLER_112_0 VPWR VGND sg13cmos5l_fill_2
XFILLER_153_223 VPWR VGND sg13cmos5l_fill_1
XFILLER_299_216 VPWR VGND sg13cmos5l_fill_2
XANTENNA__2346__A0 Tile_X0Y2_W1END[2] VPWR VGND sg13cmos5l_antennanp
XFILLER_302_209 VPWR VGND sg13cmos5l_decap_4
XFILLER_106_183 VPWR VGND sg13cmos5l_decap_4
XFILLER_206_19 VPWR VGND sg13cmos5l_decap_8
XFILLER_96_20 VPWR VGND sg13cmos5l_fill_1
XANTENNA__1190__GATE Tile_X0Y5_FrameStrobe[4] VPWR VGND sg13cmos5l_antennanp
XANTENNA__2361__A3 Tile_X0Y0_S4END[4] VPWR VGND sg13cmos5l_antennanp
XFILLER_353_69 VPWR VGND sg13cmos5l_decap_8
XFILLER_353_58 VPWR VGND sg13cmos5l_fill_1
XFILLER_353_47 VPWR VGND sg13cmos5l_decap_8
XFILLER_121_175 VPWR VGND sg13cmos5l_fill_2
XFILLER_222_18 VPWR VGND sg13cmos5l_decap_8
XANTENNA__0386__D Tile_X0Y1_FrameData[20] VPWR VGND sg13cmos5l_antennanp
XFILLER_275_190 VPWR VGND sg13cmos5l_decap_8
X_0190_ _0190_/Q Tile_X0Y0_FrameData[8] VGND VPWR Tile_X0Y5_FrameStrobe[3] latch
XFILLER_302_40 VPWR VGND sg13cmos5l_fill_1
XFILLER_290_193 VPWR VGND sg13cmos5l_fill_1
XFILLER_188_120 VPWR VGND sg13cmos5l_fill_2
XFILLER_50_118 VPWR VGND sg13cmos5l_fill_1
XFILLER_302_95 VPWR VGND sg13cmos5l_fill_2
XANTENNA__2821__A1 Tile_X0Y5_N4END[1] VPWR VGND sg13cmos5l_antennanp
X_2831_ _2831_/X Tile_X0Y4_W2MID[5] Tile_X0Y4_W2END[5] Tile_X0Y4_W6END[10] _2710_/X
+ _1120_/Q _1119_/Q VPWR VGND sg13cmos5l_mux4_1
XANTENNA__1010__D Tile_X0Y3_FrameData[4] VPWR VGND sg13cmos5l_antennanp
X_2762_ _2762_/X AXIL_S_SOC_ARPROT0 _2818_/X _2806_/X _2826_/X _1378_/Q _1377_/Q VPWR
+ VGND sg13cmos5l_mux4_1
XANTENNA__1143__GATE Tile_X0Y5_FrameStrobe[3] VPWR VGND sg13cmos5l_antennanp
X_1713_ Tile_X0Y0_E6BEG[5] _2202_/X VPWR VGND sg13cmos5l_buf_1
XFILLER_345_150 VPWR VGND sg13cmos5l_fill_2
XFILLER_144_223 VPWR VGND sg13cmos5l_fill_1
X_2693_ _2693_/X _2676_/X Tile_X0Y5_N4END[5] _2675_/X _0071_/X _1068_/Q _1067_/Q VPWR
+ VGND sg13cmos5l_mux4_1
XFILLER_6_51 VPWR VGND sg13cmos5l_fill_2
X_1644_ Tile_X0Y0_FrameStrobe_O[4] Tile_X0Y5_FrameStrobe[4] VPWR VGND sg13cmos5l_buf_1
XFILLER_6_62 VPWR VGND sg13cmos5l_fill_2
XFILLER_327_81 VPWR VGND sg13cmos5l_fill_1
XFILLER_263_14 VPWR VGND sg13cmos5l_decap_8
X_1575_ Tile_X0Y3_FrameData_O[21] Tile_X0Y3_FrameData[21] VPWR VGND sg13cmos5l_buf_1
XANTENNA__1158__GATE Tile_X0Y5_FrameStrobe[3] VPWR VGND sg13cmos5l_antennanp
XFILLER_112_120 VPWR VGND sg13cmos5l_decap_8
X_0526_ _0526_/Q Tile_X0Y1_FrameData[8] VGND VPWR Tile_X0Y5_FrameStrobe[6] latch
XFILLER_258_157 VPWR VGND sg13cmos5l_decap_8
X_0457_ _0457_/Q Tile_X0Y1_FrameData[13] VGND VPWR Tile_X0Y5_FrameStrobe[4] latch
XFILLER_343_91 VPWR VGND sg13cmos5l_decap_8
XANTENNA__0296__D Tile_X0Y0_FrameData[30] VPWR VGND sg13cmos5l_antennanp
XFILLER_266_190 VPWR VGND sg13cmos5l_decap_8
XFILLER_273_149 VPWR VGND sg13cmos5l_decap_8
X_0388_ _0388_/Q Tile_X0Y1_FrameData[18] VGND VPWR Tile_X0Y5_FrameStrobe[2] latch
X_2127_ AXIL_S_SOC_RDATA21 Tile_X0Y1_W2MID[5] Tile_X0Y1_W2END[5] Tile_X0Y1_W6END[5]
+ _2378_/X _0372_/Q _0371_/Q VPWR VGND sg13cmos5l_mux4_1
XFILLER_212_62 VPWR VGND sg13cmos5l_fill_1
X_2058_ Tile_X0Y5_S2BEG[7] _2780_/X VPWR VGND sg13cmos5l_buf_1
X_1009_ _1009_/Q Tile_X0Y3_FrameData[5] VGND VPWR Tile_X0Y5_FrameStrobe[6] latch
XFILLER_41_129 VPWR VGND sg13cmos5l_decap_4
XFILLER_288_55 VPWR VGND sg13cmos5l_decap_8
XFILLER_288_66 VPWR VGND sg13cmos5l_fill_2
XANTENNA__0352__GATE Tile_X0Y5_FrameStrobe[1] VPWR VGND sg13cmos5l_antennanp
XFILLER_179_175 VPWR VGND sg13cmos5l_fill_1
XFILLER_179_186 VPWR VGND sg13cmos5l_fill_1
XFILLER_179_197 VPWR VGND sg13cmos5l_fill_2
XFILLER_194_112 VPWR VGND sg13cmos5l_decap_8
XFILLER_288_88 VPWR VGND sg13cmos5l_decap_8
XANTENNA__0982__GATE Tile_X0Y5_FrameStrobe[5] VPWR VGND sg13cmos5l_antennanp
XFILLER_157_15 VPWR VGND sg13cmos5l_decap_8
XFILLER_336_161 VPWR VGND sg13cmos5l_decap_8
XANTENNA__1992__X Tile_X0Y5_E6BEG[5] VPWR VGND sg13cmos5l_antennanp
XFILLER_135_212 VPWR VGND sg13cmos5l_fill_2
XFILLER_351_120 VPWR VGND sg13cmos5l_decap_8
XANTENNA__0367__GATE Tile_X0Y5_FrameStrobe[1] VPWR VGND sg13cmos5l_antennanp
XFILLER_203_7 VPWR VGND sg13cmos5l_fill_1
XANTENNA__0997__GATE Tile_X0Y5_FrameStrobe[6] VPWR VGND sg13cmos5l_antennanp
XFILLER_173_69 VPWR VGND sg13cmos5l_decap_8
XFILLER_249_113 VPWR VGND sg13cmos5l_fill_1
XFILLER_106_52 VPWR VGND sg13cmos5l_decap_8
XFILLER_323_17 VPWR VGND sg13cmos5l_fill_2
XANTENNA__0920__GATE Tile_X0Y5_FrameStrobe[4] VPWR VGND sg13cmos5l_antennanp
XANTENNA__2500__A0 Tile_X0Y4_W2MID[2] VPWR VGND sg13cmos5l_antennanp
XANTENNA__0305__GATE Tile_X0Y5_FrameStrobe[7] VPWR VGND sg13cmos5l_antennanp
XFILLER_122_62 VPWR VGND sg13cmos5l_decap_8
XFILLER_122_73 VPWR VGND sg13cmos5l_fill_2
XFILLER_82_22 VPWR VGND sg13cmos5l_decap_8
XANTENNA__0934__D Tile_X0Y3_FrameData[16] VPWR VGND sg13cmos5l_antennanp
XANTENNA__0935__GATE Tile_X0Y5_FrameStrobe[4] VPWR VGND sg13cmos5l_antennanp
XFILLER_32_118 VPWR VGND sg13cmos5l_decap_4
XANTENNA__2803__A1 Tile_X0Y1_WW4END[8] VPWR VGND sg13cmos5l_antennanp
XFILLER_198_77 VPWR VGND sg13cmos5l_decap_8
XFILLER_40_151 VPWR VGND sg13cmos5l_fill_2
XANTENNA__2063__X Tile_X0Y5_S2BEGb[4] VPWR VGND sg13cmos5l_antennanp
XFILLER_327_0 VPWR VGND sg13cmos5l_decap_4
XANTENNA__2567__A0 Tile_X0Y2_W1END[1] VPWR VGND sg13cmos5l_antennanp
XFILLER_185_189 VPWR VGND sg13cmos5l_fill_2
XFILLER_126_223 VPWR VGND sg13cmos5l_fill_1
XFILLER_342_120 VPWR VGND sg13cmos5l_decap_8
XANTENNA__2319__A0 AXIL_S_SOC_WDATA6 VPWR VGND sg13cmos5l_antennanp
XANTENNA__2582__A3 Tile_X0Y0_S4END[14] VPWR VGND sg13cmos5l_antennanp
XFILLER_147_92 VPWR VGND sg13cmos5l_decap_8
X_1360_ _1360_/Q Tile_X0Y5_FrameData[0] VGND VPWR Tile_X0Y5_FrameStrobe[2] latch
XFILLER_233_28 VPWR VGND sg13cmos5l_fill_1
X_0311_ _0311_/Q Tile_X0Y0_FrameData[31] VGND VPWR Tile_X0Y5_FrameStrobe[0] latch
X_1291_ _1291_/Q Tile_X0Y5_FrameData[5] VGND VPWR Tile_X0Y5_FrameStrobe[0] latch
X_0242_ _0242_/Q Tile_X0Y0_FrameData[20] VGND VPWR Tile_X0Y5_FrameStrobe[5] latch
XANTENNA__1005__D Tile_X0Y3_FrameData[9] VPWR VGND sg13cmos5l_antennanp
X_0173_ _0173_/Q Tile_X0Y0_FrameData[25] VGND VPWR Tile_X0Y5_FrameStrobe[3] latch
XFILLER_313_61 VPWR VGND sg13cmos5l_decap_8
XANTENNA__0844__D Tile_X0Y3_FrameData[10] VPWR VGND sg13cmos5l_antennanp
XFILLER_176_101 VPWR VGND sg13cmos5l_fill_2
XANTENNA__1082__GATE Tile_X0Y5_FrameStrobe[1] VPWR VGND sg13cmos5l_antennanp
X_2814_ _2814_/X Tile_X0Y5_N1END[0] Tile_X0Y5_N4END[0] _2793_/X _0032_/X _1304_/Q
+ _1303_/Q VPWR VGND sg13cmos5l_mux4_1
XFILLER_117_201 VPWR VGND sg13cmos5l_decap_4
XFILLER_176_167 VPWR VGND sg13cmos5l_decap_8
XFILLER_325_109 VPWR VGND sg13cmos5l_fill_2
X_2745_ _2745_/X AXIL_S_SOC_ARVALID AXIL_S_SOC_RREADY _2802_/X _2828_/X _1412_/Q _1411_/Q
+ VPWR VGND sg13cmos5l_mux4_1
XANTENNA__2573__A3 Tile_X0Y0_S4END[15] VPWR VGND sg13cmos5l_antennanp
X_2676_ _2676_/X Tile_X0Y5_W1END[1] Tile_X0Y5_W6END[5] _2809_/X _2790_/X _1494_/Q
+ _1493_/Q VPWR VGND sg13cmos5l_mux4_1
XFILLER_333_120 VPWR VGND sg13cmos5l_decap_4
XANTENNA__1097__GATE Tile_X0Y5_FrameStrobe[2] VPWR VGND sg13cmos5l_antennanp
X_1627_ Tile_X0Y0_N2BEGb[7] _2264_/X VPWR VGND sg13cmos5l_buf_1
XANTENNA__2730__A0 AXIL_S_SOC_ARPROT0 VPWR VGND sg13cmos5l_antennanp
X_1558_ Tile_X0Y3_FrameData_O[4] Tile_X0Y3_FrameData[4] VPWR VGND sg13cmos5l_buf_1
XANTENNA__1020__GATE Tile_X0Y5_FrameStrobe[7] VPWR VGND sg13cmos5l_antennanp
XFILLER_100_134 VPWR VGND sg13cmos5l_fill_1
X_1489_ _1489_/Q Tile_X0Y5_FrameData[31] VGND VPWR Tile_X0Y5_FrameStrobe[7] latch
X_0509_ _0509_/Q Tile_X0Y1_FrameData[25] VGND VPWR Tile_X0Y5_FrameStrobe[6] latch
XFILLER_290_78 VPWR VGND sg13cmos5l_decap_4
XFILLER_54_221 VPWR VGND sg13cmos5l_fill_2
XFILLER_36_15 VPWR VGND sg13cmos5l_fill_1
XFILLER_299_21 VPWR VGND sg13cmos5l_decap_8
XANTENNA__0754__D Tile_X0Y2_FrameData[20] VPWR VGND sg13cmos5l_antennanp
XANTENNA__1035__GATE Tile_X0Y5_FrameStrobe[0] VPWR VGND sg13cmos5l_antennanp
XANTENNA__1987__X Tile_X0Y5_E6BEG[0] VPWR VGND sg13cmos5l_antennanp
XFILLER_299_54 VPWR VGND sg13cmos5l_fill_2
XANTENNA__2797__A0 Tile_X0Y5_N2MID[7] VPWR VGND sg13cmos5l_antennanp
XANTENNA__0291__GATE Tile_X0Y5_FrameStrobe[6] VPWR VGND sg13cmos5l_antennanp
XANTENNA__2261__A2 Tile_X0Y2_W6END[1] VPWR VGND sg13cmos5l_antennanp
XFILLER_167_101 VPWR VGND sg13cmos5l_decap_8
XFILLER_356_201 VPWR VGND sg13cmos5l_decap_8
XFILLER_168_36 VPWR VGND sg13cmos5l_decap_8
XFILLER_356_223 VPWR VGND sg13cmos5l_fill_1
XFILLER_320_7 VPWR VGND sg13cmos5l_decap_4
XANTENNA__2549__A0 AXIL_S_SOC_ARADDR0 VPWR VGND sg13cmos5l_antennanp
XFILLER_167_167 VPWR VGND sg13cmos5l_decap_8
XFILLER_182_104 VPWR VGND sg13cmos5l_decap_8
XFILLER_324_153 VPWR VGND sg13cmos5l_fill_1
XFILLER_117_40 VPWR VGND sg13cmos5l_fill_2
XFILLER_190_192 VPWR VGND sg13cmos5l_decap_8
XANTENNA__0929__D Tile_X0Y3_FrameData[21] VPWR VGND sg13cmos5l_antennanp
XANTENNA__2721__A0 Tile_X0Y5_N1END[0] VPWR VGND sg13cmos5l_antennanp
XFILLER_292_200 VPWR VGND sg13cmos5l_decap_4
XFILLER_77_77 VPWR VGND sg13cmos5l_decap_8
XANTENNA__0244__GATE Tile_X0Y5_FrameStrobe[5] VPWR VGND sg13cmos5l_antennanp
XANTENNA__2058__X Tile_X0Y5_S2BEG[7] VPWR VGND sg13cmos5l_antennanp
XFILLER_93_10 VPWR VGND sg13cmos5l_fill_2
XFILLER_350_48 VPWR VGND sg13cmos5l_decap_8
XFILLER_350_37 VPWR VGND sg13cmos5l_fill_1
XANTENNA__0874__GATE Tile_X0Y5_FrameStrobe[2] VPWR VGND sg13cmos5l_antennanp
XANTENNA__0664__D Tile_X0Y2_FrameData[14] VPWR VGND sg13cmos5l_antennanp
XANTENNA__1897__X Tile_X0Y1_FrameData_O[10] VPWR VGND sg13cmos5l_antennanp
XANTENNA__0259__GATE Tile_X0Y5_FrameStrobe[5] VPWR VGND sg13cmos5l_antennanp
XFILLER_359_24 VPWR VGND sg13cmos5l_decap_4
XANTENNA__0889__GATE Tile_X0Y5_FrameStrobe[3] VPWR VGND sg13cmos5l_antennanp
XANTENNA__2252__A2 Tile_X0Y1_W6END[6] VPWR VGND sg13cmos5l_antennanp
XFILLER_359_57 VPWR VGND sg13cmos5l_decap_8
X_0860_ _0860_/Q Tile_X0Y3_FrameData[26] VGND VPWR Tile_X0Y5_FrameStrobe[2] latch
XFILLER_9_144 VPWR VGND sg13cmos5l_fill_2
XANTENNA__0812__GATE Tile_X0Y5_FrameStrobe[0] VPWR VGND sg13cmos5l_antennanp
XANTENNA__1495__D Tile_X0Y5_FrameData[25] VPWR VGND sg13cmos5l_antennanp
XFILLER_173_137 VPWR VGND sg13cmos5l_decap_8
X_0791_ _0791_/Q Tile_X0Y2_FrameData[31] VGND VPWR Tile_X0Y5_FrameStrobe[0] latch
XFILLER_362_215 VPWR VGND sg13cmos5l_fill_2
XANTENNA__2555__A3 Tile_X0Y3_W6END[5] VPWR VGND sg13cmos5l_antennanp
X_2530_ _2530_/X AXIL_S_SOC_ARADDR5 AXIL_S_SOC_ARADDR9 _2576_/X _2591_/X _0944_/Q
+ _0943_/Q VPWR VGND sg13cmos5l_mux4_1
XFILLER_114_204 VPWR VGND sg13cmos5l_fill_2
XFILLER_181_170 VPWR VGND sg13cmos5l_decap_8
X_2461_ _2461_/X Tile_X0Y1_W1END[2] Tile_X0Y1_W6END[10] _2353_/X _2339_/X _0414_/Q
+ _0413_/Q VPWR VGND sg13cmos5l_mux4_1
XFILLER_315_175 VPWR VGND sg13cmos5l_decap_8
XFILLER_244_16 VPWR VGND sg13cmos5l_fill_1
X_1412_ _1412_/Q Tile_X0Y5_FrameData[12] VGND VPWR Tile_X0Y5_FrameStrobe[4] latch
XFILLER_330_123 VPWR VGND sg13cmos5l_fill_2
XANTENNA__0827__GATE Tile_X0Y5_FrameStrobe[1] VPWR VGND sg13cmos5l_antennanp
XANTENNA__0839__D Tile_X0Y3_FrameData[15] VPWR VGND sg13cmos5l_antennanp
X_2392_ _2392_/X Tile_X0Y3_W2MID[2] Tile_X0Y3_W2END[2] Tile_X0Y3_W6END[2] _2594_/X
+ _1012_/Q _1011_/Q VPWR VGND sg13cmos5l_mux4_1
XFILLER_330_167 VPWR VGND sg13cmos5l_decap_8
X_1343_ _1343_/Q Tile_X0Y5_FrameData[17] VGND VPWR Tile_X0Y5_FrameStrobe[2] latch
XFILLER_95_132 VPWR VGND sg13cmos5l_decap_8
XFILLER_95_110 VPWR VGND sg13cmos5l_decap_8
XFILLER_3_41 VPWR VGND sg13cmos5l_fill_1
X_1274_ _1274_/Q Tile_X0Y5_FrameData[22] VGND VPWR Tile_X0Y5_FrameStrobe[0] latch
XFILLER_324_71 VPWR VGND sg13cmos5l_decap_8
X_0225_ _0225_/Q Tile_X0Y0_FrameData[5] VGND VPWR Tile_X0Y5_FrameStrobe[4] latch
XFILLER_260_59 VPWR VGND sg13cmos5l_decap_8
XANTENNA__0574__D Tile_X0Y2_FrameData[8] VPWR VGND sg13cmos5l_antennanp
XANTENNA__2491__A2 Tile_X0Y1_W6END[9] VPWR VGND sg13cmos5l_antennanp
X_0156_ _0156_/Q Tile_X0Y0_FrameData[10] VGND VPWR Tile_X0Y5_FrameStrobe[2] latch
XANTENNA__1600__X Tile_X0Y2_EE4BEG[13] VPWR VGND sg13cmos5l_antennanp
X_0087_ _0087_/Q Tile_X0Y0_FrameData[15] VGND VPWR Tile_X0Y5_FrameStrobe[0] latch
XANTENNA__2779__A0 Tile_X0Y5_W1END[2] VPWR VGND sg13cmos5l_antennanp
XFILLER_149_112 VPWR VGND sg13cmos5l_decap_8
XANTENNA__2243__A2 Tile_X0Y0_S2MID[2] VPWR VGND sg13cmos5l_antennanp
XFILLER_269_79 VPWR VGND sg13cmos5l_decap_8
X_0989_ _0989_/Q Tile_X0Y3_FrameData[25] VGND VPWR Tile_X0Y5_FrameStrobe[6] latch
X_2728_ _2728_/X AXIL_S_SOC_ARPROT1 AXIL_S_SOC_ARVALID _2828_/X _2800_/X _1446_/Q
+ _1445_/Q VPWR VGND sg13cmos5l_mux4_1
X_2659_ _2659_/X AXIL_S_SOC_WSTRB2 _2705_/X _2704_/X _2682_/X _1136_/Q _1135_/Q VPWR
+ VGND sg13cmos5l_mux4_1
XANTENNA__0749__D Tile_X0Y2_FrameData[25] VPWR VGND sg13cmos5l_antennanp
XFILLER_274_211 VPWR VGND sg13cmos5l_fill_1
XFILLER_270_7 VPWR VGND sg13cmos5l_decap_8
XFILLER_227_171 VPWR VGND sg13cmos5l_decap_8
XFILLER_27_221 VPWR VGND sg13cmos5l_fill_2
XANTENNA__0484__D Tile_X0Y1_FrameData[18] VPWR VGND sg13cmos5l_antennanp
XFILLER_320_18 VPWR VGND sg13cmos5l_fill_2
XFILLER_187_207 VPWR VGND sg13cmos5l_fill_1
XFILLER_250_92 VPWR VGND sg13cmos5l_decap_8
XFILLER_242_196 VPWR VGND sg13cmos5l_fill_2
XANTENNA__2234__A2 Tile_X0Y0_S1END[2] VPWR VGND sg13cmos5l_antennanp
XFILLER_329_223 VPWR VGND sg13cmos5l_fill_1
XANTENNA__1893__A Tile_X0Y1_FrameData[6] VPWR VGND sg13cmos5l_antennanp
XFILLER_128_72 VPWR VGND sg13cmos5l_decap_8
XFILLER_170_118 VPWR VGND sg13cmos5l_decap_8
XFILLER_5_0 VPWR VGND sg13cmos5l_fill_1
XFILLER_312_123 VPWR VGND sg13cmos5l_fill_1
XFILLER_312_112 VPWR VGND sg13cmos5l_decap_8
XFILLER_88_98 VPWR VGND sg13cmos5l_decap_8
XANTENNA__0659__D Tile_X0Y2_FrameData[19] VPWR VGND sg13cmos5l_antennanp
XANTENNA__0183__GATE Tile_X0Y5_FrameStrobe[3] VPWR VGND sg13cmos5l_antennanp
XANTENNA__2170__A1 AXIL_S_SOC_WDATA29 VPWR VGND sg13cmos5l_antennanp
XFILLER_265_211 VPWR VGND sg13cmos5l_fill_1
XFILLER_77_165 VPWR VGND sg13cmos5l_decap_8
XFILLER_37_91 VPWR VGND sg13cmos5l_fill_1
XANTENNA__0198__GATE Tile_X0Y5_FrameStrobe[3] VPWR VGND sg13cmos5l_antennanp
XANTENNA__0394__D Tile_X0Y1_FrameData[12] VPWR VGND sg13cmos5l_antennanp
XFILLER_233_163 VPWR VGND sg13cmos5l_decap_8
XANTENNA__2225__A2 Tile_X0Y0_S1END[1] VPWR VGND sg13cmos5l_antennanp
XFILLER_239_16 VPWR VGND sg13cmos5l_fill_2
X_1961_ Tile_X0Y1_E2BEG[6] _2299_/X VPWR VGND sg13cmos5l_buf_1
XFILLER_310_84 VPWR VGND sg13cmos5l_decap_8
XANTENNA__0121__GATE Tile_X0Y5_FrameStrobe[1] VPWR VGND sg13cmos5l_antennanp
XANTENNA__0751__GATE Tile_X0Y5_FrameStrobe[6] VPWR VGND sg13cmos5l_antennanp
XFILLER_146_104 VPWR VGND sg13cmos5l_fill_2
X_1892_ Tile_X0Y1_FrameData_O[5] Tile_X0Y1_FrameData[5] VPWR VGND sg13cmos5l_buf_1
X_0912_ _0912_/Q Tile_X0Y3_FrameData[6] VGND VPWR Tile_X0Y5_FrameStrobe[3] latch
X_0843_ _0843_/Q Tile_X0Y3_FrameData[11] VGND VPWR Tile_X0Y5_FrameStrobe[1] latch
XFILLER_319_82 VPWR VGND sg13cmos5l_decap_8
XANTENNA__0136__GATE Tile_X0Y5_FrameStrobe[2] VPWR VGND sg13cmos5l_antennanp
X_2513_ _2513_/X AXIL_S_SOC_ARADDR2 AXIL_S_SOC_ARADDR4 _2592_/X _2593_/X _0978_/Q
+ _0977_/Q VPWR VGND sg13cmos5l_mux4_1
X_0774_ _0774_/Q Tile_X0Y2_FrameData[0] VGND VPWR Tile_X0Y5_FrameStrobe[6] latch
XANTENNA__0766__GATE Tile_X0Y5_FrameStrobe[6] VPWR VGND sg13cmos5l_antennanp
X_2444_ _2444_/X AXIL_S_SOC_AWADDR3 _2480_/X _2479_/X _2488_/X _0660_/Q _0659_/Q VPWR
+ VGND sg13cmos5l_mux4_1
XFILLER_335_70 VPWR VGND sg13cmos5l_decap_8
XANTENNA__0569__D Tile_X0Y2_FrameData[13] VPWR VGND sg13cmos5l_antennanp
X_2375_ _2375_/X _2253_/X _2386_/X _2385_/X Tile_X0Y0_S2MID[2] _0330_/Q _0329_/Q VPWR
+ VGND sg13cmos5l_mux4_1
XFILLER_68_121 VPWR VGND sg13cmos5l_decap_8
XANTENNA__2161__A1 Tile_X0Y0_S1END[0] VPWR VGND sg13cmos5l_antennanp
XFILLER_256_222 VPWR VGND sg13cmos5l_fill_2
X_1326_ _1326_/Q Tile_X0Y5_FrameData[2] VGND VPWR Tile_X0Y5_FrameStrobe[1] latch
X_1257_ _1257_/Q Tile_X0Y4_FrameData[29] VGND VPWR Tile_X0Y5_FrameStrobe[7] latch
XFILLER_83_146 VPWR VGND sg13cmos5l_decap_8
XFILLER_351_80 VPWR VGND sg13cmos5l_decap_4
X_1188_ _1188_/Q Tile_X0Y4_FrameData[2] VGND VPWR Tile_X0Y5_FrameStrobe[4] latch
X_0208_ _0208_/Q Tile_X0Y0_FrameData[22] VGND VPWR Tile_X0Y5_FrameStrobe[4] latch
XANTENNA__0704__GATE Tile_X0Y5_FrameStrobe[4] VPWR VGND sg13cmos5l_antennanp
X_0139_ _0139_/Q Tile_X0Y0_FrameData[27] VGND VPWR Tile_X0Y5_FrameStrobe[2] latch
XFILLER_220_84 VPWR VGND sg13cmos5l_decap_8
XANTENNA__0719__GATE Tile_X0Y5_FrameStrobe[5] VPWR VGND sg13cmos5l_antennanp
XFILLER_149_27 VPWR VGND sg13cmos5l_decap_8
XFILLER_165_15 VPWR VGND sg13cmos5l_fill_2
XFILLER_315_29 VPWR VGND sg13cmos5l_fill_1
XANTENNA__0479__D Tile_X0Y1_FrameData[23] VPWR VGND sg13cmos5l_antennanp
XFILLER_160_184 VPWR VGND sg13cmos5l_fill_1
XFILLER_58_24 VPWR VGND sg13cmos5l_fill_1
XANTENNA__2152__A1 Tile_X0Y0_W2END[0] VPWR VGND sg13cmos5l_antennanp
XFILLER_181_58 VPWR VGND sg13cmos5l_decap_8
XFILLER_59_132 VPWR VGND sg13cmos5l_decap_8
XFILLER_58_68 VPWR VGND sg13cmos5l_fill_1
XFILLER_331_39 VPWR VGND sg13cmos5l_decap_8
XANTENNA__2455__A2 Tile_X0Y2_W6END[2] VPWR VGND sg13cmos5l_antennanp
XANTENNA__1103__D Tile_X0Y4_FrameData[23] VPWR VGND sg13cmos5l_antennanp
XANTENNA__1888__A Tile_X0Y1_FrameData[1] VPWR VGND sg13cmos5l_antennanp
XFILLER_254_2 VPWR VGND sg13cmos5l_fill_1
XFILLER_130_40 VPWR VGND sg13cmos5l_decap_8
XANTENNA__0942__D Tile_X0Y3_FrameData[8] VPWR VGND sg13cmos5l_antennanp
XFILLER_142_0 VPWR VGND sg13cmos5l_decap_8
XFILLER_90_55 VPWR VGND sg13cmos5l_decap_8
XFILLER_90_88 VPWR VGND sg13cmos5l_decap_8
XFILLER_90_66 VPWR VGND sg13cmos5l_fill_1
XANTENNA__1481__GATE Tile_X0Y5_FrameStrobe[6] VPWR VGND sg13cmos5l_antennanp
XFILLER_128_104 VPWR VGND sg13cmos5l_fill_2
XFILLER_23_71 VPWR VGND sg13cmos5l_fill_2
XANTENNA__2071__X Tile_X0Y5_S4BEG[4] VPWR VGND sg13cmos5l_antennanp
XFILLER_139_71 VPWR VGND sg13cmos5l_decap_8
XFILLER_209_19 VPWR VGND sg13cmos5l_decap_8
XFILLER_356_25 VPWR VGND sg13cmos5l_fill_2
XFILLER_99_97 VPWR VGND sg13cmos5l_decap_8
XFILLER_297_100 VPWR VGND sg13cmos5l_fill_1
XANTENNA__1496__GATE Tile_X0Y5_FrameStrobe[7] VPWR VGND sg13cmos5l_antennanp
XANTENNA__2391__A1 Tile_X0Y0_W2MID[2] VPWR VGND sg13cmos5l_antennanp
X_0490_ _0490_/Q Tile_X0Y1_FrameData[12] VGND VPWR Tile_X0Y5_FrameStrobe[5] latch
XANTENNA__0389__D Tile_X0Y1_FrameData[17] VPWR VGND sg13cmos5l_antennanp
XFILLER_151_195 VPWR VGND sg13cmos5l_fill_1
XFILLER_300_104 VPWR VGND sg13cmos5l_fill_1
XFILLER_297_155 VPWR VGND sg13cmos5l_fill_2
XANTENNA__2143__A1 Tile_X0Y0_W6END[6] VPWR VGND sg13cmos5l_antennanp
XFILLER_300_159 VPWR VGND sg13cmos5l_decap_4
XFILLER_300_148 VPWR VGND sg13cmos5l_decap_4
XANTENNA__2694__A2 Tile_X0Y0_WW4END[14] VPWR VGND sg13cmos5l_antennanp
X_2160_ _2160_/X _2235_/X _2233_/X _2218_/X _2217_/X _0277_/Q _0276_/Q VPWR VGND sg13cmos5l_mux4_1
XFILLER_241_28 VPWR VGND sg13cmos5l_decap_8
XFILLER_253_214 VPWR VGND sg13cmos5l_fill_1
X_2091_ Tile_X0Y3_E2BEG[3] _2512_/X VPWR VGND sg13cmos5l_buf_1
X_1111_ _1111_/Q Tile_X0Y4_FrameData[15] VGND VPWR Tile_X0Y5_FrameStrobe[2] latch
XFILLER_65_124 VPWR VGND sg13cmos5l_fill_2
XFILLER_171_91 VPWR VGND sg13cmos5l_fill_1
XFILLER_206_130 VPWR VGND sg13cmos5l_decap_8
X_1042_ _1042_/Q Tile_X0Y4_FrameData[20] VGND VPWR Tile_X0Y5_FrameStrobe[0] latch
XFILLER_65_157 VPWR VGND sg13cmos5l_fill_2
XFILLER_206_141 VPWR VGND sg13cmos5l_fill_1
XFILLER_206_163 VPWR VGND sg13cmos5l_decap_8
XFILLER_80_116 VPWR VGND sg13cmos5l_decap_8
XANTENNA__1013__D Tile_X0Y3_FrameData[1] VPWR VGND sg13cmos5l_antennanp
XANTENNA__1434__GATE Tile_X0Y5_FrameStrobe[5] VPWR VGND sg13cmos5l_antennanp
XANTENNA__0852__D Tile_X0Y3_FrameData[2] VPWR VGND sg13cmos5l_antennanp
XANTENNA__0690__GATE Tile_X0Y5_FrameStrobe[4] VPWR VGND sg13cmos5l_antennanp
XFILLER_221_199 VPWR VGND sg13cmos5l_decap_8
X_1944_ Tile_X0Y1_E6BEG[9] _2334_/X VPWR VGND sg13cmos5l_buf_1
XANTENNA__1449__GATE Tile_X0Y5_FrameStrobe[5] VPWR VGND sg13cmos5l_antennanp
XFILLER_119_126 VPWR VGND sg13cmos5l_decap_8
XANTENNA__0075__GATE Tile_X0Y5_FrameStrobe[0] VPWR VGND sg13cmos5l_antennanp
XFILLER_119_137 VPWR VGND sg13cmos5l_fill_2
X_1875_ Tile_X0Y2_E6BEG[1] _2434_/X VPWR VGND sg13cmos5l_buf_1
XFILLER_266_58 VPWR VGND sg13cmos5l_decap_4
X_0826_ _0826_/Q Tile_X0Y3_FrameData[28] VGND VPWR Tile_X0Y5_FrameStrobe[1] latch
X_0757_ _0757_/Q Tile_X0Y2_FrameData[17] VGND VPWR Tile_X0Y5_FrameStrobe[6] latch
XANTENNA__2382__A1 Tile_X0Y3_W2END[7] VPWR VGND sg13cmos5l_antennanp
XANTENNA__0299__D Tile_X0Y0_FrameData[27] VPWR VGND sg13cmos5l_antennanp
XFILLER_282_57 VPWR VGND sg13cmos5l_decap_4
X_2427_ _2427_/X AXIL_S_SOC_AWADDR6 AXIL_S_SOC_AWPROT0 _2477_/X _2486_/X _0694_/Q
+ _0693_/Q VPWR VGND sg13cmos5l_mux4_1
X_0688_ _0688_/Q Tile_X0Y2_FrameData[22] VGND VPWR Tile_X0Y5_FrameStrobe[4] latch
XANTENNA__2134__A1 Tile_X0Y0_W2END[4] VPWR VGND sg13cmos5l_antennanp
X_2358_ _2358_/X _2344_/X _0031_/X _2343_/X Tile_X0Y0_S4END[5] _0348_/Q _0347_/Q VPWR
+ VGND sg13cmos5l_mux4_1
XFILLER_244_214 VPWR VGND sg13cmos5l_fill_1
X_1309_ _1309_/Q Tile_X0Y5_FrameData[19] VGND VPWR Tile_X0Y5_FrameStrobe[1] latch
X_2289_ _2289_/X _2342_/X _2341_/X AXIL_S_SOC_WDATA2 AXIL_S_SOC_WDATA7 _0514_/Q _0513_/Q
+ VPWR VGND sg13cmos5l_mux4_1
XANTENNA__0643__GATE Tile_X0Y5_FrameStrobe[2] VPWR VGND sg13cmos5l_antennanp
XFILLER_56_168 VPWR VGND sg13cmos5l_fill_1
XFILLER_56_157 VPWR VGND sg13cmos5l_decap_8
XFILLER_231_50 VPWR VGND sg13cmos5l_decap_8
XFILLER_212_100 VPWR VGND sg13cmos5l_decap_4
XANTENNA__0658__GATE Tile_X0Y5_FrameStrobe[3] VPWR VGND sg13cmos5l_antennanp
XANTENNA__1995__X Tile_X0Y5_E6BEG[8] VPWR VGND sg13cmos5l_antennanp
XFILLER_212_133 VPWR VGND sg13cmos5l_decap_4
XFILLER_240_8 VPWR VGND sg13cmos5l_fill_1
XFILLER_358_137 VPWR VGND sg13cmos5l_fill_2
XANTENNA__0762__D Tile_X0Y2_FrameData[12] VPWR VGND sg13cmos5l_antennanp
XFILLER_358_159 VPWR VGND sg13cmos5l_decap_8
XFILLER_100_76 VPWR VGND sg13cmos5l_decap_8
XFILLER_109_30 VPWR VGND sg13cmos5l_decap_8
XFILLER_125_118 VPWR VGND sg13cmos5l_decap_8
XFILLER_180_202 VPWR VGND sg13cmos5l_decap_4
XFILLER_192_24 VPWR VGND sg13cmos5l_fill_2
XFILLER_279_144 VPWR VGND sg13cmos5l_fill_2
XFILLER_192_68 VPWR VGND sg13cmos5l_decap_4
XFILLER_69_78 VPWR VGND sg13cmos5l_decap_8
XANTENNA__2125__A1 Tile_X0Y1_W2END[3] VPWR VGND sg13cmos5l_antennanp
XFILLER_192_79 VPWR VGND sg13cmos5l_decap_8
XFILLER_279_188 VPWR VGND sg13cmos5l_decap_4
XFILLER_294_114 VPWR VGND sg13cmos5l_decap_8
XFILLER_47_102 VPWR VGND sg13cmos5l_fill_1
XFILLER_342_49 VPWR VGND sg13cmos5l_decap_8
XANTENNA__0937__D Tile_X0Y3_FrameData[13] VPWR VGND sg13cmos5l_antennanp
XFILLER_18_71 VPWR VGND sg13cmos5l_decap_8
XFILLER_85_99 VPWR VGND sg13cmos5l_fill_1
XFILLER_85_88 VPWR VGND sg13cmos5l_decap_8
XANTENNA__2066__X Tile_X0Y5_S2BEGb[7] VPWR VGND sg13cmos5l_antennanp
XFILLER_349_115 VPWR VGND sg13cmos5l_decap_8
XANTENNA__0672__D Tile_X0Y2_FrameData[6] VPWR VGND sg13cmos5l_antennanp
XFILLER_203_199 VPWR VGND sg13cmos5l_fill_2
XFILLER_357_170 VPWR VGND sg13cmos5l_decap_8
XANTENNA__2600__A2 Tile_X0Y5_W6END[6] VPWR VGND sg13cmos5l_antennanp
XFILLER_357_181 VPWR VGND sg13cmos5l_fill_1
XFILLER_171_202 VPWR VGND sg13cmos5l_decap_4
X_1660_ Tile_X0Y0_FrameData_O[0] Tile_X0Y0_FrameData[0] VPWR VGND sg13cmos5l_buf_1
X_1591_ Tile_X0Y2_EE4BEG[4] _2421_/X VPWR VGND sg13cmos5l_buf_1
X_0611_ _0611_/Q Tile_X0Y2_FrameData[3] VGND VPWR Tile_X0Y5_FrameStrobe[1] latch
X_0542_ _0542_/Q Tile_X0Y1_FrameData[24] VGND VPWR Tile_X0Y5_FrameStrobe[7] latch
XANTENNA__1008__D Tile_X0Y3_FrameData[6] VPWR VGND sg13cmos5l_antennanp
XANTENNA__2116__A1 Tile_X0Y2_W2END[2] VPWR VGND sg13cmos5l_antennanp
X_0473_ _0473_/Q Tile_X0Y1_FrameData[29] VGND VPWR Tile_X0Y5_FrameStrobe[5] latch
XANTENNA__2667__A2 Tile_X0Y4_W6END[7] VPWR VGND sg13cmos5l_antennanp
XFILLER_182_90 VPWR VGND sg13cmos5l_fill_1
X_2212_ _2212_/X _2216_/X Tile_X0Y0_S1END[3] Tile_X0Y0_W6END[3] _2212_/A3 _0072_/Q
+ _0311_/Q VPWR VGND sg13cmos5l_mux4_1
XANTENNA__0847__D Tile_X0Y3_FrameData[7] VPWR VGND sg13cmos5l_antennanp
X_2143_ _2143_/X Tile_X0Y0_W1END[2] Tile_X0Y0_W6END[6] _2221_/X _2211_/X _0306_/Q
+ _0305_/Q VPWR VGND sg13cmos5l_mux4_1
XFILLER_332_71 VPWR VGND sg13cmos5l_decap_8
XANTENNA__1373__GATE Tile_X0Y5_FrameStrobe[3] VPWR VGND sg13cmos5l_antennanp
X_2074_ Tile_X0Y5_S4BEG[7] _2074_/A VPWR VGND sg13cmos5l_buf_1
XFILLER_53_116 VPWR VGND sg13cmos5l_fill_2
XFILLER_201_31 VPWR VGND sg13cmos5l_decap_8
X_1025_ _1025_/Q Tile_X0Y3_FrameData[21] VGND VPWR Tile_X0Y5_FrameStrobe[7] latch
XANTENNA__0582__D Tile_X0Y2_FrameData[0] VPWR VGND sg13cmos5l_antennanp
XANTENNA__1388__GATE Tile_X0Y5_FrameStrobe[3] VPWR VGND sg13cmos5l_antennanp
XFILLER_277_13 VPWR VGND sg13cmos5l_fill_2
X_1927_ Tile_X0Y1_EE4BEG[8] _2317_/X VPWR VGND sg13cmos5l_buf_1
XANTENNA__1311__GATE Tile_X0Y5_FrameStrobe[1] VPWR VGND sg13cmos5l_antennanp
X_1858_ Tile_X0Y4_FrameData_O[25] Tile_X0Y4_FrameData[25] VPWR VGND sg13cmos5l_buf_1
X_0809_ _0809_/Q Tile_X0Y3_FrameData[13] VGND VPWR Tile_X0Y5_FrameStrobe[0] latch
XANTENNA__2355__A1 Tile_X0Y5_WW4END[1] VPWR VGND sg13cmos5l_antennanp
XFILLER_293_56 VPWR VGND sg13cmos5l_decap_8
X_1789_ Tile_X0Y4_E2BEG[0] _2617_/X VPWR VGND sg13cmos5l_buf_1
XFILLER_226_61 VPWR VGND sg13cmos5l_decap_8
XANTENNA__1326__GATE Tile_X0Y5_FrameStrobe[1] VPWR VGND sg13cmos5l_antennanp
XANTENNA__2107__A1 Tile_X0Y3_W2END[1] VPWR VGND sg13cmos5l_antennanp
XFILLER_162_16 VPWR VGND sg13cmos5l_fill_1
XFILLER_226_72 VPWR VGND sg13cmos5l_fill_2
XFILLER_276_125 VPWR VGND sg13cmos5l_decap_8
XANTENNA__0582__GATE Tile_X0Y5_FrameStrobe[0] VPWR VGND sg13cmos5l_antennanp
XANTENNA__0757__D Tile_X0Y2_FrameData[17] VPWR VGND sg13cmos5l_antennanp
XFILLER_217_203 VPWR VGND sg13cmos5l_decap_8
XFILLER_217_214 VPWR VGND sg13cmos5l_fill_1
XFILLER_242_71 VPWR VGND sg13cmos5l_decap_8
XFILLER_29_168 VPWR VGND sg13cmos5l_decap_8
XFILLER_232_217 VPWR VGND sg13cmos5l_fill_1
XANTENNA__0597__GATE Tile_X0Y5_FrameStrobe[1] VPWR VGND sg13cmos5l_antennanp
XFILLER_197_110 VPWR VGND sg13cmos5l_decap_8
XFILLER_343_6 VPWR VGND sg13cmos5l_decap_8
XANTENNA__0492__D Tile_X0Y1_FrameData[10] VPWR VGND sg13cmos5l_antennanp
XANTENNA__2830__A2 Tile_X0Y4_W6END[9] VPWR VGND sg13cmos5l_antennanp
XFILLER_197_143 VPWR VGND sg13cmos5l_fill_1
XFILLER_52_182 VPWR VGND sg13cmos5l_decap_4
XFILLER_71_57 VPWR VGND sg13cmos5l_decap_8
XANTENNA__0520__GATE Tile_X0Y5_FrameStrobe[6] VPWR VGND sg13cmos5l_antennanp
XFILLER_138_221 VPWR VGND sg13cmos5l_fill_2
XFILLER_153_202 VPWR VGND sg13cmos5l_decap_8
XFILLER_4_223 VPWR VGND sg13cmos5l_fill_1
XANTENNA__0535__GATE Tile_X0Y5_FrameStrobe[7] VPWR VGND sg13cmos5l_antennanp
XANTENNA__2346__A1 Tile_X0Y2_W6END[6] VPWR VGND sg13cmos5l_antennanp
XFILLER_105_0 VPWR VGND sg13cmos5l_fill_2
XFILLER_20_61 VPWR VGND sg13cmos5l_decap_8
XFILLER_136_50 VPWR VGND sg13cmos5l_decap_8
XFILLER_353_26 VPWR VGND sg13cmos5l_decap_8
XFILLER_121_154 VPWR VGND sg13cmos5l_decap_8
XANTENNA__0667__D Tile_X0Y2_FrameData[11] VPWR VGND sg13cmos5l_antennanp
XFILLER_208_203 VPWR VGND sg13cmos5l_decap_8
XFILLER_208_214 VPWR VGND sg13cmos5l_fill_1
XFILLER_152_71 VPWR VGND sg13cmos5l_fill_1
XFILLER_152_82 VPWR VGND sg13cmos5l_decap_8
XFILLER_290_172 VPWR VGND sg13cmos5l_fill_2
X_2830_ _2830_/X Tile_X0Y4_W2MID[6] Tile_X0Y4_W2END[6] Tile_X0Y4_W6END[9] _2709_/X
+ _1122_/Q _1121_/Q VPWR VGND sg13cmos5l_mux4_1
XFILLER_188_198 VPWR VGND sg13cmos5l_fill_1
X_2761_ _2761_/X AXIL_S_SOC_RREADY _2817_/X _2802_/X _2825_/X _1380_/Q _1379_/Q VPWR
+ VGND sg13cmos5l_mux4_1
XANTENNA__2585__A1 Tile_X0Y5_N4END[9] VPWR VGND sg13cmos5l_antennanp
XFILLER_247_38 VPWR VGND sg13cmos5l_decap_4
XFILLER_247_49 VPWR VGND sg13cmos5l_decap_8
X_1712_ Tile_X0Y0_E6BEG[4] _2201_/X VPWR VGND sg13cmos5l_buf_1
X_2692_ _2692_/X _2676_/X Tile_X0Y5_N4END[5] _2675_/X _0071_/X _1060_/Q _1059_/Q VPWR
+ VGND sg13cmos5l_mux4_1
XFILLER_61_90 VPWR VGND sg13cmos5l_fill_2
XANTENNA_1 AXIL_S_SOC_WDATA0 VPWR VGND sg13cmos5l_antennanp
X_1643_ Tile_X0Y0_FrameStrobe_O[3] Tile_X0Y5_FrameStrobe[3] VPWR VGND sg13cmos5l_buf_1
XFILLER_6_30 VPWR VGND sg13cmos5l_fill_1
XFILLER_345_173 VPWR VGND sg13cmos5l_decap_8
XFILLER_360_143 VPWR VGND sg13cmos5l_fill_2
X_1574_ Tile_X0Y3_FrameData_O[20] Tile_X0Y3_FrameData[20] VPWR VGND sg13cmos5l_buf_1
XFILLER_6_96 VPWR VGND sg13cmos5l_fill_2
XFILLER_360_187 VPWR VGND sg13cmos5l_decap_4
XFILLER_360_176 VPWR VGND sg13cmos5l_decap_8
XFILLER_258_125 VPWR VGND sg13cmos5l_decap_4
X_0525_ _0525_/Q Tile_X0Y1_FrameData[9] VGND VPWR Tile_X0Y5_FrameStrobe[6] latch
XFILLER_258_136 VPWR VGND sg13cmos5l_decap_8
X_0456_ _0456_/Q Tile_X0Y1_FrameData[14] VGND VPWR Tile_X0Y5_FrameStrobe[4] latch
XANTENNA__0577__D Tile_X0Y2_FrameData[5] VPWR VGND sg13cmos5l_antennanp
XFILLER_343_70 VPWR VGND sg13cmos5l_decap_8
XANTENNA__1603__X Tile_X0Y0_UserCLKo VPWR VGND sg13cmos5l_antennanp
X_0387_ _0387_/Q Tile_X0Y1_FrameData[19] VGND VPWR Tile_X0Y5_FrameStrobe[2] latch
XFILLER_212_30 VPWR VGND sg13cmos5l_decap_8
XFILLER_212_41 VPWR VGND sg13cmos5l_fill_1
XFILLER_26_105 VPWR VGND sg13cmos5l_decap_8
X_2126_ AXIL_S_SOC_RDATA20 Tile_X0Y1_W2MID[4] Tile_X0Y1_W2END[4] Tile_X0Y1_W6END[4]
+ _2377_/X _0374_/Q _0373_/Q VPWR VGND sg13cmos5l_mux4_1
X_2057_ Tile_X0Y5_S2BEG[6] _2779_/X VPWR VGND sg13cmos5l_buf_1
XANTENNA__2273__A0 Tile_X0Y2_W1END[3] VPWR VGND sg13cmos5l_antennanp
XFILLER_179_110 VPWR VGND sg13cmos5l_decap_8
X_1008_ _1008_/Q Tile_X0Y3_FrameData[6] VGND VPWR Tile_X0Y5_FrameStrobe[6] latch
XFILLER_41_108 VPWR VGND sg13cmos5l_decap_8
XFILLER_288_34 VPWR VGND sg13cmos5l_decap_8
XANTENNA__1201__D Tile_X0Y4_FrameData[21] VPWR VGND sg13cmos5l_antennanp
XANTENNA__1250__GATE Tile_X0Y5_FrameStrobe[6] VPWR VGND sg13cmos5l_antennanp
XFILLER_41_16 VPWR VGND sg13cmos5l_fill_1
XANTENNA__2576__A1 Tile_X0Y5_N4END[10] VPWR VGND sg13cmos5l_antennanp
XANTENNA__2328__A1 Tile_X0Y0_S4END[7] VPWR VGND sg13cmos5l_antennanp
XANTENNA__1265__GATE Tile_X0Y5_FrameStrobe[0] VPWR VGND sg13cmos5l_antennanp
XFILLER_173_48 VPWR VGND sg13cmos5l_decap_8
XFILLER_249_125 VPWR VGND sg13cmos5l_decap_8
XANTENNA__0487__D Tile_X0Y1_FrameData[15] VPWR VGND sg13cmos5l_antennanp
XFILLER_249_169 VPWR VGND sg13cmos5l_decap_8
XFILLER_253_81 VPWR VGND sg13cmos5l_decap_8
XFILLER_264_106 VPWR VGND sg13cmos5l_decap_4
XANTENNA__2500__A1 Tile_X0Y4_W2END[2] VPWR VGND sg13cmos5l_antennanp
XFILLER_264_139 VPWR VGND sg13cmos5l_decap_4
XFILLER_72_222 VPWR VGND sg13cmos5l_fill_2
XANTENNA__1203__GATE Tile_X0Y5_FrameStrobe[5] VPWR VGND sg13cmos5l_antennanp
XANTENNA__2264__A0 Tile_X0Y1_W2MID[0] VPWR VGND sg13cmos5l_antennanp
XFILLER_122_96 VPWR VGND sg13cmos5l_decap_8
XFILLER_359_221 VPWR VGND sg13cmos5l_fill_2
XANTENNA__1896__A Tile_X0Y1_FrameData[9] VPWR VGND sg13cmos5l_antennanp
XANTENNA__2803__A2 Tile_X0Y1_WW4END[12] VPWR VGND sg13cmos5l_antennanp
XFILLER_15_50 VPWR VGND sg13cmos5l_fill_1
XFILLER_198_56 VPWR VGND sg13cmos5l_decap_8
XFILLER_25_193 VPWR VGND sg13cmos5l_decap_4
XANTENNA__1111__D Tile_X0Y4_FrameData[15] VPWR VGND sg13cmos5l_antennanp
XFILLER_319_118 VPWR VGND sg13cmos5l_fill_2
XANTENNA__1218__GATE Tile_X0Y5_FrameStrobe[5] VPWR VGND sg13cmos5l_antennanp
XANTENNA__0950__D Tile_X0Y3_FrameData[0] VPWR VGND sg13cmos5l_antennanp
XANTENNA__2567__A1 Tile_X0Y2_W6END[9] VPWR VGND sg13cmos5l_antennanp
XFILLER_222_0 VPWR VGND sg13cmos5l_fill_2
XFILLER_40_196 VPWR VGND sg13cmos5l_fill_1
XANTENNA__0474__GATE Tile_X0Y5_FrameStrobe[5] VPWR VGND sg13cmos5l_antennanp
XFILLER_327_162 VPWR VGND sg13cmos5l_decap_8
XANTENNA__2319__A1 AXIL_S_SOC_WDATA10 VPWR VGND sg13cmos5l_antennanp
XFILLER_31_82 VPWR VGND sg13cmos5l_decap_8
XFILLER_141_205 VPWR VGND sg13cmos5l_decap_8
XFILLER_141_216 VPWR VGND sg13cmos5l_fill_2
XANTENNA__0489__GATE Tile_X0Y5_FrameStrobe[5] VPWR VGND sg13cmos5l_antennanp
X_0310_ _0310_/Q Tile_X0Y0_FrameData[16] VGND VPWR Tile_X0Y5_FrameStrobe[7] latch
XANTENNA__0397__D Tile_X0Y1_FrameData[9] VPWR VGND sg13cmos5l_antennanp
XFILLER_255_106 VPWR VGND sg13cmos5l_decap_8
XFILLER_255_117 VPWR VGND sg13cmos5l_fill_1
X_1290_ _1290_/Q Tile_X0Y5_FrameData[6] VGND VPWR Tile_X0Y5_FrameStrobe[0] latch
X_0241_ _0241_/Q Tile_X0Y0_FrameData[21] VGND VPWR Tile_X0Y5_FrameStrobe[5] latch
XANTENNA__0412__GATE Tile_X0Y5_FrameStrobe[3] VPWR VGND sg13cmos5l_antennanp
X_0172_ _0172_/Q Tile_X0Y0_FrameData[26] VGND VPWR Tile_X0Y5_FrameStrobe[3] latch
XANTENNA__2255__A0 Tile_X0Y2_W2MID[4] VPWR VGND sg13cmos5l_antennanp
XANTENNA__0427__GATE Tile_X0Y5_FrameStrobe[3] VPWR VGND sg13cmos5l_antennanp
XFILLER_16_182 VPWR VGND sg13cmos5l_fill_1
XANTENNA__1021__D Tile_X0Y3_FrameData[25] VPWR VGND sg13cmos5l_antennanp
X_2813_ _2813_/X Tile_X0Y5_N1END[0] Tile_X0Y5_N4END[0] _2793_/X _0032_/X _1296_/Q
+ _1295_/Q VPWR VGND sg13cmos5l_mux4_1
XANTENNA__0860__D Tile_X0Y3_FrameData[26] VPWR VGND sg13cmos5l_antennanp
XFILLER_191_105 VPWR VGND sg13cmos5l_fill_2
X_2744_ _2744_/X AXIL_S_SOC_ARPROT0 AXIL_S_SOC_ARVALID _2813_/X _2800_/X _1414_/Q
+ _1413_/Q VPWR VGND sg13cmos5l_mux4_1
X_2675_ _2675_/X Tile_X0Y3_W1END[1] Tile_X0Y3_W6END[9] _2577_/X _2562_/X _0896_/Q
+ _0895_/Q VPWR VGND sg13cmos5l_mux4_1
XFILLER_207_30 VPWR VGND sg13cmos5l_fill_1
XFILLER_274_58 VPWR VGND sg13cmos5l_decap_4
X_1626_ Tile_X0Y0_N2BEGb[6] _2262_/X VPWR VGND sg13cmos5l_buf_1
XFILLER_333_187 VPWR VGND sg13cmos5l_fill_2
XFILLER_333_165 VPWR VGND sg13cmos5l_fill_1
XFILLER_207_52 VPWR VGND sg13cmos5l_fill_2
X_1557_ Tile_X0Y3_FrameData_O[3] Tile_X0Y3_FrameData[3] VPWR VGND sg13cmos5l_buf_1
XANTENNA__2730__A1 AXIL_S_SOC_ARVALID VPWR VGND sg13cmos5l_antennanp
X_0508_ _0508_/Q Tile_X0Y1_FrameData[26] VGND VPWR Tile_X0Y5_FrameStrobe[6] latch
XFILLER_98_163 VPWR VGND sg13cmos5l_decap_4
XFILLER_100_113 VPWR VGND sg13cmos5l_decap_8
XFILLER_290_46 VPWR VGND sg13cmos5l_fill_1
XFILLER_290_57 VPWR VGND sg13cmos5l_decap_8
X_1488_ _1488_/Q Tile_X0Y5_FrameData[0] VGND VPWR Tile_X0Y5_FrameStrobe[6] latch
XFILLER_98_196 VPWR VGND sg13cmos5l_decap_8
XANTENNA__0100__D Tile_X0Y0_FrameData[2] VPWR VGND sg13cmos5l_antennanp
X_0439_ _0439_/Q Tile_X0Y1_FrameData[31] VGND VPWR Tile_X0Y5_FrameStrobe[4] latch
XANTENNA__2494__A0 Tile_X0Y4_W2MID[5] VPWR VGND sg13cmos5l_antennanp
XFILLER_54_200 VPWR VGND sg13cmos5l_fill_1
X_2109_ AXIL_S_SOC_RDATA3 Tile_X0Y3_W2MID[3] Tile_X0Y3_W2END[3] Tile_X0Y3_W6END[3]
+ _2592_/X _0856_/Q _0855_/Q VPWR VGND sg13cmos5l_mux4_1
XFILLER_160_9 VPWR VGND sg13cmos5l_fill_2
XANTENNA__2797__A1 Tile_X0Y5_N2END[7] VPWR VGND sg13cmos5l_antennanp
XFILLER_146_7 VPWR VGND sg13cmos5l_decap_8
XFILLER_22_141 VPWR VGND sg13cmos5l_fill_2
XFILLER_167_146 VPWR VGND sg13cmos5l_decap_8
XANTENNA__0770__D Tile_X0Y2_FrameData[4] VPWR VGND sg13cmos5l_antennanp
XFILLER_324_165 VPWR VGND sg13cmos5l_decap_8
XFILLER_334_28 VPWR VGND sg13cmos5l_decap_8
XFILLER_117_85 VPWR VGND sg13cmos5l_decap_8
XFILLER_77_56 VPWR VGND sg13cmos5l_decap_8
XANTENNA__1106__D Tile_X0Y4_FrameData[20] VPWR VGND sg13cmos5l_antennanp
XFILLER_237_139 VPWR VGND sg13cmos5l_fill_2
XFILLER_284_2 VPWR VGND sg13cmos5l_fill_1
XFILLER_252_109 VPWR VGND sg13cmos5l_fill_2
XFILLER_93_22 VPWR VGND sg13cmos5l_decap_4
XANTENNA__0945__D Tile_X0Y3_FrameData[5] VPWR VGND sg13cmos5l_antennanp
XANTENNA__1142__GATE Tile_X0Y5_FrameStrobe[3] VPWR VGND sg13cmos5l_antennanp
XFILLER_172_0 VPWR VGND sg13cmos5l_fill_2
XFILLER_45_222 VPWR VGND sg13cmos5l_fill_2
XFILLER_26_93 VPWR VGND sg13cmos5l_fill_1
XANTENNA__1157__GATE Tile_X0Y5_FrameStrobe[3] VPWR VGND sg13cmos5l_antennanp
XANTENNA__2074__X Tile_X0Y5_S4BEG[7] VPWR VGND sg13cmos5l_antennanp
XFILLER_158_135 VPWR VGND sg13cmos5l_decap_8
XFILLER_347_213 VPWR VGND sg13cmos5l_fill_2
XANTENNA__0680__D Tile_X0Y2_FrameData[30] VPWR VGND sg13cmos5l_antennanp
XFILLER_158_179 VPWR VGND sg13cmos5l_decap_8
XFILLER_173_116 VPWR VGND sg13cmos5l_decap_8
X_0790_ _0790_/Q Tile_X0Y2_FrameData[16] VGND VPWR Tile_X0Y5_FrameStrobe[7] latch
XFILLER_166_190 VPWR VGND sg13cmos5l_decap_8
X_2460_ _2460_/X Tile_X0Y3_W1END[1] Tile_X0Y3_W6END[5] _2577_/X _2562_/X _1028_/Q
+ _1027_/Q VPWR VGND sg13cmos5l_mux4_1
XFILLER_308_62 VPWR VGND sg13cmos5l_fill_1
XFILLER_244_28 VPWR VGND sg13cmos5l_fill_2
X_1411_ _1411_/Q Tile_X0Y5_FrameData[13] VGND VPWR Tile_X0Y5_FrameStrobe[4] latch
XANTENNA__2712__A1 Tile_X0Y5_N2MID[4] VPWR VGND sg13cmos5l_antennanp
X_2391_ _2391_/X Tile_X0Y0_W1END[1] Tile_X0Y0_W2MID[2] Tile_X0Y0_W2END[2] _2246_/X
+ _0160_/Q _0159_/Q VPWR VGND sg13cmos5l_mux4_1
X_1342_ _1342_/Q Tile_X0Y5_FrameData[18] VGND VPWR Tile_X0Y5_FrameStrobe[2] latch
XANTENNA__0351__GATE Tile_X0Y5_FrameStrobe[1] VPWR VGND sg13cmos5l_antennanp
XANTENNA__1016__D Tile_X0Y3_FrameData[30] VPWR VGND sg13cmos5l_antennanp
XFILLER_283_223 VPWR VGND sg13cmos5l_fill_1
X_1273_ _1273_/Q Tile_X0Y5_FrameData[23] VGND VPWR Tile_X0Y5_FrameStrobe[0] latch
XANTENNA__0981__GATE Tile_X0Y5_FrameStrobe[5] VPWR VGND sg13cmos5l_antennanp
XFILLER_260_16 VPWR VGND sg13cmos5l_fill_2
XFILLER_260_27 VPWR VGND sg13cmos5l_fill_1
XFILLER_260_38 VPWR VGND sg13cmos5l_decap_4
X_0224_ _0224_/Q Tile_X0Y0_FrameData[6] VGND VPWR Tile_X0Y5_FrameStrobe[4] latch
XFILLER_95_199 VPWR VGND sg13cmos5l_decap_8
XANTENNA__0855__D Tile_X0Y3_FrameData[31] VPWR VGND sg13cmos5l_antennanp
XFILLER_236_194 VPWR VGND sg13cmos5l_decap_8
X_0155_ _0155_/Q Tile_X0Y0_FrameData[11] VGND VPWR Tile_X0Y5_FrameStrobe[2] latch
XANTENNA__0366__GATE Tile_X0Y5_FrameStrobe[1] VPWR VGND sg13cmos5l_antennanp
X_0086_ _0086_/Q Tile_X0Y0_FrameData[16] VGND VPWR Tile_X0Y5_FrameStrobe[0] latch
XANTENNA__0996__GATE Tile_X0Y5_FrameStrobe[6] VPWR VGND sg13cmos5l_antennanp
XANTENNA__2779__A1 Tile_X0Y5_W2MID[1] VPWR VGND sg13cmos5l_antennanp
XFILLER_269_58 VPWR VGND sg13cmos5l_decap_8
XANTENNA__2243__A3 Tile_X0Y0_S2END[2] VPWR VGND sg13cmos5l_antennanp
XANTENNA__0590__D Tile_X0Y2_FrameData[24] VPWR VGND sg13cmos5l_antennanp
XFILLER_22_29 VPWR VGND sg13cmos5l_fill_2
XFILLER_349_80 VPWR VGND sg13cmos5l_decap_8
X_0988_ _0988_/Q Tile_X0Y3_FrameData[26] VGND VPWR Tile_X0Y5_FrameStrobe[6] latch
X_2727_ _2727_/X AXIL_S_SOC_ARPROT0 AXIL_S_SOC_ARPROT2 _2827_/X _2799_/X _1448_/Q
+ _1447_/Q VPWR VGND sg13cmos5l_mux4_1
XANTENNA__0304__GATE Tile_X0Y5_FrameStrobe[7] VPWR VGND sg13cmos5l_antennanp
XFILLER_105_216 VPWR VGND sg13cmos5l_fill_2
XANTENNA__0934__GATE Tile_X0Y5_FrameStrobe[4] VPWR VGND sg13cmos5l_antennanp
X_2658_ _2658_/X AXIL_S_SOC_WSTRB1 _2703_/X _2701_/X _2683_/X _1138_/Q _1137_/Q VPWR
+ VGND sg13cmos5l_mux4_1
XFILLER_321_113 VPWR VGND sg13cmos5l_decap_4
XANTENNA__2703__A1 Tile_X0Y5_N4END[6] VPWR VGND sg13cmos5l_antennanp
X_1609_ Tile_X0Y0_N4BEG[5] _1609_/A VPWR VGND sg13cmos5l_buf_1
X_2589_ _2589_/X _2490_/X _2598_/X _2597_/X _2489_/X _0814_/Q _0813_/Q VPWR VGND sg13cmos5l_mux4_1
XANTENNA__0319__GATE Tile_X0Y5_FrameStrobe[0] VPWR VGND sg13cmos5l_antennanp
XFILLER_86_155 VPWR VGND sg13cmos5l_fill_2
XANTENNA__0949__GATE Tile_X0Y5_FrameStrobe[4] VPWR VGND sg13cmos5l_antennanp
XFILLER_86_199 VPWR VGND sg13cmos5l_decap_8
XANTENNA__0765__D Tile_X0Y2_FrameData[9] VPWR VGND sg13cmos5l_antennanp
XANTENNA__1998__X Tile_X0Y5_E6BEG[11] VPWR VGND sg13cmos5l_antennanp
XFILLER_227_150 VPWR VGND sg13cmos5l_decap_8
XFILLER_103_76 VPWR VGND sg13cmos5l_decap_8
XFILLER_242_120 VPWR VGND sg13cmos5l_decap_8
XFILLER_263_7 VPWR VGND sg13cmos5l_decap_8
XANTENNA__2219__A0 Tile_X0Y4_W1END[0] VPWR VGND sg13cmos5l_antennanp
XFILLER_179_25 VPWR VGND sg13cmos5l_decap_8
XFILLER_63_58 VPWR VGND sg13cmos5l_fill_1
XFILLER_179_36 VPWR VGND sg13cmos5l_fill_1
XFILLER_242_175 VPWR VGND sg13cmos5l_decap_8
XFILLER_63_69 VPWR VGND sg13cmos5l_fill_2
XANTENNA__2234__A3 Tile_X0Y0_S4END[2] VPWR VGND sg13cmos5l_antennanp
XFILLER_88_11 VPWR VGND sg13cmos5l_fill_1
XFILLER_88_55 VPWR VGND sg13cmos5l_fill_1
XFILLER_111_208 VPWR VGND sg13cmos5l_fill_2
XFILLER_88_77 VPWR VGND sg13cmos5l_decap_8
XFILLER_77_100 VPWR VGND sg13cmos5l_fill_1
XANTENNA__2069__X Tile_X0Y5_S4BEG[2] VPWR VGND sg13cmos5l_antennanp
XFILLER_265_223 VPWR VGND sg13cmos5l_fill_1
XANTENNA__1081__GATE Tile_X0Y5_FrameStrobe[1] VPWR VGND sg13cmos5l_antennanp
XANTENNA__2458__A0 Tile_X0Y3_W1END[0] VPWR VGND sg13cmos5l_antennanp
XANTENNA__0675__D Tile_X0Y2_FrameData[3] VPWR VGND sg13cmos5l_antennanp
XFILLER_92_136 VPWR VGND sg13cmos5l_fill_2
XFILLER_92_125 VPWR VGND sg13cmos5l_decap_8
XANTENNA__1701__X Tile_X0Y0_EE4BEG[9] VPWR VGND sg13cmos5l_antennanp
XANTENNA__2473__A3 Tile_X0Y0_S4END[11] VPWR VGND sg13cmos5l_antennanp
XFILLER_218_183 VPWR VGND sg13cmos5l_decap_4
XFILLER_37_70 VPWR VGND sg13cmos5l_decap_8
XANTENNA__1096__GATE Tile_X0Y5_FrameStrobe[2] VPWR VGND sg13cmos5l_antennanp
XANTENNA__2225__A3 Tile_X0Y0_S4END[1] VPWR VGND sg13cmos5l_antennanp
X_1960_ Tile_X0Y1_E2BEG[5] _2298_/X VPWR VGND sg13cmos5l_buf_1
XANTENNA__2630__A0 AXIL_S_SOC_WSTRB1 VPWR VGND sg13cmos5l_antennanp
XFILLER_239_39 VPWR VGND sg13cmos5l_fill_1
X_1891_ Tile_X0Y1_FrameData_O[4] Tile_X0Y1_FrameData[4] VPWR VGND sg13cmos5l_buf_1
X_0911_ _0911_/Q Tile_X0Y3_FrameData[7] VGND VPWR Tile_X0Y5_FrameStrobe[3] latch
X_0842_ _0842_/Q Tile_X0Y3_FrameData[12] VGND VPWR Tile_X0Y5_FrameStrobe[1] latch
XFILLER_139_190 VPWR VGND sg13cmos5l_decap_8
X_0773_ _0773_/Q Tile_X0Y2_FrameData[1] VGND VPWR Tile_X0Y5_FrameStrobe[6] latch
X_2512_ _2512_/X AXIL_S_SOC_ARADDR1 AXIL_S_SOC_ARADDR3 _2592_/X _2593_/X _0980_/Q
+ _0979_/Q VPWR VGND sg13cmos5l_mux4_1
XANTENNA__1034__GATE Tile_X0Y5_FrameStrobe[0] VPWR VGND sg13cmos5l_antennanp
XFILLER_154_171 VPWR VGND sg13cmos5l_decap_4
XFILLER_303_102 VPWR VGND sg13cmos5l_decap_8
X_2443_ _2443_/X AXIL_S_SOC_AWADDR2 _2478_/X _2477_/X _2487_/X _0662_/Q _0661_/Q VPWR
+ VGND sg13cmos5l_mux4_1
XFILLER_303_157 VPWR VGND sg13cmos5l_decap_8
XFILLER_303_146 VPWR VGND sg13cmos5l_fill_1
XANTENNA__0290__GATE Tile_X0Y5_FrameStrobe[6] VPWR VGND sg13cmos5l_antennanp
XFILLER_271_15 VPWR VGND sg13cmos5l_fill_2
X_2374_ _2374_/X _2251_/X _2384_/X _2383_/X Tile_X0Y0_S2MID[1] _0332_/Q _0331_/Q VPWR
+ VGND sg13cmos5l_mux4_1
XFILLER_303_179 VPWR VGND sg13cmos5l_decap_4
XANTENNA__2161__A2 AXIL_S_SOC_WDATA18 VPWR VGND sg13cmos5l_antennanp
XFILLER_271_48 VPWR VGND sg13cmos5l_fill_2
X_1325_ _1325_/Q Tile_X0Y5_FrameData[3] VGND VPWR Tile_X0Y5_FrameStrobe[1] latch
XANTENNA__1049__GATE Tile_X0Y5_FrameStrobe[0] VPWR VGND sg13cmos5l_antennanp
XANTENNA__2449__A0 Tile_X0Y2_W1END[2] VPWR VGND sg13cmos5l_antennanp
XFILLER_204_42 VPWR VGND sg13cmos5l_fill_1
XANTENNA__0585__D Tile_X0Y2_FrameData[29] VPWR VGND sg13cmos5l_antennanp
XFILLER_204_64 VPWR VGND sg13cmos5l_decap_8
X_1256_ _1256_/Q Tile_X0Y4_FrameData[30] VGND VPWR Tile_X0Y5_FrameStrobe[7] latch
XFILLER_83_125 VPWR VGND sg13cmos5l_decap_8
XANTENNA__1611__X Tile_X0Y0_N4BEG[7] VPWR VGND sg13cmos5l_antennanp
X_1187_ _1187_/Q Tile_X0Y4_FrameData[3] VGND VPWR Tile_X0Y5_FrameStrobe[4] latch
X_0207_ _0207_/Q Tile_X0Y0_FrameData[23] VGND VPWR Tile_X0Y5_FrameStrobe[4] latch
XFILLER_83_169 VPWR VGND sg13cmos5l_decap_8
X_0138_ _0138_/Q Tile_X0Y0_FrameData[28] VGND VPWR Tile_X0Y5_FrameStrobe[2] latch
XFILLER_224_197 VPWR VGND sg13cmos5l_decap_8
XFILLER_220_74 VPWR VGND sg13cmos5l_fill_2
X_0069_ _2074_/A _2559_/X _2560_/X _0863_/Q VPWR VGND sg13cmos5l_mux2_1
XANTENNA__2621__A0 AXIL_S_SOC_WSTRB0 VPWR VGND sg13cmos5l_antennanp
XFILLER_296_56 VPWR VGND sg13cmos5l_decap_8
XFILLER_137_116 VPWR VGND sg13cmos5l_decap_8
XFILLER_296_89 VPWR VGND sg13cmos5l_fill_1
XFILLER_296_78 VPWR VGND sg13cmos5l_fill_1
XFILLER_296_67 VPWR VGND sg13cmos5l_fill_1
XANTENNA__0243__GATE Tile_X0Y5_FrameStrobe[5] VPWR VGND sg13cmos5l_antennanp
XFILLER_229_50 VPWR VGND sg13cmos5l_decap_4
XFILLER_229_61 VPWR VGND sg13cmos5l_decap_8
XANTENNA__0873__GATE Tile_X0Y5_FrameStrobe[2] VPWR VGND sg13cmos5l_antennanp
XFILLER_3_107 VPWR VGND sg13cmos5l_fill_2
XFILLER_145_182 VPWR VGND sg13cmos5l_decap_8
XFILLER_165_38 VPWR VGND sg13cmos5l_decap_8
XANTENNA__0258__GATE Tile_X0Y5_FrameStrobe[5] VPWR VGND sg13cmos5l_antennanp
XFILLER_59_111 VPWR VGND sg13cmos5l_decap_8
XANTENNA__0888__GATE Tile_X0Y5_FrameStrobe[3] VPWR VGND sg13cmos5l_antennanp
XANTENNA__2152__A2 Tile_X0Y0_W6END[0] VPWR VGND sg13cmos5l_antennanp
XFILLER_181_37 VPWR VGND sg13cmos5l_decap_8
XFILLER_114_42 VPWR VGND sg13cmos5l_decap_4
XFILLER_74_114 VPWR VGND sg13cmos5l_fill_1
XANTENNA__0495__D Tile_X0Y1_FrameData[7] VPWR VGND sg13cmos5l_antennanp
XFILLER_114_75 VPWR VGND sg13cmos5l_decap_8
XFILLER_74_147 VPWR VGND sg13cmos5l_fill_2
XFILLER_74_136 VPWR VGND sg13cmos5l_decap_8
XANTENNA__0811__GATE Tile_X0Y5_FrameStrobe[0] VPWR VGND sg13cmos5l_antennanp
XFILLER_215_120 VPWR VGND sg13cmos5l_decap_8
XFILLER_215_175 VPWR VGND sg13cmos5l_fill_2
XANTENNA__0826__GATE Tile_X0Y5_FrameStrobe[1] VPWR VGND sg13cmos5l_antennanp
XFILLER_230_134 VPWR VGND sg13cmos5l_fill_2
XFILLER_90_34 VPWR VGND sg13cmos5l_decap_8
XANTENNA__2612__A0 Tile_X0Y5_W2MID[0] VPWR VGND sg13cmos5l_antennanp
XFILLER_230_167 VPWR VGND sg13cmos5l_fill_1
XFILLER_230_189 VPWR VGND sg13cmos5l_decap_8
XFILLER_128_127 VPWR VGND sg13cmos5l_decap_4
XFILLER_135_0 VPWR VGND sg13cmos5l_decap_8
XFILLER_23_50 VPWR VGND sg13cmos5l_fill_1
XFILLER_128_149 VPWR VGND sg13cmos5l_decap_8
XFILLER_139_50 VPWR VGND sg13cmos5l_decap_8
XFILLER_356_37 VPWR VGND sg13cmos5l_fill_2
XFILLER_136_160 VPWR VGND sg13cmos5l_decap_8
XFILLER_143_119 VPWR VGND sg13cmos5l_fill_1
XFILLER_302_0 VPWR VGND sg13cmos5l_decap_4
XFILLER_99_76 VPWR VGND sg13cmos5l_decap_8
XANTENNA__2391__A2 Tile_X0Y0_W2END[2] VPWR VGND sg13cmos5l_antennanp
XFILLER_297_123 VPWR VGND sg13cmos5l_decap_8
XANTENNA__2679__A0 Tile_X0Y3_W1END[3] VPWR VGND sg13cmos5l_antennanp
XFILLER_97_217 VPWR VGND sg13cmos5l_fill_1
XFILLER_300_116 VPWR VGND sg13cmos5l_fill_2
XFILLER_305_41 VPWR VGND sg13cmos5l_decap_8
XANTENNA__2694__A3 Tile_X0Y0_W6END[6] VPWR VGND sg13cmos5l_antennanp
X_1110_ _1110_/Q Tile_X0Y4_FrameData[16] VGND VPWR Tile_X0Y5_FrameStrobe[2] latch
X_2090_ Tile_X0Y3_E2BEG[2] _2511_/X VPWR VGND sg13cmos5l_buf_1
XFILLER_0_21 VPWR VGND sg13cmos5l_fill_2
X_1041_ _1041_/Q Tile_X0Y4_FrameData[21] VGND VPWR Tile_X0Y5_FrameStrobe[0] latch
XFILLER_321_51 VPWR VGND sg13cmos5l_decap_4
XFILLER_21_217 VPWR VGND sg13cmos5l_fill_1
XFILLER_221_145 VPWR VGND sg13cmos5l_decap_4
XFILLER_221_156 VPWR VGND sg13cmos5l_fill_1
XANTENNA__2603__A0 Tile_X0Y2_W2MID[4] VPWR VGND sg13cmos5l_antennanp
X_1943_ Tile_X0Y1_E6BEG[8] _2333_/X VPWR VGND sg13cmos5l_buf_1
X_1874_ Tile_X0Y2_E6BEG[0] _2433_/X VPWR VGND sg13cmos5l_buf_1
X_0825_ _0825_/Q Tile_X0Y3_FrameData[29] VGND VPWR Tile_X0Y5_FrameStrobe[1] latch
X_0756_ _0756_/Q Tile_X0Y2_FrameData[18] VGND VPWR Tile_X0Y5_FrameStrobe[6] latch
XANTENNA__2382__A2 Tile_X0Y3_W6END[7] VPWR VGND sg13cmos5l_antennanp
XFILLER_282_14 VPWR VGND sg13cmos5l_decap_8
XFILLER_282_25 VPWR VGND sg13cmos5l_fill_1
X_0687_ _0687_/Q Tile_X0Y2_FrameData[23] VGND VPWR Tile_X0Y5_FrameStrobe[4] latch
XANTENNA__1606__X Tile_X0Y0_N4BEG[2] VPWR VGND sg13cmos5l_antennanp
XFILLER_282_36 VPWR VGND sg13cmos5l_decap_8
XFILLER_288_167 VPWR VGND sg13cmos5l_decap_8
X_2426_ _2426_/X AXIL_S_SOC_AWADDR5 AXIL_S_SOC_AWADDR9 _2474_/X _2487_/X _0696_/Q
+ _0695_/Q VPWR VGND sg13cmos5l_mux4_1
XANTENNA__2134__A2 Tile_X0Y0_W6END[4] VPWR VGND sg13cmos5l_antennanp
XFILLER_229_201 VPWR VGND sg13cmos5l_fill_2
XFILLER_215_85 VPWR VGND sg13cmos5l_decap_8
X_2357_ _2357_/X _2344_/X _0031_/X _2343_/X Tile_X0Y0_S4END[5] _0340_/Q _0339_/Q VPWR
+ VGND sg13cmos5l_mux4_1
XFILLER_362_91 VPWR VGND sg13cmos5l_fill_1
X_1308_ _1308_/Q Tile_X0Y5_FrameData[20] VGND VPWR Tile_X0Y5_FrameStrobe[1] latch
X_2288_ _2288_/X _2588_/X _2587_/X _2580_/X _2579_/X _1006_/Q _1005_/Q VPWR VGND sg13cmos5l_mux4_1
XFILLER_56_136 VPWR VGND sg13cmos5l_decap_8
XANTENNA__1204__D Tile_X0Y4_FrameData[18] VPWR VGND sg13cmos5l_antennanp
X_1239_ _1239_/Q Tile_X0Y4_FrameData[15] VGND VPWR Tile_X0Y5_FrameStrobe[6] latch
XFILLER_71_139 VPWR VGND sg13cmos5l_decap_8
XFILLER_358_105 VPWR VGND sg13cmos5l_decap_4
XFILLER_100_55 VPWR VGND sg13cmos5l_decap_8
XFILLER_60_15 VPWR VGND sg13cmos5l_fill_2
XANTENNA__0182__GATE Tile_X0Y5_FrameStrobe[3] VPWR VGND sg13cmos5l_antennanp
XFILLER_100_99 VPWR VGND sg13cmos5l_decap_8
XFILLER_109_53 VPWR VGND sg13cmos5l_fill_1
XANTENNA__0197__GATE Tile_X0Y5_FrameStrobe[3] VPWR VGND sg13cmos5l_antennanp
XFILLER_109_75 VPWR VGND sg13cmos5l_decap_8
XFILLER_109_86 VPWR VGND sg13cmos5l_fill_2
XFILLER_109_97 VPWR VGND sg13cmos5l_fill_1
XFILLER_256_81 VPWR VGND sg13cmos5l_decap_8
XFILLER_133_163 VPWR VGND sg13cmos5l_fill_2
XFILLER_192_36 VPWR VGND sg13cmos5l_decap_4
XFILLER_192_47 VPWR VGND sg13cmos5l_decap_8
XANTENNA__2125__A2 Tile_X0Y1_W6END[3] VPWR VGND sg13cmos5l_antennanp
XFILLER_125_52 VPWR VGND sg13cmos5l_decap_8
XANTENNA__0120__GATE Tile_X0Y5_FrameStrobe[1] VPWR VGND sg13cmos5l_antennanp
XFILLER_125_63 VPWR VGND sg13cmos5l_fill_2
XFILLER_197_2 VPWR VGND sg13cmos5l_fill_1
XFILLER_272_80 VPWR VGND sg13cmos5l_decap_8
XFILLER_272_91 VPWR VGND sg13cmos5l_fill_1
XFILLER_342_28 VPWR VGND sg13cmos5l_decap_8
XANTENNA__0750__GATE Tile_X0Y5_FrameStrobe[6] VPWR VGND sg13cmos5l_antennanp
XFILLER_235_204 VPWR VGND sg13cmos5l_fill_1
XANTENNA__1114__D Tile_X0Y4_FrameData[12] VPWR VGND sg13cmos5l_antennanp
XANTENNA__1899__A Tile_X0Y1_FrameData[12] VPWR VGND sg13cmos5l_antennanp
XANTENNA__2833__A0 Tile_X0Y4_W1END[0] VPWR VGND sg13cmos5l_antennanp
XANTENNA__0135__GATE Tile_X0Y5_FrameStrobe[2] VPWR VGND sg13cmos5l_antennanp
XANTENNA__0953__D Tile_X0Y3_FrameData[29] VPWR VGND sg13cmos5l_antennanp
XFILLER_252_0 VPWR VGND sg13cmos5l_fill_1
XANTENNA__0765__GATE Tile_X0Y5_FrameStrobe[6] VPWR VGND sg13cmos5l_antennanp
XFILLER_70_172 VPWR VGND sg13cmos5l_fill_1
XFILLER_203_178 VPWR VGND sg13cmos5l_decap_8
XANTENNA__2082__X Tile_X0Y5_S4BEG[15] VPWR VGND sg13cmos5l_antennanp
XFILLER_171_214 VPWR VGND sg13cmos5l_fill_1
X_1590_ Tile_X0Y2_EE4BEG[3] _2420_/X VPWR VGND sg13cmos5l_buf_1
X_0610_ _0610_/Q Tile_X0Y2_FrameData[4] VGND VPWR Tile_X0Y5_FrameStrobe[1] latch
XANTENNA__0703__GATE Tile_X0Y5_FrameStrobe[4] VPWR VGND sg13cmos5l_antennanp
XFILLER_124_152 VPWR VGND sg13cmos5l_fill_2
X_0541_ _0541_/Q Tile_X0Y1_FrameData[25] VGND VPWR Tile_X0Y5_FrameStrobe[7] latch
XANTENNA__2116__A2 Tile_X0Y2_W6END[2] VPWR VGND sg13cmos5l_antennanp
X_0472_ _0472_/Q Tile_X0Y1_FrameData[30] VGND VPWR Tile_X0Y5_FrameStrobe[5] latch
XFILLER_182_80 VPWR VGND sg13cmos5l_decap_8
X_2211_ _2211_/X _2215_/X Tile_X0Y0_S1END[2] Tile_X0Y0_W6END[2] _2211_/A3 _0074_/Q
+ _0073_/Q VPWR VGND sg13cmos5l_mux4_1
XANTENNA__0718__GATE Tile_X0Y5_FrameStrobe[5] VPWR VGND sg13cmos5l_antennanp
XFILLER_226_215 VPWR VGND sg13cmos5l_fill_2
X_2142_ _2142_/X Tile_X0Y0_W1END[1] Tile_X0Y0_W6END[5] _2225_/X _2210_/X _0308_/Q
+ _0307_/Q VPWR VGND sg13cmos5l_mux4_1
XANTENNA__1024__D Tile_X0Y3_FrameData[22] VPWR VGND sg13cmos5l_antennanp
XFILLER_293_181 VPWR VGND sg13cmos5l_decap_8
X_2073_ Tile_X0Y5_S4BEG[6] _2073_/A VPWR VGND sg13cmos5l_buf_1
X_1024_ _1024_/Q Tile_X0Y3_FrameData[22] VGND VPWR Tile_X0Y5_FrameStrobe[7] latch
XFILLER_53_139 VPWR VGND sg13cmos5l_fill_2
XANTENNA__0863__D Tile_X0Y3_FrameData[23] VPWR VGND sg13cmos5l_antennanp
XANTENNA__2824__A0 Tile_X0Y5_N1END[0] VPWR VGND sg13cmos5l_antennanp
XFILLER_46_180 VPWR VGND sg13cmos5l_fill_1
XFILLER_277_58 VPWR VGND sg13cmos5l_decap_8
X_1926_ Tile_X0Y1_EE4BEG[7] _2316_/X VPWR VGND sg13cmos5l_buf_1
X_1857_ Tile_X0Y4_FrameData_O[24] Tile_X0Y4_FrameData[24] VPWR VGND sg13cmos5l_buf_1
XFILLER_293_13 VPWR VGND sg13cmos5l_fill_1
X_0808_ _0808_/Q Tile_X0Y3_FrameData[14] VGND VPWR Tile_X0Y5_FrameStrobe[0] latch
XANTENNA__2355__A2 Tile_X0Y5_WW4END[7] VPWR VGND sg13cmos5l_antennanp
X_1788_ Tile_X0Y4_E1BEG[3] _2616_/X VPWR VGND sg13cmos5l_buf_1
XANTENNA__0103__D Tile_X0Y0_FrameData[31] VPWR VGND sg13cmos5l_antennanp
X_0739_ _0739_/Q Tile_X0Y2_FrameData[3] VGND VPWR Tile_X0Y5_FrameStrobe[5] latch
XANTENNA__2107__A2 Tile_X0Y3_W6END[1] VPWR VGND sg13cmos5l_antennanp
X_2409_ _2409_/X AXIL_S_SOC_AWADDR0 AXIL_S_SOC_AWADDR8 _2481_/X _2488_/X _0730_/Q
+ _0729_/Q VPWR VGND sg13cmos5l_mux4_1
XFILLER_291_107 VPWR VGND sg13cmos5l_decap_8
XANTENNA__1480__GATE Tile_X0Y5_FrameStrobe[6] VPWR VGND sg13cmos5l_antennanp
XFILLER_242_50 VPWR VGND sg13cmos5l_fill_1
XFILLER_242_61 VPWR VGND sg13cmos5l_fill_2
XFILLER_29_147 VPWR VGND sg13cmos5l_decap_8
XFILLER_44_117 VPWR VGND sg13cmos5l_fill_1
XANTENNA__0773__D Tile_X0Y2_FrameData[1] VPWR VGND sg13cmos5l_antennanp
XANTENNA__2815__A0 Tile_X0Y1_W1END[3] VPWR VGND sg13cmos5l_antennanp
XFILLER_44_139 VPWR VGND sg13cmos5l_decap_8
XFILLER_197_100 VPWR VGND sg13cmos5l_fill_2
XANTENNA__1495__GATE Tile_X0Y5_FrameStrobe[7] VPWR VGND sg13cmos5l_antennanp
XFILLER_111_98 VPWR VGND sg13cmos5l_decap_8
XFILLER_197_177 VPWR VGND sg13cmos5l_fill_1
XFILLER_200_137 VPWR VGND sg13cmos5l_decap_4
XFILLER_187_69 VPWR VGND sg13cmos5l_decap_4
XFILLER_337_28 VPWR VGND sg13cmos5l_decap_8
XFILLER_354_185 VPWR VGND sg13cmos5l_decap_8
XANTENNA__1109__D Tile_X0Y4_FrameData[17] VPWR VGND sg13cmos5l_antennanp
XANTENNA__1433__GATE Tile_X0Y5_FrameStrobe[5] VPWR VGND sg13cmos5l_antennanp
XFILLER_121_133 VPWR VGND sg13cmos5l_decap_8
XFILLER_136_95 VPWR VGND sg13cmos5l_fill_2
XANTENNA__0948__D Tile_X0Y3_FrameData[2] VPWR VGND sg13cmos5l_antennanp
XFILLER_121_177 VPWR VGND sg13cmos5l_fill_1
XFILLER_96_77 VPWR VGND sg13cmos5l_decap_8
XFILLER_282_118 VPWR VGND sg13cmos5l_decap_8
XANTENNA__1448__GATE Tile_X0Y5_FrameStrobe[5] VPWR VGND sg13cmos5l_antennanp
XANTENNA__2077__X Tile_X0Y5_S4BEG[10] VPWR VGND sg13cmos5l_antennanp
XFILLER_29_93 VPWR VGND sg13cmos5l_decap_4
XANTENNA__0074__GATE Tile_X0Y5_FrameStrobe[0] VPWR VGND sg13cmos5l_antennanp
XFILLER_290_140 VPWR VGND sg13cmos5l_fill_1
XFILLER_35_117 VPWR VGND sg13cmos5l_decap_8
XANTENNA__2806__A0 Tile_X0Y5_N1END[2] VPWR VGND sg13cmos5l_antennanp
XANTENNA__0683__D Tile_X0Y2_FrameData[27] VPWR VGND sg13cmos5l_antennanp
XFILLER_45_81 VPWR VGND sg13cmos5l_fill_2
XFILLER_45_70 VPWR VGND sg13cmos5l_decap_8
XFILLER_43_150 VPWR VGND sg13cmos5l_decap_4
XANTENNA__0089__GATE Tile_X0Y5_FrameStrobe[0] VPWR VGND sg13cmos5l_antennanp
XFILLER_188_133 VPWR VGND sg13cmos5l_fill_2
XFILLER_43_183 VPWR VGND sg13cmos5l_decap_8
XFILLER_84_6 VPWR VGND sg13cmos5l_decap_8
X_2760_ _2760_/X Tile_X0Y5_N4END[3] _0057_/X _2814_/X _2813_/X _1382_/Q _1381_/Q VPWR
+ VGND sg13cmos5l_mux4_1
XFILLER_247_17 VPWR VGND sg13cmos5l_decap_4
X_1711_ Tile_X0Y0_E6BEG[3] _2200_/X VPWR VGND sg13cmos5l_buf_1
X_2691_ _2691_/X _2238_/X _2237_/X _2226_/X _2225_/X _0151_/Q _0150_/Q VPWR VGND sg13cmos5l_mux4_1
XANTENNA_2 AXIL_S_SOC_WDATA0 VPWR VGND sg13cmos5l_antennanp
XANTENNA__0642__GATE Tile_X0Y5_FrameStrobe[2] VPWR VGND sg13cmos5l_antennanp
X_1642_ Tile_X0Y0_FrameStrobe_O[2] Tile_X0Y5_FrameStrobe[2] VPWR VGND sg13cmos5l_buf_1
XANTENNA__2337__A2 Tile_X0Y1_W6END[0] VPWR VGND sg13cmos5l_antennanp
XFILLER_360_133 VPWR VGND sg13cmos5l_fill_1
XFILLER_360_122 VPWR VGND sg13cmos5l_decap_8
XFILLER_327_72 VPWR VGND sg13cmos5l_decap_4
XANTENNA__1019__D Tile_X0Y3_FrameData[27] VPWR VGND sg13cmos5l_antennanp
X_1573_ Tile_X0Y3_FrameData_O[19] Tile_X0Y3_FrameData[19] VPWR VGND sg13cmos5l_buf_1
XFILLER_258_104 VPWR VGND sg13cmos5l_decap_8
XFILLER_263_49 VPWR VGND sg13cmos5l_decap_8
X_0524_ _0524_/Q Tile_X0Y1_FrameData[10] VGND VPWR Tile_X0Y5_FrameStrobe[6] latch
XANTENNA__0657__GATE Tile_X0Y5_FrameStrobe[3] VPWR VGND sg13cmos5l_antennanp
XANTENNA__0858__D Tile_X0Y3_FrameData[28] VPWR VGND sg13cmos5l_antennanp
XFILLER_112_166 VPWR VGND sg13cmos5l_decap_4
X_0455_ _0455_/Q Tile_X0Y1_FrameData[15] VGND VPWR Tile_X0Y5_FrameStrobe[4] latch
XFILLER_13_0 VPWR VGND sg13cmos5l_fill_2
X_0386_ _0386_/Q Tile_X0Y1_FrameData[20] VGND VPWR Tile_X0Y5_FrameStrobe[2] latch
XFILLER_281_151 VPWR VGND sg13cmos5l_decap_4
X_2125_ AXIL_S_SOC_RDATA19 Tile_X0Y1_W2MID[3] Tile_X0Y1_W2END[3] Tile_X0Y1_W6END[3]
+ _2376_/X _0376_/Q _0375_/Q VPWR VGND sg13cmos5l_mux4_1
XFILLER_214_207 VPWR VGND sg13cmos5l_decap_8
XFILLER_281_184 VPWR VGND sg13cmos5l_fill_2
X_2056_ Tile_X0Y5_S2BEG[5] _2778_/X VPWR VGND sg13cmos5l_buf_1
XANTENNA__0593__D Tile_X0Y2_FrameData[21] VPWR VGND sg13cmos5l_antennanp
XANTENNA__2273__A1 Tile_X0Y2_WW4END[3] VPWR VGND sg13cmos5l_antennanp
X_1007_ _1007_/Q Tile_X0Y3_FrameData[7] VGND VPWR Tile_X0Y5_FrameStrobe[6] latch
XFILLER_179_199 VPWR VGND sg13cmos5l_fill_1
X_1909_ Tile_X0Y1_FrameData_O[22] Tile_X0Y1_FrameData[22] VPWR VGND sg13cmos5l_buf_1
XFILLER_135_214 VPWR VGND sg13cmos5l_fill_1
XFILLER_150_206 VPWR VGND sg13cmos5l_fill_2
XFILLER_351_177 VPWR VGND sg13cmos5l_fill_1
XFILLER_103_133 VPWR VGND sg13cmos5l_decap_4
XANTENNA__0768__D Tile_X0Y2_FrameData[6] VPWR VGND sg13cmos5l_antennanp
XFILLER_106_32 VPWR VGND sg13cmos5l_fill_2
XFILLER_249_148 VPWR VGND sg13cmos5l_decap_8
XFILLER_323_19 VPWR VGND sg13cmos5l_fill_1
XFILLER_106_87 VPWR VGND sg13cmos5l_decap_8
XANTENNA__2500__A2 Tile_X0Y4_W6END[2] VPWR VGND sg13cmos5l_antennanp
XFILLER_122_31 VPWR VGND sg13cmos5l_fill_2
XFILLER_205_207 VPWR VGND sg13cmos5l_fill_2
XANTENNA__2264__A1 Tile_X0Y1_W2END[0] VPWR VGND sg13cmos5l_antennanp
XFILLER_198_13 VPWR VGND sg13cmos5l_fill_2
XFILLER_272_195 VPWR VGND sg13cmos5l_decap_8
XFILLER_359_211 VPWR VGND sg13cmos5l_fill_1
XANTENNA__2803__A3 Tile_X0Y1_W6END[4] VPWR VGND sg13cmos5l_antennanp
XFILLER_198_35 VPWR VGND sg13cmos5l_decap_8
XFILLER_40_153 VPWR VGND sg13cmos5l_fill_1
XFILLER_40_175 VPWR VGND sg13cmos5l_decap_8
XFILLER_348_38 VPWR VGND sg13cmos5l_decap_4
XFILLER_327_152 VPWR VGND sg13cmos5l_fill_2
XFILLER_327_130 VPWR VGND sg13cmos5l_fill_1
XFILLER_215_0 VPWR VGND sg13cmos5l_fill_1
XFILLER_342_111 VPWR VGND sg13cmos5l_fill_2
XFILLER_342_100 VPWR VGND sg13cmos5l_decap_8
XANTENNA__1372__GATE Tile_X0Y5_FrameStrobe[3] VPWR VGND sg13cmos5l_antennanp
XFILLER_147_83 VPWR VGND sg13cmos5l_fill_2
XFILLER_49_9 VPWR VGND sg13cmos5l_fill_2
XANTENNA__0678__D Tile_X0Y2_FrameData[0] VPWR VGND sg13cmos5l_antennanp
XANTENNA__1387__GATE Tile_X0Y5_FrameStrobe[3] VPWR VGND sg13cmos5l_antennanp
XANTENNA__1704__X Tile_X0Y0_EE4BEG[12] VPWR VGND sg13cmos5l_antennanp
X_0240_ _0240_/Q Tile_X0Y0_FrameData[22] VGND VPWR Tile_X0Y5_FrameStrobe[5] latch
XFILLER_163_93 VPWR VGND sg13cmos5l_decap_4
XFILLER_313_30 VPWR VGND sg13cmos5l_decap_4
X_0171_ _0171_/Q Tile_X0Y0_FrameData[27] VGND VPWR Tile_X0Y5_FrameStrobe[3] latch
XANTENNA__1310__GATE Tile_X0Y5_FrameStrobe[1] VPWR VGND sg13cmos5l_antennanp
XFILLER_263_162 VPWR VGND sg13cmos5l_decap_8
XFILLER_263_173 VPWR VGND sg13cmos5l_fill_1
XANTENNA__2255__A1 Tile_X0Y2_W2END[4] VPWR VGND sg13cmos5l_antennanp
XANTENNA__1302__D Tile_X0Y5_FrameData[26] VPWR VGND sg13cmos5l_antennanp
XANTENNA__1325__GATE Tile_X0Y5_FrameStrobe[1] VPWR VGND sg13cmos5l_antennanp
XFILLER_176_103 VPWR VGND sg13cmos5l_fill_1
XFILLER_258_16 VPWR VGND sg13cmos5l_decap_4
XFILLER_176_125 VPWR VGND sg13cmos5l_fill_1
XFILLER_176_147 VPWR VGND sg13cmos5l_decap_8
XFILLER_258_49 VPWR VGND sg13cmos5l_fill_2
X_2812_ _2812_/X _2368_/X _2366_/X _2354_/X _2353_/X _0388_/Q _0387_/Q VPWR VGND sg13cmos5l_mux4_1
XFILLER_176_158 VPWR VGND sg13cmos5l_fill_2
X_2743_ _2743_/X AXIL_S_SOC_ARPROT2 AXIL_S_SOC_RREADY _2809_/X _2799_/X _1416_/Q _1415_/Q
+ VPWR VGND sg13cmos5l_mux4_1
XFILLER_318_130 VPWR VGND sg13cmos5l_fill_2
XANTENNA__0581__GATE Tile_X0Y5_FrameStrobe[0] VPWR VGND sg13cmos5l_antennanp
X_2674_ _2674_/X Tile_X0Y5_W1END[0] Tile_X0Y5_W6END[4] _2813_/X _2789_/X _1496_/Q
+ _1495_/Q VPWR VGND sg13cmos5l_mux4_1
X_1625_ Tile_X0Y0_N2BEGb[5] _2260_/X VPWR VGND sg13cmos5l_buf_1
XANTENNA__0596__GATE Tile_X0Y5_FrameStrobe[1] VPWR VGND sg13cmos5l_antennanp
X_1556_ Tile_X0Y3_FrameData_O[2] Tile_X0Y3_FrameData[2] VPWR VGND sg13cmos5l_buf_1
XANTENNA__0588__D Tile_X0Y2_FrameData[26] VPWR VGND sg13cmos5l_antennanp
XANTENNA__2191__A0 AXIL_S_SOC_WDATA22 VPWR VGND sg13cmos5l_antennanp
X_0507_ _0507_/Q Tile_X0Y1_FrameData[27] VGND VPWR Tile_X0Y5_FrameStrobe[6] latch
XFILLER_98_142 VPWR VGND sg13cmos5l_decap_8
XANTENNA__1614__X Tile_X0Y0_N4BEG[10] VPWR VGND sg13cmos5l_antennanp
XFILLER_246_107 VPWR VGND sg13cmos5l_fill_2
X_1487_ _1487_/Q Tile_X0Y5_FrameData[1] VGND VPWR Tile_X0Y5_FrameStrobe[6] latch
XFILLER_98_175 VPWR VGND sg13cmos5l_decap_8
X_0438_ _0438_/Q Tile_X0Y1_FrameData[0] VGND VPWR Tile_X0Y5_FrameStrobe[3] latch
XANTENNA__2494__A1 Tile_X0Y4_W2END[5] VPWR VGND sg13cmos5l_antennanp
XFILLER_223_63 VPWR VGND sg13cmos5l_decap_8
X_0369_ _0369_/Q Tile_X0Y1_FrameData[5] VGND VPWR Tile_X0Y5_FrameStrobe[1] latch
X_2108_ AXIL_S_SOC_RDATA2 Tile_X0Y3_W2MID[2] Tile_X0Y3_W2END[2] Tile_X0Y3_W6END[2]
+ _2591_/X _0858_/Q _0857_/Q VPWR VGND sg13cmos5l_mux4_1
XFILLER_54_223 VPWR VGND sg13cmos5l_fill_1
XFILLER_299_67 VPWR VGND sg13cmos5l_fill_2
XFILLER_299_56 VPWR VGND sg13cmos5l_fill_1
XANTENNA__0534__GATE Tile_X0Y5_FrameStrobe[6] VPWR VGND sg13cmos5l_antennanp
XANTENNA__1212__D Tile_X0Y4_FrameData[10] VPWR VGND sg13cmos5l_antennanp
X_2039_ Tile_X0Y5_FrameData_O[24] Tile_X0Y5_FrameData[24] VPWR VGND sg13cmos5l_buf_1
XANTENNA__0549__GATE Tile_X0Y5_FrameStrobe[7] VPWR VGND sg13cmos5l_antennanp
XFILLER_108_203 VPWR VGND sg13cmos5l_fill_2
XFILLER_182_139 VPWR VGND sg13cmos5l_decap_8
XFILLER_175_191 VPWR VGND sg13cmos5l_decap_8
XFILLER_324_122 VPWR VGND sg13cmos5l_fill_1
XFILLER_123_217 VPWR VGND sg13cmos5l_fill_1
XFILLER_184_37 VPWR VGND sg13cmos5l_fill_2
XANTENNA__0498__D Tile_X0Y1_FrameData[4] VPWR VGND sg13cmos5l_antennanp
XANTENNA__2182__A0 AXIL_S_SOC_WDATA17 VPWR VGND sg13cmos5l_antennanp
XANTENNA__2721__A2 Tile_X0Y5_WW4END[4] VPWR VGND sg13cmos5l_antennanp
XFILLER_277_210 VPWR VGND sg13cmos5l_fill_2
XFILLER_89_164 VPWR VGND sg13cmos5l_decap_8
XANTENNA__1524__X Tile_X0Y3_E2BEGb[6] VPWR VGND sg13cmos5l_antennanp
XFILLER_237_118 VPWR VGND sg13cmos5l_decap_8
XFILLER_350_28 VPWR VGND sg13cmos5l_decap_8
XFILLER_93_56 VPWR VGND sg13cmos5l_decap_4
XFILLER_260_132 VPWR VGND sg13cmos5l_decap_8
XFILLER_93_67 VPWR VGND sg13cmos5l_decap_8
XANTENNA__1122__D Tile_X0Y4_FrameData[4] VPWR VGND sg13cmos5l_antennanp
XFILLER_260_154 VPWR VGND sg13cmos5l_decap_8
XFILLER_260_165 VPWR VGND sg13cmos5l_fill_1
XFILLER_158_103 VPWR VGND sg13cmos5l_decap_8
XFILLER_260_187 VPWR VGND sg13cmos5l_fill_1
XFILLER_332_0 VPWR VGND sg13cmos5l_decap_8
XANTENNA__0961__D Tile_X0Y3_FrameData[21] VPWR VGND sg13cmos5l_antennanp
XFILLER_158_114 VPWR VGND sg13cmos5l_fill_1
XFILLER_158_158 VPWR VGND sg13cmos5l_decap_8
XANTENNA__2090__X Tile_X0Y3_E2BEG[2] VPWR VGND sg13cmos5l_antennanp
XFILLER_228_19 VPWR VGND sg13cmos5l_decap_4
XFILLER_315_100 VPWR VGND sg13cmos5l_decap_4
XFILLER_158_82 VPWR VGND sg13cmos5l_decap_8
XFILLER_114_206 VPWR VGND sg13cmos5l_fill_1
X_1410_ _1410_/Q Tile_X0Y5_FrameData[14] VGND VPWR Tile_X0Y5_FrameStrobe[4] latch
XANTENNA__2173__A0 AXIL_S_SOC_WDATA16 VPWR VGND sg13cmos5l_antennanp
XFILLER_174_81 VPWR VGND sg13cmos5l_decap_8
X_2390_ _2390_/X Tile_X0Y3_W2MID[3] Tile_X0Y3_W2END[3] Tile_X0Y3_W6END[3] _2593_/X
+ _1014_/Q _1013_/Q VPWR VGND sg13cmos5l_mux4_1
XFILLER_3_21 VPWR VGND sg13cmos5l_fill_2
XANTENNA__0201__D Tile_X0Y0_FrameData[29] VPWR VGND sg13cmos5l_antennanp
X_1341_ _1341_/Q Tile_X0Y5_FrameData[19] VGND VPWR Tile_X0Y5_FrameStrobe[2] latch
XFILLER_3_65 VPWR VGND sg13cmos5l_fill_1
X_1272_ _1272_/Q Tile_X0Y5_FrameData[24] VGND VPWR Tile_X0Y5_FrameStrobe[0] latch
XANTENNA__2476__A1 Tile_X0Y5_N4END[14] VPWR VGND sg13cmos5l_antennanp
X_0223_ _0223_/Q Tile_X0Y0_FrameData[7] VGND VPWR Tile_X0Y5_FrameStrobe[4] latch
XFILLER_95_178 VPWR VGND sg13cmos5l_decap_8
XFILLER_95_167 VPWR VGND sg13cmos5l_decap_4
XFILLER_236_173 VPWR VGND sg13cmos5l_decap_8
X_0154_ _0154_/Q Tile_X0Y0_FrameData[12] VGND VPWR Tile_X0Y5_FrameStrobe[2] latch
XFILLER_340_50 VPWR VGND sg13cmos5l_decap_8
XANTENNA__1032__D Tile_X0Y4_FrameData[30] VPWR VGND sg13cmos5l_antennanp
X_0085_ _0085_/Q Tile_X0Y0_FrameData[17] VGND VPWR Tile_X0Y5_FrameStrobe[0] latch
XANTENNA__1264__GATE Tile_X0Y5_FrameStrobe[7] VPWR VGND sg13cmos5l_antennanp
XANTENNA__2779__A2 Tile_X0Y5_W2END[1] VPWR VGND sg13cmos5l_antennanp
XANTENNA__0871__D Tile_X0Y3_FrameData[15] VPWR VGND sg13cmos5l_antennanp
XANTENNA__1279__GATE Tile_X0Y5_FrameStrobe[0] VPWR VGND sg13cmos5l_antennanp
XANTENNA__1609__X Tile_X0Y0_N4BEG[5] VPWR VGND sg13cmos5l_antennanp
X_0987_ _0987_/Q Tile_X0Y3_FrameData[27] VGND VPWR Tile_X0Y5_FrameStrobe[6] latch
X_2726_ _2726_/X AXIL_S_SOC_ARPROT1 AXIL_S_SOC_RREADY _2826_/X _2798_/X _1450_/Q _1449_/Q
+ VPWR VGND sg13cmos5l_mux4_1
X_2657_ _2657_/X AXIL_S_SOC_WSTRB0 _2702_/X _2700_/X _2712_/X _1140_/Q _1139_/Q VPWR
+ VGND sg13cmos5l_mux4_1
XFILLER_306_144 VPWR VGND sg13cmos5l_fill_2
XANTENNA__1202__GATE Tile_X0Y5_FrameStrobe[5] VPWR VGND sg13cmos5l_antennanp
XFILLER_172_194 VPWR VGND sg13cmos5l_decap_8
X_1608_ Tile_X0Y0_N4BEG[4] _1608_/A VPWR VGND sg13cmos5l_buf_1
X_2588_ _2588_/X _2566_/X Tile_X0Y5_N4END[8] _2565_/X Tile_X0Y0_S4END[12] _0846_/Q
+ _0845_/Q VPWR VGND sg13cmos5l_mux4_1
XANTENNA__0111__D Tile_X0Y0_FrameData[23] VPWR VGND sg13cmos5l_antennanp
XANTENNA__1207__D Tile_X0Y4_FrameData[15] VPWR VGND sg13cmos5l_antennanp
X_1539_ Tile_X0Y3_EE4BEG[1] _2526_/X VPWR VGND sg13cmos5l_buf_1
XFILLER_234_73 VPWR VGND sg13cmos5l_decap_8
XFILLER_86_134 VPWR VGND sg13cmos5l_decap_8
XANTENNA__1217__GATE Tile_X0Y5_FrameStrobe[5] VPWR VGND sg13cmos5l_antennanp
XANTENNA__2467__A1 Tile_X0Y5_N4END[14] VPWR VGND sg13cmos5l_antennanp
XFILLER_170_39 VPWR VGND sg13cmos5l_decap_8
XFILLER_27_201 VPWR VGND sg13cmos5l_decap_4
XFILLER_86_178 VPWR VGND sg13cmos5l_decap_8
XFILLER_27_212 VPWR VGND sg13cmos5l_fill_2
XFILLER_27_223 VPWR VGND sg13cmos5l_fill_1
XANTENNA__0473__GATE Tile_X0Y5_FrameStrobe[5] VPWR VGND sg13cmos5l_antennanp
XFILLER_103_55 VPWR VGND sg13cmos5l_decap_8
XANTENNA__2219__A1 Tile_X0Y4_WW4END[0] VPWR VGND sg13cmos5l_antennanp
XFILLER_103_99 VPWR VGND sg13cmos5l_decap_8
XFILLER_179_15 VPWR VGND sg13cmos5l_fill_1
XFILLER_250_83 VPWR VGND sg13cmos5l_fill_2
XFILLER_256_7 VPWR VGND sg13cmos5l_decap_8
XFILLER_151_6 VPWR VGND sg13cmos5l_decap_4
XANTENNA__0488__GATE Tile_X0Y5_FrameStrobe[5] VPWR VGND sg13cmos5l_antennanp
XANTENNA__0781__D Tile_X0Y2_FrameData[25] VPWR VGND sg13cmos5l_antennanp
XFILLER_329_18 VPWR VGND sg13cmos5l_fill_2
XANTENNA__0411__GATE Tile_X0Y5_FrameStrobe[3] VPWR VGND sg13cmos5l_antennanp
XFILLER_148_191 VPWR VGND sg13cmos5l_decap_8
XFILLER_155_139 VPWR VGND sg13cmos5l_decap_8
XFILLER_128_63 VPWR VGND sg13cmos5l_fill_2
XFILLER_345_17 VPWR VGND sg13cmos5l_decap_4
XFILLER_345_39 VPWR VGND sg13cmos5l_decap_8
XANTENNA__2155__A0 Tile_X0Y0_W1END[1] VPWR VGND sg13cmos5l_antennanp
XANTENNA__0426__GATE Tile_X0Y5_FrameStrobe[3] VPWR VGND sg13cmos5l_antennanp
XANTENNA__1117__D Tile_X0Y4_FrameData[9] VPWR VGND sg13cmos5l_antennanp
XFILLER_77_112 VPWR VGND sg13cmos5l_fill_1
XFILLER_77_145 VPWR VGND sg13cmos5l_decap_4
XFILLER_320_180 VPWR VGND sg13cmos5l_decap_4
XANTENNA__0956__D Tile_X0Y3_FrameData[26] VPWR VGND sg13cmos5l_antennanp
XANTENNA__2458__A1 Tile_X0Y3_W6END[4] VPWR VGND sg13cmos5l_antennanp
XFILLER_280_205 VPWR VGND sg13cmos5l_decap_8
XFILLER_160_61 VPWR VGND sg13cmos5l_decap_8
XFILLER_92_159 VPWR VGND sg13cmos5l_decap_8
XANTENNA__2085__X Tile_X0Y3_E1BEG[1] VPWR VGND sg13cmos5l_antennanp
XFILLER_310_53 VPWR VGND sg13cmos5l_decap_8
XANTENNA__0691__D Tile_X0Y2_FrameData[19] VPWR VGND sg13cmos5l_antennanp
X_0910_ _0910_/Q Tile_X0Y3_FrameData[8] VGND VPWR Tile_X0Y5_FrameStrobe[3] latch
XANTENNA__2630__A1 AXIL_S_SOC_BREADY VPWR VGND sg13cmos5l_antennanp
XFILLER_239_18 VPWR VGND sg13cmos5l_fill_1
XFILLER_239_29 VPWR VGND sg13cmos5l_fill_2
X_1890_ Tile_X0Y1_FrameData_O[3] Tile_X0Y1_FrameData[3] VPWR VGND sg13cmos5l_buf_1
XFILLER_53_92 VPWR VGND sg13cmos5l_fill_1
XFILLER_146_106 VPWR VGND sg13cmos5l_fill_1
XFILLER_146_128 VPWR VGND sg13cmos5l_decap_8
X_0841_ _0841_/Q Tile_X0Y3_FrameData[13] VGND VPWR Tile_X0Y5_FrameStrobe[1] latch
X_0772_ _0772_/Q Tile_X0Y2_FrameData[2] VGND VPWR Tile_X0Y5_FrameStrobe[6] latch
XFILLER_319_51 VPWR VGND sg13cmos5l_decap_8
XANTENNA__2394__A0 Tile_X0Y3_W2MID[1] VPWR VGND sg13cmos5l_antennanp
XFILLER_255_17 VPWR VGND sg13cmos5l_decap_8
XFILLER_255_28 VPWR VGND sg13cmos5l_fill_1
X_2511_ _2511_/X AXIL_S_SOC_ARADDR0 AXIL_S_SOC_ARADDR2 _2591_/X _2594_/X _0982_/Q
+ _0981_/Q VPWR VGND sg13cmos5l_mux4_1
XFILLER_255_39 VPWR VGND sg13cmos5l_fill_2
XFILLER_303_114 VPWR VGND sg13cmos5l_fill_2
XANTENNA__2146__A0 Tile_X0Y0_W2MID[6] VPWR VGND sg13cmos5l_antennanp
X_2442_ _2442_/X AXIL_S_SOC_AWADDR1 _2476_/X _2474_/X _2486_/X _0664_/Q _0663_/Q VPWR
+ VGND sg13cmos5l_mux4_1
XFILLER_303_136 VPWR VGND sg13cmos5l_decap_8
XANTENNA__1027__D Tile_X0Y3_FrameData[19] VPWR VGND sg13cmos5l_antennanp
XANTENNA__2697__A1 Tile_X0Y5_N4END[4] VPWR VGND sg13cmos5l_antennanp
X_2373_ _2373_/X _2249_/X _2382_/X _2381_/X Tile_X0Y0_S2MID[0] _0334_/Q _0333_/Q VPWR
+ VGND sg13cmos5l_mux4_1
XANTENNA__2161__A3 AXIL_S_SOC_WDATA23 VPWR VGND sg13cmos5l_antennanp
X_1324_ _1324_/Q Tile_X0Y5_FrameData[4] VGND VPWR Tile_X0Y5_FrameStrobe[1] latch
XANTENNA__0866__D Tile_X0Y3_FrameData[20] VPWR VGND sg13cmos5l_antennanp
XFILLER_204_21 VPWR VGND sg13cmos5l_decap_8
XFILLER_68_189 VPWR VGND sg13cmos5l_fill_2
XANTENNA__2449__A1 Tile_X0Y2_WW4END[10] VPWR VGND sg13cmos5l_antennanp
XFILLER_209_162 VPWR VGND sg13cmos5l_decap_8
X_1255_ _1255_/Q Tile_X0Y4_FrameData[31] VGND VPWR Tile_X0Y5_FrameStrobe[7] latch
X_1186_ _1186_/Q Tile_X0Y4_FrameData[4] VGND VPWR Tile_X0Y5_FrameStrobe[4] latch
X_0206_ _0206_/Q Tile_X0Y0_FrameData[24] VGND VPWR Tile_X0Y5_FrameStrobe[4] latch
X_0137_ _0137_/Q Tile_X0Y0_FrameData[29] VGND VPWR Tile_X0Y5_FrameStrobe[2] latch
XFILLER_91_181 VPWR VGND sg13cmos5l_decap_8
XFILLER_220_53 VPWR VGND sg13cmos5l_decap_8
XFILLER_224_176 VPWR VGND sg13cmos5l_decap_8
X_0068_ _2073_/A _2557_/X _2558_/X _0866_/Q VPWR VGND sg13cmos5l_mux2_1
XANTENNA__2621__A1 AXIL_S_SOC_WVALID VPWR VGND sg13cmos5l_antennanp
XANTENNA__0106__D Tile_X0Y0_FrameData[28] VPWR VGND sg13cmos5l_antennanp
XFILLER_137_139 VPWR VGND sg13cmos5l_fill_1
XANTENNA__1141__GATE Tile_X0Y5_FrameStrobe[3] VPWR VGND sg13cmos5l_antennanp
XANTENNA__2385__A0 Tile_X0Y0_W2MID[5] VPWR VGND sg13cmos5l_antennanp
XFILLER_145_161 VPWR VGND sg13cmos5l_decap_8
X_2709_ _2709_/X _2600_/X Tile_X0Y5_N2MID[1] _2714_/X _2599_/X _1052_/Q _1051_/Q VPWR
+ VGND sg13cmos5l_mux4_1
XANTENNA__2137__A0 Tile_X0Y0_W2MID[7] VPWR VGND sg13cmos5l_antennanp
XFILLER_160_142 VPWR VGND sg13cmos5l_decap_8
XANTENNA__2688__A1 Tile_X0Y5_N4END[6] VPWR VGND sg13cmos5l_antennanp
XFILLER_245_72 VPWR VGND sg13cmos5l_decap_4
XANTENNA__1156__GATE Tile_X0Y5_FrameStrobe[3] VPWR VGND sg13cmos5l_antennanp
XFILLER_302_180 VPWR VGND sg13cmos5l_decap_8
XANTENNA__0776__D Tile_X0Y2_FrameData[30] VPWR VGND sg13cmos5l_antennanp
XFILLER_114_10 VPWR VGND sg13cmos5l_fill_2
XFILLER_199_6 VPWR VGND sg13cmos5l_decap_4
XFILLER_59_167 VPWR VGND sg13cmos5l_decap_8
XANTENNA__1802__X Tile_X0Y4_E2BEGb[5] VPWR VGND sg13cmos5l_antennanp
XFILLER_262_216 VPWR VGND sg13cmos5l_fill_2
XFILLER_74_47 VPWR VGND sg13cmos5l_decap_8
XFILLER_82_192 VPWR VGND sg13cmos5l_decap_8
XFILLER_130_75 VPWR VGND sg13cmos5l_decap_8
XFILLER_90_13 VPWR VGND sg13cmos5l_decap_8
XANTENNA__1400__D Tile_X0Y5_FrameData[24] VPWR VGND sg13cmos5l_antennanp
XANTENNA__2612__A1 Tile_X0Y5_W2END[0] VPWR VGND sg13cmos5l_antennanp
XANTENNA__0350__GATE Tile_X0Y5_FrameStrobe[1] VPWR VGND sg13cmos5l_antennanp
XFILLER_128_0 VPWR VGND sg13cmos5l_fill_2
XANTENNA__0980__GATE Tile_X0Y5_FrameStrobe[5] VPWR VGND sg13cmos5l_antennanp
XANTENNA__1109__GATE Tile_X0Y5_FrameStrobe[2] VPWR VGND sg13cmos5l_antennanp
XFILLER_99_55 VPWR VGND sg13cmos5l_decap_8
XFILLER_356_49 VPWR VGND sg13cmos5l_decap_8
XFILLER_136_183 VPWR VGND sg13cmos5l_decap_8
XANTENNA__0365__GATE Tile_X0Y5_FrameStrobe[1] VPWR VGND sg13cmos5l_antennanp
XANTENNA__2128__A0 Tile_X0Y1_W2MID[6] VPWR VGND sg13cmos5l_antennanp
XFILLER_151_131 VPWR VGND sg13cmos5l_fill_1
XFILLER_151_153 VPWR VGND sg13cmos5l_decap_8
XFILLER_155_50 VPWR VGND sg13cmos5l_decap_8
XFILLER_297_113 VPWR VGND sg13cmos5l_decap_8
XANTENNA__0995__GATE Tile_X0Y5_FrameStrobe[6] VPWR VGND sg13cmos5l_antennanp
XANTENNA__2679__A1 Tile_X0Y3_W6END[11] VPWR VGND sg13cmos5l_antennanp
XFILLER_155_83 VPWR VGND sg13cmos5l_decap_8
XFILLER_238_202 VPWR VGND sg13cmos5l_fill_1
XFILLER_238_213 VPWR VGND sg13cmos5l_fill_2
XFILLER_300_128 VPWR VGND sg13cmos5l_fill_2
XANTENNA__0686__D Tile_X0Y2_FrameData[24] VPWR VGND sg13cmos5l_antennanp
XFILLER_305_86 VPWR VGND sg13cmos5l_fill_2
XFILLER_305_75 VPWR VGND sg13cmos5l_fill_2
XANTENNA__1712__X Tile_X0Y0_E6BEG[4] VPWR VGND sg13cmos5l_antennanp
XFILLER_171_60 VPWR VGND sg13cmos5l_fill_2
XFILLER_65_126 VPWR VGND sg13cmos5l_fill_1
XANTENNA__2300__A0 AXIL_S_SOC_WDATA7 VPWR VGND sg13cmos5l_antennanp
X_1040_ _1040_/Q Tile_X0Y4_FrameData[22] VGND VPWR Tile_X0Y5_FrameStrobe[0] latch
XFILLER_65_159 VPWR VGND sg13cmos5l_fill_1
XFILLER_321_41 VPWR VGND sg13cmos5l_decap_8
XANTENNA__0303__GATE Tile_X0Y5_FrameStrobe[7] VPWR VGND sg13cmos5l_antennanp
XFILLER_73_181 VPWR VGND sg13cmos5l_decap_8
XANTENNA__0933__GATE Tile_X0Y5_FrameStrobe[4] VPWR VGND sg13cmos5l_antennanp
XFILLER_221_124 VPWR VGND sg13cmos5l_decap_8
XANTENNA__1310__D Tile_X0Y5_FrameData[18] VPWR VGND sg13cmos5l_antennanp
XANTENNA__2603__A1 Tile_X0Y2_W2END[4] VPWR VGND sg13cmos5l_antennanp
X_1942_ Tile_X0Y1_E6BEG[7] _2332_/X VPWR VGND sg13cmos5l_buf_1
XANTENNA__0318__GATE Tile_X0Y5_FrameStrobe[0] VPWR VGND sg13cmos5l_antennanp
X_1873_ Tile_X0Y2_E2BEGb[7] _2416_/X VPWR VGND sg13cmos5l_buf_1
XANTENNA__0948__GATE Tile_X0Y5_FrameStrobe[4] VPWR VGND sg13cmos5l_antennanp
X_0824_ _0824_/Q Tile_X0Y3_FrameData[30] VGND VPWR Tile_X0Y5_FrameStrobe[1] latch
XFILLER_288_102 VPWR VGND sg13cmos5l_fill_1
X_0755_ _0755_/Q Tile_X0Y2_FrameData[19] VGND VPWR Tile_X0Y5_FrameStrobe[6] latch
XANTENNA__2119__A0 Tile_X0Y2_W2MID[5] VPWR VGND sg13cmos5l_antennanp
X_0686_ _0686_/Q Tile_X0Y2_FrameData[24] VGND VPWR Tile_X0Y5_FrameStrobe[4] latch
XFILLER_43_0 VPWR VGND sg13cmos5l_fill_2
XFILLER_346_82 VPWR VGND sg13cmos5l_decap_8
X_2425_ _2425_/X AXIL_S_SOC_AWADDR4 AXIL_S_SOC_AWADDR8 _2473_/X _2488_/X _0698_/Q
+ _0697_/Q VPWR VGND sg13cmos5l_mux4_1
XFILLER_142_197 VPWR VGND sg13cmos5l_decap_8
XFILLER_215_20 VPWR VGND sg13cmos5l_fill_2
XANTENNA__0596__D Tile_X0Y2_FrameData[18] VPWR VGND sg13cmos5l_antennanp
XFILLER_215_64 VPWR VGND sg13cmos5l_decap_8
X_2356_ _2356_/X _2822_/X _2821_/X _2810_/X _2809_/X _1469_/Q _1468_/Q VPWR VGND sg13cmos5l_mux4_1
XANTENNA__1622__X Tile_X0Y0_N2BEGb[2] VPWR VGND sg13cmos5l_antennanp
XFILLER_244_205 VPWR VGND sg13cmos5l_decap_8
X_1307_ _1307_/Q Tile_X0Y5_FrameData[21] VGND VPWR Tile_X0Y5_FrameStrobe[1] latch
X_2287_ _2287_/X Tile_X0Y3_W1END[0] Tile_X0Y3_WW4END[0] Tile_X0Y3_WW4END[4] Tile_X0Y3_W6END[8]
+ _1006_/Q _1005_/Q VPWR VGND sg13cmos5l_mux4_1
XFILLER_56_115 VPWR VGND sg13cmos5l_decap_8
X_1238_ _1238_/Q Tile_X0Y4_FrameData[16] VGND VPWR Tile_X0Y5_FrameStrobe[6] latch
XFILLER_71_107 VPWR VGND sg13cmos5l_decap_4
XFILLER_231_85 VPWR VGND sg13cmos5l_decap_8
X_1169_ _1169_/Q Tile_X0Y4_FrameData[21] VGND VPWR Tile_X0Y5_FrameStrobe[4] latch
XANTENNA__1220__D Tile_X0Y4_FrameData[2] VPWR VGND sg13cmos5l_antennanp
XFILLER_100_34 VPWR VGND sg13cmos5l_decap_8
XFILLER_358_139 VPWR VGND sg13cmos5l_fill_1
XANTENNA__1080__GATE Tile_X0Y5_FrameStrobe[1] VPWR VGND sg13cmos5l_antennanp
XFILLER_118_150 VPWR VGND sg13cmos5l_fill_1
XFILLER_118_172 VPWR VGND sg13cmos5l_decap_8
XFILLER_256_60 VPWR VGND sg13cmos5l_decap_8
XANTENNA__2373__A3 Tile_X0Y0_S2MID[0] VPWR VGND sg13cmos5l_antennanp
XFILLER_133_142 VPWR VGND sg13cmos5l_decap_8
XFILLER_69_36 VPWR VGND sg13cmos5l_decap_8
XANTENNA__1095__GATE Tile_X0Y5_FrameStrobe[2] VPWR VGND sg13cmos5l_antennanp
XFILLER_133_186 VPWR VGND sg13cmos5l_decap_8
XFILLER_279_146 VPWR VGND sg13cmos5l_fill_1
XFILLER_79_207 VPWR VGND sg13cmos5l_decap_8
XFILLER_279_179 VPWR VGND sg13cmos5l_fill_2
XANTENNA__2530__A0 AXIL_S_SOC_ARADDR5 VPWR VGND sg13cmos5l_antennanp
XANTENNA__1532__X Tile_X0Y3_E6BEG[6] VPWR VGND sg13cmos5l_antennanp
XFILLER_125_97 VPWR VGND sg13cmos5l_decap_8
XFILLER_62_129 VPWR VGND sg13cmos5l_decap_8
XANTENNA__2833__A1 Tile_X0Y4_W2MID[3] VPWR VGND sg13cmos5l_antennanp
XFILLER_55_181 VPWR VGND sg13cmos5l_fill_2
XANTENNA__1033__GATE Tile_X0Y5_FrameStrobe[0] VPWR VGND sg13cmos5l_antennanp
XFILLER_245_0 VPWR VGND sg13cmos5l_decap_4
XANTENNA__1130__D Tile_X0Y4_FrameData[28] VPWR VGND sg13cmos5l_antennanp
XFILLER_70_184 VPWR VGND sg13cmos5l_fill_1
XFILLER_34_61 VPWR VGND sg13cmos5l_decap_8
XANTENNA__2597__A0 Tile_X0Y2_W2MID[7] VPWR VGND sg13cmos5l_antennanp
XFILLER_34_83 VPWR VGND sg13cmos5l_fill_2
XANTENNA__1048__GATE Tile_X0Y5_FrameStrobe[0] VPWR VGND sg13cmos5l_antennanp
XANTENNA__1707__X Tile_X0Y0_EE4BEG[15] VPWR VGND sg13cmos5l_antennanp
XFILLER_109_172 VPWR VGND sg13cmos5l_decap_8
XFILLER_166_60 VPWR VGND sg13cmos5l_decap_8
XFILLER_236_19 VPWR VGND sg13cmos5l_fill_2
X_0540_ _0540_/Q Tile_X0Y1_FrameData[26] VGND VPWR Tile_X0Y5_FrameStrobe[7] latch
XFILLER_316_30 VPWR VGND sg13cmos5l_decap_4
X_2210_ _2210_/X _2214_/X Tile_X0Y0_S1END[1] Tile_X0Y0_W6END[1] _2210_/A3 _0076_/Q
+ _0075_/Q VPWR VGND sg13cmos5l_mux4_1
X_0471_ _0471_/Q Tile_X0Y1_FrameData[31] VGND VPWR Tile_X0Y5_FrameStrobe[5] latch
XFILLER_316_96 VPWR VGND sg13cmos5l_decap_4
XANTENNA__2521__A0 AXIL_S_SOC_ARADDR2 VPWR VGND sg13cmos5l_antennanp
XANTENNA__1305__D Tile_X0Y5_FrameData[23] VPWR VGND sg13cmos5l_antennanp
X_2141_ _2141_/X Tile_X0Y0_W1END[0] Tile_X0Y0_W6END[4] _2229_/X _2209_/X _0310_/Q
+ _0309_/Q VPWR VGND sg13cmos5l_mux4_1
XFILLER_93_221 VPWR VGND sg13cmos5l_fill_2
XFILLER_332_40 VPWR VGND sg13cmos5l_fill_1
X_2072_ Tile_X0Y5_S4BEG[5] _2072_/A VPWR VGND sg13cmos5l_buf_1
XFILLER_332_62 VPWR VGND sg13cmos5l_fill_2
XFILLER_332_51 VPWR VGND sg13cmos5l_decap_8
XANTENNA__0242__GATE Tile_X0Y5_FrameStrobe[5] VPWR VGND sg13cmos5l_antennanp
X_1023_ _1023_/Q Tile_X0Y3_FrameData[23] VGND VPWR Tile_X0Y5_FrameStrobe[7] latch
XANTENNA__0872__GATE Tile_X0Y5_FrameStrobe[2] VPWR VGND sg13cmos5l_antennanp
XANTENNA__2824__A1 Tile_X0Y5_N4END[0] VPWR VGND sg13cmos5l_antennanp
XFILLER_46_192 VPWR VGND sg13cmos5l_fill_2
XFILLER_61_140 VPWR VGND sg13cmos5l_fill_1
XANTENNA__1040__D Tile_X0Y4_FrameData[22] VPWR VGND sg13cmos5l_antennanp
XFILLER_201_66 VPWR VGND sg13cmos5l_fill_1
XFILLER_61_173 VPWR VGND sg13cmos5l_fill_1
XANTENNA__0257__GATE Tile_X0Y5_FrameStrobe[5] VPWR VGND sg13cmos5l_antennanp
XANTENNA__0887__GATE Tile_X0Y5_FrameStrobe[3] VPWR VGND sg13cmos5l_antennanp
XFILLER_277_37 VPWR VGND sg13cmos5l_decap_8
X_1925_ Tile_X0Y1_EE4BEG[6] _2315_/X VPWR VGND sg13cmos5l_buf_1
XFILLER_147_223 VPWR VGND sg13cmos5l_fill_1
X_1856_ Tile_X0Y4_FrameData_O[23] Tile_X0Y4_FrameData[23] VPWR VGND sg13cmos5l_buf_1
XANTENNA__0810__GATE Tile_X0Y5_FrameStrobe[0] VPWR VGND sg13cmos5l_antennanp
XFILLER_162_215 VPWR VGND sg13cmos5l_decap_8
X_1787_ Tile_X0Y4_E1BEG[2] _2615_/X VPWR VGND sg13cmos5l_buf_1
X_0807_ _0807_/Q Tile_X0Y3_FrameData[15] VGND VPWR Tile_X0Y5_FrameStrobe[0] latch
XANTENNA__1617__X Tile_X0Y0_N4BEG[13] VPWR VGND sg13cmos5l_antennanp
XANTENNA__2355__A3 Tile_X0Y5_W6END[9] VPWR VGND sg13cmos5l_antennanp
XFILLER_293_36 VPWR VGND sg13cmos5l_fill_1
X_0738_ _0738_/Q Tile_X0Y2_FrameData[4] VGND VPWR Tile_X0Y5_FrameStrobe[5] latch
XANTENNA__2760__A0 Tile_X0Y5_N4END[3] VPWR VGND sg13cmos5l_antennanp
XFILLER_115_175 VPWR VGND sg13cmos5l_decap_8
XFILLER_226_30 VPWR VGND sg13cmos5l_decap_8
XFILLER_226_85 VPWR VGND sg13cmos5l_fill_1
X_0669_ _0669_/Q Tile_X0Y2_FrameData[9] VGND VPWR Tile_X0Y5_FrameStrobe[3] latch
XANTENNA__0825__GATE Tile_X0Y5_FrameStrobe[1] VPWR VGND sg13cmos5l_antennanp
XANTENNA__2512__A0 AXIL_S_SOC_ARADDR1 VPWR VGND sg13cmos5l_antennanp
XFILLER_130_167 VPWR VGND sg13cmos5l_decap_4
XFILLER_130_178 VPWR VGND sg13cmos5l_fill_2
X_2408_ _2408_/X AXIL_S_SOC_AWADDR1 AXIL_S_SOC_AWADDR7 _2481_/X _2488_/X _0732_/Q
+ _0731_/Q VPWR VGND sg13cmos5l_mux4_1
XANTENNA__1215__D Tile_X0Y4_FrameData[7] VPWR VGND sg13cmos5l_antennanp
XFILLER_242_40 VPWR VGND sg13cmos5l_fill_2
X_2339_ _2339_/X _2346_/X _2345_/X Tile_X0Y1_W6END[2] _2339_/A3 _0314_/Q _0313_/Q
+ VPWR VGND sg13cmos5l_mux4_1
XFILLER_55_49 VPWR VGND sg13cmos5l_fill_2
XANTENNA__2815__A1 Tile_X0Y1_WW4END[11] VPWR VGND sg13cmos5l_antennanp
XFILLER_37_181 VPWR VGND sg13cmos5l_decap_8
XANTENNA__2291__A2 AXIL_S_SOC_WDATA0 VPWR VGND sg13cmos5l_antennanp
XFILLER_111_44 VPWR VGND sg13cmos5l_decap_4
XFILLER_52_140 VPWR VGND sg13cmos5l_decap_8
XFILLER_111_77 VPWR VGND sg13cmos5l_decap_8
XFILLER_336_7 VPWR VGND sg13cmos5l_decap_8
XFILLER_187_37 VPWR VGND sg13cmos5l_decap_4
XFILLER_138_223 VPWR VGND sg13cmos5l_fill_1
XFILLER_354_164 VPWR VGND sg13cmos5l_decap_8
XANTENNA__1527__X Tile_X0Y3_E6BEG[1] VPWR VGND sg13cmos5l_antennanp
XFILLER_106_142 VPWR VGND sg13cmos5l_decap_4
XANTENNA__2751__A0 AXIL_S_SOC_ARPROT0 VPWR VGND sg13cmos5l_antennanp
XFILLER_20_96 VPWR VGND sg13cmos5l_fill_2
XFILLER_310_212 VPWR VGND sg13cmos5l_fill_1
XANTENNA__2503__A0 Tile_X0Y1_W1END[3] VPWR VGND sg13cmos5l_antennanp
XFILLER_96_56 VPWR VGND sg13cmos5l_decap_8
XANTENNA__1125__D Tile_X0Y4_FrameData[1] VPWR VGND sg13cmos5l_antennanp
XFILLER_152_62 VPWR VGND sg13cmos5l_decap_8
XANTENNA__0964__D Tile_X0Y3_FrameData[18] VPWR VGND sg13cmos5l_antennanp
XFILLER_362_0 VPWR VGND sg13cmos5l_fill_2
XFILLER_302_21 VPWR VGND sg13cmos5l_decap_8
XANTENNA__2806__A1 Tile_X0Y5_N4END[2] VPWR VGND sg13cmos5l_antennanp
XFILLER_290_174 VPWR VGND sg13cmos5l_fill_1
XFILLER_302_65 VPWR VGND sg13cmos5l_fill_1
XFILLER_45_60 VPWR VGND sg13cmos5l_fill_1
XANTENNA__2093__X Tile_X0Y3_E2BEG[5] VPWR VGND sg13cmos5l_antennanp
XANTENNA__2585__A3 Tile_X0Y0_S4END[13] VPWR VGND sg13cmos5l_antennanp
XFILLER_177_70 VPWR VGND sg13cmos5l_decap_4
X_1710_ Tile_X0Y0_E6BEG[2] _2199_/X VPWR VGND sg13cmos5l_buf_1
X_2690_ _2690_/X Tile_X0Y0_W1END[1] Tile_X0Y0_WW4END[9] Tile_X0Y0_WW4END[13] Tile_X0Y0_W6END[5]
+ _0151_/Q _0150_/Q VPWR VGND sg13cmos5l_mux4_1
XFILLER_61_81 VPWR VGND sg13cmos5l_fill_2
XFILLER_345_142 VPWR VGND sg13cmos5l_fill_1
XANTENNA_3 AXIL_S_SOC_WDATA0 VPWR VGND sg13cmos5l_antennanp
X_1641_ Tile_X0Y0_FrameStrobe_O[1] Tile_X0Y5_FrameStrobe[1] VPWR VGND sg13cmos5l_buf_1
XANTENNA__0204__D Tile_X0Y0_FrameData[26] VPWR VGND sg13cmos5l_antennanp
XFILLER_360_145 VPWR VGND sg13cmos5l_fill_1
XFILLER_327_51 VPWR VGND sg13cmos5l_decap_8
XANTENNA__2742__A0 AXIL_S_SOC_ARPROT1 VPWR VGND sg13cmos5l_antennanp
X_1572_ Tile_X0Y3_FrameData_O[18] Tile_X0Y3_FrameData[18] VPWR VGND sg13cmos5l_buf_1
XFILLER_360_167 VPWR VGND sg13cmos5l_fill_2
XFILLER_360_156 VPWR VGND sg13cmos5l_fill_2
XFILLER_112_134 VPWR VGND sg13cmos5l_decap_4
X_0523_ _0523_/Q Tile_X0Y1_FrameData[11] VGND VPWR Tile_X0Y5_FrameStrobe[6] latch
X_0454_ _0454_/Q Tile_X0Y1_FrameData[16] VGND VPWR Tile_X0Y5_FrameStrobe[4] latch
XANTENNA__1035__D Tile_X0Y4_FrameData[27] VPWR VGND sg13cmos5l_antennanp
XANTENNA__0181__GATE Tile_X0Y5_FrameStrobe[3] VPWR VGND sg13cmos5l_antennanp
X_2124_ AXIL_S_SOC_RDATA18 Tile_X0Y1_W2MID[2] Tile_X0Y1_W2END[2] Tile_X0Y1_W6END[2]
+ _2375_/X _0378_/Q _0377_/Q VPWR VGND sg13cmos5l_mux4_1
X_0385_ _0385_/Q Tile_X0Y1_FrameData[21] VGND VPWR Tile_X0Y5_FrameStrobe[2] latch
XANTENNA__0874__D Tile_X0Y3_FrameData[12] VPWR VGND sg13cmos5l_antennanp
XFILLER_281_130 VPWR VGND sg13cmos5l_decap_8
XFILLER_81_213 VPWR VGND sg13cmos5l_decap_8
XANTENNA__1900__X Tile_X0Y1_FrameData_O[13] VPWR VGND sg13cmos5l_antennanp
X_2055_ Tile_X0Y5_S2BEG[4] _2777_/X VPWR VGND sg13cmos5l_buf_1
XANTENNA__2273__A2 Tile_X0Y2_WW4END[7] VPWR VGND sg13cmos5l_antennanp
X_1006_ _1006_/Q Tile_X0Y3_FrameData[8] VGND VPWR Tile_X0Y5_FrameStrobe[6] latch
XANTENNA__0196__GATE Tile_X0Y5_FrameStrobe[3] VPWR VGND sg13cmos5l_antennanp
XFILLER_179_145 VPWR VGND sg13cmos5l_decap_8
XFILLER_179_156 VPWR VGND sg13cmos5l_decap_8
XFILLER_34_173 VPWR VGND sg13cmos5l_fill_1
XFILLER_34_195 VPWR VGND sg13cmos5l_decap_8
XFILLER_194_126 VPWR VGND sg13cmos5l_decap_8
XFILLER_194_148 VPWR VGND sg13cmos5l_decap_8
XANTENNA__2576__A3 Tile_X0Y0_S4END[14] VPWR VGND sg13cmos5l_antennanp
XFILLER_157_29 VPWR VGND sg13cmos5l_decap_8
X_1908_ Tile_X0Y1_FrameData_O[21] Tile_X0Y1_FrameData[21] VPWR VGND sg13cmos5l_buf_1
X_1839_ Tile_X0Y4_FrameData_O[6] Tile_X0Y4_FrameData[6] VPWR VGND sg13cmos5l_buf_1
XFILLER_351_101 VPWR VGND sg13cmos5l_fill_2
XFILLER_336_175 VPWR VGND sg13cmos5l_decap_8
XANTENNA__0114__D Tile_X0Y0_FrameData[20] VPWR VGND sg13cmos5l_antennanp
XFILLER_237_40 VPWR VGND sg13cmos5l_fill_2
XFILLER_237_62 VPWR VGND sg13cmos5l_fill_1
XFILLER_351_134 VPWR VGND sg13cmos5l_decap_8
XANTENNA__0134__GATE Tile_X0Y5_FrameStrobe[1] VPWR VGND sg13cmos5l_antennanp
XANTENNA__2733__A0 AXIL_S_SOC_ARPROT0 VPWR VGND sg13cmos5l_antennanp
XANTENNA__0764__GATE Tile_X0Y5_FrameStrobe[6] VPWR VGND sg13cmos5l_antennanp
XFILLER_351_189 VPWR VGND sg13cmos5l_decap_4
XFILLER_103_167 VPWR VGND sg13cmos5l_decap_4
XFILLER_106_66 VPWR VGND sg13cmos5l_decap_8
XFILLER_253_61 VPWR VGND sg13cmos5l_decap_8
XFILLER_253_72 VPWR VGND sg13cmos5l_fill_2
XANTENNA__0149__GATE Tile_X0Y5_FrameStrobe[2] VPWR VGND sg13cmos5l_antennanp
XANTENNA__0779__GATE Tile_X0Y5_FrameStrobe[7] VPWR VGND sg13cmos5l_antennanp
XANTENNA__0784__D Tile_X0Y2_FrameData[22] VPWR VGND sg13cmos5l_antennanp
XFILLER_279_6 VPWR VGND sg13cmos5l_decap_8
XANTENNA__1810__X Tile_X0Y4_E6BEG[5] VPWR VGND sg13cmos5l_antennanp
XFILLER_122_43 VPWR VGND sg13cmos5l_decap_8
XFILLER_122_54 VPWR VGND sg13cmos5l_fill_1
XFILLER_272_174 VPWR VGND sg13cmos5l_decap_8
XFILLER_82_14 VPWR VGND sg13cmos5l_fill_1
XFILLER_25_151 VPWR VGND sg13cmos5l_decap_8
XFILLER_82_36 VPWR VGND sg13cmos5l_decap_8
XANTENNA__0702__GATE Tile_X0Y5_FrameStrobe[4] VPWR VGND sg13cmos5l_antennanp
XANTENNA__2264__A2 Tile_X0Y1_W6END[0] VPWR VGND sg13cmos5l_antennanp
XFILLER_359_223 VPWR VGND sg13cmos5l_fill_1
XFILLER_348_17 VPWR VGND sg13cmos5l_decap_8
XANTENNA__0717__GATE Tile_X0Y5_FrameStrobe[5] VPWR VGND sg13cmos5l_antennanp
XFILLER_31_51 VPWR VGND sg13cmos5l_decap_8
XFILLER_110_0 VPWR VGND sg13cmos5l_fill_1
XFILLER_208_0 VPWR VGND sg13cmos5l_decap_4
XANTENNA__2724__A0 Tile_X0Y5_N1END[3] VPWR VGND sg13cmos5l_antennanp
XANTENNA__0959__D Tile_X0Y3_FrameData[23] VPWR VGND sg13cmos5l_antennanp
XANTENNA__2088__X Tile_X0Y3_E2BEG[0] VPWR VGND sg13cmos5l_antennanp
XFILLER_163_50 VPWR VGND sg13cmos5l_decap_8
XANTENNA__0694__D Tile_X0Y2_FrameData[16] VPWR VGND sg13cmos5l_antennanp
X_0170_ _0170_/Q Tile_X0Y0_FrameData[28] VGND VPWR Tile_X0Y5_FrameStrobe[3] latch
XFILLER_313_75 VPWR VGND sg13cmos5l_decap_8
XANTENNA__1720__X Tile_X0Y0_E2BEGb[0] VPWR VGND sg13cmos5l_antennanp
XFILLER_263_185 VPWR VGND sg13cmos5l_fill_1
XANTENNA__2255__A2 Tile_X0Y2_W6END[4] VPWR VGND sg13cmos5l_antennanp
XFILLER_72_80 VPWR VGND sg13cmos5l_decap_8
XFILLER_31_143 VPWR VGND sg13cmos5l_decap_8
XFILLER_258_28 VPWR VGND sg13cmos5l_decap_8
X_2811_ _2811_/X Tile_X0Y1_W1END[2] Tile_X0Y1_WW4END[10] Tile_X0Y1_WW4END[14] Tile_X0Y1_W6END[6]
+ _0388_/Q _0387_/Q VPWR VGND sg13cmos5l_mux4_1
X_2742_ _2742_/X AXIL_S_SOC_ARPROT1 AXIL_S_SOC_ARVALID _2805_/X _2798_/X _1418_/Q
+ _1417_/Q VPWR VGND sg13cmos5l_mux4_1
XFILLER_338_50 VPWR VGND sg13cmos5l_decap_8
XFILLER_184_192 VPWR VGND sg13cmos5l_fill_2
XFILLER_274_16 VPWR VGND sg13cmos5l_fill_1
X_2673_ _2673_/X Tile_X0Y3_W1END[0] Tile_X0Y3_W6END[8] _2579_/X _2561_/X _0898_/Q
+ _0897_/Q VPWR VGND sg13cmos5l_mux4_1
XANTENNA__2715__A0 Tile_X0Y3_W2MID[5] VPWR VGND sg13cmos5l_antennanp
XFILLER_132_218 VPWR VGND sg13cmos5l_decap_4
X_1624_ Tile_X0Y0_N2BEGb[4] _2258_/X VPWR VGND sg13cmos5l_buf_1
XFILLER_333_156 VPWR VGND sg13cmos5l_decap_8
XANTENNA__0869__D Tile_X0Y3_FrameData[17] VPWR VGND sg13cmos5l_antennanp
XFILLER_207_54 VPWR VGND sg13cmos5l_fill_1
X_1555_ Tile_X0Y3_FrameData_O[1] Tile_X0Y3_FrameData[1] VPWR VGND sg13cmos5l_buf_1
XANTENNA__1494__GATE Tile_X0Y5_FrameStrobe[7] VPWR VGND sg13cmos5l_antennanp
XANTENNA__2191__A1 AXIL_S_SOC_WDATA26 VPWR VGND sg13cmos5l_antennanp
X_0506_ _0506_/Q Tile_X0Y1_FrameData[28] VGND VPWR Tile_X0Y5_FrameStrobe[6] latch
XFILLER_354_71 VPWR VGND sg13cmos5l_decap_4
XFILLER_290_37 VPWR VGND sg13cmos5l_decap_8
X_1486_ _1486_/Q Tile_X0Y5_FrameData[2] VGND VPWR Tile_X0Y5_FrameStrobe[6] latch
XFILLER_223_42 VPWR VGND sg13cmos5l_decap_8
X_0437_ _0437_/Q Tile_X0Y1_FrameData[1] VGND VPWR Tile_X0Y5_FrameStrobe[3] latch
XANTENNA__2494__A2 Tile_X0Y4_W6END[5] VPWR VGND sg13cmos5l_antennanp
X_0368_ _0368_/Q Tile_X0Y1_FrameData[6] VGND VPWR Tile_X0Y5_FrameStrobe[1] latch
XFILLER_254_152 VPWR VGND sg13cmos5l_fill_2
X_2107_ AXIL_S_SOC_RDATA1 Tile_X0Y3_W2MID[1] Tile_X0Y3_W2END[1] Tile_X0Y3_W6END[1]
+ _2590_/X _0860_/Q _0859_/Q VPWR VGND sg13cmos5l_mux4_1
XANTENNA__1630__X Tile_X0Y0_N2BEG[2] VPWR VGND sg13cmos5l_antennanp
X_2038_ Tile_X0Y5_FrameData_O[23] Tile_X0Y5_FrameData[23] VPWR VGND sg13cmos5l_buf_1
X_0299_ _0299_/Q Tile_X0Y0_FrameData[27] VGND VPWR Tile_X0Y5_FrameStrobe[7] latch
XFILLER_299_35 VPWR VGND sg13cmos5l_fill_2
XANTENNA__0109__D Tile_X0Y0_FrameData[25] VPWR VGND sg13cmos5l_antennanp
XANTENNA__2246__A2 Tile_X0Y0_S2MID[5] VPWR VGND sg13cmos5l_antennanp
XFILLER_299_79 VPWR VGND sg13cmos5l_decap_8
XANTENNA__1432__GATE Tile_X0Y5_FrameStrobe[5] VPWR VGND sg13cmos5l_antennanp
XFILLER_210_200 VPWR VGND sg13cmos5l_fill_1
XANTENNA__1447__GATE Tile_X0Y5_FrameStrobe[5] VPWR VGND sg13cmos5l_antennanp
XFILLER_175_170 VPWR VGND sg13cmos5l_decap_8
XFILLER_248_61 VPWR VGND sg13cmos5l_decap_8
XFILLER_309_164 VPWR VGND sg13cmos5l_decap_8
XANTENNA__0073__GATE Tile_X0Y5_FrameStrobe[0] VPWR VGND sg13cmos5l_antennanp
XANTENNA__0779__D Tile_X0Y2_FrameData[27] VPWR VGND sg13cmos5l_antennanp
XFILLER_7_6 VPWR VGND sg13cmos5l_fill_2
XANTENNA__1805__X Tile_X0Y4_E6BEG[0] VPWR VGND sg13cmos5l_antennanp
XANTENNA__2182__A1 AXIL_S_SOC_WDATA29 VPWR VGND sg13cmos5l_antennanp
XANTENNA__2721__A3 AXIL_S_SOC_ARPROT2 VPWR VGND sg13cmos5l_antennanp
XFILLER_264_60 VPWR VGND sg13cmos5l_decap_8
XANTENNA__0088__GATE Tile_X0Y5_FrameStrobe[0] VPWR VGND sg13cmos5l_antennanp
XFILLER_89_198 VPWR VGND sg13cmos5l_decap_4
XFILLER_133_42 VPWR VGND sg13cmos5l_decap_8
XFILLER_45_202 VPWR VGND sg13cmos5l_fill_2
XANTENNA__1403__D Tile_X0Y5_FrameData[21] VPWR VGND sg13cmos5l_antennanp
XFILLER_245_163 VPWR VGND sg13cmos5l_decap_8
XFILLER_93_35 VPWR VGND sg13cmos5l_decap_8
XANTENNA__0641__GATE Tile_X0Y5_FrameStrobe[2] VPWR VGND sg13cmos5l_antennanp
XANTENNA__1540__X Tile_X0Y3_EE4BEG[2] VPWR VGND sg13cmos5l_antennanp
XFILLER_260_111 VPWR VGND sg13cmos5l_decap_8
XANTENNA__2237__A2 Tile_X0Y0_S1END[1] VPWR VGND sg13cmos5l_antennanp
XFILLER_359_38 VPWR VGND sg13cmos5l_decap_4
XANTENNA__0656__GATE Tile_X0Y5_FrameStrobe[3] VPWR VGND sg13cmos5l_antennanp
XFILLER_42_61 VPWR VGND sg13cmos5l_fill_1
XFILLER_325_0 VPWR VGND sg13cmos5l_fill_1
XFILLER_158_61 VPWR VGND sg13cmos5l_decap_8
XFILLER_315_134 VPWR VGND sg13cmos5l_fill_1
XFILLER_181_140 VPWR VGND sg13cmos5l_decap_8
XFILLER_315_167 VPWR VGND sg13cmos5l_fill_1
XANTENNA__0689__D Tile_X0Y2_FrameData[21] VPWR VGND sg13cmos5l_antennanp
XFILLER_181_184 VPWR VGND sg13cmos5l_decap_8
XFILLER_308_86 VPWR VGND sg13cmos5l_fill_2
XANTENNA__1715__X Tile_X0Y0_E6BEG[7] VPWR VGND sg13cmos5l_antennanp
XANTENNA__2173__A1 AXIL_S_SOC_WDATA24 VPWR VGND sg13cmos5l_antennanp
X_1340_ _1340_/Q Tile_X0Y5_FrameData[20] VGND VPWR Tile_X0Y5_FrameStrobe[2] latch
XFILLER_228_108 VPWR VGND sg13cmos5l_decap_8
X_1271_ _1271_/Q Tile_X0Y5_FrameData[25] VGND VPWR Tile_X0Y5_FrameStrobe[0] latch
XFILLER_95_146 VPWR VGND sg13cmos5l_decap_8
XFILLER_95_124 VPWR VGND sg13cmos5l_decap_4
XFILLER_324_85 VPWR VGND sg13cmos5l_fill_1
XFILLER_190_70 VPWR VGND sg13cmos5l_fill_1
XFILLER_236_130 VPWR VGND sg13cmos5l_decap_8
XFILLER_260_18 VPWR VGND sg13cmos5l_fill_1
X_0222_ _0222_/Q Tile_X0Y0_FrameData[8] VGND VPWR Tile_X0Y5_FrameStrobe[4] latch
XANTENNA__1313__D Tile_X0Y5_FrameData[15] VPWR VGND sg13cmos5l_antennanp
XFILLER_236_152 VPWR VGND sg13cmos5l_decap_8
X_0153_ _0153_/Q Tile_X0Y0_FrameData[13] VGND VPWR Tile_X0Y5_FrameStrobe[2] latch
XANTENNA__0609__GATE Tile_X0Y5_FrameStrobe[1] VPWR VGND sg13cmos5l_antennanp
X_0084_ _0084_/Q Tile_X0Y0_FrameData[18] VGND VPWR Tile_X0Y5_FrameStrobe[0] latch
XFILLER_51_205 VPWR VGND sg13cmos5l_decap_8
XFILLER_251_177 VPWR VGND sg13cmos5l_decap_4
XFILLER_269_27 VPWR VGND sg13cmos5l_decap_8
XFILLER_269_49 VPWR VGND sg13cmos5l_decap_4
XFILLER_149_126 VPWR VGND sg13cmos5l_fill_2
XFILLER_164_107 VPWR VGND sg13cmos5l_fill_1
X_0986_ _0986_/Q Tile_X0Y3_FrameData[28] VGND VPWR Tile_X0Y5_FrameStrobe[6] latch
XANTENNA__2400__A2 AXIL_S_SOC_AWADDR1 VPWR VGND sg13cmos5l_antennanp
XFILLER_285_48 VPWR VGND sg13cmos5l_decap_8
X_2725_ _2725_/X AXIL_S_SOC_ARPROT0 AXIL_S_SOC_ARVALID _2825_/X _2797_/X _1452_/Q
+ _1451_/Q VPWR VGND sg13cmos5l_mux4_1
XFILLER_306_123 VPWR VGND sg13cmos5l_decap_8
XFILLER_218_64 VPWR VGND sg13cmos5l_decap_8
X_2656_ _2656_/X AXIL_S_SOC_WSTRB1 _2706_/X _2697_/X _2711_/X _1142_/Q _1141_/Q VPWR
+ VGND sg13cmos5l_mux4_1
XANTENNA__0599__D Tile_X0Y2_FrameData[15] VPWR VGND sg13cmos5l_antennanp
XFILLER_172_173 VPWR VGND sg13cmos5l_decap_8
X_1607_ Tile_X0Y0_N4BEG[3] _1607_/A VPWR VGND sg13cmos5l_buf_1
XANTENNA__1625__X Tile_X0Y0_N2BEGb[5] VPWR VGND sg13cmos5l_antennanp
XANTENNA__2164__A1 Tile_X0Y0_S1END[3] VPWR VGND sg13cmos5l_antennanp
XFILLER_259_211 VPWR VGND sg13cmos5l_fill_1
X_2587_ _2587_/X _2566_/X Tile_X0Y5_N4END[8] _2565_/X Tile_X0Y0_S4END[12] _0838_/Q
+ _0837_/Q VPWR VGND sg13cmos5l_mux4_1
X_1538_ Tile_X0Y3_EE4BEG[0] _2525_/X VPWR VGND sg13cmos5l_buf_1
XFILLER_86_113 VPWR VGND sg13cmos5l_decap_8
X_1469_ _1469_/Q Tile_X0Y5_FrameData[19] VGND VPWR Tile_X0Y5_FrameStrobe[6] latch
XFILLER_47_17 VPWR VGND sg13cmos5l_fill_1
XFILLER_234_96 VPWR VGND sg13cmos5l_decap_4
XFILLER_103_23 VPWR VGND sg13cmos5l_fill_1
XANTENNA__1223__D Tile_X0Y4_FrameData[31] VPWR VGND sg13cmos5l_antennanp
XFILLER_103_34 VPWR VGND sg13cmos5l_decap_8
XFILLER_227_185 VPWR VGND sg13cmos5l_decap_8
XFILLER_250_51 VPWR VGND sg13cmos5l_fill_1
XANTENNA__1371__GATE Tile_X0Y5_FrameStrobe[3] VPWR VGND sg13cmos5l_antennanp
XANTENNA__2219__A2 Tile_X0Y4_W6END[8] VPWR VGND sg13cmos5l_antennanp
XFILLER_179_49 VPWR VGND sg13cmos5l_fill_1
XFILLER_195_221 VPWR VGND sg13cmos5l_fill_2
XANTENNA__1386__GATE Tile_X0Y5_FrameStrobe[3] VPWR VGND sg13cmos5l_antennanp
XFILLER_128_42 VPWR VGND sg13cmos5l_decap_8
XFILLER_128_86 VPWR VGND sg13cmos5l_decap_4
XFILLER_128_97 VPWR VGND sg13cmos5l_decap_8
XFILLER_163_184 VPWR VGND sg13cmos5l_decap_4
XANTENNA__0302__D Tile_X0Y0_FrameData[24] VPWR VGND sg13cmos5l_antennanp
XANTENNA__1535__X Tile_X0Y3_E6BEG[9] VPWR VGND sg13cmos5l_antennanp
XANTENNA__2155__A1 Tile_X0Y0_WW4END[1] VPWR VGND sg13cmos5l_antennanp
XANTENNA__1324__GATE Tile_X0Y5_FrameStrobe[1] VPWR VGND sg13cmos5l_antennanp
XFILLER_144_63 VPWR VGND sg13cmos5l_decap_8
XFILLER_77_124 VPWR VGND sg13cmos5l_decap_8
XFILLER_77_179 VPWR VGND sg13cmos5l_decap_4
XANTENNA__0580__GATE Tile_X0Y5_FrameStrobe[0] VPWR VGND sg13cmos5l_antennanp
XFILLER_218_141 VPWR VGND sg13cmos5l_decap_8
XFILLER_275_0 VPWR VGND sg13cmos5l_decap_8
XANTENNA__1133__D Tile_X0Y4_FrameData[25] VPWR VGND sg13cmos5l_antennanp
XFILLER_85_190 VPWR VGND sg13cmos5l_decap_8
XFILLER_37_61 VPWR VGND sg13cmos5l_fill_2
XANTENNA__1339__GATE Tile_X0Y5_FrameStrobe[2] VPWR VGND sg13cmos5l_antennanp
XFILLER_310_21 VPWR VGND sg13cmos5l_fill_2
XANTENNA__0972__D Tile_X0Y3_FrameData[10] VPWR VGND sg13cmos5l_antennanp
XFILLER_233_177 VPWR VGND sg13cmos5l_decap_8
XFILLER_233_188 VPWR VGND sg13cmos5l_fill_1
XANTENNA__0595__GATE Tile_X0Y5_FrameStrobe[1] VPWR VGND sg13cmos5l_antennanp
XFILLER_186_210 VPWR VGND sg13cmos5l_fill_1
XFILLER_53_71 VPWR VGND sg13cmos5l_decap_8
X_0840_ _0840_/Q Tile_X0Y3_FrameData[14] VGND VPWR Tile_X0Y5_FrameStrobe[1] latch
X_0771_ _0771_/Q Tile_X0Y2_FrameData[3] VGND VPWR Tile_X0Y5_FrameStrobe[6] latch
XANTENNA__2394__A1 Tile_X0Y3_W2END[1] VPWR VGND sg13cmos5l_antennanp
X_2510_ _2510_/X AXIL_S_SOC_ARADDR1 AXIL_S_SOC_ARADDR9 _2590_/X _2595_/X _0984_/Q
+ _0983_/Q VPWR VGND sg13cmos5l_mux4_1
X_2441_ _2441_/X AXIL_S_SOC_AWADDR0 _2475_/X _2473_/X _2485_/X _0666_/Q _0665_/Q VPWR
+ VGND sg13cmos5l_mux4_1
XANTENNA__0212__D Tile_X0Y0_FrameData[18] VPWR VGND sg13cmos5l_antennanp
XANTENNA__0533__GATE Tile_X0Y5_FrameStrobe[6] VPWR VGND sg13cmos5l_antennanp
XANTENNA__1308__D Tile_X0Y5_FrameData[20] VPWR VGND sg13cmos5l_antennanp
XANTENNA__2146__A1 Tile_X0Y0_W2END[6] VPWR VGND sg13cmos5l_antennanp
X_2372_ _2372_/X _2342_/X _0063_/X _2341_/X Tile_X0Y0_S4END[4] _0366_/Q _0365_/Q VPWR
+ VGND sg13cmos5l_mux4_1
XFILLER_335_84 VPWR VGND sg13cmos5l_fill_1
X_1323_ _1323_/Q Tile_X0Y5_FrameData[5] VGND VPWR Tile_X0Y5_FrameStrobe[1] latch
XFILLER_78_90 VPWR VGND sg13cmos5l_fill_1
X_1254_ _1254_/Q Tile_X0Y4_FrameData[0] VGND VPWR Tile_X0Y5_FrameStrobe[6] latch
XFILLER_68_179 VPWR VGND sg13cmos5l_fill_2
XFILLER_68_157 VPWR VGND sg13cmos5l_decap_8
XANTENNA__0548__GATE Tile_X0Y5_FrameStrobe[7] VPWR VGND sg13cmos5l_antennanp
XANTENNA__2449__A2 Tile_X0Y2_WW4END[14] VPWR VGND sg13cmos5l_antennanp
X_0205_ _0205_/Q Tile_X0Y0_FrameData[25] VGND VPWR Tile_X0Y5_FrameStrobe[4] latch
XANTENNA__1043__D Tile_X0Y4_FrameData[19] VPWR VGND sg13cmos5l_antennanp
XFILLER_204_99 VPWR VGND sg13cmos5l_decap_8
XFILLER_224_122 VPWR VGND sg13cmos5l_decap_8
X_1185_ _1185_/Q Tile_X0Y4_FrameData[5] VGND VPWR Tile_X0Y5_FrameStrobe[4] latch
X_0136_ _0136_/Q Tile_X0Y0_FrameData[30] VGND VPWR Tile_X0Y5_FrameStrobe[2] latch
XANTENNA__0882__D Tile_X0Y3_FrameData[4] VPWR VGND sg13cmos5l_antennanp
XFILLER_220_32 VPWR VGND sg13cmos5l_decap_8
X_0067_ _2075_/A _2661_/X _2662_/X _1106_/Q VPWR VGND sg13cmos5l_mux2_1
XFILLER_220_76 VPWR VGND sg13cmos5l_fill_1
XFILLER_33_19 VPWR VGND sg13cmos5l_fill_2
XFILLER_220_98 VPWR VGND sg13cmos5l_decap_8
XFILLER_296_25 VPWR VGND sg13cmos5l_decap_4
XFILLER_192_213 VPWR VGND sg13cmos5l_fill_2
X_0969_ _0969_/Q Tile_X0Y3_FrameData[13] VGND VPWR Tile_X0Y5_FrameStrobe[5] latch
XANTENNA__2385__A1 Tile_X0Y0_W2END[5] VPWR VGND sg13cmos5l_antennanp
XFILLER_229_96 VPWR VGND sg13cmos5l_decap_8
X_2708_ _2708_/X _2598_/X Tile_X0Y5_N2MID[0] _2713_/X _2597_/X _1054_/Q _1053_/Q VPWR
+ VGND sg13cmos5l_mux4_1
XFILLER_109_9 VPWR VGND sg13cmos5l_fill_2
XFILLER_160_110 VPWR VGND sg13cmos5l_decap_8
XANTENNA__0122__D Tile_X0Y0_FrameData[12] VPWR VGND sg13cmos5l_antennanp
XANTENNA__1218__D Tile_X0Y4_FrameData[4] VPWR VGND sg13cmos5l_antennanp
XANTENNA__2137__A1 Tile_X0Y0_W2END[7] VPWR VGND sg13cmos5l_antennanp
X_2639_ _2639_/X AXIL_S_SOC_WSTRB0 AXIL_S_SOC_WVALID _2693_/X _2709_/X _1176_/Q _1175_/Q
+ VPWR VGND sg13cmos5l_mux4_1
XFILLER_59_146 VPWR VGND sg13cmos5l_decap_8
XFILLER_82_171 VPWR VGND sg13cmos5l_decap_8
XANTENNA__0792__D Tile_X0Y3_FrameData[30] VPWR VGND sg13cmos5l_antennanp
XFILLER_130_54 VPWR VGND sg13cmos5l_decap_8
XANTENNA__2612__A2 Tile_X0Y5_W6END[0] VPWR VGND sg13cmos5l_antennanp
XFILLER_230_158 VPWR VGND sg13cmos5l_decap_8
XFILLER_23_41 VPWR VGND sg13cmos5l_fill_1
XFILLER_356_17 VPWR VGND sg13cmos5l_fill_2
XFILLER_286_80 VPWR VGND sg13cmos5l_decap_8
XFILLER_99_34 VPWR VGND sg13cmos5l_decap_8
XANTENNA__1128__D Tile_X0Y4_FrameData[30] VPWR VGND sg13cmos5l_antennanp
XANTENNA__2128__A1 Tile_X0Y1_W2END[6] VPWR VGND sg13cmos5l_antennanp
XANTENNA__1263__GATE Tile_X0Y5_FrameStrobe[7] VPWR VGND sg13cmos5l_antennanp
XFILLER_155_62 VPWR VGND sg13cmos5l_fill_2
XFILLER_2_142 VPWR VGND sg13cmos5l_fill_1
XANTENNA__0967__D Tile_X0Y3_FrameData[15] VPWR VGND sg13cmos5l_antennanp
XFILLER_305_65 VPWR VGND sg13cmos5l_decap_8
XFILLER_305_98 VPWR VGND sg13cmos5l_fill_2
XANTENNA__1278__GATE Tile_X0Y5_FrameStrobe[0] VPWR VGND sg13cmos5l_antennanp
XANTENNA__2096__X Tile_X0Y3_E2BEGb[0] VPWR VGND sg13cmos5l_antennanp
XANTENNA__2300__A1 AXIL_S_SOC_WDATA15 VPWR VGND sg13cmos5l_antennanp
XFILLER_206_100 VPWR VGND sg13cmos5l_fill_2
XFILLER_321_20 VPWR VGND sg13cmos5l_decap_8
XFILLER_73_160 VPWR VGND sg13cmos5l_decap_8
XFILLER_206_177 VPWR VGND sg13cmos5l_decap_8
XFILLER_221_103 VPWR VGND sg13cmos5l_decap_8
XFILLER_64_81 VPWR VGND sg13cmos5l_decap_4
XANTENNA__1201__GATE Tile_X0Y5_FrameStrobe[5] VPWR VGND sg13cmos5l_antennanp
XANTENNA__0207__D Tile_X0Y0_FrameData[23] VPWR VGND sg13cmos5l_antennanp
XANTENNA__2603__A2 Tile_X0Y2_W6END[11] VPWR VGND sg13cmos5l_antennanp
XFILLER_159_221 VPWR VGND sg13cmos5l_fill_2
X_1941_ Tile_X0Y1_E6BEG[6] _2331_/X VPWR VGND sg13cmos5l_buf_1
XFILLER_119_118 VPWR VGND sg13cmos5l_fill_1
XFILLER_174_202 VPWR VGND sg13cmos5l_fill_1
X_1872_ Tile_X0Y2_E2BEGb[6] _2415_/X VPWR VGND sg13cmos5l_buf_1
XFILLER_9_87 VPWR VGND sg13cmos5l_fill_2
XANTENNA__1216__GATE Tile_X0Y5_FrameStrobe[5] VPWR VGND sg13cmos5l_antennanp
XFILLER_266_28 VPWR VGND sg13cmos5l_fill_2
X_0823_ _0823_/Q Tile_X0Y3_FrameData[31] VGND VPWR Tile_X0Y5_FrameStrobe[1] latch
XANTENNA__0472__GATE Tile_X0Y5_FrameStrobe[5] VPWR VGND sg13cmos5l_antennanp
XFILLER_127_173 VPWR VGND sg13cmos5l_decap_8
X_0754_ _0754_/Q Tile_X0Y2_FrameData[20] VGND VPWR Tile_X0Y5_FrameStrobe[6] latch
XFILLER_346_61 VPWR VGND sg13cmos5l_decap_8
XANTENNA__1038__D Tile_X0Y4_FrameData[24] VPWR VGND sg13cmos5l_antennanp
XANTENNA__2119__A1 Tile_X0Y2_W2END[5] VPWR VGND sg13cmos5l_antennanp
X_0685_ _0685_/Q Tile_X0Y2_FrameData[25] VGND VPWR Tile_X0Y5_FrameStrobe[4] latch
XFILLER_331_210 VPWR VGND sg13cmos5l_fill_2
XFILLER_142_176 VPWR VGND sg13cmos5l_decap_8
X_2424_ _2424_/X AXIL_S_SOC_AWADDR7 AXIL_S_SOC_AWPROT1 _2472_/X _2481_/X _0700_/Q
+ _0699_/Q VPWR VGND sg13cmos5l_mux4_1
XANTENNA__0877__D Tile_X0Y3_FrameData[9] VPWR VGND sg13cmos5l_antennanp
XFILLER_215_32 VPWR VGND sg13cmos5l_decap_8
XFILLER_215_43 VPWR VGND sg13cmos5l_fill_2
X_2355_ _2355_/X Tile_X0Y5_W1END[1] Tile_X0Y5_WW4END[1] Tile_X0Y5_WW4END[7] Tile_X0Y5_W6END[9]
+ _1469_/Q _1468_/Q VPWR VGND sg13cmos5l_mux4_1
XFILLER_36_0 VPWR VGND sg13cmos5l_fill_2
XANTENNA__0487__GATE Tile_X0Y5_FrameStrobe[5] VPWR VGND sg13cmos5l_antennanp
XANTENNA__1903__X Tile_X0Y1_FrameData_O[16] VPWR VGND sg13cmos5l_antennanp
XFILLER_28_19 VPWR VGND sg13cmos5l_fill_2
X_1306_ _1306_/Q Tile_X0Y5_FrameData[22] VGND VPWR Tile_X0Y5_FrameStrobe[1] latch
XFILLER_296_180 VPWR VGND sg13cmos5l_decap_4
X_2286_ _2286_/X _2586_/X _2585_/X _2578_/X _2577_/X _1003_/Q _1002_/Q VPWR VGND sg13cmos5l_mux4_1
X_1237_ _1237_/Q Tile_X0Y4_FrameData[17] VGND VPWR Tile_X0Y5_FrameStrobe[6] latch
XANTENNA__0410__GATE Tile_X0Y5_FrameStrobe[3] VPWR VGND sg13cmos5l_antennanp
XFILLER_231_64 VPWR VGND sg13cmos5l_decap_8
X_1168_ _1168_/Q Tile_X0Y4_FrameData[22] VGND VPWR Tile_X0Y5_FrameStrobe[4] latch
X_0119_ _0119_/Q Tile_X0Y0_FrameData[15] VGND VPWR Tile_X0Y5_FrameStrobe[1] latch
X_1099_ _1099_/Q Tile_X0Y4_FrameData[27] VGND VPWR Tile_X0Y5_FrameStrobe[2] latch
XANTENNA__0117__D Tile_X0Y0_FrameData[17] VPWR VGND sg13cmos5l_antennanp
XANTENNA__0425__GATE Tile_X0Y5_FrameStrobe[3] VPWR VGND sg13cmos5l_antennanp
XFILLER_226_9 VPWR VGND sg13cmos5l_fill_2
XFILLER_109_44 VPWR VGND sg13cmos5l_decap_8
XFILLER_180_216 VPWR VGND sg13cmos5l_fill_1
XFILLER_256_50 VPWR VGND sg13cmos5l_fill_2
XFILLER_133_121 VPWR VGND sg13cmos5l_decap_8
XFILLER_279_114 VPWR VGND sg13cmos5l_fill_2
XFILLER_69_15 VPWR VGND sg13cmos5l_decap_8
XANTENNA__0787__D Tile_X0Y2_FrameData[19] VPWR VGND sg13cmos5l_antennanp
XFILLER_294_128 VPWR VGND sg13cmos5l_fill_1
XANTENNA__1813__X Tile_X0Y4_E6BEG[8] VPWR VGND sg13cmos5l_antennanp
XANTENNA__2530__A1 AXIL_S_SOC_ARADDR9 VPWR VGND sg13cmos5l_antennanp
XFILLER_85_14 VPWR VGND sg13cmos5l_fill_1
XFILLER_125_87 VPWR VGND sg13cmos5l_decap_4
XFILLER_47_127 VPWR VGND sg13cmos5l_decap_8
XANTENNA__2294__A0 AXIL_S_SOC_WDATA1 VPWR VGND sg13cmos5l_antennanp
XFILLER_141_42 VPWR VGND sg13cmos5l_decap_8
XFILLER_62_108 VPWR VGND sg13cmos5l_decap_8
XANTENNA__2833__A2 Tile_X0Y4_W2END[3] VPWR VGND sg13cmos5l_antennanp
XANTENNA__1411__D Tile_X0Y5_FrameData[13] VPWR VGND sg13cmos5l_antennanp
XFILLER_70_163 VPWR VGND sg13cmos5l_decap_8
XFILLER_349_129 VPWR VGND sg13cmos5l_decap_4
XFILLER_140_0 VPWR VGND sg13cmos5l_fill_2
XFILLER_203_169 VPWR VGND sg13cmos5l_fill_2
XANTENNA__2597__A1 Tile_X0Y2_W2END[7] VPWR VGND sg13cmos5l_antennanp
XFILLER_238_0 VPWR VGND sg13cmos5l_fill_1
XFILLER_166_83 VPWR VGND sg13cmos5l_decap_4
XFILLER_124_165 VPWR VGND sg13cmos5l_decap_8
XFILLER_124_176 VPWR VGND sg13cmos5l_fill_1
X_0470_ _0470_/Q Tile_X0Y1_FrameData[0] VGND VPWR Tile_X0Y5_FrameStrobe[4] latch
XANTENNA__0697__D Tile_X0Y2_FrameData[13] VPWR VGND sg13cmos5l_antennanp
XFILLER_316_75 VPWR VGND sg13cmos5l_decap_8
XANTENNA__1723__X Tile_X0Y0_E2BEGb[3] VPWR VGND sg13cmos5l_antennanp
XANTENNA__2521__A1 AXIL_S_SOC_ARADDR4 VPWR VGND sg13cmos5l_antennanp
XFILLER_226_206 VPWR VGND sg13cmos5l_fill_2
X_2140_ AXIL_S_SOC_RVALID Tile_X0Y5_W2MID[3] Tile_X0Y5_W2END[3] Tile_X0Y5_W6END[3]
+ _2828_/X _1322_/Q _1321_/Q VPWR VGND sg13cmos5l_mux4_1
XFILLER_93_211 VPWR VGND sg13cmos5l_decap_4
XFILLER_38_127 VPWR VGND sg13cmos5l_fill_2
X_2071_ Tile_X0Y5_S4BEG[4] _2071_/A VPWR VGND sg13cmos5l_buf_1
XANTENNA__2285__A0 Tile_X0Y3_W1END[1] VPWR VGND sg13cmos5l_antennanp
X_1022_ _1022_/Q Tile_X0Y3_FrameData[24] VGND VPWR Tile_X0Y5_FrameStrobe[7] latch
XFILLER_53_108 VPWR VGND sg13cmos5l_fill_1
XANTENNA__1140__GATE Tile_X0Y5_FrameStrobe[3] VPWR VGND sg13cmos5l_antennanp
XANTENNA__1321__D Tile_X0Y5_FrameData[7] VPWR VGND sg13cmos5l_antennanp
XFILLER_201_45 VPWR VGND sg13cmos5l_decap_8
XANTENNA__2588__A1 Tile_X0Y5_N4END[8] VPWR VGND sg13cmos5l_antennanp
XFILLER_147_202 VPWR VGND sg13cmos5l_decap_8
X_1924_ Tile_X0Y1_EE4BEG[5] _2314_/X VPWR VGND sg13cmos5l_buf_1
XFILLER_348_151 VPWR VGND sg13cmos5l_decap_8
XANTENNA__1155__GATE Tile_X0Y5_FrameStrobe[3] VPWR VGND sg13cmos5l_antennanp
X_1855_ Tile_X0Y4_FrameData_O[22] Tile_X0Y4_FrameData[22] VPWR VGND sg13cmos5l_buf_1
XFILLER_348_195 VPWR VGND sg13cmos5l_fill_2
X_1786_ Tile_X0Y4_E1BEG[1] _2614_/X VPWR VGND sg13cmos5l_buf_1
X_0806_ _0806_/Q Tile_X0Y3_FrameData[16] VGND VPWR Tile_X0Y5_FrameStrobe[0] latch
XFILLER_115_121 VPWR VGND sg13cmos5l_decap_8
X_0737_ _0737_/Q Tile_X0Y2_FrameData[5] VGND VPWR Tile_X0Y5_FrameStrobe[5] latch
XFILLER_304_210 VPWR VGND sg13cmos5l_fill_2
X_0668_ _0668_/Q Tile_X0Y2_FrameData[10] VGND VPWR Tile_X0Y5_FrameStrobe[3] latch
XANTENNA__0400__D Tile_X0Y1_FrameData[6] VPWR VGND sg13cmos5l_antennanp
XANTENNA__1633__X Tile_X0Y0_N2BEG[5] VPWR VGND sg13cmos5l_antennanp
XANTENNA__2512__A1 AXIL_S_SOC_ARADDR3 VPWR VGND sg13cmos5l_antennanp
XFILLER_269_180 VPWR VGND sg13cmos5l_decap_4
X_2407_ _2407_/X AXIL_S_SOC_AWADDR0 AXIL_S_SOC_AWADDR6 _2482_/X _2487_/X _0734_/Q
+ _0733_/Q VPWR VGND sg13cmos5l_mux4_1
X_0599_ _0599_/Q Tile_X0Y2_FrameData[15] VGND VPWR Tile_X0Y5_FrameStrobe[1] latch
X_2338_ _2338_/X _2344_/X _2343_/X Tile_X0Y1_W6END[1] _2338_/A3 _0316_/Q _0315_/Q
+ VPWR VGND sg13cmos5l_mux4_1
XFILLER_242_63 VPWR VGND sg13cmos5l_fill_1
X_2269_ _2269_/X Tile_X0Y1_W1END[1] Tile_X0Y1_WW4END[1] Tile_X0Y1_WW4END[5] Tile_X0Y1_W6END[9]
+ _0523_/Q _0522_/Q VPWR VGND sg13cmos5l_mux4_1
XFILLER_29_138 VPWR VGND sg13cmos5l_fill_2
XFILLER_242_85 VPWR VGND sg13cmos5l_decap_8
XFILLER_55_28 VPWR VGND sg13cmos5l_fill_2
XFILLER_37_160 VPWR VGND sg13cmos5l_decap_8
XANTENNA__1108__GATE Tile_X0Y5_FrameStrobe[2] VPWR VGND sg13cmos5l_antennanp
XANTENNA__2815__A2 Tile_X0Y1_WW4END[15] VPWR VGND sg13cmos5l_antennanp
XANTENNA__1231__D Tile_X0Y4_FrameData[23] VPWR VGND sg13cmos5l_antennanp
XANTENNA__2291__A3 AXIL_S_SOC_WDATA5 VPWR VGND sg13cmos5l_antennanp
XFILLER_111_56 VPWR VGND sg13cmos5l_decap_8
XFILLER_197_102 VPWR VGND sg13cmos5l_fill_1
XANTENNA__0364__GATE Tile_X0Y5_FrameStrobe[1] VPWR VGND sg13cmos5l_antennanp
XANTENNA__0994__GATE Tile_X0Y5_FrameStrobe[6] VPWR VGND sg13cmos5l_antennanp
XANTENNA__2579__A1 Tile_X0Y5_N4END[8] VPWR VGND sg13cmos5l_antennanp
XFILLER_187_16 VPWR VGND sg13cmos5l_fill_2
XFILLER_52_196 VPWR VGND sg13cmos5l_fill_1
XFILLER_329_7 VPWR VGND sg13cmos5l_decap_8
XANTENNA__0379__GATE Tile_X0Y5_FrameStrobe[2] VPWR VGND sg13cmos5l_antennanp
XANTENNA__1808__X Tile_X0Y4_E6BEG[3] VPWR VGND sg13cmos5l_antennanp
XFILLER_354_143 VPWR VGND sg13cmos5l_decap_8
XFILLER_153_216 VPWR VGND sg13cmos5l_fill_2
XFILLER_267_82 VPWR VGND sg13cmos5l_fill_1
XANTENNA__0302__GATE Tile_X0Y5_FrameStrobe[7] VPWR VGND sg13cmos5l_antennanp
XANTENNA__2751__A1 AXIL_S_SOC_ARPROT1 VPWR VGND sg13cmos5l_antennanp
XFILLER_136_42 VPWR VGND sg13cmos5l_fill_1
XANTENNA__0932__GATE Tile_X0Y5_FrameStrobe[4] VPWR VGND sg13cmos5l_antennanp
XFILLER_106_176 VPWR VGND sg13cmos5l_decap_8
XFILLER_106_187 VPWR VGND sg13cmos5l_fill_2
XFILLER_283_92 VPWR VGND sg13cmos5l_fill_2
XANTENNA__0310__D Tile_X0Y0_FrameData[16] VPWR VGND sg13cmos5l_antennanp
XANTENNA__1406__D Tile_X0Y5_FrameData[18] VPWR VGND sg13cmos5l_antennanp
XANTENNA__1543__X Tile_X0Y3_EE4BEG[5] VPWR VGND sg13cmos5l_antennanp
XANTENNA__2503__A1 Tile_X0Y1_W2MID[0] VPWR VGND sg13cmos5l_antennanp
XFILLER_121_168 VPWR VGND sg13cmos5l_decap_8
XANTENNA__0317__GATE Tile_X0Y5_FrameStrobe[0] VPWR VGND sg13cmos5l_antennanp
XFILLER_188_0 VPWR VGND sg13cmos5l_fill_1
XFILLER_275_183 VPWR VGND sg13cmos5l_decap_8
XFILLER_75_222 VPWR VGND sg13cmos5l_fill_2
XANTENNA__0947__GATE Tile_X0Y5_FrameStrobe[4] VPWR VGND sg13cmos5l_antennanp
XANTENNA__2267__A0 Tile_X0Y1_W1END[2] VPWR VGND sg13cmos5l_antennanp
XFILLER_152_96 VPWR VGND sg13cmos5l_decap_8
XFILLER_302_11 VPWR VGND sg13cmos5l_fill_1
XFILLER_28_182 VPWR VGND sg13cmos5l_fill_1
XFILLER_355_0 VPWR VGND sg13cmos5l_fill_1
XFILLER_302_44 VPWR VGND sg13cmos5l_fill_2
XANTENNA__1141__D Tile_X0Y4_FrameData[17] VPWR VGND sg13cmos5l_antennanp
XFILLER_188_113 VPWR VGND sg13cmos5l_decap_8
XFILLER_290_186 VPWR VGND sg13cmos5l_decap_8
XFILLER_302_88 VPWR VGND sg13cmos5l_decap_8
XANTENNA__0980__D Tile_X0Y3_FrameData[2] VPWR VGND sg13cmos5l_antennanp
XFILLER_91_9 VPWR VGND sg13cmos5l_decap_4
XANTENNA__1718__X Tile_X0Y0_E6BEG[10] VPWR VGND sg13cmos5l_antennanp
XFILLER_144_205 VPWR VGND sg13cmos5l_decap_4
XFILLER_177_82 VPWR VGND sg13cmos5l_decap_8
X_1640_ Tile_X0Y0_FrameStrobe_O[0] Tile_X0Y5_FrameStrobe[0] VPWR VGND sg13cmos5l_buf_1
XFILLER_360_102 VPWR VGND sg13cmos5l_decap_8
XFILLER_327_30 VPWR VGND sg13cmos5l_decap_8
XANTENNA_4 Tile_X0Y5_FrameStrobe[14] VPWR VGND sg13cmos5l_antennanp
X_1571_ Tile_X0Y3_FrameData_O[17] Tile_X0Y3_FrameData[17] VPWR VGND sg13cmos5l_buf_1
XANTENNA__2742__A1 AXIL_S_SOC_ARVALID VPWR VGND sg13cmos5l_antennanp
X_0522_ _0522_/Q Tile_X0Y1_FrameData[12] VGND VPWR Tile_X0Y5_FrameStrobe[6] latch
XFILLER_327_96 VPWR VGND sg13cmos5l_decap_4
XFILLER_112_113 VPWR VGND sg13cmos5l_decap_8
XFILLER_301_202 VPWR VGND sg13cmos5l_fill_2
XANTENNA__0220__D Tile_X0Y0_FrameData[10] VPWR VGND sg13cmos5l_antennanp
XANTENNA__1316__D Tile_X0Y5_FrameData[12] VPWR VGND sg13cmos5l_antennanp
X_0453_ _0453_/Q Tile_X0Y1_FrameData[17] VGND VPWR Tile_X0Y5_FrameStrobe[4] latch
X_0384_ _0384_/Q Tile_X0Y1_FrameData[22] VGND VPWR Tile_X0Y5_FrameStrobe[2] latch
XFILLER_343_84 VPWR VGND sg13cmos5l_decap_8
X_2123_ AXIL_S_SOC_RDATA17 Tile_X0Y1_W2MID[1] Tile_X0Y1_W2END[1] Tile_X0Y1_W6END[1]
+ _2374_/X _0380_/Q _0379_/Q VPWR VGND sg13cmos5l_mux4_1
XANTENNA__2258__A0 Tile_X0Y1_W2MID[3] VPWR VGND sg13cmos5l_antennanp
XFILLER_19_182 VPWR VGND sg13cmos5l_fill_2
XFILLER_212_55 VPWR VGND sg13cmos5l_decap_8
X_2054_ Tile_X0Y5_S2BEG[3] _2776_/X VPWR VGND sg13cmos5l_buf_1
XANTENNA__1051__D Tile_X0Y4_FrameData[11] VPWR VGND sg13cmos5l_antennanp
XFILLER_281_186 VPWR VGND sg13cmos5l_fill_1
X_1005_ _1005_/Q Tile_X0Y3_FrameData[9] VGND VPWR Tile_X0Y5_FrameStrobe[6] latch
XANTENNA__2273__A3 Tile_X0Y2_W6END[11] VPWR VGND sg13cmos5l_antennanp
XFILLER_288_48 VPWR VGND sg13cmos5l_decap_4
XANTENNA__0890__D Tile_X0Y3_FrameData[28] VPWR VGND sg13cmos5l_antennanp
XANTENNA__1094__GATE Tile_X0Y5_FrameStrobe[1] VPWR VGND sg13cmos5l_antennanp
XFILLER_194_105 VPWR VGND sg13cmos5l_decap_8
XANTENNA__1628__X Tile_X0Y0_N2BEG[0] VPWR VGND sg13cmos5l_antennanp
XANTENNA__2430__A0 AXIL_S_SOC_AWADDR1 VPWR VGND sg13cmos5l_antennanp
X_1907_ Tile_X0Y1_FrameData_O[20] Tile_X0Y1_FrameData[20] VPWR VGND sg13cmos5l_buf_1
XFILLER_336_121 VPWR VGND sg13cmos5l_decap_4
XFILLER_135_205 VPWR VGND sg13cmos5l_decap_8
X_1838_ Tile_X0Y4_FrameData_O[5] Tile_X0Y4_FrameData[5] VPWR VGND sg13cmos5l_buf_1
XFILLER_237_52 VPWR VGND sg13cmos5l_decap_8
XFILLER_351_113 VPWR VGND sg13cmos5l_decap_8
XANTENNA__2733__A1 AXIL_S_SOC_ARVALID VPWR VGND sg13cmos5l_antennanp
X_1769_ Tile_X0Y2_FrameData_O[29] Tile_X0Y2_FrameData[29] VPWR VGND sg13cmos5l_buf_1
XANTENNA__1032__GATE Tile_X0Y5_FrameStrobe[0] VPWR VGND sg13cmos5l_antennanp
XFILLER_103_113 VPWR VGND sg13cmos5l_decap_4
XANTENNA__1226__D Tile_X0Y4_FrameData[28] VPWR VGND sg13cmos5l_antennanp
XFILLER_249_139 VPWR VGND sg13cmos5l_fill_2
XANTENNA__0130__D Tile_X0Y0_FrameData[4] VPWR VGND sg13cmos5l_antennanp
XANTENNA__2497__A0 Tile_X0Y1_W1END[0] VPWR VGND sg13cmos5l_antennanp
XFILLER_66_27 VPWR VGND sg13cmos5l_decap_4
XFILLER_253_95 VPWR VGND sg13cmos5l_decap_4
XFILLER_286_8 VPWR VGND sg13cmos5l_decap_8
XANTENNA__1047__GATE Tile_X0Y5_FrameStrobe[0] VPWR VGND sg13cmos5l_antennanp
XANTENNA__2249__A0 Tile_X0Y2_W2MID[7] VPWR VGND sg13cmos5l_antennanp
XFILLER_272_120 VPWR VGND sg13cmos5l_decap_8
XFILLER_25_185 VPWR VGND sg13cmos5l_fill_1
XFILLER_185_127 VPWR VGND sg13cmos5l_fill_2
XFILLER_185_138 VPWR VGND sg13cmos5l_fill_2
XANTENNA__2421__A0 AXIL_S_SOC_AWADDR4 VPWR VGND sg13cmos5l_antennanp
XANTENNA__0305__D Tile_X0Y0_FrameData[21] VPWR VGND sg13cmos5l_antennanp
XANTENNA__1538__X Tile_X0Y3_EE4BEG[0] VPWR VGND sg13cmos5l_antennanp
XFILLER_327_176 VPWR VGND sg13cmos5l_decap_4
XFILLER_327_154 VPWR VGND sg13cmos5l_fill_1
XFILLER_147_30 VPWR VGND sg13cmos5l_decap_8
XFILLER_193_182 VPWR VGND sg13cmos5l_decap_8
XANTENNA__0241__GATE Tile_X0Y5_FrameStrobe[5] VPWR VGND sg13cmos5l_antennanp
XANTENNA__0871__GATE Tile_X0Y5_FrameStrobe[2] VPWR VGND sg13cmos5l_antennanp
XFILLER_103_0 VPWR VGND sg13cmos5l_fill_1
XFILLER_31_96 VPWR VGND sg13cmos5l_decap_8
XFILLER_295_201 VPWR VGND sg13cmos5l_fill_2
XANTENNA__1136__D Tile_X0Y4_FrameData[22] VPWR VGND sg13cmos5l_antennanp
XFILLER_295_223 VPWR VGND sg13cmos5l_fill_1
XANTENNA__0256__GATE Tile_X0Y5_FrameStrobe[5] VPWR VGND sg13cmos5l_antennanp
XFILLER_163_62 VPWR VGND sg13cmos5l_decap_8
XANTENNA__0886__GATE Tile_X0Y5_FrameStrobe[2] VPWR VGND sg13cmos5l_antennanp
XANTENNA__0975__D Tile_X0Y3_FrameData[7] VPWR VGND sg13cmos5l_antennanp
XFILLER_313_54 VPWR VGND sg13cmos5l_decap_8
XFILLER_263_142 VPWR VGND sg13cmos5l_decap_8
XFILLER_263_153 VPWR VGND sg13cmos5l_fill_2
XANTENNA__2660__A0 AXIL_S_SOC_WSTRB3 VPWR VGND sg13cmos5l_antennanp
X_2810_ _2810_/X Tile_X0Y5_N1END[1] Tile_X0Y5_N4END[1] _2794_/X _0059_/X _1302_/Q
+ _1301_/Q VPWR VGND sg13cmos5l_mux4_1
XANTENNA__0824__GATE Tile_X0Y5_FrameStrobe[1] VPWR VGND sg13cmos5l_antennanp
XANTENNA__2412__A0 AXIL_S_SOC_AWADDR3 VPWR VGND sg13cmos5l_antennanp
X_2741_ _2741_/X AXIL_S_SOC_ARPROT0 AXIL_S_SOC_ARPROT2 _2801_/X _2797_/X _1420_/Q
+ _1419_/Q VPWR VGND sg13cmos5l_mux4_1
XFILLER_318_132 VPWR VGND sg13cmos5l_fill_1
XANTENNA__0215__D Tile_X0Y0_FrameData[15] VPWR VGND sg13cmos5l_antennanp
XFILLER_117_205 VPWR VGND sg13cmos5l_fill_2
XFILLER_318_154 VPWR VGND sg13cmos5l_fill_1
XANTENNA__0209__GATE Tile_X0Y5_FrameStrobe[4] VPWR VGND sg13cmos5l_antennanp
X_2672_ _2672_/X _2680_/X _2679_/X Tile_X0Y4_W6END[3] _2672_/A3 _1032_/Q _1265_/Q
+ VPWR VGND sg13cmos5l_mux4_1
XFILLER_338_95 VPWR VGND sg13cmos5l_fill_2
XFILLER_333_124 VPWR VGND sg13cmos5l_fill_1
XFILLER_333_113 VPWR VGND sg13cmos5l_decap_8
XFILLER_318_187 VPWR VGND sg13cmos5l_fill_1
XANTENNA__0839__GATE Tile_X0Y5_FrameStrobe[1] VPWR VGND sg13cmos5l_antennanp
XANTENNA__2715__A1 Tile_X0Y3_W2END[5] VPWR VGND sg13cmos5l_antennanp
X_1623_ Tile_X0Y0_N2BEGb[3] _2256_/X VPWR VGND sg13cmos5l_buf_1
X_1554_ Tile_X0Y3_FrameData_O[0] Tile_X0Y3_FrameData[0] VPWR VGND sg13cmos5l_buf_1
XFILLER_354_50 VPWR VGND sg13cmos5l_decap_8
XANTENNA__1046__D Tile_X0Y4_FrameData[16] VPWR VGND sg13cmos5l_antennanp
XFILLER_286_223 VPWR VGND sg13cmos5l_fill_1
X_1485_ _1485_/Q Tile_X0Y5_FrameData[3] VGND VPWR Tile_X0Y5_FrameStrobe[6] latch
X_0505_ _0505_/Q Tile_X0Y1_FrameData[29] VGND VPWR Tile_X0Y5_FrameStrobe[6] latch
X_0436_ _0436_/Q Tile_X0Y1_FrameData[2] VGND VPWR Tile_X0Y5_FrameStrobe[3] latch
.ends
