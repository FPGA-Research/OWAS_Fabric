* NGSPICE file created from FLUT51PSDM.ext - technology: ihp-sg13cmos5l

* Black-box entry subcircuit for sg13cmos5l_mux4_1 abstract view
.subckt sg13cmos5l_mux4_1 X A0 A1 A2 A3 S0 S1 VDD VSS
.ends

* Black-box entry subcircuit for latch abstract view
.subckt latch Q D VSS VDD GATE
.ends

* Black-box entry subcircuit for sg13cmos5l_decap_4 abstract view
.subckt sg13cmos5l_decap_4 VDD VSS
.ends

* Black-box entry subcircuit for sg13cmos5l_fill_2 abstract view
.subckt sg13cmos5l_fill_2 VDD VSS
.ends

* Black-box entry subcircuit for sg13cmos5l_fill_1 abstract view
.subckt sg13cmos5l_fill_1 VDD VSS
.ends

* Black-box entry subcircuit for sg13cmos5l_antennanp abstract view
.subckt sg13cmos5l_antennanp A VDD VSS
.ends

* Black-box entry subcircuit for sg13cmos5l_decap_8 abstract view
.subckt sg13cmos5l_decap_8 VDD VSS
.ends

* Black-box entry subcircuit for sg13cmos5l_o21ai_1 abstract view
.subckt sg13cmos5l_o21ai_1 Y A1 A2 B1 VDD VSS
.ends

* Black-box entry subcircuit for sg13cmos5l_buf_1 abstract view
.subckt sg13cmos5l_buf_1 X A VDD VSS
.ends

* Black-box entry subcircuit for sg13cmos5l_nor2_1 abstract view
.subckt sg13cmos5l_nor2_1 Y A B VDD VSS
.ends

* Black-box entry subcircuit for sg13cmos5l_tielo abstract view
.subckt sg13cmos5l_tielo L_LO VDD VSS
.ends

* Black-box entry subcircuit for sg13cmos5l_and2_1 abstract view
.subckt sg13cmos5l_and2_1 X A B VDD VSS
.ends

* Black-box entry subcircuit for sg13cmos5l_nand2_1 abstract view
.subckt sg13cmos5l_nand2_1 Y A B VDD VSS
.ends

* Black-box entry subcircuit for sg13cmos5l_a221oi_1 abstract view
.subckt sg13cmos5l_a221oi_1 Y A1 A2 B1 B2 C1 VDD VSS
.ends

* Black-box entry subcircuit for sg13cmos5l_a21oi_1 abstract view
.subckt sg13cmos5l_a21oi_1 Y A1 A2 B1 VDD VSS
.ends

* Black-box entry subcircuit for sg13cmos5l_dfrbpq_1 abstract view
.subckt sg13cmos5l_dfrbpq_1 Q CLK D RESET_B VDD VSS
.ends

* Black-box entry subcircuit for sg13cmos5l_tiehi abstract view
.subckt sg13cmos5l_tiehi L_HI VDD VSS
.ends

* Black-box entry subcircuit for sg13cmos5l_inv_1 abstract view
.subckt sg13cmos5l_inv_1 Y A VDD VSS
.ends

* Black-box entry subcircuit for sg13cmos5l_mux2_1 abstract view
.subckt sg13cmos5l_mux2_1 X A0 A1 S VDD VSS
.ends

* Black-box entry subcircuit for sg13cmos5l_nand2b_1 abstract view
.subckt sg13cmos5l_nand2b_1 Y A_N B VDD VSS
.ends

* Black-box entry subcircuit for sg13cmos5l_nor2b_1 abstract view
.subckt sg13cmos5l_nor2b_1 Y A B_N VDD VSS
.ends

* Black-box entry subcircuit for sg13cmos5l_a22oi_1 abstract view
.subckt sg13cmos5l_a22oi_1 Y A1 A2 B1 B2 VDD VSS
.ends

* Black-box entry subcircuit for sg13cmos5l_nor4_1 abstract view
.subckt sg13cmos5l_nor4_1 Y A B C D VDD VSS
.ends

* Black-box entry subcircuit for sg13cmos5l_or3_1 abstract view
.subckt sg13cmos5l_or3_1 X A B C VDD VSS
.ends

* Black-box entry subcircuit for sg13cmos5l_buf_16 abstract view
.subckt sg13cmos5l_buf_16 X A VDD VSS
.ends

* Black-box entry subcircuit for sg13cmos5l_xnor2_1 abstract view
.subckt sg13cmos5l_xnor2_1 Y A B VDD VSS
.ends

* Black-box entry subcircuit for sg13cmos5l_or2_1 abstract view
.subckt sg13cmos5l_or2_1 X A B VDD VSS
.ends

* Black-box entry subcircuit for sg13cmos5l_a21o_1 abstract view
.subckt sg13cmos5l_a21o_1 X A1 A2 B1 VDD VSS
.ends

* Black-box entry subcircuit for sg13cmos5l_nor3_1 abstract view
.subckt sg13cmos5l_nor3_1 Y A B C VDD VSS
.ends

* Black-box entry subcircuit for sg13cmos5l_and3_1 abstract view
.subckt sg13cmos5l_and3_1 X A B C VDD VSS
.ends

* Black-box entry subcircuit for sg13cmos5l_nand3_1 abstract view
.subckt sg13cmos5l_nand3_1 Y A B C VDD VSS
.ends

.subckt FLUT51PSDM Ci Co E1BEG[0] E1BEG[1] E1BEG[2] E1BEG[3] E1END[0] E1END[1] E1END[2]
+ E1END[3] E2BEG[0] E2BEG[1] E2BEG[2] E2BEG[3] E2BEG[4] E2BEG[5] E2BEG[6] E2BEG[7]
+ E2BEGb[0] E2BEGb[1] E2BEGb[2] E2BEGb[3] E2BEGb[4] E2BEGb[5] E2BEGb[6] E2BEGb[7]
+ E2END[0] E2END[1] E2END[2] E2END[3] E2END[4] E2END[5] E2END[6] E2END[7] E2MID[0]
+ E2MID[1] E2MID[2] E2MID[3] E2MID[4] E2MID[5] E2MID[6] E2MID[7] E6BEG[0] E6BEG[10]
+ E6BEG[11] E6BEG[1] E6BEG[2] E6BEG[3] E6BEG[4] E6BEG[5] E6BEG[6] E6BEG[7] E6BEG[8]
+ E6BEG[9] E6END[0] E6END[10] E6END[11] E6END[1] E6END[2] E6END[3] E6END[4] E6END[5]
+ E6END[6] E6END[7] E6END[8] E6END[9] EE4BEG[0] EE4BEG[10] EE4BEG[11] EE4BEG[12] EE4BEG[13]
+ EE4BEG[14] EE4BEG[15] EE4BEG[1] EE4BEG[2] EE4BEG[3] EE4BEG[4] EE4BEG[5] EE4BEG[6]
+ EE4BEG[7] EE4BEG[8] EE4BEG[9] EE4END[0] EE4END[10] EE4END[11] EE4END[12] EE4END[13]
+ EE4END[14] EE4END[15] EE4END[1] EE4END[2] EE4END[3] EE4END[4] EE4END[5] EE4END[6]
+ EE4END[7] EE4END[8] EE4END[9] FrameData[0] FrameData[10] FrameData[11] FrameData[12]
+ FrameData[13] FrameData[14] FrameData[15] FrameData[16] FrameData[17] FrameData[18]
+ FrameData[19] FrameData[1] FrameData[20] FrameData[21] FrameData[22] FrameData[23]
+ FrameData[24] FrameData[25] FrameData[26] FrameData[27] FrameData[28] FrameData[29]
+ FrameData[2] FrameData[30] FrameData[31] FrameData[3] FrameData[4] FrameData[5]
+ FrameData[6] FrameData[7] FrameData[8] FrameData[9] FrameData_O[0] FrameData_O[10]
+ FrameData_O[11] FrameData_O[12] FrameData_O[13] FrameData_O[14] FrameData_O[15]
+ FrameData_O[16] FrameData_O[17] FrameData_O[18] FrameData_O[19] FrameData_O[1] FrameData_O[20]
+ FrameData_O[21] FrameData_O[22] FrameData_O[23] FrameData_O[24] FrameData_O[25]
+ FrameData_O[26] FrameData_O[27] FrameData_O[28] FrameData_O[29] FrameData_O[2] FrameData_O[30]
+ FrameData_O[31] FrameData_O[3] FrameData_O[4] FrameData_O[5] FrameData_O[6] FrameData_O[7]
+ FrameData_O[8] FrameData_O[9] FrameStrobe[0] FrameStrobe[10] FrameStrobe[11] FrameStrobe[12]
+ FrameStrobe[13] FrameStrobe[14] FrameStrobe[15] FrameStrobe[16] FrameStrobe[17]
+ FrameStrobe[18] FrameStrobe[19] FrameStrobe[1] FrameStrobe[2] FrameStrobe[3] FrameStrobe[4]
+ FrameStrobe[5] FrameStrobe[6] FrameStrobe[7] FrameStrobe[8] FrameStrobe[9] FrameStrobe_O[0]
+ FrameStrobe_O[10] FrameStrobe_O[11] FrameStrobe_O[12] FrameStrobe_O[13] FrameStrobe_O[14]
+ FrameStrobe_O[15] FrameStrobe_O[16] FrameStrobe_O[17] FrameStrobe_O[18] FrameStrobe_O[19]
+ FrameStrobe_O[1] FrameStrobe_O[2] FrameStrobe_O[3] FrameStrobe_O[4] FrameStrobe_O[5]
+ FrameStrobe_O[6] FrameStrobe_O[7] FrameStrobe_O[8] FrameStrobe_O[9] N1BEG[0] N1BEG[1]
+ N1BEG[2] N1BEG[3] N1END[0] N1END[1] N1END[2] N1END[3] N2BEG[0] N2BEG[1] N2BEG[2]
+ N2BEG[3] N2BEG[4] N2BEG[5] N2BEG[6] N2BEG[7] N2BEGb[0] N2BEGb[1] N2BEGb[2] N2BEGb[3]
+ N2BEGb[4] N2BEGb[5] N2BEGb[6] N2BEGb[7] N2END[0] N2END[1] N2END[2] N2END[3] N2END[4]
+ N2END[5] N2END[6] N2END[7] N2MID[0] N2MID[1] N2MID[2] N2MID[3] N2MID[4] N2MID[5]
+ N2MID[6] N2MID[7] N4BEG[0] N4BEG[10] N4BEG[11] N4BEG[12] N4BEG[13] N4BEG[14] N4BEG[15]
+ N4BEG[1] N4BEG[2] N4BEG[3] N4BEG[4] N4BEG[5] N4BEG[6] N4BEG[7] N4BEG[8] N4BEG[9]
+ N4END[0] N4END[10] N4END[11] N4END[12] N4END[13] N4END[14] N4END[15] N4END[1] N4END[2]
+ N4END[3] N4END[4] N4END[5] N4END[6] N4END[7] N4END[8] N4END[9] NN4BEG[0] NN4BEG[10]
+ NN4BEG[11] NN4BEG[12] NN4BEG[13] NN4BEG[14] NN4BEG[15] NN4BEG[1] NN4BEG[2] NN4BEG[3]
+ NN4BEG[4] NN4BEG[5] NN4BEG[6] NN4BEG[7] NN4BEG[8] NN4BEG[9] NN4END[0] NN4END[10]
+ NN4END[11] NN4END[12] NN4END[13] NN4END[14] NN4END[15] NN4END[1] NN4END[2] NN4END[3]
+ NN4END[4] NN4END[5] NN4END[6] NN4END[7] NN4END[8] NN4END[9] S1BEG[0] S1BEG[1] S1BEG[2]
+ S1BEG[3] S1END[0] S1END[1] S1END[2] S1END[3] S2BEG[0] S2BEG[1] S2BEG[2] S2BEG[3]
+ S2BEG[4] S2BEG[5] S2BEG[6] S2BEG[7] S2BEGb[0] S2BEGb[1] S2BEGb[2] S2BEGb[3] S2BEGb[4]
+ S2BEGb[5] S2BEGb[6] S2BEGb[7] S2END[0] S2END[1] S2END[2] S2END[3] S2END[4] S2END[5]
+ S2END[6] S2END[7] S2MID[0] S2MID[1] S2MID[2] S2MID[3] S2MID[4] S2MID[5] S2MID[6]
+ S2MID[7] S4BEG[0] S4BEG[10] S4BEG[11] S4BEG[12] S4BEG[13] S4BEG[14] S4BEG[15] S4BEG[1]
+ S4BEG[2] S4BEG[3] S4BEG[4] S4BEG[5] S4BEG[6] S4BEG[7] S4BEG[8] S4BEG[9] S4END[0]
+ S4END[10] S4END[11] S4END[12] S4END[13] S4END[14] S4END[15] S4END[1] S4END[2] S4END[3]
+ S4END[4] S4END[5] S4END[6] S4END[7] S4END[8] S4END[9] SS4BEG[0] SS4BEG[10] SS4BEG[11]
+ SS4BEG[12] SS4BEG[13] SS4BEG[14] SS4BEG[15] SS4BEG[1] SS4BEG[2] SS4BEG[3] SS4BEG[4]
+ SS4BEG[5] SS4BEG[6] SS4BEG[7] SS4BEG[8] SS4BEG[9] SS4END[0] SS4END[10] SS4END[11]
+ SS4END[12] SS4END[13] SS4END[14] SS4END[15] SS4END[1] SS4END[2] SS4END[3] SS4END[4]
+ SS4END[5] SS4END[6] SS4END[7] SS4END[8] SS4END[9] UserCLK UserCLKo VGND VPWR W1BEG[0]
+ W1BEG[1] W1BEG[2] W1BEG[3] W1END[0] W1END[1] W1END[2] W1END[3] W2BEG[0] W2BEG[1]
+ W2BEG[2] W2BEG[3] W2BEG[4] W2BEG[5] W2BEG[6] W2BEG[7] W2BEGb[0] W2BEGb[1] W2BEGb[2]
+ W2BEGb[3] W2BEGb[4] W2BEGb[5] W2BEGb[6] W2BEGb[7] W2END[0] W2END[1] W2END[2] W2END[3]
+ W2END[4] W2END[5] W2END[6] W2END[7] W2MID[0] W2MID[1] W2MID[2] W2MID[3] W2MID[4]
+ W2MID[5] W2MID[6] W2MID[7] W6BEG[0] W6BEG[10] W6BEG[11] W6BEG[1] W6BEG[2] W6BEG[3]
+ W6BEG[4] W6BEG[5] W6BEG[6] W6BEG[7] W6BEG[8] W6BEG[9] W6END[0] W6END[10] W6END[11]
+ W6END[1] W6END[2] W6END[3] W6END[4] W6END[5] W6END[6] W6END[7] W6END[8] W6END[9]
+ WW4BEG[0] WW4BEG[10] WW4BEG[11] WW4BEG[12] WW4BEG[13] WW4BEG[14] WW4BEG[15] WW4BEG[1]
+ WW4BEG[2] WW4BEG[3] WW4BEG[4] WW4BEG[5] WW4BEG[6] WW4BEG[7] WW4BEG[8] WW4BEG[9]
+ WW4END[0] WW4END[10] WW4END[11] WW4END[12] WW4END[13] WW4END[14] WW4END[15] WW4END[1]
+ WW4END[2] WW4END[3] WW4END[4] WW4END[5] WW4END[6] WW4END[7] WW4END[8] WW4END[9]
X_3086_ _3086_/X S2MID[3] S2END[3] S4END[3] _1205_/Y _2143_/Q _2144_/Q VPWR VGND sg13cmos5l_mux4_1
X_3155_ _3155_/X _3151_/X _3152_/X _3153_/X _3154_/X _2236_/Q _2237_/Q VPWR VGND sg13cmos5l_mux4_1
X_2106_ _2106_/Q FrameData[31] VGND VPWR FrameStrobe[7] latch
X_2037_ _2037_/Q FrameData[26] VGND VPWR FrameStrobe[9] latch
XFILLER_10_328 VPWR VGND sg13cmos5l_decap_4
X_2939_ _2939_/X N2END[3] S1END[3] _1250_/Q _3136_/X _2029_/Q _2030_/Q VPWR VGND sg13cmos5l_mux4_1
XFILLER_26_52 VPWR VGND sg13cmos5l_fill_2
XFILLER_13_166 VPWR VGND sg13cmos5l_fill_1
XFILLER_3_45 VPWR VGND sg13cmos5l_fill_2
X_1270_ _1270_/Q FrameData[27] VGND VPWR _1180_/X latch
XANTENNA__2562__X FrameData_O[15] VPWR VGND sg13cmos5l_antennanp
XFILLER_17_461 VPWR VGND sg13cmos5l_decap_8
X_0985_ _0986_/A _2319_/Q _0983_/Y _0984_/Y VPWR VGND sg13cmos5l_o21ai_1
X_1606_ _1606_/Q FrameData[11] VGND VPWR _1189_/X latch
X_2724_ _2724_/X _2720_/X _2721_/X _2722_/X _2723_/X _1795_/Q _1796_/Q VPWR VGND sg13cmos5l_mux4_1
X_2655_ _2655_/X _3170_/X _0862_/X _3122_/X _0857_/X _1741_/Q _1742_/Q VPWR VGND sg13cmos5l_mux4_1
X_1399_ _1399_/Q FrameData[28] VGND VPWR _1181_/X latch
X_1468_ _1468_/Q FrameData[1] VGND VPWR _1182_/X latch
X_1537_ _1537_/Q FrameData[6] VGND VPWR _1187_/X latch
X_3207_ _3207_/X _2899_/X _0861_/X _3122_/X _3010_/X _1881_/Q _1882_/Q VPWR VGND sg13cmos5l_mux4_1
X_2586_ SS4BEG[7] SS4END[11] VPWR VGND sg13cmos5l_buf_1
XFILLER_55_556 VPWR VGND sg13cmos5l_fill_1
X_3069_ _3069_/X W2END[1] _3069_/A1 _3069_/A2 _1066_/Y _2094_/Q _2095_/Q VPWR VGND
+ sg13cmos5l_mux4_1
X_3138_ _3138_/X _1240_/Q _3138_/A1 _3138_/A2 _1066_/Y _2091_/Q _2092_/Q VPWR VGND
+ sg13cmos5l_mux4_1
XANTENNA__2472__X N2BEGb[1] VPWR VGND sg13cmos5l_antennanp
XFILLER_12_43 VPWR VGND sg13cmos5l_fill_1
XFILLER_18_247 VPWR VGND sg13cmos5l_fill_1
X_0770_ _0770_/Y _1841_/Q _1842_/Q VPWR VGND sg13cmos5l_nor2_1
X_2440_ FrameStrobe_O[1] FrameStrobe[1] VPWR VGND sg13cmos5l_buf_1
XANTENNA__2557__X FrameData_O[10] VPWR VGND sg13cmos5l_antennanp
X_1253_ _1253_/Q FrameData[10] VGND VPWR _1180_/X latch
X_1322_ _1322_/Q FrameData[15] VGND VPWR _1184_/X latch
X_2371_ _2916_/A1 VPWR VGND sg13cmos5l_tielo
X_1184_ _1184_/X FrameStrobe[13] FrameStrobe[19] VPWR VGND sg13cmos5l_and2_1
XFILLER_32_250 VPWR VGND sg13cmos5l_fill_1
X_0968_ _0968_/Y _1782_/Q _2601_/A VPWR VGND sg13cmos5l_nand2_1
XFILLER_9_490 VPWR VGND sg13cmos5l_decap_8
X_0899_ _0899_/Y _2876_/X _0899_/B VPWR VGND sg13cmos5l_nor2_1
X_2707_ _2707_/X _1355_/Q _1356_/Q _1357_/Q _1358_/Q _3244_/X _3239_/X VPWR VGND sg13cmos5l_mux4_1
X_2638_ WW4BEG[11] WW4END[15] VPWR VGND sg13cmos5l_buf_1
X_2569_ FrameData_O[22] FrameData[22] VPWR VGND sg13cmos5l_buf_1
XANTENNA__2467__X N2BEG[4] VPWR VGND sg13cmos5l_antennanp
XFILLER_28_523 VPWR VGND sg13cmos5l_fill_1
X_0822_ _0823_/B _1118_/A _1537_/Q _0789_/Y _0791_/Y _0795_/B VPWR VGND sg13cmos5l_a221oi_1
X_1940_ _1940_/Q FrameData[25] VGND VPWR _1137_/X latch
X_1871_ _1871_/Q FrameData[20] VGND VPWR _1157_/X latch
X_0684_ _0684_/Y _0575_/Y _2795_/X _1493_/Q VPWR VGND sg13cmos5l_a21oi_1
X_0753_ _0753_/Y _0751_/B _0752_/Y _1285_/Q VPWR VGND sg13cmos5l_a21oi_1
X_2423_ E2BEGb[4] E2MID[4] VPWR VGND sg13cmos5l_buf_1
X_1236_ _1236_/Q _1250_/CLK _1236_/D _2368_/L_HI VPWR VGND sg13cmos5l_dfrbpq_1
X_1305_ _1305_/Q FrameData[30] VGND VPWR _1197_/X latch
X_2354_ _2354_/L_HI VPWR VGND sg13cmos5l_tiehi
X_2285_ _2285_/Q FrameData[18] VGND VPWR FrameStrobe[1] latch
XFILLER_25_504 VPWR VGND sg13cmos5l_fill_2
X_1098_ _1098_/Y _3198_/X _3197_/X VPWR VGND sg13cmos5l_nor2_1
X_1167_ _1167_/X FrameStrobe[12] FrameStrobe[14] VPWR VGND sg13cmos5l_and2_1
XFILLER_20_297 VPWR VGND sg13cmos5l_decap_8
XFILLER_18_64 VPWR VGND sg13cmos5l_fill_2
XFILLER_28_386 VPWR VGND sg13cmos5l_decap_4
XFILLER_34_52 VPWR VGND sg13cmos5l_fill_2
X_2070_ _2070_/Q FrameData[27] VGND VPWR FrameStrobe[8] latch
X_1021_ _1021_/Y _1846_/Q _2603_/A VPWR VGND sg13cmos5l_nand2_1
X_2972_ _2972_/X N2MID[1] E1END[3] W2END[3] _3087_/X _2003_/Q _2004_/Q VPWR VGND sg13cmos5l_mux4_1
XANTENNA__2570__X FrameData_O[23] VPWR VGND sg13cmos5l_antennanp
X_0805_ _0805_/Y _2324_/Q _0805_/B VPWR VGND sg13cmos5l_nor2_1
X_1785_ _1785_/Q FrameData[30] VGND VPWR _1139_/X latch
X_1923_ _1923_/Q FrameData[8] VGND VPWR _1137_/X latch
X_1854_ _1854_/Q FrameData[3] VGND VPWR _1157_/X latch
X_0598_ _0808_/A _2308_/Q VPWR VGND sg13cmos5l_inv_1
X_0667_ _2469_/A _2972_/X _2973_/X _2005_/Q VPWR VGND sg13cmos5l_mux2_1
X_0736_ _0878_/A _0735_/D _0584_/Y _0736_/S VPWR VGND sg13cmos5l_mux2_1
X_2406_ EE4BEG[15] _2406_/A VPWR VGND sg13cmos5l_buf_1
X_1219_ _1219_/Y _2850_/X _1581_/Q VPWR VGND sg13cmos5l_nand2_1
X_2337_ _3063_/A2 VPWR VGND sg13cmos5l_tiehi
X_2268_ _2268_/Q FrameData[1] VGND VPWR FrameStrobe[1] latch
X_2199_ _2199_/Q FrameData[28] VGND VPWR FrameStrobe[4] latch
XANTENNA__2480__X N4BEG[1] VPWR VGND sg13cmos5l_antennanp
XFILLER_52_197 VPWR VGND sg13cmos5l_fill_2
XFILLER_0_455 VPWR VGND sg13cmos5l_fill_2
XANTENNA_5 FrameStrobe[15] VPWR VGND sg13cmos5l_antennanp
X_1570_ _1570_/Q FrameData[7] VGND VPWR _1166_/X latch
X_3240_ _3240_/X _0658_/X _3006_/X _3136_/X _0656_/X _1785_/Q _1786_/Q VPWR VGND sg13cmos5l_mux4_1
XANTENNA__2565__X FrameData_O[18] VPWR VGND sg13cmos5l_antennanp
XFILLER_19_150 VPWR VGND sg13cmos5l_decap_8
X_3171_ _3171_/X NN4END[0] EE4END[0] S2MID[0] W1END[0] _2259_/Q _2260_/Q VPWR VGND
+ sg13cmos5l_mux4_1
X_2122_ _2122_/Q FrameData[15] VGND VPWR FrameStrobe[6] latch
X_2053_ _2053_/Q FrameData[10] VGND VPWR FrameStrobe[8] latch
X_1004_ _1005_/A _2942_/X _2056_/Q _1003_/Y VPWR VGND sg13cmos5l_a21oi_1
X_2955_ _2955_/X _0871_/X _2917_/X _0858_/X _0921_/Y _2022_/Q _2023_/Q VPWR VGND sg13cmos5l_mux4_1
XFILLER_30_381 VPWR VGND sg13cmos5l_fill_1
X_1768_ _1768_/Q FrameData[13] VGND VPWR _1139_/X latch
X_2886_ _2886_/X N1END[0] N2MID[4] N2END[4] NN4END[0] _2277_/Q _2278_/Q VPWR VGND
+ sg13cmos5l_mux4_1
X_1906_ _1906_/Q FrameData[23] VGND VPWR _1152_/X latch
X_1837_ _1837_/Q FrameData[18] VGND VPWR _1136_/X latch
X_0719_ _0719_/Y _0581_/Y _2708_/X _1367_/Q VPWR VGND sg13cmos5l_a21oi_1
X_1699_ _1699_/Q FrameData[8] VGND VPWR _1133_/X latch
XANTENNA__2475__X N2BEGb[4] VPWR VGND sg13cmos5l_antennanp
XFILLER_13_304 VPWR VGND sg13cmos5l_fill_2
XFILLER_57_256 VPWR VGND sg13cmos5l_fill_1
XFILLER_57_278 VPWR VGND sg13cmos5l_fill_2
XFILLER_21_370 VPWR VGND sg13cmos5l_decap_8
XFILLER_16_186 VPWR VGND sg13cmos5l_fill_1
XFILLER_31_101 VPWR VGND sg13cmos5l_fill_2
X_1622_ _1622_/Q FrameData[27] VGND VPWR _1189_/X latch
X_2740_ _2740_/X _3100_/X _0650_/X _3144_/X _3093_/X _1837_/Q _1838_/Q VPWR VGND sg13cmos5l_mux4_1
X_2671_ _2671_/X _2667_/X _2668_/X _2669_/X _2670_/X _1739_/Q _1740_/Q VPWR VGND sg13cmos5l_mux4_1
XFILLER_39_234 VPWR VGND sg13cmos5l_decap_4
X_1484_ _1484_/Q FrameData[17] VGND VPWR _1182_/X latch
X_1553_ _1553_/Q FrameData[22] VGND VPWR _1187_/X latch
X_3223_ _3223_/X _3006_/X _3036_/X _0657_/X _3059_/X _1821_/Q _1822_/Q VPWR VGND sg13cmos5l_mux4_1
XFILLER_11_0 VPWR VGND sg13cmos5l_decap_4
X_3085_ _3085_/X E1END[1] E2MID[5] E2END[5] EE4END[3] _2143_/Q _2144_/Q VPWR VGND
+ sg13cmos5l_mux4_1
X_3154_ _3154_/X _1244_/Q _0875_/A _1208_/Y _1223_/Y _2234_/Q _2235_/Q VPWR VGND sg13cmos5l_mux4_1
X_2105_ _2105_/Q FrameData[30] VGND VPWR FrameStrobe[7] latch
X_2036_ _2036_/Q FrameData[25] VGND VPWR FrameStrobe[9] latch
X_2938_ _2938_/X _0650_/X _3107_/X _0860_/X _1208_/Y _2082_/Q _2083_/Q VPWR VGND sg13cmos5l_mux4_1
X_2869_ _2869_/X _2865_/X _2866_/X _2867_/X _2868_/X _1955_/Q _1956_/Q VPWR VGND sg13cmos5l_mux4_1
XFILLER_45_204 VPWR VGND sg13cmos5l_fill_2
XFILLER_13_156 VPWR VGND sg13cmos5l_fill_1
XFILLER_53_292 VPWR VGND sg13cmos5l_fill_2
XFILLER_36_226 VPWR VGND sg13cmos5l_decap_8
XFILLER_32_432 VPWR VGND sg13cmos5l_decap_4
XFILLER_32_465 VPWR VGND sg13cmos5l_fill_1
XFILLER_32_487 VPWR VGND sg13cmos5l_fill_1
X_0984_ _0984_/Y _0984_/A _2319_/Q VPWR VGND sg13cmos5l_nand2_1
X_2723_ _2723_/X _2890_/X _0861_/X _0860_/X _0858_/X _1793_/Q _1794_/Q VPWR VGND sg13cmos5l_mux4_1
X_1536_ _1536_/Q FrameData[5] VGND VPWR _1187_/X latch
X_1605_ _1605_/Q FrameData[10] VGND VPWR _1189_/X latch
X_2654_ _2654_/X _0871_/X _0869_/X _3155_/X _3150_/X _1741_/Q _1742_/Q VPWR VGND sg13cmos5l_mux4_1
X_2585_ SS4BEG[6] SS4END[10] VPWR VGND sg13cmos5l_buf_1
X_1398_ _1398_/Q FrameData[27] VGND VPWR _1181_/X latch
X_1467_ _1467_/Q FrameData[0] VGND VPWR _1182_/X latch
X_3137_ _3137_/X NN4END[2] E2MID[4] S2END[2] W2MID[0] _2091_/Q _2092_/Q VPWR VGND
+ sg13cmos5l_mux4_1
X_3206_ _3206_/X _3163_/X _3159_/X _3155_/X _0867_/X _1881_/Q _1882_/Q VPWR VGND sg13cmos5l_mux4_1
XFILLER_35_270 VPWR VGND sg13cmos5l_fill_1
XFILLER_35_292 VPWR VGND sg13cmos5l_fill_1
XFILLER_50_251 VPWR VGND sg13cmos5l_fill_2
X_3068_ _3068_/X NN4END[2] E1END[0] EE4END[2] S2END[2] _2094_/Q _2095_/Q VPWR VGND
+ sg13cmos5l_mux4_1
X_2019_ _2019_/Q FrameData[8] VGND VPWR FrameStrobe[9] latch
XFILLER_12_88 VPWR VGND sg13cmos5l_fill_2
XFILLER_2_358 VPWR VGND sg13cmos5l_fill_2
XFILLER_33_207 VPWR VGND sg13cmos5l_fill_2
XFILLER_41_262 VPWR VGND sg13cmos5l_fill_2
X_1252_ _1252_/Q FrameData[9] VGND VPWR _1180_/X latch
X_1321_ _1321_/Q FrameData[14] VGND VPWR _1184_/X latch
X_2370_ _3054_/A1 VPWR VGND sg13cmos5l_tielo
XANTENNA__2573__X FrameData_O[26] VPWR VGND sg13cmos5l_antennanp
XFILLER_49_395 VPWR VGND sg13cmos5l_fill_2
X_1183_ _1183_/X FrameStrobe[13] FrameStrobe[18] VPWR VGND sg13cmos5l_and2_1
X_0967_ _2601_/A _2991_/X _2992_/X _2068_/Q VPWR VGND sg13cmos5l_mux2_1
X_2706_ _2706_/X _1351_/Q _1352_/Q _1353_/Q _1354_/Q _3244_/X _3239_/X VPWR VGND sg13cmos5l_mux4_1
X_0898_ _0898_/Y _1587_/Q _0896_/X _1588_/Q VPWR VGND sg13cmos5l_a21oi_1
X_1519_ _1519_/Q FrameData[20] VGND VPWR _1188_/X latch
X_2637_ WW4BEG[10] WW4END[14] VPWR VGND sg13cmos5l_buf_1
X_2568_ FrameData_O[21] FrameData[21] VPWR VGND sg13cmos5l_buf_1
X_2499_ NN4BEG[4] NN4END[8] VPWR VGND sg13cmos5l_buf_1
XANTENNA__2483__X N4BEG[4] VPWR VGND sg13cmos5l_antennanp
XFILLER_23_262 VPWR VGND sg13cmos5l_fill_2
XANTENNA__2393__X EE4BEG[2] VPWR VGND sg13cmos5l_antennanp
X_0752_ _0752_/Y _1746_/Q Ci VPWR VGND sg13cmos5l_nand2b_1
X_0821_ _0823_/A _0821_/A _0669_/Y VPWR VGND sg13cmos5l_nor2b_1
X_1870_ _1870_/Q FrameData[19] VGND VPWR _1157_/X latch
XANTENNA__2568__X FrameData_O[21] VPWR VGND sg13cmos5l_antennanp
XFILLER_10_490 VPWR VGND sg13cmos5l_fill_1
X_0683_ _0683_/Y _2811_/X _2796_/X VPWR VGND sg13cmos5l_nand2_1
X_2422_ E2BEGb[3] E2MID[3] VPWR VGND sg13cmos5l_buf_1
X_2353_ _2353_/L_HI VPWR VGND sg13cmos5l_tiehi
XFILLER_25_516 VPWR VGND sg13cmos5l_fill_2
X_1166_ _1166_/X FrameStrobe[12] FrameStrobe[17] VPWR VGND sg13cmos5l_and2_1
X_1235_ _1235_/Q _1250_/CLK _1235_/D _2366_/L_HI VPWR VGND sg13cmos5l_dfrbpq_1
X_1304_ _1304_/Q FrameData[29] VGND VPWR _1197_/X latch
X_2284_ _2284_/Q FrameData[17] VGND VPWR FrameStrobe[1] latch
X_1097_ _1242_/D _0565_/Y _1093_/Y _1094_/Y _1096_/Y VPWR VGND sg13cmos5l_a22oi_1
XFILLER_4_409 VPWR VGND sg13cmos5l_fill_1
X_1999_ _1999_/Q FrameData[20] VGND VPWR FrameStrobe[10] latch
XANTENNA__2478__X N2BEGb[7] VPWR VGND sg13cmos5l_antennanp
XFILLER_28_354 VPWR VGND sg13cmos5l_fill_2
XFILLER_28_398 VPWR VGND sg13cmos5l_fill_1
XFILLER_55_151 VPWR VGND sg13cmos5l_fill_2
XFILLER_3_486 VPWR VGND sg13cmos5l_fill_1
X_1020_ _1020_/Y _1875_/Q _1018_/A _1019_/Y VPWR VGND sg13cmos5l_a21oi_1
XFILLER_22_508 VPWR VGND sg13cmos5l_fill_2
XFILLER_30_530 VPWR VGND sg13cmos5l_fill_1
XFILLER_34_346 VPWR VGND sg13cmos5l_fill_2
X_2971_ _2971_/X _3136_/X _0627_/X _3127_/X _1066_/Y _2010_/Q _2011_/Q VPWR VGND sg13cmos5l_mux4_1
X_1922_ _1922_/Q FrameData[7] VGND VPWR _1137_/X latch
X_0735_ _0735_/Y _2676_/X _2700_/X _1333_/Q _0735_/D VPWR VGND sg13cmos5l_nor4_1
X_0804_ _0805_/B _1457_/Q _0702_/Y _0803_/Y VPWR VGND sg13cmos5l_a21oi_1
X_1784_ _1784_/Q FrameData[29] VGND VPWR _1139_/X latch
X_1853_ _1853_/Q FrameData[2] VGND VPWR _1157_/X latch
XFILLER_41_0 VPWR VGND sg13cmos5l_decap_4
X_0597_ _0751_/B _1745_/Q VPWR VGND sg13cmos5l_inv_1
X_0666_ _2468_/A _2979_/X _2980_/X _2002_/Q VPWR VGND sg13cmos5l_mux2_1
X_2405_ EE4BEG[14] _2405_/A VPWR VGND sg13cmos5l_buf_1
X_2336_ _3081_/A2 VPWR VGND sg13cmos5l_tiehi
X_1149_ _1149_/Y _1332_/Q _0878_/A _3246_/X VPWR VGND sg13cmos5l_a21oi_1
X_1218_ Co _1218_/A VPWR VGND sg13cmos5l_inv_1
X_2267_ _2267_/Q FrameData[0] VGND VPWR FrameStrobe[1] latch
X_2198_ _2198_/Q FrameData[27] VGND VPWR FrameStrobe[4] latch
XFILLER_40_305 VPWR VGND sg13cmos5l_fill_1
XFILLER_16_368 VPWR VGND sg13cmos5l_fill_1
XFILLER_45_63 VPWR VGND sg13cmos5l_fill_1
XFILLER_56_460 VPWR VGND sg13cmos5l_fill_2
XANTENNA_6 FrameStrobe[15] VPWR VGND sg13cmos5l_antennanp
XFILLER_8_556 VPWR VGND sg13cmos5l_fill_1
X_3170_ _3170_/X _3166_/X _3167_/X _3168_/X _3169_/X _2267_/Q _2268_/Q VPWR VGND sg13cmos5l_mux4_1
XFILLER_19_195 VPWR VGND sg13cmos5l_decap_4
X_1003_ _1003_/Y _2056_/Q _2941_/X VPWR VGND sg13cmos5l_nor2b_1
X_2121_ _2121_/Q FrameData[14] VGND VPWR FrameStrobe[6] latch
X_2052_ _2052_/Q FrameData[9] VGND VPWR FrameStrobe[8] latch
XANTENNA__2581__X SS4BEG[2] VPWR VGND sg13cmos5l_antennanp
XFILLER_15_390 VPWR VGND sg13cmos5l_fill_2
XFILLER_34_187 VPWR VGND sg13cmos5l_decap_8
XFILLER_34_198 VPWR VGND sg13cmos5l_fill_1
X_2954_ _2954_/X N1END[1] S2MID[5] _1246_/Q _2910_/X _2022_/Q _2023_/Q VPWR VGND sg13cmos5l_mux4_1
X_2885_ _2885_/X _2881_/X _2882_/X _2883_/X _2884_/X _2302_/Q _2303_/Q VPWR VGND sg13cmos5l_mux4_1
X_1905_ _1905_/Q FrameData[22] VGND VPWR _1152_/X latch
X_0718_ _0718_/Y _2724_/X _2709_/X VPWR VGND sg13cmos5l_nand2_1
X_1698_ _1698_/Q FrameData[7] VGND VPWR _1133_/X latch
X_1767_ _1767_/Q FrameData[12] VGND VPWR _1139_/X latch
X_1836_ _1836_/Q FrameData[17] VGND VPWR _1136_/X latch
X_0649_ _2544_/A _3301_/X _3302_/X _1672_/Q VPWR VGND sg13cmos5l_mux2_1
X_3299_ _3299_/X E1END[3] SS4END[3] W6END[1] _3001_/X _1673_/Q _1674_/Q VPWR VGND
+ sg13cmos5l_mux4_1
X_2319_ _2319_/Q FrameData[20] VGND VPWR FrameStrobe[0] latch
XANTENNA__2491__X N4BEG[12] VPWR VGND sg13cmos5l_antennanp
XFILLER_25_165 VPWR VGND sg13cmos5l_decap_8
XFILLER_31_87 VPWR VGND sg13cmos5l_fill_1
XFILLER_31_124 VPWR VGND sg13cmos5l_decap_4
XFILLER_31_179 VPWR VGND sg13cmos5l_decap_4
XFILLER_8_331 VPWR VGND sg13cmos5l_fill_1
X_1552_ _1552_/Q FrameData[21] VGND VPWR _1187_/X latch
X_1621_ _1621_/Q FrameData[26] VGND VPWR _1189_/X latch
X_2670_ _2670_/X _0863_/X _2890_/X _0860_/X _3122_/X _1737_/Q _1738_/Q VPWR VGND sg13cmos5l_mux4_1
XANTENNA__2576__X FrameData_O[29] VPWR VGND sg13cmos5l_antennanp
X_1483_ _1483_/Q FrameData[16] VGND VPWR _1182_/X latch
X_3153_ _3153_/X S2END[7] SS4END[3] W1END[2] W2MID[5] _2234_/Q _2235_/Q VPWR VGND
+ sg13cmos5l_mux4_1
X_3222_ _3222_/X _0955_/Y _1033_/Y _1843_/Q _1035_/Y _1844_/Q _1845_/Q VPWR VGND sg13cmos5l_mux4_1
X_2104_ _2104_/Q FrameData[29] VGND VPWR FrameStrobe[7] latch
X_3084_ _3084_/X N1END[3] N2MID[7] N2END[7] NN4END[3] _2143_/Q _2144_/Q VPWR VGND
+ sg13cmos5l_mux4_1
X_2035_ _2035_/Q FrameData[24] VGND VPWR FrameStrobe[9] latch
XFILLER_22_168 VPWR VGND sg13cmos5l_decap_8
X_2937_ _2937_/X N1END[0] S2END[4] WW4END[0] _3036_/X _2082_/Q _2083_/Q VPWR VGND
+ sg13cmos5l_mux4_1
X_2868_ _2868_/X _0863_/X _2890_/X _0859_/X _2929_/X _1953_/Q _1954_/Q VPWR VGND sg13cmos5l_mux4_1
X_1819_ _1819_/Q FrameData[0] VGND VPWR _1136_/X latch
X_2799_ _2799_/X _3163_/X _0871_/X _2917_/X _0865_/X _1901_/Q _1902_/Q VPWR VGND sg13cmos5l_mux4_1
XANTENNA__2486__X N4BEG[7] VPWR VGND sg13cmos5l_antennanp
XFILLER_18_408 VPWR VGND sg13cmos5l_fill_2
XANTENNA__2396__X EE4BEG[5] VPWR VGND sg13cmos5l_antennanp
XFILLER_3_47 VPWR VGND sg13cmos5l_fill_1
XFILLER_49_555 VPWR VGND sg13cmos5l_fill_2
XFILLER_51_219 VPWR VGND sg13cmos5l_fill_2
XFILLER_8_161 VPWR VGND sg13cmos5l_fill_2
X_0983_ _0983_/Y _1371_/Q _0769_/Y _0982_/Y VPWR VGND sg13cmos5l_o21ai_1
X_2722_ _2722_/X _3163_/X _0871_/X _3107_/X _0866_/X _1793_/Q _1794_/Q VPWR VGND sg13cmos5l_mux4_1
XFILLER_8_194 VPWR VGND sg13cmos5l_fill_2
X_1535_ _1535_/Q FrameData[4] VGND VPWR _1187_/X latch
X_1604_ _1604_/Q FrameData[9] VGND VPWR _1189_/X latch
X_2653_ _2653_/X _0653_/X _3050_/X _3144_/X _3093_/X _1741_/Q _1742_/Q VPWR VGND sg13cmos5l_mux4_1
X_2584_ SS4BEG[5] SS4END[9] VPWR VGND sg13cmos5l_buf_1
XFILLER_27_205 VPWR VGND sg13cmos5l_fill_2
XFILLER_55_525 VPWR VGND sg13cmos5l_fill_1
X_1397_ _1397_/Q FrameData[26] VGND VPWR _1181_/X latch
X_1466_ _1466_/Q FrameData[31] VGND VPWR _1185_/X latch
X_3067_ _3067_/X _1010_/Y _3067_/A1 _3067_/A2 _1208_/Y _2132_/Q _2133_/Q VPWR VGND
+ sg13cmos5l_mux4_1
X_3136_ _3136_/X _3132_/X _3133_/X _3134_/X _3135_/X _2121_/Q _2122_/Q VPWR VGND sg13cmos5l_mux4_1
X_3205_ _3205_/X _3145_/X _3050_/X _3074_/X _0628_/X _1881_/Q _1882_/Q VPWR VGND sg13cmos5l_mux4_1
XFILLER_23_433 VPWR VGND sg13cmos5l_decap_4
XFILLER_50_285 VPWR VGND sg13cmos5l_decap_4
X_2018_ _2018_/Q FrameData[7] VGND VPWR FrameStrobe[9] latch
XFILLER_26_271 VPWR VGND sg13cmos5l_fill_1
XFILLER_26_282 VPWR VGND sg13cmos5l_decap_8
XFILLER_5_153 VPWR VGND sg13cmos5l_fill_2
X_1320_ _1320_/Q FrameData[13] VGND VPWR _1184_/X latch
X_1182_ _1182_/X FrameStrobe[13] FrameStrobe[14] VPWR VGND sg13cmos5l_and2_1
X_1251_ _1251_/Q FrameData[8] VGND VPWR _1180_/X latch
XFILLER_52_506 VPWR VGND sg13cmos5l_fill_1
X_0897_ _0897_/Y _1587_/Q _0897_/B VPWR VGND sg13cmos5l_nand2b_1
X_0966_ _2519_/A _0966_/A VPWR VGND sg13cmos5l_inv_1
X_2705_ _2705_/X _2701_/X _2702_/X _2703_/X _2704_/X _3239_/X _0947_/Y VPWR VGND sg13cmos5l_mux4_1
X_2636_ WW4BEG[9] WW4END[13] VPWR VGND sg13cmos5l_buf_1
X_1449_ _1449_/Q FrameData[14] VGND VPWR _1185_/X latch
X_1518_ _1518_/Q FrameData[19] VGND VPWR _1188_/X latch
X_2567_ FrameData_O[20] FrameData[20] VPWR VGND sg13cmos5l_buf_1
X_2498_ NN4BEG[3] NN4END[7] VPWR VGND sg13cmos5l_buf_1
X_3119_ _3119_/X E2MID[3] E2END[3] EE4END[1] S2MID[1] _2296_/Q _2297_/Q VPWR VGND
+ sg13cmos5l_mux4_1
XFILLER_2_112 VPWR VGND sg13cmos5l_fill_2
XFILLER_48_30 VPWR VGND sg13cmos5l_fill_2
X_0751_ _0751_/X _1746_/Q _0751_/B _2463_/A VPWR VGND sg13cmos5l_or3_1
X_0820_ _0830_/A _0820_/A VPWR VGND sg13cmos5l_inv_1
X_0682_ _0682_/X _2793_/X _2794_/X _2811_/X VPWR VGND sg13cmos5l_mux2_1
X_1303_ _1303_/Q FrameData[28] VGND VPWR _1197_/X latch
X_2421_ E2BEGb[2] E2MID[2] VPWR VGND sg13cmos5l_buf_1
X_2352_ _2880_/A2 VPWR VGND sg13cmos5l_tiehi
X_2283_ _2283_/Q FrameData[16] VGND VPWR FrameStrobe[1] latch
XANTENNA__2584__X SS4BEG[5] VPWR VGND sg13cmos5l_antennanp
XFILLER_37_344 VPWR VGND sg13cmos5l_fill_2
XFILLER_49_193 VPWR VGND sg13cmos5l_decap_4
X_1096_ _1096_/Y _1416_/Q _0843_/Y _1095_/Y VPWR VGND sg13cmos5l_o21ai_1
X_1165_ _1165_/Y _1974_/Q _0932_/A _1164_/Y VPWR VGND sg13cmos5l_o21ai_1
X_1234_ _1234_/Y _2215_/Q _1232_/Y _1233_/Y VPWR VGND sg13cmos5l_o21ai_1
X_0949_ _0950_/A _3018_/X _2047_/Q _0948_/Y VPWR VGND sg13cmos5l_a21oi_1
X_2619_ W6BEG[4] W6END[6] VPWR VGND sg13cmos5l_buf_1
X_1998_ _1998_/Q FrameData[19] VGND VPWR FrameStrobe[10] latch
XANTENNA__2494__X N4BEG[15] VPWR VGND sg13cmos5l_antennanp
XFILLER_31_509 VPWR VGND sg13cmos5l_fill_1
XFILLER_1_0 VPWR VGND sg13cmos5l_fill_2
XFILLER_3_432 VPWR VGND sg13cmos5l_fill_1
Xclkbuf_2_3__f_Inst_LA_FLUT51PSDM_architecture.UserCLK _1248_/CLK clkbuf_0_Inst_LA_FLUT51PSDM_architecture.UserCLK/X
+ VPWR VGND sg13cmos5l_buf_16
X_2970_ _2970_/X N2END[5] E2MID[1] S1END[1] _0630_/X _2010_/Q _2011_/Q VPWR VGND sg13cmos5l_mux4_1
X_1921_ _1921_/Q FrameData[6] VGND VPWR _1137_/X latch
X_1852_ _1852_/Q FrameData[1] VGND VPWR _1157_/X latch
XANTENNA__2579__X SS4BEG[0] VPWR VGND sg13cmos5l_antennanp
X_0665_ _2467_/A _2981_/X _2982_/X _1999_/Q VPWR VGND sg13cmos5l_mux2_1
X_0734_ _0736_/S _2700_/X _1333_/Q VPWR VGND sg13cmos5l_nor2_1
X_0803_ _0803_/Y _1457_/Q _0803_/B VPWR VGND sg13cmos5l_nor2_1
X_1783_ _1783_/Q FrameData[28] VGND VPWR _1139_/X latch
X_0596_ _0596_/Y _1240_/Q VPWR VGND sg13cmos5l_inv_1
X_2404_ EE4BEG[13] _2404_/A VPWR VGND sg13cmos5l_buf_1
X_2335_ _3129_/A2 VPWR VGND sg13cmos5l_tiehi
X_2266_ _2266_/Q FrameData[31] VGND VPWR FrameStrobe[2] latch
X_1079_ _1079_/Y _1079_/A _1456_/Q VPWR VGND sg13cmos5l_nand2_1
X_1148_ _1237_/D _0972_/A _1143_/Y _1144_/Y _1147_/X VPWR VGND sg13cmos5l_a22oi_1
X_1217_ _1218_/A _0820_/A _0828_/Y _1216_/Y VPWR VGND sg13cmos5l_a21oi_1
X_2197_ _2197_/Q FrameData[26] VGND VPWR FrameStrobe[4] latch
XANTENNA__2489__X N4BEG[10] VPWR VGND sg13cmos5l_antennanp
XFILLER_28_174 VPWR VGND sg13cmos5l_fill_2
XFILLER_24_380 VPWR VGND sg13cmos5l_decap_8
XANTENNA_7 FrameStrobe[15] VPWR VGND sg13cmos5l_antennanp
XANTENNA__2399__X EE4BEG[8] VPWR VGND sg13cmos5l_antennanp
X_2120_ _2120_/Q FrameData[13] VGND VPWR FrameStrobe[6] latch
XFILLER_34_155 VPWR VGND sg13cmos5l_decap_8
X_1002_ _1002_/Y _1878_/Q _1000_/A _1001_/Y VPWR VGND sg13cmos5l_a21oi_1
X_2051_ _2051_/Q FrameData[8] VGND VPWR FrameStrobe[8] latch
X_2953_ _2953_/X _0639_/X _3107_/X _0863_/X _0974_/Y _2075_/Q _2076_/Q VPWR VGND sg13cmos5l_mux4_1
X_2884_ _2884_/X W2MID[5] W2END[5] WW4END[3] _0807_/B _2300_/Q _2301_/Q VPWR VGND
+ sg13cmos5l_mux4_1
X_1904_ _1904_/Q FrameData[21] VGND VPWR _1152_/X latch
X_1835_ _1835_/Q FrameData[16] VGND VPWR _1136_/X latch
X_0648_ _2545_/A _3299_/X _3300_/X _1675_/Q VPWR VGND sg13cmos5l_mux2_1
X_0717_ _0717_/X _2706_/X _2707_/X _2724_/X VPWR VGND sg13cmos5l_mux2_1
X_1697_ _1697_/Q FrameData[6] VGND VPWR _1133_/X latch
X_1766_ _1766_/Q FrameData[11] VGND VPWR _1139_/X latch
X_0579_ _0579_/Y _2695_/X VPWR VGND sg13cmos5l_inv_1
X_3298_ _3298_/X _3100_/X _0866_/X _2885_/X _0856_/Y _1676_/Q _1677_/Q VPWR VGND sg13cmos5l_mux4_1
X_2318_ _2318_/Q FrameData[19] VGND VPWR FrameStrobe[0] latch
X_2249_ _2249_/Q FrameData[14] VGND VPWR FrameStrobe[2] latch
XFILLER_15_67 VPWR VGND sg13cmos5l_fill_1
XFILLER_0_210 VPWR VGND sg13cmos5l_fill_1
XFILLER_0_232 VPWR VGND sg13cmos5l_fill_2
XFILLER_16_122 VPWR VGND sg13cmos5l_fill_1
XFILLER_31_158 VPWR VGND sg13cmos5l_decap_4
X_1482_ _1482_/Q FrameData[15] VGND VPWR _1182_/X latch
X_1551_ _1551_/Q FrameData[20] VGND VPWR _1187_/X latch
X_1620_ _1620_/Q FrameData[25] VGND VPWR _1189_/X latch
X_3083_ _3083_/X _0839_/B _3083_/A1 _3083_/A2 _0808_/B _2290_/Q _2291_/Q VPWR VGND
+ sg13cmos5l_mux4_1
X_3152_ _3152_/X E2END[1] E6END[1] S1END[3] S2MID[7] _2234_/Q _2235_/Q VPWR VGND sg13cmos5l_mux4_1
X_3221_ _3221_/X _1031_/Y _1022_/Y _1846_/Q _1029_/Y _1847_/Q _1848_/Q VPWR VGND sg13cmos5l_mux4_1
X_2103_ _2103_/Q FrameData[28] VGND VPWR FrameStrobe[7] latch
XANTENNA__2592__X SS4BEG[13] VPWR VGND sg13cmos5l_antennanp
XFILLER_22_147 VPWR VGND sg13cmos5l_decap_8
X_2034_ _2034_/Q FrameData[23] VGND VPWR FrameStrobe[9] latch
XFILLER_30_191 VPWR VGND sg13cmos5l_fill_1
XFILLER_50_489 VPWR VGND sg13cmos5l_fill_1
X_1818_ _1818_/Q FrameData[31] VGND VPWR _1138_/X latch
X_2936_ _2936_/X _0653_/X _3155_/X _0857_/X _0807_/B _2057_/Q _2058_/Q VPWR VGND sg13cmos5l_mux4_1
X_2867_ _2867_/X _3117_/X _3112_/X _0868_/X _3150_/X _1953_/Q _1954_/Q VPWR VGND sg13cmos5l_mux4_1
X_2798_ _2798_/X _3079_/X _0653_/X _3074_/X _0628_/X _1901_/Q _1902_/Q VPWR VGND sg13cmos5l_mux4_1
X_1749_ _1749_/Q FrameData[26] VGND VPWR _1177_/X latch
XFILLER_26_431 VPWR VGND sg13cmos5l_decap_8
XFILLER_26_44 VPWR VGND sg13cmos5l_fill_1
XFILLER_45_206 VPWR VGND sg13cmos5l_fill_1
XFILLER_45_228 VPWR VGND sg13cmos5l_decap_4
XFILLER_44_283 VPWR VGND sg13cmos5l_decap_8
X_0982_ _0982_/Y _2705_/X _1371_/Q VPWR VGND sg13cmos5l_nand2_1
X_2721_ _2721_/X _3100_/X _0650_/X _3093_/X _0627_/X _1793_/Q _1794_/Q VPWR VGND sg13cmos5l_mux4_1
X_2652_ _2652_/X _2924_/X _3036_/X _0657_/X _0655_/X _1741_/Q _1742_/Q VPWR VGND sg13cmos5l_mux4_1
XANTENNA__2587__X SS4BEG[8] VPWR VGND sg13cmos5l_antennanp
X_1465_ _1465_/Q FrameData[30] VGND VPWR _1185_/X latch
X_1534_ _1534_/Q FrameData[3] VGND VPWR _1187_/X latch
X_1603_ _1603_/Q FrameData[8] VGND VPWR _1189_/X latch
X_3204_ _3204_/X _0631_/X _2924_/X _3059_/X _3087_/X _1881_/Q _1882_/Q VPWR VGND sg13cmos5l_mux4_1
X_2583_ SS4BEG[4] SS4END[8] VPWR VGND sg13cmos5l_buf_1
XFILLER_27_217 VPWR VGND sg13cmos5l_fill_1
X_1396_ _1396_/Q FrameData[25] VGND VPWR _1181_/X latch
X_3066_ _3066_/X N2MID[7] E1END[1] S4END[3] W2MID[7] _2132_/Q _2133_/Q VPWR VGND sg13cmos5l_mux4_1
X_3135_ _3135_/X WW4END[2] W6END[0] _0856_/Y _0833_/Y _2119_/Q _2120_/Q VPWR VGND
+ sg13cmos5l_mux4_1
X_2017_ _2017_/Q FrameData[6] VGND VPWR FrameStrobe[9] latch
XFILLER_23_467 VPWR VGND sg13cmos5l_fill_2
X_2919_ _2919_/X _0906_/X _2919_/A1 _2919_/A2 _1056_/Y _2222_/Q _2223_/Q VPWR VGND
+ sg13cmos5l_mux4_1
XANTENNA__2497__X NN4BEG[2] VPWR VGND sg13cmos5l_antennanp
XFILLER_46_504 VPWR VGND sg13cmos5l_fill_1
XFILLER_14_456 VPWR VGND sg13cmos5l_decap_8
XFILLER_41_264 VPWR VGND sg13cmos5l_fill_1
X_1181_ _1181_/X FrameStrobe[13] FrameStrobe[17] VPWR VGND sg13cmos5l_and2_1
X_1250_ _1250_/Q _1250_/CLK _1250_/D _2360_/L_HI VPWR VGND sg13cmos5l_dfrbpq_1
XFILLER_20_426 VPWR VGND sg13cmos5l_decap_4
XFILLER_9_482 VPWR VGND sg13cmos5l_decap_4
X_0896_ _0896_/X _0897_/B _0875_/Y _0896_/S VPWR VGND sg13cmos5l_mux2_1
X_0965_ _0966_/A _2960_/X _2050_/Q _0964_/Y VPWR VGND sg13cmos5l_a21oi_1
X_2704_ _2704_/X _1341_/Q _1349_/Q _1342_/Q _1350_/Q _2719_/X _3244_/X VPWR VGND sg13cmos5l_mux4_1
X_2635_ WW4BEG[8] WW4END[12] VPWR VGND sg13cmos5l_buf_1
X_1448_ _1448_/Q FrameData[13] VGND VPWR _1185_/X latch
X_1517_ _1517_/Q FrameData[18] VGND VPWR _1188_/X latch
X_2566_ FrameData_O[19] FrameData[19] VPWR VGND sg13cmos5l_buf_1
X_2497_ NN4BEG[2] NN4END[6] VPWR VGND sg13cmos5l_buf_1
X_1379_ _1379_/Q FrameData[8] VGND VPWR _1181_/X latch
X_3049_ _3049_/X _1058_/Y _0899_/B _0974_/Y _0840_/Y _2167_/Q _2168_/Q VPWR VGND sg13cmos5l_mux4_1
X_3118_ _3118_/X N1END[1] N2MID[5] N2END[5] NN4END[1] _2296_/Q _2297_/Q VPWR VGND
+ sg13cmos5l_mux4_1
XFILLER_11_426 VPWR VGND sg13cmos5l_decap_4
XFILLER_23_275 VPWR VGND sg13cmos5l_fill_2
XFILLER_2_168 VPWR VGND sg13cmos5l_fill_2
XFILLER_48_97 VPWR VGND sg13cmos5l_fill_1
X_0681_ _0681_/Y _2801_/X _1494_/Q _0680_/Y VPWR VGND sg13cmos5l_a21oi_1
X_0750_ _0851_/A _0755_/A _0755_/B VPWR VGND sg13cmos5l_nor2_1
X_2420_ E2BEGb[1] E2MID[1] VPWR VGND sg13cmos5l_buf_1
X_1233_ _1233_/Y _2216_/Q _0983_/Y _2215_/Q VPWR VGND sg13cmos5l_o21ai_1
X_1302_ _1302_/Q FrameData[27] VGND VPWR _1197_/X latch
X_2351_ _3067_/A2 VPWR VGND sg13cmos5l_tiehi
X_2282_ _2282_/Q FrameData[15] VGND VPWR FrameStrobe[1] latch
XFILLER_37_312 VPWR VGND sg13cmos5l_fill_2
XFILLER_37_389 VPWR VGND sg13cmos5l_decap_4
X_1095_ _1095_/Y _1416_/Q _0844_/B _3222_/X VPWR VGND sg13cmos5l_a21oi_1
X_1164_ _1164_/Y _1974_/Q _2599_/A VPWR VGND sg13cmos5l_nand2_1
X_0948_ _0948_/Y _2047_/Q _3017_/X VPWR VGND sg13cmos5l_nor2b_1
X_1997_ _1997_/Q FrameData[18] VGND VPWR FrameStrobe[10] latch
X_0879_ _0879_/Y _1331_/Q _0879_/B VPWR VGND sg13cmos5l_nor2_1
X_2618_ W6BEG[3] W6END[5] VPWR VGND sg13cmos5l_buf_1
X_2549_ FrameData_O[2] FrameData[2] VPWR VGND sg13cmos5l_buf_1
XFILLER_28_356 VPWR VGND sg13cmos5l_fill_1
XFILLER_47_109 VPWR VGND sg13cmos5l_fill_1
XFILLER_3_422 VPWR VGND sg13cmos5l_fill_2
XFILLER_30_510 VPWR VGND sg13cmos5l_fill_2
X_0802_ _0803_/B _0802_/A _0802_/B VPWR VGND sg13cmos5l_xnor2_1
X_1920_ _1920_/Q FrameData[5] VGND VPWR _1137_/X latch
X_1851_ _1851_/Q FrameData[0] VGND VPWR _1157_/X latch
X_0664_ _2466_/A _2983_/X _2984_/X _1996_/Q VPWR VGND sg13cmos5l_mux2_1
X_0733_ _0735_/D _0728_/Y _0729_/X _0732_/Y VPWR VGND sg13cmos5l_a21oi_1
X_1782_ _1782_/Q FrameData[27] VGND VPWR _1139_/X latch
X_2403_ EE4BEG[12] _2403_/A VPWR VGND sg13cmos5l_buf_1
XANTENNA__2595__X W1BEG[0] VPWR VGND sg13cmos5l_antennanp
XFILLER_27_0 VPWR VGND sg13cmos5l_fill_2
XFILLER_57_429 VPWR VGND sg13cmos5l_fill_2
X_0595_ _1025_/A _1241_/Q VPWR VGND sg13cmos5l_inv_1
X_1216_ _1216_/Y _1216_/A _0811_/Y VPWR VGND sg13cmos5l_nor2b_1
X_2334_ _3172_/A2 VPWR VGND sg13cmos5l_tiehi
X_2265_ _2265_/Q FrameData[30] VGND VPWR FrameStrobe[2] latch
X_2196_ _2196_/Q FrameData[25] VGND VPWR FrameStrobe[4] latch
XFILLER_21_521 VPWR VGND sg13cmos5l_fill_2
XFILLER_52_112 VPWR VGND sg13cmos5l_fill_1
X_1078_ _1236_/D _0566_/Y _1074_/Y _1075_/Y _1077_/Y VPWR VGND sg13cmos5l_a22oi_1
X_1147_ _1147_/X _3246_/X _1147_/B VPWR VGND sg13cmos5l_or2_1
XFILLER_21_554 VPWR VGND sg13cmos5l_fill_2
XFILLER_28_153 VPWR VGND sg13cmos5l_fill_2
XFILLER_29_77 VPWR VGND sg13cmos5l_fill_1
XFILLER_8_525 VPWR VGND sg13cmos5l_fill_1
XANTENNA_8 FrameStrobe[15] VPWR VGND sg13cmos5l_antennanp
XFILLER_6_37 VPWR VGND sg13cmos5l_fill_2
X_2050_ _2050_/Q FrameData[7] VGND VPWR FrameStrobe[8] latch
XFILLER_19_164 VPWR VGND sg13cmos5l_fill_1
XFILLER_34_123 VPWR VGND sg13cmos5l_fill_1
XFILLER_34_145 VPWR VGND sg13cmos5l_decap_4
X_1001_ _1001_/Y _1878_/Q _2466_/A VPWR VGND sg13cmos5l_nor2_1
X_2952_ _2952_/X N2MID[6] S1END[2] W2END[0] _3036_/X _2075_/Q _2076_/Q VPWR VGND sg13cmos5l_mux4_1
XFILLER_15_392 VPWR VGND sg13cmos5l_fill_1
XFILLER_30_351 VPWR VGND sg13cmos5l_fill_1
X_1765_ _1765_/Q FrameData[10] VGND VPWR _1139_/X latch
X_2883_ _2883_/X S2MID[1] S2END[1] S4END[1] W1END[1] _2300_/Q _2301_/Q VPWR VGND sg13cmos5l_mux4_1
X_1903_ _1903_/Q FrameData[20] VGND VPWR _1152_/X latch
X_1834_ _1834_/Q FrameData[15] VGND VPWR _1136_/X latch
X_0578_ _1079_/A _2772_/X VPWR VGND sg13cmos5l_inv_1
X_0647_ _2546_/A _3297_/X _3298_/X _1678_/Q VPWR VGND sg13cmos5l_mux2_1
X_0716_ _0716_/Y _2714_/X _1368_/Q _0715_/Y VPWR VGND sg13cmos5l_a21oi_1
X_1696_ _1696_/Q FrameData[5] VGND VPWR _1133_/X latch
XFILLER_53_421 VPWR VGND sg13cmos5l_fill_1
X_3297_ _3297_/X E1END[0] S2MID[3] W6END[0] _0658_/X _1676_/Q _1677_/Q VPWR VGND sg13cmos5l_mux4_1
X_2317_ _2317_/Q FrameData[18] VGND VPWR FrameStrobe[0] latch
X_2248_ _2248_/Q FrameData[13] VGND VPWR FrameStrobe[2] latch
X_2179_ _2179_/Q FrameData[8] VGND VPWR FrameStrobe[4] latch
XFILLER_12_351 VPWR VGND sg13cmos5l_fill_2
X_1481_ _1481_/Q FrameData[14] VGND VPWR _1182_/X latch
X_1550_ _1550_/Q FrameData[19] VGND VPWR _1187_/X latch
X_3220_ _3220_/X _3216_/X _3217_/X _3218_/X _3219_/X _1851_/Q _1852_/Q VPWR VGND sg13cmos5l_mux4_1
XFILLER_47_292 VPWR VGND sg13cmos5l_fill_2
X_3082_ _3082_/X N2MID[5] E2MID[3] S4END[1] W1END[1] _2290_/Q _2291_/Q VPWR VGND sg13cmos5l_mux4_1
X_3151_ _3151_/X N2MID[3] N2END[3] N4END[3] E2MID[1] _2234_/Q _2235_/Q VPWR VGND sg13cmos5l_mux4_1
X_2102_ _2102_/Q FrameData[27] VGND VPWR FrameStrobe[7] latch
X_2033_ _2033_/Q FrameData[22] VGND VPWR FrameStrobe[9] latch
XFILLER_22_104 VPWR VGND sg13cmos5l_fill_1
X_2935_ _2935_/X E2END[4] S2END[0] W1END[0] _3043_/X _2057_/Q _2058_/Q VPWR VGND sg13cmos5l_mux4_1
XFILLER_7_80 VPWR VGND sg13cmos5l_fill_1
X_1748_ _1748_/Q FrameData[25] VGND VPWR _1177_/X latch
X_1817_ _1817_/Q FrameData[30] VGND VPWR _1138_/X latch
X_2866_ _2866_/X _2932_/X _3050_/X _0639_/X _2903_/X _1953_/Q _1954_/Q VPWR VGND sg13cmos5l_mux4_1
X_2797_ _2797_/X _0630_/X _0658_/X _0657_/X _3059_/X _1901_/Q _1902_/Q VPWR VGND sg13cmos5l_mux4_1
X_1679_ _1679_/Q FrameData[20] VGND VPWR _1167_/X latch
X_3349_ _3349_/X N2END[2] E2END[4] W2MID[0] _3087_/X _1598_/Q _1599_/Q VPWR VGND sg13cmos5l_mux4_1
XFILLER_38_292 VPWR VGND sg13cmos5l_decap_4
XFILLER_41_435 VPWR VGND sg13cmos5l_fill_1
XFILLER_42_99 VPWR VGND sg13cmos5l_fill_2
XFILLER_1_520 VPWR VGND sg13cmos5l_fill_1
XFILLER_44_240 VPWR VGND sg13cmos5l_fill_2
X_0981_ _0981_/Y _1779_/Q _0974_/A _0980_/Y VPWR VGND sg13cmos5l_a21oi_1
X_1602_ _1602_/Q FrameData[7] VGND VPWR _1189_/X latch
X_2720_ _2720_/X _0629_/X _3043_/X _0657_/X _0655_/X _1793_/Q _1794_/Q VPWR VGND sg13cmos5l_mux4_1
X_2651_ _2651_/X _1279_/Q _1280_/Q _1281_/Q _1282_/Q _3268_/X _3263_/X VPWR VGND sg13cmos5l_mux4_1
X_2582_ SS4BEG[3] SS4END[7] VPWR VGND sg13cmos5l_buf_1
X_1395_ _1395_/Q FrameData[24] VGND VPWR _1181_/X latch
X_1464_ _1464_/Q FrameData[29] VGND VPWR _1185_/X latch
X_1533_ _1533_/Q FrameData[2] VGND VPWR _1187_/X latch
X_3203_ _3203_/X _3199_/X _3200_/X _3201_/X _3202_/X _1887_/Q _1888_/Q VPWR VGND sg13cmos5l_mux4_1
X_3065_ _3065_/X W1END[1] _3065_/A1 _3065_/A2 _1027_/Y _2312_/Q _2313_/Q VPWR VGND
+ sg13cmos5l_mux4_1
X_3134_ _3134_/X S2MID[3] S2END[3] S4END[3] W2MID[6] _2119_/Q _2120_/Q VPWR VGND sg13cmos5l_mux4_1
X_2016_ _2016_/Q FrameData[5] VGND VPWR FrameStrobe[9] latch
XFILLER_12_14 VPWR VGND sg13cmos5l_fill_1
XFILLER_12_36 VPWR VGND sg13cmos5l_decap_8
X_2918_ _2918_/X N2END[2] E2MID[0] WW4END[0] _0797_/Y _2222_/Q _2223_/Q VPWR VGND
+ sg13cmos5l_mux4_1
X_2849_ _2849_/X _1551_/Q _1559_/Q _1552_/Q _1560_/Q _2864_/X _3184_/X VPWR VGND sg13cmos5l_mux4_1
XFILLER_26_262 VPWR VGND sg13cmos5l_fill_2
XFILLER_1_394 VPWR VGND sg13cmos5l_fill_1
XFILLER_49_365 VPWR VGND sg13cmos5l_fill_2
X_1180_ _1180_/X FrameStrobe[16] FrameStrobe[14] VPWR VGND sg13cmos5l_and2_1
XFILLER_13_490 VPWR VGND sg13cmos5l_decap_8
X_0964_ _0964_/Y _2050_/Q _2959_/X VPWR VGND sg13cmos5l_nor2b_1
XANTENNA__2598__X W1BEG[3] VPWR VGND sg13cmos5l_antennanp
XFILLER_57_0 VPWR VGND sg13cmos5l_fill_2
X_0895_ _0897_/B _0832_/B _0894_/B _0894_/Y VPWR VGND sg13cmos5l_a21oi_1
X_1516_ _1516_/Q FrameData[17] VGND VPWR _1188_/X latch
X_2703_ _2703_/X _1339_/Q _1347_/Q _1340_/Q _1348_/Q _2719_/X _3244_/X VPWR VGND sg13cmos5l_mux4_1
X_2634_ WW4BEG[7] WW4END[11] VPWR VGND sg13cmos5l_buf_1
X_2565_ FrameData_O[18] FrameData[18] VPWR VGND sg13cmos5l_buf_1
X_1378_ _1378_/Q FrameData[7] VGND VPWR _1181_/X latch
X_1447_ _1447_/Q FrameData[12] VGND VPWR _1185_/X latch
X_3117_ _3117_/X _3113_/X _3114_/X _3115_/X _3116_/X _2205_/Q _2206_/Q VPWR VGND sg13cmos5l_mux4_1
X_2496_ NN4BEG[1] NN4END[5] VPWR VGND sg13cmos5l_buf_1
X_3048_ _3048_/X W2MID[1] W2MID[2] W2MID[7] W2END[0] _2167_/Q _2168_/Q VPWR VGND sg13cmos5l_mux4_1
XFILLER_19_516 VPWR VGND sg13cmos5l_fill_2
XFILLER_9_37 VPWR VGND sg13cmos5l_fill_2
XFILLER_6_453 VPWR VGND sg13cmos5l_fill_2
X_0680_ _0680_/Y _1494_/Q _2806_/X VPWR VGND sg13cmos5l_nor2b_1
X_1232_ _1232_/Y _2216_/Q WW4END[0] VPWR VGND sg13cmos5l_nand2b_1
X_1301_ _1301_/Q FrameData[26] VGND VPWR _1197_/X latch
X_2350_ _2905_/A2 VPWR VGND sg13cmos5l_tiehi
X_2281_ _2281_/Q FrameData[14] VGND VPWR FrameStrobe[1] latch
X_1094_ _1094_/Y _3222_/X _1418_/Q _1093_/Y VPWR VGND sg13cmos5l_a21oi_1
X_1163_ _1163_/Y _1061_/A _1162_/X _1161_/Y VPWR VGND sg13cmos5l_a21oi_1
XFILLER_20_257 VPWR VGND sg13cmos5l_decap_4
X_0947_ _0947_/Y _0581_/Y _1375_/Q _0946_/Y VPWR VGND sg13cmos5l_o21ai_1
X_1996_ _1996_/Q FrameData[17] VGND VPWR FrameStrobe[10] latch
X_0878_ _0879_/B _0878_/A _0878_/B VPWR VGND sg13cmos5l_xnor2_1
X_2617_ W6BEG[2] W6END[4] VPWR VGND sg13cmos5l_buf_1
X_2548_ FrameData_O[1] FrameData[1] VPWR VGND sg13cmos5l_buf_1
X_2479_ N4BEG[0] N4END[4] VPWR VGND sg13cmos5l_buf_1
XFILLER_11_202 VPWR VGND sg13cmos5l_fill_1
XFILLER_3_401 VPWR VGND sg13cmos5l_fill_1
XFILLER_1_2 VPWR VGND sg13cmos5l_fill_1
XFILLER_19_346 VPWR VGND sg13cmos5l_decap_4
XFILLER_46_154 VPWR VGND sg13cmos5l_fill_2
XFILLER_30_555 VPWR VGND sg13cmos5l_fill_2
X_0801_ _0802_/B _2772_/X _1454_/Q _0800_/Y VPWR VGND sg13cmos5l_a21oi_1
X_1781_ _1781_/Q FrameData[26] VGND VPWR _1139_/X latch
X_1850_ _1850_/Q FrameData[31] VGND VPWR _1136_/X latch
XFILLER_10_290 VPWR VGND sg13cmos5l_decap_4
X_0594_ _1059_/A _1245_/Q VPWR VGND sg13cmos5l_inv_1
X_0663_ _2465_/A _2987_/X _2988_/X _1993_/Q VPWR VGND sg13cmos5l_mux2_1
X_0732_ _0732_/Y _1145_/A _1325_/Q _0730_/Y _0731_/Y _0728_/Y VPWR VGND sg13cmos5l_a221oi_1
X_2402_ EE4BEG[11] EE4END[15] VPWR VGND sg13cmos5l_buf_1
X_2333_ _2916_/A2 VPWR VGND sg13cmos5l_tiehi
X_1146_ _1147_/B _2676_/X _1330_/Q _1145_/Y VPWR VGND sg13cmos5l_o21ai_1
X_1215_ _1215_/Y _1939_/Q _1208_/A _1214_/Y VPWR VGND sg13cmos5l_a21oi_1
X_2264_ _2264_/Q FrameData[29] VGND VPWR FrameStrobe[2] latch
X_2195_ _2195_/Q FrameData[24] VGND VPWR FrameStrobe[4] latch
XFILLER_21_511 VPWR VGND sg13cmos5l_fill_1
XFILLER_25_327 VPWR VGND sg13cmos5l_fill_2
X_1077_ _1077_/Y _0601_/Y _0851_/A _1076_/Y VPWR VGND sg13cmos5l_o21ai_1
X_1979_ _1979_/Q FrameData[0] VGND VPWR FrameStrobe[10] latch
XFILLER_16_305 VPWR VGND sg13cmos5l_decap_8
XFILLER_43_113 VPWR VGND sg13cmos5l_fill_1
XFILLER_12_555 VPWR VGND sg13cmos5l_fill_2
XANTENNA_9 FrameStrobe[15] VPWR VGND sg13cmos5l_antennanp
XFILLER_19_121 VPWR VGND sg13cmos5l_fill_1
X_1000_ _2433_/A _1000_/A VPWR VGND sg13cmos5l_inv_1
X_2951_ _2951_/X _3139_/X _3155_/X _0864_/X _0833_/Y _2051_/Q _2052_/Q VPWR VGND sg13cmos5l_mux4_1
X_1902_ _1902_/Q FrameData[19] VGND VPWR _1152_/X latch
XFILLER_30_374 VPWR VGND sg13cmos5l_decap_8
XFILLER_30_385 VPWR VGND sg13cmos5l_fill_1
X_0715_ _0715_/Y _1368_/Q _2719_/X VPWR VGND sg13cmos5l_nor2b_1
X_1764_ _1764_/Q FrameData[9] VGND VPWR _1139_/X latch
X_2882_ _2882_/X E1END[2] E2MID[3] E2END[3] EE4END[1] _2300_/Q _2301_/Q VPWR VGND
+ sg13cmos5l_mux4_1
X_1833_ _1833_/Q FrameData[14] VGND VPWR _1136_/X latch
XFILLER_57_216 VPWR VGND sg13cmos5l_fill_1
X_0577_ _0577_/Y _2763_/X VPWR VGND sg13cmos5l_inv_1
X_0646_ _2591_/A _3295_/X _3296_/X _1681_/Q VPWR VGND sg13cmos5l_mux2_1
X_1695_ _1695_/Q FrameData[4] VGND VPWR _1133_/X latch
X_3296_ _3296_/X _3087_/X _0628_/X _3170_/X _1027_/Y _1679_/Q _1680_/Q VPWR VGND sg13cmos5l_mux4_1
X_2316_ _2316_/Q FrameData[17] VGND VPWR FrameStrobe[0] latch
X_1129_ _1131_/A _2200_/Q _1056_/Y _2199_/Q VPWR VGND sg13cmos5l_a21oi_1
X_2247_ _2247_/Q FrameData[12] VGND VPWR FrameStrobe[2] latch
X_2178_ _2178_/Q FrameData[7] VGND VPWR FrameStrobe[4] latch
XFILLER_16_179 VPWR VGND sg13cmos5l_fill_2
XFILLER_12_374 VPWR VGND sg13cmos5l_fill_2
X_1480_ _1480_/Q FrameData[13] VGND VPWR _1182_/X latch
X_3150_ _3150_/X _3146_/X _3147_/X _3148_/X _3149_/X _2244_/Q _2245_/Q VPWR VGND sg13cmos5l_mux4_1
XFILLER_11_4 VPWR VGND sg13cmos5l_fill_2
XFILLER_35_433 VPWR VGND sg13cmos5l_fill_2
XFILLER_39_227 VPWR VGND sg13cmos5l_decap_8
XFILLER_39_238 VPWR VGND sg13cmos5l_fill_1
X_3081_ _3081_/X WW4END[0] _3081_/A1 _3081_/A2 _0840_/Y _2219_/Q _2220_/Q VPWR VGND
+ sg13cmos5l_mux4_1
X_2101_ _2101_/Q FrameData[26] VGND VPWR FrameStrobe[7] latch
X_2032_ _2032_/Q FrameData[21] VGND VPWR FrameStrobe[9] latch
X_2934_ _2934_/X _3145_/X _0868_/X _3010_/X _1027_/Y _2032_/Q _2033_/Q VPWR VGND sg13cmos5l_mux4_1
X_2865_ _2865_/X _0658_/X _3036_/X _3136_/X _0655_/X _1953_/Q _1954_/Q VPWR VGND sg13cmos5l_mux4_1
X_1678_ _1678_/Q FrameData[19] VGND VPWR _1167_/X latch
X_1747_ _1747_/Q FrameData[24] VGND VPWR _1177_/X latch
X_1816_ _1816_/Q FrameData[29] VGND VPWR _1138_/X latch
X_2796_ _2796_/X _1489_/Q _1490_/Q _1491_/Q _1492_/Q _3208_/X _3203_/X VPWR VGND sg13cmos5l_mux4_1
X_0629_ _0629_/X _2893_/X _2894_/X _2099_/Q VPWR VGND sg13cmos5l_mux2_1
X_3348_ _3348_/X _3059_/X _3139_/X _0864_/X _1208_/Y _1601_/Q _1602_/Q VPWR VGND sg13cmos5l_mux4_1
X_3279_ _3279_/X N4END[1] SS4END[1] _1244_/Q _3050_/X _1703_/Q _1704_/Q VPWR VGND
+ sg13cmos5l_mux4_1
XFILLER_26_466 VPWR VGND sg13cmos5l_fill_1
XFILLER_53_263 VPWR VGND sg13cmos5l_fill_1
XFILLER_21_182 VPWR VGND sg13cmos5l_fill_2
XFILLER_42_23 VPWR VGND sg13cmos5l_fill_1
XFILLER_42_67 VPWR VGND sg13cmos5l_fill_1
XFILLER_36_208 VPWR VGND sg13cmos5l_decap_8
XFILLER_36_219 VPWR VGND sg13cmos5l_decap_8
XFILLER_32_403 VPWR VGND sg13cmos5l_decap_4
XFILLER_32_436 VPWR VGND sg13cmos5l_fill_1
X_0980_ _0980_/Y _1779_/Q _1224_/B VPWR VGND sg13cmos5l_nor2_1
X_1532_ _1532_/Q FrameData[1] VGND VPWR _1187_/X latch
X_1601_ _1601_/Q FrameData[6] VGND VPWR _1189_/X latch
X_2650_ _2650_/X _1275_/Q _1276_/Q _1277_/Q _1278_/Q _3268_/X _3263_/X VPWR VGND sg13cmos5l_mux4_1
X_2581_ SS4BEG[2] SS4END[6] VPWR VGND sg13cmos5l_buf_1
X_1394_ _1394_/Q FrameData[23] VGND VPWR _1181_/X latch
X_1463_ _1463_/Q FrameData[28] VGND VPWR _1185_/X latch
X_3133_ _3133_/X E1END[1] E2MID[5] E2END[5] EE4END[3] _2119_/Q _2120_/Q VPWR VGND
+ sg13cmos5l_mux4_1
X_3202_ _3202_/X _3170_/X _0862_/X _0858_/X _2929_/X _1885_/Q _1886_/Q VPWR VGND sg13cmos5l_mux4_1
XFILLER_35_230 VPWR VGND sg13cmos5l_decap_8
X_3064_ _3064_/X N1END[1] NN4END[1] E2MID[3] S4END[1] _2312_/Q _2313_/Q VPWR VGND
+ sg13cmos5l_mux4_1
X_2015_ _2015_/Q FrameData[4] VGND VPWR FrameStrobe[9] latch
X_2917_ _2917_/X _2913_/X _2914_/X _2915_/X _2916_/X _2248_/Q _2249_/Q VPWR VGND sg13cmos5l_mux4_1
X_2848_ _2848_/X _1549_/Q _1557_/Q _1550_/Q _1558_/Q _2864_/X _3184_/X VPWR VGND sg13cmos5l_mux4_1
X_2779_ _2779_/X _3145_/X _2910_/X _3074_/X _0639_/X _1857_/Q _1858_/Q VPWR VGND sg13cmos5l_mux4_1
XFILLER_18_219 VPWR VGND sg13cmos5l_decap_4
XFILLER_5_123 VPWR VGND sg13cmos5l_fill_2
X_0894_ _0894_/Y _0894_/A _0894_/B VPWR VGND sg13cmos5l_nor2_1
X_0963_ _0963_/X _2463_/A _2430_/A _1811_/Q VPWR VGND sg13cmos5l_mux2_1
X_2702_ _2702_/X _1337_/Q _1345_/Q _1338_/Q _1346_/Q _2719_/X _3244_/X VPWR VGND sg13cmos5l_mux4_1
X_1515_ _1515_/Q FrameData[16] VGND VPWR _1188_/X latch
X_2633_ WW4BEG[6] WW4END[10] VPWR VGND sg13cmos5l_buf_1
X_2564_ FrameData_O[17] FrameData[17] VPWR VGND sg13cmos5l_buf_1
X_2495_ NN4BEG[0] NN4END[4] VPWR VGND sg13cmos5l_buf_1
X_1377_ _1377_/Q FrameData[6] VGND VPWR _1181_/X latch
X_1446_ _1446_/Q FrameData[11] VGND VPWR _1185_/X latch
X_3116_ _3116_/X WW4END[0] _0906_/X _1027_/Y _1013_/Y _2203_/Q _2204_/Q VPWR VGND
+ sg13cmos5l_mux4_1
X_3047_ _3047_/X E2MID[6] E2END[6] S1END[0] W1END[3] _2167_/Q _2168_/Q VPWR VGND sg13cmos5l_mux4_1
XFILLER_19_539 VPWR VGND sg13cmos5l_fill_2
XFILLER_6_498 VPWR VGND sg13cmos5l_fill_1
XFILLER_1_192 VPWR VGND sg13cmos5l_fill_1
XFILLER_37_325 VPWR VGND sg13cmos5l_fill_2
X_1162_ _1162_/X _2116_/Q _2115_/Q VPWR VGND sg13cmos5l_and2_1
X_1231_ _1231_/Y _1971_/Q _1200_/A _1230_/Y VPWR VGND sg13cmos5l_o21ai_1
X_1300_ _1300_/Q FrameData[25] VGND VPWR _1197_/X latch
X_2280_ _2280_/Q FrameData[13] VGND VPWR FrameStrobe[1] latch
X_1093_ _1093_/Y _3222_/X _3221_/X VPWR VGND sg13cmos5l_nor2_1
XANTENNA__2402__X EE4BEG[11] VPWR VGND sg13cmos5l_antennanp
X_0877_ _0878_/B _1145_/A _1328_/Q _0876_/Y VPWR VGND sg13cmos5l_a21oi_1
X_0946_ _0946_/Y _2729_/X _1375_/Q VPWR VGND sg13cmos5l_nand2_1
X_2616_ W6BEG[1] W6END[3] VPWR VGND sg13cmos5l_buf_1
X_1995_ _1995_/Q FrameData[16] VGND VPWR FrameStrobe[10] latch
X_1429_ _1429_/Q FrameData[26] VGND VPWR _1186_/X latch
X_2547_ FrameData_O[0] FrameData[0] VPWR VGND sg13cmos5l_buf_1
X_2478_ N2BEGb[7] N2MID[7] VPWR VGND sg13cmos5l_buf_1
XFILLER_24_520 VPWR VGND sg13cmos5l_fill_1
XFILLER_7_207 VPWR VGND sg13cmos5l_fill_1
XFILLER_3_457 VPWR VGND sg13cmos5l_decap_4
XFILLER_34_339 VPWR VGND sg13cmos5l_decap_8
XFILLER_42_394 VPWR VGND sg13cmos5l_fill_2
X_0731_ _0731_/Y _0579_/Y _2679_/X _1325_/Q VPWR VGND sg13cmos5l_a21oi_1
X_0800_ _0800_/Y _1079_/A _1453_/Q _0777_/Y _0779_/Y _1454_/Q VPWR VGND sg13cmos5l_a221oi_1
X_1780_ _1780_/Q FrameData[25] VGND VPWR _1139_/X latch
XFILLER_41_4 VPWR VGND sg13cmos5l_fill_2
X_0593_ _0593_/Y _1249_/Q VPWR VGND sg13cmos5l_inv_1
X_0662_ _2464_/A _0662_/A VPWR VGND sg13cmos5l_inv_1
X_2401_ EE4BEG[10] EE4END[14] VPWR VGND sg13cmos5l_buf_1
X_2332_ _3054_/A2 VPWR VGND sg13cmos5l_tiehi
XFILLER_37_133 VPWR VGND sg13cmos5l_decap_8
X_1145_ _1145_/Y _1145_/A _1330_/Q VPWR VGND sg13cmos5l_nand2_1
X_1214_ _1214_/Y _1939_/Q _1224_/B VPWR VGND sg13cmos5l_nor2_1
X_2263_ _2263_/Q FrameData[28] VGND VPWR FrameStrobe[2] latch
X_2194_ _2194_/Q FrameData[23] VGND VPWR FrameStrobe[4] latch
XFILLER_21_556 VPWR VGND sg13cmos5l_fill_1
X_1076_ _1076_/Y _0601_/Y _0852_/B _3258_/X VPWR VGND sg13cmos5l_a21oi_1
X_0929_ _0929_/Y _1750_/Q _0927_/A _0928_/Y VPWR VGND sg13cmos5l_a21oi_1
X_1978_ _1978_/Q FrameData[31] VGND VPWR _1044_/X latch
XFILLER_0_405 VPWR VGND sg13cmos5l_fill_1
XFILLER_28_155 VPWR VGND sg13cmos5l_fill_1
XFILLER_12_523 VPWR VGND sg13cmos5l_fill_1
XFILLER_24_394 VPWR VGND sg13cmos5l_fill_2
XFILLER_19_188 VPWR VGND sg13cmos5l_decap_8
XFILLER_34_169 VPWR VGND sg13cmos5l_fill_1
X_2950_ _2950_/X E1END[2] W2MID[6] _1243_/Q _3043_/X _2051_/Q _2052_/Q VPWR VGND sg13cmos5l_mux4_1
X_2881_ _2881_/X N1END[1] N2MID[5] N2END[5] NN4END[1] _2300_/Q _2301_/Q VPWR VGND
+ sg13cmos5l_mux4_1
X_1901_ _1901_/Q FrameData[18] VGND VPWR _1152_/X latch
X_1832_ _1832_/Q FrameData[13] VGND VPWR _1136_/X latch
X_0645_ _2592_/A _3293_/X _3294_/X _1684_/Q VPWR VGND sg13cmos5l_mux2_1
X_0714_ _0844_/B _0843_/A VPWR VGND sg13cmos5l_inv_1
X_1694_ _1694_/Q FrameData[3] VGND VPWR _1133_/X latch
X_1763_ _1763_/Q FrameData[8] VGND VPWR _1139_/X latch
XFILLER_32_0 VPWR VGND sg13cmos5l_fill_1
X_0576_ _1118_/A _2830_/X VPWR VGND sg13cmos5l_inv_1
X_3295_ _3295_/X E6END[1] S2END[1] WW4END[1] _0631_/X _1679_/Q _1680_/Q VPWR VGND
+ sg13cmos5l_mux4_1
X_2315_ _2315_/Q FrameData[16] VGND VPWR FrameStrobe[0] latch
X_2246_ _2246_/Q FrameData[11] VGND VPWR FrameStrobe[2] latch
XFILLER_15_26 VPWR VGND sg13cmos5l_fill_1
XFILLER_15_37 VPWR VGND sg13cmos5l_fill_2
XFILLER_25_147 VPWR VGND sg13cmos5l_decap_4
XFILLER_25_158 VPWR VGND sg13cmos5l_fill_2
XFILLER_40_106 VPWR VGND sg13cmos5l_fill_1
X_1059_ _1059_/Y _1059_/A _2325_/Q VPWR VGND sg13cmos5l_nand2_1
X_1128_ _1128_/X E1END[3] S2END[5] _2187_/Q VPWR VGND sg13cmos5l_mux2_1
X_2177_ _2177_/Q FrameData[6] VGND VPWR FrameStrobe[4] latch
XFILLER_31_47 VPWR VGND sg13cmos5l_fill_1
XFILLER_33_191 VPWR VGND sg13cmos5l_decap_8
XFILLER_56_44 VPWR VGND sg13cmos5l_fill_1
XFILLER_31_128 VPWR VGND sg13cmos5l_fill_2
XANTENNA__2500__X NN4BEG[5] VPWR VGND sg13cmos5l_antennanp
X_3080_ _3080_/X N2END[2] N4END[2] E2MID[0] S2MID[6] _2219_/Q _2220_/Q VPWR VGND sg13cmos5l_mux4_1
X_2100_ _2100_/Q FrameData[25] VGND VPWR FrameStrobe[7] latch
XFILLER_47_250 VPWR VGND sg13cmos5l_decap_8
XFILLER_47_294 VPWR VGND sg13cmos5l_fill_1
X_2031_ _2031_/Q FrameData[20] VGND VPWR FrameStrobe[9] latch
XFILLER_30_150 VPWR VGND sg13cmos5l_fill_2
X_1815_ _1815_/Q FrameData[28] VGND VPWR _1138_/X latch
X_2933_ _2933_/X N2END[4] S1END[0] _0889_/Y _3006_/X _2032_/Q _2033_/Q VPWR VGND sg13cmos5l_mux4_1
X_2864_ _2864_/X _2860_/X _2861_/X _2862_/X _2863_/X _1959_/Q _1960_/Q VPWR VGND sg13cmos5l_mux4_1
X_2795_ _2795_/X _1485_/Q _1486_/Q _1487_/Q _1488_/Q _3208_/X _3203_/X VPWR VGND sg13cmos5l_mux4_1
XANTENNA__2410__X E6BEG[3] VPWR VGND sg13cmos5l_antennanp
X_0628_ _0628_/X _3011_/X _3012_/X _2195_/Q VPWR VGND sg13cmos5l_mux2_1
X_1677_ _1677_/Q FrameData[18] VGND VPWR _1167_/X latch
X_1746_ _1746_/Q FrameData[23] VGND VPWR _1177_/X latch
XFILLER_38_272 VPWR VGND sg13cmos5l_decap_4
X_3347_ _3347_/X N2END[0] EE4END[1] W6END[1] _3043_/X _1601_/Q _1602_/Q VPWR VGND
+ sg13cmos5l_mux4_1
X_3278_ _3278_/X _3074_/X _0865_/X _0862_/X _1061_/Y _1706_/Q _1707_/Q VPWR VGND sg13cmos5l_mux4_1
X_2229_ _2229_/Q FrameData[26] VGND VPWR FrameStrobe[3] latch
XFILLER_3_29 VPWR VGND sg13cmos5l_decap_4
XFILLER_17_489 VPWR VGND sg13cmos5l_decap_4
XFILLER_29_261 VPWR VGND sg13cmos5l_decap_4
XFILLER_44_242 VPWR VGND sg13cmos5l_fill_1
XFILLER_4_371 VPWR VGND sg13cmos5l_fill_1
X_1462_ _1462_/Q FrameData[27] VGND VPWR _1185_/X latch
X_1531_ _1531_/Q FrameData[0] VGND VPWR _1187_/X latch
X_1600_ _1600_/Q FrameData[5] VGND VPWR _1189_/X latch
X_2580_ SS4BEG[1] SS4END[5] VPWR VGND sg13cmos5l_buf_1
X_1393_ _1393_/Q FrameData[22] VGND VPWR _1181_/X latch
X_3063_ _3063_/X _0875_/A _3063_/A1 _3063_/A2 _1223_/Y _2231_/Q _2232_/Q VPWR VGND
+ sg13cmos5l_mux4_1
X_3132_ _3132_/X N1END[3] N2MID[7] N2END[7] NN4END[3] _2119_/Q _2120_/Q VPWR VGND
+ sg13cmos5l_mux4_1
X_3201_ _3201_/X _0872_/X _0869_/X _0868_/X _3107_/X _1885_/Q _1886_/Q VPWR VGND sg13cmos5l_mux4_1
XFILLER_23_404 VPWR VGND sg13cmos5l_fill_1
XFILLER_23_437 VPWR VGND sg13cmos5l_fill_2
X_2014_ _2014_/Q FrameData[3] VGND VPWR FrameStrobe[9] latch
XANTENNA__2405__X EE4BEG[14] VPWR VGND sg13cmos5l_antennanp
XFILLER_50_289 VPWR VGND sg13cmos5l_fill_1
X_2916_ _2916_/X _1242_/Q _2916_/A1 _2916_/A2 _0856_/Y _2246_/Q _2247_/Q VPWR VGND
+ sg13cmos5l_mux4_1
X_2847_ _2847_/X _1547_/Q _1555_/Q _1548_/Q _1556_/Q _2864_/X _3184_/X VPWR VGND sg13cmos5l_mux4_1
X_2778_ _2778_/X _2924_/X _3043_/X _0656_/X _3001_/X _1857_/Q _1858_/Q VPWR VGND sg13cmos5l_mux4_1
XFILLER_2_308 VPWR VGND sg13cmos5l_fill_1
X_1729_ _1729_/Q FrameData[6] VGND VPWR _1177_/X latch
XFILLER_26_220 VPWR VGND sg13cmos5l_fill_2
XFILLER_14_426 VPWR VGND sg13cmos5l_fill_2
XFILLER_41_234 VPWR VGND sg13cmos5l_fill_2
XFILLER_37_518 VPWR VGND sg13cmos5l_fill_2
XFILLER_9_452 VPWR VGND sg13cmos5l_decap_8
X_0893_ _0894_/B _1587_/Q _0896_/S _0892_/Y VPWR VGND sg13cmos5l_o21ai_1
X_0962_ _2430_/A _2993_/X _2994_/X _2021_/Q VPWR VGND sg13cmos5l_mux2_1
X_2701_ _2701_/X _1335_/Q _1343_/Q _1336_/Q _1344_/Q _2719_/X _3244_/X VPWR VGND sg13cmos5l_mux4_1
X_2632_ WW4BEG[5] WW4END[9] VPWR VGND sg13cmos5l_buf_1
X_1445_ _1445_/Q FrameData[10] VGND VPWR _1185_/X latch
X_1514_ _1514_/Q FrameData[15] VGND VPWR _1188_/X latch
X_2563_ FrameData_O[16] FrameData[16] VPWR VGND sg13cmos5l_buf_1
X_2494_ N4BEG[15] _2494_/A VPWR VGND sg13cmos5l_buf_1
X_1376_ _1376_/Q FrameData[5] VGND VPWR _1181_/X latch
X_3046_ _3046_/X N2MID[0] N2END[0] N4END[0] E1END[2] _2167_/Q _2168_/Q VPWR VGND sg13cmos5l_mux4_1
X_3115_ _3115_/X S2END[6] W2MID[3] W2MID[6] W2END[2] _2203_/Q _2204_/Q VPWR VGND sg13cmos5l_mux4_1
XFILLER_23_223 VPWR VGND sg13cmos5l_fill_1
XFILLER_3_7 VPWR VGND sg13cmos5l_fill_1
XFILLER_10_462 VPWR VGND sg13cmos5l_decap_8
XFILLER_9_39 VPWR VGND sg13cmos5l_fill_1
XFILLER_6_455 VPWR VGND sg13cmos5l_fill_1
XFILLER_49_197 VPWR VGND sg13cmos5l_fill_2
X_1092_ _1239_/D _0984_/A _1087_/Y _1088_/Y _1091_/X VPWR VGND sg13cmos5l_a22oi_1
X_1161_ _1161_/Y _2116_/Q _1066_/Y _2115_/Q VPWR VGND sg13cmos5l_a21oi_1
X_1230_ _1230_/Y _1971_/Q _2606_/A VPWR VGND sg13cmos5l_nand2_1
X_1994_ _1994_/Q FrameData[15] VGND VPWR FrameStrobe[10] latch
XFILLER_9_282 VPWR VGND sg13cmos5l_decap_4
X_0876_ _0876_/Y _1328_/Q _0876_/B VPWR VGND sg13cmos5l_nor2_1
X_0945_ _0945_/Y _0579_/Y _1333_/Q _0944_/Y VPWR VGND sg13cmos5l_o21ai_1
X_2615_ W6BEG[0] W6END[2] VPWR VGND sg13cmos5l_buf_1
X_1428_ _1428_/Q FrameData[25] VGND VPWR _1186_/X latch
X_2546_ S4BEG[15] _2546_/A VPWR VGND sg13cmos5l_buf_1
X_2477_ N2BEGb[6] N2MID[6] VPWR VGND sg13cmos5l_buf_1
X_1359_ _1359_/Q FrameData[20] VGND VPWR _1183_/X latch
X_3029_ _3029_/X N2MID[0] N4END[0] E2MID[2] EE4END[0] _2085_/Q _2086_/Q VPWR VGND
+ sg13cmos5l_mux4_1
XFILLER_50_46 VPWR VGND sg13cmos5l_fill_1
XFILLER_27_370 VPWR VGND sg13cmos5l_decap_8
XFILLER_27_381 VPWR VGND sg13cmos5l_decap_8
XANTENNA__2503__X NN4BEG[8] VPWR VGND sg13cmos5l_antennanp
X_0661_ _0662_/A _2996_/X _1990_/Q _0660_/Y VPWR VGND sg13cmos5l_a21oi_1
X_0730_ _0730_/Y _2695_/X _2680_/X VPWR VGND sg13cmos5l_nand2_1
X_2400_ EE4BEG[9] EE4END[13] VPWR VGND sg13cmos5l_buf_1
X_0592_ _0592_/Y _1243_/Q VPWR VGND sg13cmos5l_inv_1
X_1213_ _1213_/X _2978_/X _2947_/X _1939_/Q VPWR VGND sg13cmos5l_mux2_1
X_2331_ _3102_/A2 VPWR VGND sg13cmos5l_tiehi
X_2262_ _2262_/Q FrameData[27] VGND VPWR FrameStrobe[2] latch
XFILLER_1_95 VPWR VGND sg13cmos5l_fill_2
X_1075_ _1075_/Y _3258_/X _1292_/Q _1074_/Y VPWR VGND sg13cmos5l_a21oi_1
X_1144_ _1144_/Y _3246_/X _1334_/Q _1143_/Y VPWR VGND sg13cmos5l_a21oi_1
X_2193_ _2193_/Q FrameData[22] VGND VPWR FrameStrobe[4] latch
XANTENNA__2413__X E6BEG[6] VPWR VGND sg13cmos5l_antennanp
XFILLER_33_395 VPWR VGND sg13cmos5l_decap_8
X_1977_ _1977_/Q FrameData[30] VGND VPWR _1044_/X latch
X_0859_ _0859_/X _3082_/X _3083_/X _2292_/Q VPWR VGND sg13cmos5l_mux2_1
X_0928_ _0928_/Y _2967_/X _1750_/Q VPWR VGND sg13cmos5l_nor2_1
X_2529_ S2BEGb[6] S2MID[6] VPWR VGND sg13cmos5l_buf_1
XFILLER_29_36 VPWR VGND sg13cmos5l_fill_1
XFILLER_12_513 VPWR VGND sg13cmos5l_fill_2
XFILLER_24_340 VPWR VGND sg13cmos5l_decap_8
XFILLER_45_68 VPWR VGND sg13cmos5l_fill_2
XFILLER_3_233 VPWR VGND sg13cmos5l_fill_2
XFILLER_47_476 VPWR VGND sg13cmos5l_fill_2
X_2880_ _2880_/X W2END[7] _2880_/A1 _2880_/A2 _0848_/Y _2126_/Q _2127_/Q VPWR VGND
+ sg13cmos5l_mux4_1
X_1900_ _1900_/Q FrameData[17] VGND VPWR _1152_/X latch
X_1831_ _1831_/Q FrameData[12] VGND VPWR _1136_/X latch
X_0644_ _2593_/A _3291_/X _3292_/X _1687_/Q VPWR VGND sg13cmos5l_mux2_1
X_0713_ _0843_/A _0711_/D _0712_/B _0712_/Y VPWR VGND sg13cmos5l_o21ai_1
X_1693_ _1693_/Q FrameData[2] VGND VPWR _1133_/X latch
X_1762_ _1762_/Q FrameData[7] VGND VPWR _1139_/X latch
X_0575_ _0575_/Y _2811_/X VPWR VGND sg13cmos5l_inv_1
X_3294_ _3294_/X _2932_/X _3117_/X _2929_/X _0840_/Y _1682_/Q _1683_/Q VPWR VGND sg13cmos5l_mux4_1
X_2314_ _2314_/Q FrameData[15] VGND VPWR FrameStrobe[0] latch
X_2245_ _2245_/Q FrameData[10] VGND VPWR FrameStrobe[2] latch
X_2176_ _2176_/Q FrameData[5] VGND VPWR FrameStrobe[4] latch
XANTENNA__2408__X E6BEG[1] VPWR VGND sg13cmos5l_antennanp
XFILLER_38_476 VPWR VGND sg13cmos5l_fill_2
X_1058_ _1058_/Y _1497_/Q _0787_/Y _1057_/Y VPWR VGND sg13cmos5l_o21ai_1
X_1127_ _1127_/Y _1907_/Q _1061_/A _1126_/Y VPWR VGND sg13cmos5l_a21oi_1
XFILLER_21_332 VPWR VGND sg13cmos5l_decap_4
XFILLER_4_520 VPWR VGND sg13cmos5l_fill_1
X_2030_ _2030_/Q FrameData[19] VGND VPWR FrameStrobe[9] latch
XFILLER_35_435 VPWR VGND sg13cmos5l_fill_1
XFILLER_50_438 VPWR VGND sg13cmos5l_fill_2
X_2932_ _2932_/X _1046_/X _1047_/X _1073_/Y _2155_/Q _2156_/Q _2157_/Q VPWR VGND sg13cmos5l_mux4_1
X_1745_ _1745_/Q FrameData[22] VGND VPWR _1177_/X latch
X_1814_ _1814_/Q FrameData[27] VGND VPWR _1138_/X latch
X_2863_ _2863_/X _0864_/X _2899_/X _0858_/X _3010_/X _1957_/Q _1958_/Q VPWR VGND sg13cmos5l_mux4_1
X_2794_ _2794_/X _1481_/Q _1482_/Q _1483_/Q _1484_/Q _3208_/X _3203_/X VPWR VGND sg13cmos5l_mux4_1
X_0627_ _0627_/X _3088_/X _3089_/X _2198_/Q VPWR VGND sg13cmos5l_mux2_1
X_1676_ _1676_/Q FrameData[17] VGND VPWR _1167_/X latch
X_3346_ _3346_/X _3079_/X _0870_/X _3122_/X _0856_/Y _1604_/Q _1605_/Q VPWR VGND sg13cmos5l_mux4_1
XFILLER_26_413 VPWR VGND sg13cmos5l_decap_4
X_3277_ _3277_/X N4END[2] SS4END[2] W2MID[3] _2924_/X _1706_/Q _1707_/Q VPWR VGND
+ sg13cmos5l_mux4_1
X_2228_ _2228_/Q FrameData[25] VGND VPWR FrameStrobe[3] latch
X_2159_ _2159_/Q FrameData[20] VGND VPWR FrameStrobe[5] latch
XANTENNA__2601__X W2BEG[2] VPWR VGND sg13cmos5l_antennanp
XFILLER_17_468 VPWR VGND sg13cmos5l_fill_2
XFILLER_44_210 VPWR VGND sg13cmos5l_fill_1
XFILLER_44_276 VPWR VGND sg13cmos5l_decap_8
XANTENNA__2511__X S1BEG[0] VPWR VGND sg13cmos5l_antennanp
X_1392_ _1392_/Q FrameData[21] VGND VPWR _1181_/X latch
X_1461_ _1461_/Q FrameData[26] VGND VPWR _1185_/X latch
X_1530_ _1530_/Q FrameData[31] VGND VPWR _1188_/X latch
X_3200_ _3200_/X _2932_/X _3050_/X _3074_/X _3139_/X _1885_/Q _1886_/Q VPWR VGND sg13cmos5l_mux4_1
X_3062_ _3062_/X N2END[3] E6END[1] S1END[3] _1236_/Q _2231_/Q _2232_/Q VPWR VGND sg13cmos5l_mux4_1
X_3131_ _3131_/X EE4END[3] S2MID[3] S4END[3] W2END[3] _2129_/Q _2130_/Q VPWR VGND
+ sg13cmos5l_mux4_1
X_2013_ _2013_/Q FrameData[2] VGND VPWR FrameStrobe[9] latch
XFILLER_16_490 VPWR VGND sg13cmos5l_fill_2
X_2915_ _2915_/X SS4END[3] W2MID[3] W2END[3] WW4END[1] _2246_/Q _2247_/Q VPWR VGND
+ sg13cmos5l_mux4_1
XANTENNA__2421__X E2BEGb[2] VPWR VGND sg13cmos5l_antennanp
X_1728_ _1728_/Q FrameData[5] VGND VPWR _1177_/X latch
X_2846_ _2846_/X _1545_/Q _1553_/Q _1546_/Q _1554_/Q _2864_/X _3184_/X VPWR VGND sg13cmos5l_mux4_1
X_2777_ _2777_/X _2773_/X _2774_/X _2775_/X _2776_/X _1863_/Q _1864_/Q VPWR VGND sg13cmos5l_mux4_1
X_1659_ _1659_/Q FrameData[0] VGND VPWR _1167_/X latch
X_3329_ _3329_/X N2END[6] S1END[2] _0805_/B _0631_/X _1628_/Q _1629_/Q VPWR VGND sg13cmos5l_mux4_1
XFILLER_26_243 VPWR VGND sg13cmos5l_decap_4
XANTENNA__2506__X NN4BEG[11] VPWR VGND sg13cmos5l_antennanp
XFILLER_20_419 VPWR VGND sg13cmos5l_decap_8
XFILLER_32_224 VPWR VGND sg13cmos5l_decap_8
X_0961_ _0961_/Y _1814_/Q _0958_/A _0960_/Y VPWR VGND sg13cmos5l_o21ai_1
XFILLER_9_420 VPWR VGND sg13cmos5l_fill_1
XFILLER_9_486 VPWR VGND sg13cmos5l_fill_1
XFILLER_9_497 VPWR VGND sg13cmos5l_fill_2
X_0892_ _0892_/Y _1587_/Q _0892_/B VPWR VGND sg13cmos5l_nand2_1
X_2700_ _2700_/X _2696_/X _2697_/X _2698_/X _2699_/X _1771_/Q _1772_/Q VPWR VGND sg13cmos5l_mux4_1
X_2631_ WW4BEG[4] WW4END[8] VPWR VGND sg13cmos5l_buf_1
X_2562_ FrameData_O[15] FrameData[15] VPWR VGND sg13cmos5l_buf_1
X_1375_ _1375_/Q FrameData[4] VGND VPWR _1181_/X latch
X_1444_ _1444_/Q FrameData[9] VGND VPWR _1185_/X latch
X_1513_ _1513_/Q FrameData[14] VGND VPWR _1188_/X latch
X_2493_ N4BEG[14] _2493_/A VPWR VGND sg13cmos5l_buf_1
XFILLER_28_519 VPWR VGND sg13cmos5l_fill_1
X_3045_ _3045_/X _1250_/Q _3045_/A1 _3045_/A2 _1013_/Y _2190_/Q _2191_/Q VPWR VGND
+ sg13cmos5l_mux4_1
X_3114_ _3114_/X E2END[0] E6END[0] S1END[2] S2MID[6] _2203_/Q _2204_/Q VPWR VGND sg13cmos5l_mux4_1
XANTENNA__2416__X E6BEG[9] VPWR VGND sg13cmos5l_antennanp
XFILLER_23_16 VPWR VGND sg13cmos5l_fill_1
XFILLER_51_555 VPWR VGND sg13cmos5l_fill_2
X_2829_ _2829_/X _2890_/X _0861_/X _2885_/X _0857_/X _1933_/Q _1934_/Q VPWR VGND sg13cmos5l_mux4_1
XFILLER_14_268 VPWR VGND sg13cmos5l_fill_2
XFILLER_42_555 VPWR VGND sg13cmos5l_fill_2
XFILLER_49_143 VPWR VGND sg13cmos5l_fill_1
X_1091_ _1091_/X _3234_/X _1091_/B VPWR VGND sg13cmos5l_or2_1
X_1160_ _1160_/Y _1061_/A _1159_/X _1158_/Y VPWR VGND sg13cmos5l_a21oi_1
XFILLER_20_205 VPWR VGND sg13cmos5l_fill_2
X_0944_ _0944_/Y _2700_/X _1333_/Q VPWR VGND sg13cmos5l_nand2_1
X_1993_ _1993_/Q FrameData[14] VGND VPWR FrameStrobe[10] latch
XFILLER_55_0 VPWR VGND sg13cmos5l_fill_2
X_0875_ _0875_/Y _0875_/A VPWR VGND sg13cmos5l_inv_1
X_2614_ W2BEGb[7] W2MID[7] VPWR VGND sg13cmos5l_buf_1
X_2545_ S4BEG[14] _2545_/A VPWR VGND sg13cmos5l_buf_1
X_1358_ _1358_/Q FrameData[19] VGND VPWR _1183_/X latch
X_1427_ _1427_/Q FrameData[24] VGND VPWR _1186_/X latch
X_2476_ N2BEGb[5] N2MID[5] VPWR VGND sg13cmos5l_buf_1
X_1289_ _1289_/Q FrameData[14] VGND VPWR _1197_/X latch
X_3028_ _3028_/X _3145_/X _3163_/X _3010_/X _1013_/Y _2013_/Q _2014_/Q VPWR VGND sg13cmos5l_mux4_1
XFILLER_42_396 VPWR VGND sg13cmos5l_fill_1
XFILLER_10_260 VPWR VGND sg13cmos5l_fill_1
XFILLER_10_282 VPWR VGND sg13cmos5l_fill_1
X_0591_ _0591_/Y _1247_/Q VPWR VGND sg13cmos5l_inv_1
X_0660_ _0660_/Y _1990_/Q _2995_/X VPWR VGND sg13cmos5l_nor2b_1
X_1212_ _1212_/Y _1942_/Q _1192_/A _1211_/Y VPWR VGND sg13cmos5l_a21oi_1
X_2330_ _2330_/Q FrameData[31] VGND VPWR FrameStrobe[0] latch
X_2261_ _2261_/Q FrameData[26] VGND VPWR FrameStrobe[2] latch
X_2192_ _2192_/Q FrameData[21] VGND VPWR FrameStrobe[4] latch
XFILLER_21_503 VPWR VGND sg13cmos5l_fill_1
XFILLER_37_168 VPWR VGND sg13cmos5l_fill_1
X_1074_ _1074_/Y _3258_/X _3257_/X VPWR VGND sg13cmos5l_nor2_1
X_1143_ _1143_/Y _3246_/X _3245_/X VPWR VGND sg13cmos5l_nor2_1
X_0927_ _2429_/A _0927_/A VPWR VGND sg13cmos5l_inv_1
X_1976_ _1976_/Q FrameData[29] VGND VPWR _1044_/X latch
X_0789_ _0789_/Y _0787_/A _0787_/B _0788_/Y VPWR VGND sg13cmos5l_o21ai_1
X_0858_ _0858_/X _2911_/X _2912_/X _2295_/Q VPWR VGND sg13cmos5l_mux2_1
X_2528_ S2BEGb[5] S2MID[5] VPWR VGND sg13cmos5l_buf_1
X_2459_ N1BEG[0] _2459_/A VPWR VGND sg13cmos5l_buf_1
XANTENNA__2604__X W2BEG[5] VPWR VGND sg13cmos5l_antennanp
XFILLER_24_396 VPWR VGND sg13cmos5l_fill_1
XFILLER_43_138 VPWR VGND sg13cmos5l_decap_4
XFILLER_43_149 VPWR VGND sg13cmos5l_fill_2
XFILLER_10_83 VPWR VGND sg13cmos5l_fill_1
XFILLER_19_157 VPWR VGND sg13cmos5l_decap_8
XFILLER_34_149 VPWR VGND sg13cmos5l_fill_1
XANTENNA__2514__X S1BEG[3] VPWR VGND sg13cmos5l_antennanp
XFILLER_30_333 VPWR VGND sg13cmos5l_fill_1
X_1761_ _1761_/Q FrameData[6] VGND VPWR _1139_/X latch
X_1830_ _1830_/Q FrameData[11] VGND VPWR _1136_/X latch
X_0574_ _1109_/A _2801_/X VPWR VGND sg13cmos5l_inv_1
X_0643_ _2594_/A _3289_/X _3290_/X _1690_/Q VPWR VGND sg13cmos5l_mux2_1
X_0712_ _0712_/Y _2734_/X _0712_/B VPWR VGND sg13cmos5l_nand2_1
X_1692_ _1692_/Q FrameData[1] VGND VPWR _1133_/X latch
X_2313_ _2313_/Q FrameData[14] VGND VPWR FrameStrobe[0] latch
X_1126_ _1126_/Y _1907_/Q _1224_/B VPWR VGND sg13cmos5l_nor2_1
X_3293_ _3293_/X E6END[0] S4END[0] WW4END[2] _0655_/X _1682_/Q _1683_/Q VPWR VGND
+ sg13cmos5l_mux4_1
X_2244_ _2244_/Q FrameData[9] VGND VPWR FrameStrobe[2] latch
X_2175_ _2175_/Q FrameData[4] VGND VPWR FrameStrobe[4] latch
XANTENNA__2424__X E2BEGb[5] VPWR VGND sg13cmos5l_antennanp
XFILLER_18_190 VPWR VGND sg13cmos5l_fill_1
X_1057_ _1057_/Y _2792_/X _1497_/Q VPWR VGND sg13cmos5l_nand2_1
XFILLER_21_377 VPWR VGND sg13cmos5l_decap_4
X_1959_ _1959_/Q FrameData[12] VGND VPWR _1044_/X latch
XANTENNA__2509__X NN4BEG[14] VPWR VGND sg13cmos5l_antennanp
X_2931_ _2931_/X W1END[2] W2MID[5] _0875_/A _0833_/Y _2256_/Q _2257_/Q VPWR VGND sg13cmos5l_mux4_1
X_1744_ _1744_/Q FrameData[21] VGND VPWR _1177_/X latch
X_1813_ _1813_/Q FrameData[26] VGND VPWR _1138_/X latch
X_2862_ _2862_/X _3159_/X _0869_/X _3155_/X _3150_/X _1957_/Q _1958_/Q VPWR VGND sg13cmos5l_mux4_1
X_2793_ _2793_/X _1477_/Q _1478_/Q _1479_/Q _1480_/Q _3208_/X _3203_/X VPWR VGND sg13cmos5l_mux4_1
X_0626_ _2438_/A _3325_/X _3326_/X _1636_/Q VPWR VGND sg13cmos5l_mux2_1
X_1675_ _1675_/Q FrameData[16] VGND VPWR _1167_/X latch
X_3345_ _3345_/X EE4END[2] W6END[0] _1237_/Q _0657_/X _1604_/Q _1605_/Q VPWR VGND
+ sg13cmos5l_mux4_1
X_3276_ _3276_/X _0872_/X _3170_/X _0859_/X _0833_/Y _1709_/Q _1710_/Q VPWR VGND sg13cmos5l_mux4_1
XANTENNA__2419__X E2BEGb[0] VPWR VGND sg13cmos5l_antennanp
XFILLER_38_296 VPWR VGND sg13cmos5l_fill_1
X_1109_ _1109_/Y _1109_/A _1498_/Q VPWR VGND sg13cmos5l_nand2_1
X_2227_ _2227_/Q FrameData[24] VGND VPWR FrameStrobe[3] latch
X_2158_ _2158_/Q FrameData[19] VGND VPWR FrameStrobe[5] latch
X_2089_ _2089_/Q FrameData[14] VGND VPWR FrameStrobe[7] latch
XFILLER_21_152 VPWR VGND sg13cmos5l_decap_4
XFILLER_42_48 VPWR VGND sg13cmos5l_fill_1
XFILLER_42_59 VPWR VGND sg13cmos5l_fill_1
XFILLER_53_299 VPWR VGND sg13cmos5l_fill_2
XFILLER_17_403 VPWR VGND sg13cmos5l_fill_1
X_1391_ _1391_/Q FrameData[20] VGND VPWR _1181_/X latch
X_1460_ _1460_/Q FrameData[25] VGND VPWR _1185_/X latch
X_3130_ _3130_/X N2END[7] NN4END[3] E1END[1] E2END[5] _2129_/Q _2130_/Q VPWR VGND
+ sg13cmos5l_mux4_1
XFILLER_35_222 VPWR VGND sg13cmos5l_fill_1
X_3061_ _3061_/X S2END[2] S4END[2] W1END[2] W2END[6] _2100_/Q _2101_/Q VPWR VGND sg13cmos5l_mux4_1
X_2012_ _2012_/Q FrameData[1] VGND VPWR FrameStrobe[9] latch
XFILLER_35_266 VPWR VGND sg13cmos5l_decap_4
X_2914_ _2914_/X E2END[1] E6END[1] S2MID[7] S2END[7] _2246_/Q _2247_/Q VPWR VGND sg13cmos5l_mux4_1
X_2845_ _2845_/X _2841_/X _2842_/X _2843_/X _2844_/X _1931_/Q _1932_/Q VPWR VGND sg13cmos5l_mux4_1
X_1658_ _1658_/Q FrameData[31] VGND VPWR _1171_/X latch
X_1727_ _1727_/Q FrameData[4] VGND VPWR _1177_/X latch
X_2776_ _2776_/X _0863_/X _2899_/X _0859_/X _2929_/X _1861_/Q _1862_/Q VPWR VGND sg13cmos5l_mux4_1
X_0609_ _2508_/A _3337_/X _3338_/X _1618_/Q VPWR VGND sg13cmos5l_mux2_1
X_1589_ _1589_/Q FrameData[26] VGND VPWR _1166_/X latch
X_3259_ _3259_/X _0631_/X _0629_/X _0655_/X _3087_/X _1725_/Q _1726_/Q VPWR VGND sg13cmos5l_mux4_1
X_3328_ _3328_/X _3117_/X _0862_/X _2929_/X _1056_/Y _1631_/Q _1632_/Q VPWR VGND sg13cmos5l_mux4_1
XFILLER_26_255 VPWR VGND sg13cmos5l_decap_8
XANTENNA__2612__X W2BEGb[5] VPWR VGND sg13cmos5l_antennanp
XFILLER_49_314 VPWR VGND sg13cmos5l_fill_2
XFILLER_45_520 VPWR VGND sg13cmos5l_fill_2
XFILLER_20_409 VPWR VGND sg13cmos5l_fill_2
X_0960_ _0960_/Y _1814_/Q _2602_/A VPWR VGND sg13cmos5l_nand2_1
XANTENNA__2522__X S2BEG[7] VPWR VGND sg13cmos5l_antennanp
X_0891_ _0896_/S _2876_/X _1588_/Q _0890_/Y VPWR VGND sg13cmos5l_a21oi_1
X_1512_ _1512_/Q FrameData[13] VGND VPWR _1188_/X latch
X_2630_ WW4BEG[3] WW4END[7] VPWR VGND sg13cmos5l_buf_1
X_2561_ FrameData_O[14] FrameData[14] VPWR VGND sg13cmos5l_buf_1
X_2492_ N4BEG[13] _2492_/A VPWR VGND sg13cmos5l_buf_1
XFILLER_4_41 VPWR VGND sg13cmos5l_fill_1
X_1374_ _1374_/Q FrameData[3] VGND VPWR _1181_/X latch
X_1443_ _1443_/Q FrameData[8] VGND VPWR _1185_/X latch
X_3113_ _3113_/X N2MID[2] N2END[2] N4END[2] E2MID[0] _2203_/Q _2204_/Q VPWR VGND sg13cmos5l_mux4_1
XFILLER_51_545 VPWR VGND sg13cmos5l_fill_2
X_3044_ _3044_/X N2END[1] E1END[3] SS4END[1] W2MID[1] _2190_/Q _2191_/Q VPWR VGND
+ sg13cmos5l_mux4_1
XANTENNA__2432__X E2BEG[5] VPWR VGND sg13cmos5l_antennanp
XFILLER_23_258 VPWR VGND sg13cmos5l_decap_4
X_2828_ _2828_/X _0872_/X _0870_/X _3150_/X _0865_/X _1933_/Q _1934_/Q VPWR VGND sg13cmos5l_mux4_1
X_2759_ _2759_/X _1419_/Q _1427_/Q _1420_/Q _1428_/Q _2777_/X _3220_/X VPWR VGND sg13cmos5l_mux4_1
XANTENNA__2607__X W2BEGb[0] VPWR VGND sg13cmos5l_antennanp
XFILLER_22_291 VPWR VGND sg13cmos5l_fill_1
XANTENNA__2517__X S2BEG[2] VPWR VGND sg13cmos5l_antennanp
X_1090_ _1091_/B _2705_/X _1372_/Q _1089_/Y VPWR VGND sg13cmos5l_o21ai_1
XFILLER_33_556 VPWR VGND sg13cmos5l_fill_1
X_0874_ _0875_/A _0805_/B _0839_/B _0892_/B VPWR VGND sg13cmos5l_mux2_1
X_0943_ _0943_/Y _1747_/Q _0941_/A _0942_/Y VPWR VGND sg13cmos5l_a21oi_1
X_1992_ _1992_/Q FrameData[13] VGND VPWR FrameStrobe[10] latch
XFILLER_48_0 VPWR VGND sg13cmos5l_fill_2
X_2613_ W2BEGb[6] W2MID[6] VPWR VGND sg13cmos5l_buf_1
X_2544_ S4BEG[13] _2544_/A VPWR VGND sg13cmos5l_buf_1
X_2475_ N2BEGb[4] N2MID[4] VPWR VGND sg13cmos5l_buf_1
XFILLER_55_158 VPWR VGND sg13cmos5l_fill_2
X_1288_ _1288_/Q FrameData[13] VGND VPWR _1197_/X latch
X_1357_ _1357_/Q FrameData[18] VGND VPWR _1183_/X latch
X_1426_ _1426_/Q FrameData[23] VGND VPWR _1186_/X latch
XANTENNA__2427__X E2BEG[0] VPWR VGND sg13cmos5l_antennanp
XFILLER_51_397 VPWR VGND sg13cmos5l_fill_2
X_3027_ _3027_/X N2END[6] S1END[2] _1238_/Q _0654_/X _2013_/Q _2014_/Q VPWR VGND sg13cmos5l_mux4_1
XFILLER_15_523 VPWR VGND sg13cmos5l_decap_4
XFILLER_34_309 VPWR VGND sg13cmos5l_decap_4
XFILLER_15_556 VPWR VGND sg13cmos5l_fill_1
X_0590_ _0590_/Y _1238_/Q VPWR VGND sg13cmos5l_inv_1
XFILLER_2_493 VPWR VGND sg13cmos5l_decap_4
X_1142_ _1240_/D _0596_/Y _1087_/Y _1088_/Y _1141_/Y VPWR VGND sg13cmos5l_a22oi_1
X_1211_ _1211_/Y _1942_/Q _2468_/A VPWR VGND sg13cmos5l_nor2_1
X_2260_ _2260_/Q FrameData[25] VGND VPWR FrameStrobe[2] latch
X_2191_ _2191_/Q FrameData[20] VGND VPWR FrameStrobe[4] latch
XFILLER_18_361 VPWR VGND sg13cmos5l_decap_4
XFILLER_33_331 VPWR VGND sg13cmos5l_fill_2
X_1073_ _1073_/Y _2155_/Q _0883_/A _1072_/Y VPWR VGND sg13cmos5l_a21oi_1
X_0857_ _0857_/X _3064_/X _3065_/X _2314_/Q VPWR VGND sg13cmos5l_mux2_1
X_0926_ _0927_/A _3020_/X _2018_/Q _0925_/Y VPWR VGND sg13cmos5l_a21oi_1
X_1975_ _1975_/Q FrameData[28] VGND VPWR _1044_/X latch
X_0788_ _0788_/Y _1937_/Q _1938_/Q VPWR VGND sg13cmos5l_nor2_1
X_1409_ _1409_/Q FrameData[6] VGND VPWR _1186_/X latch
X_2527_ S2BEGb[4] S2MID[4] VPWR VGND sg13cmos5l_buf_1
X_2458_ FrameStrobe_O[19] FrameStrobe[19] VPWR VGND sg13cmos5l_buf_1
X_2389_ _3067_/A1 VPWR VGND sg13cmos5l_tielo
XFILLER_12_515 VPWR VGND sg13cmos5l_fill_1
XFILLER_24_364 VPWR VGND sg13cmos5l_fill_2
XANTENNA__2620__X W6BEG[5] VPWR VGND sg13cmos5l_antennanp
XFILLER_19_169 VPWR VGND sg13cmos5l_fill_2
XFILLER_47_489 VPWR VGND sg13cmos5l_fill_2
XFILLER_42_194 VPWR VGND sg13cmos5l_fill_1
X_0711_ _1023_/B _2734_/X _2758_/X _1417_/Q _0711_/D VPWR VGND sg13cmos5l_nor4_1
X_1691_ _1691_/Q FrameData[0] VGND VPWR _1133_/X latch
X_1760_ _1760_/Q FrameData[5] VGND VPWR _1139_/X latch
XANTENNA__2530__X S2BEGb[7] VPWR VGND sg13cmos5l_antennanp
X_0573_ _0573_/Y _2782_/X VPWR VGND sg13cmos5l_inv_1
X_0642_ _2595_/A _3287_/X _3288_/X _1693_/Q VPWR VGND sg13cmos5l_mux2_1
X_3292_ _3292_/X _3050_/X _0628_/X _3150_/X _0921_/Y _1685_/Q _1686_/Q VPWR VGND sg13cmos5l_mux4_1
X_2312_ _2312_/Q FrameData[13] VGND VPWR FrameStrobe[0] latch
X_1125_ _1125_/X W2END[6] W6END[1] _2187_/Q VPWR VGND sg13cmos5l_mux2_1
X_2243_ _2243_/Q FrameData[8] VGND VPWR FrameStrobe[2] latch
X_2174_ _2174_/Q FrameData[3] VGND VPWR FrameStrobe[4] latch
X_1056_ _1056_/Y _2320_/Q _0901_/A _1055_/Y VPWR VGND sg13cmos5l_o21ai_1
XANTENNA__2440__X FrameStrobe_O[1] VPWR VGND sg13cmos5l_antennanp
X_0909_ _0909_/Y _2845_/X _1543_/Q VPWR VGND sg13cmos5l_nand2_1
X_1958_ _1958_/Q FrameData[11] VGND VPWR _1044_/X latch
X_1889_ _1889_/Q FrameData[6] VGND VPWR _1152_/X latch
XANTENNA__2615__X W6BEG[0] VPWR VGND sg13cmos5l_antennanp
XANTENNA_90 W1END[3] VPWR VGND sg13cmos5l_antennanp
XFILLER_4_511 VPWR VGND sg13cmos5l_decap_8
XANTENNA__2525__X S2BEGb[2] VPWR VGND sg13cmos5l_antennanp
X_2930_ _2930_/X N4END[3] E2END[1] E6END[1] S2END[7] _2256_/Q _2257_/Q VPWR VGND sg13cmos5l_mux4_1
X_2861_ _2861_/X _0653_/X _3050_/X _3139_/X _0627_/X _1957_/Q _1958_/Q VPWR VGND sg13cmos5l_mux4_1
X_0625_ _2403_/A _3323_/X _3324_/X _1639_/Q VPWR VGND sg13cmos5l_mux2_1
X_1674_ _1674_/Q FrameData[15] VGND VPWR _1167_/X latch
X_1743_ _1743_/Q FrameData[20] VGND VPWR _1177_/X latch
X_1812_ _1812_/Q FrameData[25] VGND VPWR _1138_/X latch
X_2792_ _2792_/X _2788_/X _2789_/X _2790_/X _2791_/X _3203_/X _0916_/Y VPWR VGND sg13cmos5l_mux4_1
XFILLER_30_0 VPWR VGND sg13cmos5l_fill_2
X_3344_ _3344_/X _0653_/X _3139_/X _3155_/X _1027_/Y _1607_/Q _1608_/Q VPWR VGND sg13cmos5l_mux4_1
X_3275_ _3275_/X NN4END[3] S1END[3] _1248_/Q _3087_/X _1709_/Q _1710_/Q VPWR VGND
+ sg13cmos5l_mux4_1
X_2226_ _2226_/Q FrameData[23] VGND VPWR FrameStrobe[3] latch
XANTENNA__2435__X E1BEG[0] VPWR VGND sg13cmos5l_antennanp
XFILLER_53_278 VPWR VGND sg13cmos5l_fill_2
X_1039_ _2604_/A _2952_/X _2953_/X _2077_/Q VPWR VGND sg13cmos5l_mux2_1
X_1108_ _1249_/D _0593_/Y _1103_/Y _1104_/Y _1107_/Y VPWR VGND sg13cmos5l_a22oi_1
X_2157_ _2157_/Q FrameData[18] VGND VPWR FrameStrobe[5] latch
X_2088_ _2088_/Q FrameData[13] VGND VPWR FrameStrobe[7] latch
XFILLER_12_197 VPWR VGND sg13cmos5l_fill_1
XFILLER_8_124 VPWR VGND sg13cmos5l_fill_2
X_1390_ _1390_/Q FrameData[19] VGND VPWR _1181_/X latch
X_3060_ _3060_/X N2END[6] NN4END[2] E2MID[4] EE4END[2] _2100_/Q _2101_/Q VPWR VGND
+ sg13cmos5l_mux4_1
X_2011_ _2011_/Q FrameData[0] VGND VPWR FrameStrobe[9] latch
XFILLER_16_492 VPWR VGND sg13cmos5l_fill_1
XFILLER_31_473 VPWR VGND sg13cmos5l_fill_2
XFILLER_31_495 VPWR VGND sg13cmos5l_fill_2
X_2913_ _2913_/X N2MID[3] N2END[3] N4END[3] E2MID[1] _2246_/Q _2247_/Q VPWR VGND sg13cmos5l_mux4_1
X_2844_ _2844_/X _3127_/X _0862_/X _0858_/X _3010_/X _1929_/Q _1930_/Q VPWR VGND sg13cmos5l_mux4_1
X_0608_ _2509_/A _3335_/X _3336_/X _1621_/Q VPWR VGND sg13cmos5l_mux2_1
X_1588_ _1588_/Q FrameData[25] VGND VPWR _1166_/X latch
X_1657_ _1657_/Q FrameData[30] VGND VPWR _1171_/X latch
X_1726_ _1726_/Q FrameData[3] VGND VPWR _1177_/X latch
X_2775_ _2775_/X _3112_/X _0872_/X _3150_/X _0866_/X _1861_/Q _1862_/Q VPWR VGND sg13cmos5l_mux4_1
XFILLER_54_521 VPWR VGND sg13cmos5l_fill_2
X_3189_ _3189_/X _3159_/X _0869_/X _3155_/X _0867_/X _1917_/Q _1918_/Q VPWR VGND sg13cmos5l_mux4_1
X_3258_ _3258_/X _0943_/Y _0935_/Y _1747_/Q _0938_/Y _1748_/Q _1749_/Q VPWR VGND sg13cmos5l_mux4_1
X_3327_ _3327_/X N2MID[7] EE4END[3] S2END[3] _0655_/X _1631_/Q _1632_/Q VPWR VGND
+ sg13cmos5l_mux4_1
X_2209_ _2209_/Q FrameData[6] VGND VPWR FrameStrobe[3] latch
XFILLER_26_267 VPWR VGND sg13cmos5l_decap_4
XFILLER_26_289 VPWR VGND sg13cmos5l_decap_4
XFILLER_41_248 VPWR VGND sg13cmos5l_decap_8
XFILLER_13_451 VPWR VGND sg13cmos5l_fill_2
X_0890_ _0890_/Y _1588_/Q _2875_/X VPWR VGND sg13cmos5l_nor2b_1
X_1442_ _1442_/Q FrameData[7] VGND VPWR _1185_/X latch
X_1511_ _1511_/Q FrameData[12] VGND VPWR _1188_/X latch
X_2560_ FrameData_O[13] FrameData[13] VPWR VGND sg13cmos5l_buf_1
X_2491_ N4BEG[12] _2491_/A VPWR VGND sg13cmos5l_buf_1
X_1373_ _1373_/Q FrameData[2] VGND VPWR _1181_/X latch
X_3043_ _3043_/X _3039_/X _3040_/X _3041_/X _3042_/X _2113_/Q _2114_/Q VPWR VGND sg13cmos5l_mux4_1
X_3112_ _3112_/X _3108_/X _3109_/X _3110_/X _3111_/X _2213_/Q _2214_/Q VPWR VGND sg13cmos5l_mux4_1
X_2827_ _2827_/X _0653_/X _2910_/X _3093_/X _0627_/X _1933_/Q _1934_/Q VPWR VGND sg13cmos5l_mux4_1
X_2758_ _2758_/X _2754_/X _2755_/X _2756_/X _2757_/X _1835_/Q _1836_/Q VPWR VGND sg13cmos5l_mux4_1
X_1709_ _1709_/Q FrameData[18] VGND VPWR _1133_/X latch
X_2689_ _2689_/X _3127_/X _0862_/X _2929_/X _0857_/X _1765_/Q _1766_/Q VPWR VGND sg13cmos5l_mux4_1
XANTENNA__2623__X W6BEG[8] VPWR VGND sg13cmos5l_antennanp
XFILLER_10_432 VPWR VGND sg13cmos5l_fill_2
XFILLER_10_498 VPWR VGND sg13cmos5l_decap_4
XFILLER_8_0 VPWR VGND sg13cmos5l_decap_8
XANTENNA__2533__X S4BEG[2] VPWR VGND sg13cmos5l_antennanp
XFILLER_20_207 VPWR VGND sg13cmos5l_fill_1
X_0873_ _0892_/B _2877_/X _2878_/X _1588_/Q VPWR VGND sg13cmos5l_mux2_1
X_0942_ _0942_/Y _1747_/Q _2469_/A VPWR VGND sg13cmos5l_nor2_1
Xtest1 UserCLKo UserCLK VPWR VGND sg13cmos5l_buf_16
X_2612_ W2BEGb[5] W2MID[5] VPWR VGND sg13cmos5l_buf_1
X_1991_ _1991_/Q FrameData[12] VGND VPWR FrameStrobe[10] latch
X_1425_ _1425_/Q FrameData[22] VGND VPWR _1186_/X latch
X_2543_ S4BEG[12] _2543_/A VPWR VGND sg13cmos5l_buf_1
X_2474_ N2BEGb[3] N2MID[3] VPWR VGND sg13cmos5l_buf_1
XFILLER_55_137 VPWR VGND sg13cmos5l_fill_1
X_1287_ _1287_/Q FrameData[12] VGND VPWR _1197_/X latch
X_1356_ _1356_/Q FrameData[17] VGND VPWR _1183_/X latch
X_3026_ _3026_/X _3079_/X _2903_/X _0867_/X _0921_/Y _2042_/Q _2043_/Q VPWR VGND sg13cmos5l_mux4_1
XANTENNA__2443__X FrameStrobe_O[4] VPWR VGND sg13cmos5l_antennanp
XFILLER_3_439 VPWR VGND sg13cmos5l_fill_2
XANTENNA__2618__X W6BEG[3] VPWR VGND sg13cmos5l_antennanp
XFILLER_42_321 VPWR VGND sg13cmos5l_decap_4
XANTENNA__2528__X S2BEGb[5] VPWR VGND sg13cmos5l_antennanp
X_1072_ _1072_/Y _1235_/Q _2155_/Q VPWR VGND sg13cmos5l_nor2_1
X_1141_ _1141_/Y _1374_/Q _0886_/Y _1140_/Y VPWR VGND sg13cmos5l_o21ai_1
X_1210_ _1210_/Y _1942_/Q _1208_/A _1209_/Y VPWR VGND sg13cmos5l_a21oi_1
X_2190_ _2190_/Q FrameData[19] VGND VPWR FrameStrobe[4] latch
X_1974_ _1974_/Q FrameData[27] VGND VPWR _1044_/X latch
X_0787_ _0787_/Y _0787_/A _0787_/B VPWR VGND sg13cmos5l_nor2_1
X_0856_ _0856_/Y _2316_/Q _0881_/B _0855_/Y VPWR VGND sg13cmos5l_o21ai_1
X_0925_ _0925_/Y _2018_/Q _3019_/X VPWR VGND sg13cmos5l_nor2b_1
X_1408_ _1408_/Q FrameData[5] VGND VPWR _1186_/X latch
X_2526_ S2BEGb[3] S2MID[3] VPWR VGND sg13cmos5l_buf_1
X_2457_ FrameStrobe_O[18] FrameStrobe[18] VPWR VGND sg13cmos5l_buf_1
X_2388_ _2905_/A1 VPWR VGND sg13cmos5l_tielo
XANTENNA__2438__X E1BEG[3] VPWR VGND sg13cmos5l_antennanp
XFILLER_24_354 VPWR VGND sg13cmos5l_decap_4
X_1339_ _1339_/Q FrameData[0] VGND VPWR _1183_/X latch
X_3009_ _3009_/X S2END[1] S4END[1] W1END[1] _1237_/Q _2308_/Q _2309_/Q VPWR VGND sg13cmos5l_mux4_1
XFILLER_24_387 VPWR VGND sg13cmos5l_decap_8
XFILLER_10_41 VPWR VGND sg13cmos5l_fill_1
XFILLER_19_50 VPWR VGND sg13cmos5l_fill_1
X_0641_ _2596_/A _3285_/X _3286_/X _1696_/Q VPWR VGND sg13cmos5l_mux2_1
X_0710_ _0712_/B _2758_/X _1417_/Q VPWR VGND sg13cmos5l_nor2_1
X_1690_ _1690_/Q FrameData[31] VGND VPWR _1167_/X latch
X_0572_ _0572_/Y _2753_/X VPWR VGND sg13cmos5l_inv_1
X_3291_ _3291_/X E1END[3] S2MID[2] W6END[1] _0631_/X _1685_/Q _1686_/Q VPWR VGND sg13cmos5l_mux4_1
X_2311_ _2311_/Q FrameData[12] VGND VPWR FrameStrobe[0] latch
X_2242_ _2242_/Q FrameData[7] VGND VPWR FrameStrobe[2] latch
X_1055_ _1055_/Y _1240_/Q _2320_/Q VPWR VGND sg13cmos5l_nand2_1
X_1124_ _1248_/D _0568_/Y _1116_/Y _1117_/Y _1123_/Y VPWR VGND sg13cmos5l_a22oi_1
X_2173_ _2173_/Q FrameData[2] VGND VPWR FrameStrobe[4] latch
X_1957_ _1957_/Q FrameData[10] VGND VPWR _1044_/X latch
X_0839_ _0839_/Y _2326_/Q _0839_/B VPWR VGND sg13cmos5l_nor2_1
X_0908_ _0908_/Y _0570_/Y _1585_/Q _0907_/Y VPWR VGND sg13cmos5l_o21ai_1
X_2509_ NN4BEG[14] _2509_/A VPWR VGND sg13cmos5l_buf_1
X_1888_ _1888_/Q FrameData[5] VGND VPWR _1152_/X latch
XFILLER_24_162 VPWR VGND sg13cmos5l_fill_2
XANTENNA_80 WW4END[1] VPWR VGND sg13cmos5l_antennanp
XANTENNA_91 W1END[3] VPWR VGND sg13cmos5l_antennanp
XANTENNA__2631__X WW4BEG[4] VPWR VGND sg13cmos5l_antennanp
XFILLER_46_70 VPWR VGND sg13cmos5l_fill_1
XFILLER_30_143 VPWR VGND sg13cmos5l_decap_8
XFILLER_30_187 VPWR VGND sg13cmos5l_decap_4
X_1811_ _1811_/Q FrameData[24] VGND VPWR _1138_/X latch
X_2860_ _2860_/X _2924_/X _3036_/X _3136_/X _0656_/X _1957_/Q _1958_/Q VPWR VGND sg13cmos5l_mux4_1
X_2791_ _2791_/X _1467_/Q _1475_/Q _1468_/Q _1476_/Q _2806_/X _3208_/X VPWR VGND sg13cmos5l_mux4_1
XANTENNA__2541__X S4BEG[10] VPWR VGND sg13cmos5l_antennanp
X_0624_ _2404_/A _3321_/X _3322_/X _1642_/Q VPWR VGND sg13cmos5l_mux2_1
X_1673_ _1673_/Q FrameData[14] VGND VPWR _1167_/X latch
X_1742_ _1742_/Q FrameData[19] VGND VPWR _1177_/X latch
XFILLER_38_232 VPWR VGND sg13cmos5l_fill_1
X_3343_ _3343_/X E6END[1] W1END[3] _1245_/Q _3043_/X _1607_/Q _1608_/Q VPWR VGND sg13cmos5l_mux4_1
X_3274_ _3274_/X _2932_/X _0865_/X _2929_/X _0986_/Y _1712_/Q _1713_/Q VPWR VGND sg13cmos5l_mux4_1
X_2225_ _2225_/Q FrameData[22] VGND VPWR FrameStrobe[3] latch
XFILLER_19_490 VPWR VGND sg13cmos5l_fill_2
XFILLER_34_460 VPWR VGND sg13cmos5l_fill_2
XFILLER_38_276 VPWR VGND sg13cmos5l_fill_2
X_1038_ _2522_/A _1038_/A VPWR VGND sg13cmos5l_inv_1
X_1107_ _1107_/Y _3174_/X _1107_/B VPWR VGND sg13cmos5l_nand2b_1
X_2156_ _2156_/Q FrameData[17] VGND VPWR FrameStrobe[5] latch
X_2087_ _2087_/Q FrameData[12] VGND VPWR FrameStrobe[7] latch
XANTENNA__2451__X FrameStrobe_O[12] VPWR VGND sg13cmos5l_antennanp
X_2989_ _2989_/X N2END[4] NN4END[0] E2MID[2] S2MID[0] _2284_/Q _2285_/Q VPWR VGND
+ sg13cmos5l_mux4_1
XANTENNA__2626__X W6BEG[11] VPWR VGND sg13cmos5l_antennanp
XFILLER_29_265 VPWR VGND sg13cmos5l_fill_1
XFILLER_32_72 VPWR VGND sg13cmos5l_fill_1
XFILLER_4_342 VPWR VGND sg13cmos5l_fill_1
X_2010_ _2010_/Q FrameData[31] VGND VPWR FrameStrobe[10] latch
XANTENNA__2536__X S4BEG[5] VPWR VGND sg13cmos5l_antennanp
X_2912_ _2912_/X S4END[1] W2MID[5] WW4END[3] _1027_/Y _2293_/Q _2294_/Q VPWR VGND
+ sg13cmos5l_mux4_1
X_1725_ _1725_/Q FrameData[2] VGND VPWR _1177_/X latch
X_2843_ _2843_/X _3163_/X _0871_/X _3150_/X _0866_/X _1929_/Q _1930_/Q VPWR VGND sg13cmos5l_mux4_1
X_2774_ _2774_/X _3079_/X _2932_/X _0628_/X _2903_/X _1861_/Q _1862_/Q VPWR VGND sg13cmos5l_mux4_1
X_0607_ _2510_/A _3333_/X _3334_/X _1624_/Q VPWR VGND sg13cmos5l_mux2_1
X_1587_ _1587_/Q FrameData[24] VGND VPWR _1166_/X latch
X_1656_ _1656_/Q FrameData[29] VGND VPWR _1171_/X latch
X_3326_ _3326_/X _3050_/X _3150_/X _0859_/X _1061_/Y _1634_/Q _1635_/Q VPWR VGND sg13cmos5l_mux4_1
XANTENNA__2446__X FrameStrobe_O[7] VPWR VGND sg13cmos5l_antennanp
XFILLER_39_530 VPWR VGND sg13cmos5l_fill_2
X_3188_ _3188_/X _2932_/X _3050_/X _3093_/X _0627_/X _1917_/Q _1918_/Q VPWR VGND sg13cmos5l_mux4_1
X_3257_ _3257_/X _0929_/Y _0953_/Y _1750_/Q _0924_/Y _1751_/Q _1752_/Q VPWR VGND sg13cmos5l_mux4_1
X_2208_ _2208_/Q FrameData[5] VGND VPWR FrameStrobe[3] latch
X_2139_ _2139_/Q FrameData[0] VGND VPWR FrameStrobe[5] latch
XFILLER_41_227 VPWR VGND sg13cmos5l_decap_8
XFILLER_17_213 VPWR VGND sg13cmos5l_fill_2
X_1441_ _1441_/Q FrameData[6] VGND VPWR _1185_/X latch
X_1510_ _1510_/Q FrameData[11] VGND VPWR _1188_/X latch
X_2490_ N4BEG[11] N4END[15] VPWR VGND sg13cmos5l_buf_1
XFILLER_4_98 VPWR VGND sg13cmos5l_fill_1
X_1372_ _1372_/Q FrameData[1] VGND VPWR _1181_/X latch
X_3042_ _3042_/X W2END[6] _1249_/Q _1066_/Y _1208_/Y _2111_/Q _2112_/Q VPWR VGND sg13cmos5l_mux4_1
X_3111_ _3111_/X W2END[2] WW4END[0] _0906_/X _1208_/Y _2211_/Q _2212_/Q VPWR VGND
+ sg13cmos5l_mux4_1
XFILLER_23_216 VPWR VGND sg13cmos5l_decap_8
XFILLER_36_555 VPWR VGND sg13cmos5l_fill_2
X_1708_ _1708_/Q FrameData[17] VGND VPWR _1133_/X latch
X_2826_ _2826_/X _0630_/X _3006_/X _3059_/X _3087_/X _1933_/Q _1934_/Q VPWR VGND sg13cmos5l_mux4_1
X_2757_ _2757_/X _0864_/X _3127_/X _3122_/X _3010_/X _1833_/Q _1834_/Q VPWR VGND sg13cmos5l_mux4_1
X_2688_ _2688_/X _3117_/X _3159_/X _0867_/X _0865_/X _1765_/Q _1766_/Q VPWR VGND sg13cmos5l_mux4_1
X_1639_ _1639_/Q FrameData[12] VGND VPWR _1171_/X latch
X_3309_ _3309_/X E2END[6] S2END[2] W1END[2] _3136_/X _1658_/Q _1659_/Q VPWR VGND sg13cmos5l_mux4_1
XFILLER_39_382 VPWR VGND sg13cmos5l_decap_4
XFILLER_42_514 VPWR VGND sg13cmos5l_fill_1
XFILLER_10_400 VPWR VGND sg13cmos5l_fill_1
XFILLER_10_455 VPWR VGND sg13cmos5l_decap_8
XFILLER_37_319 VPWR VGND sg13cmos5l_fill_2
XFILLER_18_555 VPWR VGND sg13cmos5l_fill_2
XFILLER_45_341 VPWR VGND sg13cmos5l_fill_2
XFILLER_45_396 VPWR VGND sg13cmos5l_fill_2
X_0941_ _2428_/A _0941_/A VPWR VGND sg13cmos5l_inv_1
X_1990_ _1990_/Q FrameData[11] VGND VPWR FrameStrobe[10] latch
XFILLER_9_286 VPWR VGND sg13cmos5l_fill_1
X_0872_ _0872_/X _3080_/X _3081_/X _2221_/Q VPWR VGND sg13cmos5l_mux2_1
X_2611_ W2BEGb[4] W2MID[4] VPWR VGND sg13cmos5l_buf_1
X_2542_ S4BEG[11] S4END[15] VPWR VGND sg13cmos5l_buf_1
X_1355_ _1355_/Q FrameData[16] VGND VPWR _1183_/X latch
X_1424_ _1424_/Q FrameData[21] VGND VPWR _1186_/X latch
X_2473_ N2BEGb[2] N2MID[2] VPWR VGND sg13cmos5l_buf_1
XFILLER_51_322 VPWR VGND sg13cmos5l_fill_2
X_1286_ _1286_/Q FrameData[11] VGND VPWR _1197_/X latch
X_3025_ _3025_/X E2MID[7] SS4END[0] W2END[3] _0629_/X _2042_/Q _2043_/Q VPWR VGND
+ sg13cmos5l_mux4_1
X_2809_ _2809_/X _3112_/X _0870_/X _0868_/X _2917_/X _1889_/Q _1890_/Q VPWR VGND sg13cmos5l_mux4_1
XANTENNA__2634__X WW4BEG[7] VPWR VGND sg13cmos5l_antennanp
XFILLER_27_352 VPWR VGND sg13cmos5l_fill_2
XFILLER_42_355 VPWR VGND sg13cmos5l_decap_4
XFILLER_6_278 VPWR VGND sg13cmos5l_fill_1
X_1071_ _1244_/D _0567_/Y _1067_/Y _1068_/Y _1070_/Y VPWR VGND sg13cmos5l_a22oi_1
X_1140_ _1140_/Y _1374_/Q _0887_/B _3234_/X VPWR VGND sg13cmos5l_a21oi_1
XANTENNA__2544__X S4BEG[13] VPWR VGND sg13cmos5l_antennanp
XFILLER_21_517 VPWR VGND sg13cmos5l_decap_4
X_0924_ _0924_/Y _1750_/Q _0921_/A _0923_/Y VPWR VGND sg13cmos5l_a21oi_1
X_1973_ _1973_/Q FrameData[26] VGND VPWR _1044_/X latch
X_0786_ _0787_/B _1109_/A _1495_/Q _0782_/Y _0784_/Y _0836_/A VPWR VGND sg13cmos5l_a221oi_1
X_0855_ _0855_/Y _1236_/Q _2316_/Q VPWR VGND sg13cmos5l_nand2_1
X_2525_ S2BEGb[2] S2MID[2] VPWR VGND sg13cmos5l_buf_1
X_1338_ _1338_/Q FrameData[31] VGND VPWR _1184_/X latch
X_1407_ _1407_/Q FrameData[4] VGND VPWR _1186_/X latch
X_2456_ FrameStrobe_O[17] FrameStrobe[17] VPWR VGND sg13cmos5l_buf_1
X_2387_ _3069_/A1 VPWR VGND sg13cmos5l_tielo
XANTENNA__2454__X FrameStrobe_O[15] VPWR VGND sg13cmos5l_antennanp
XFILLER_24_333 VPWR VGND sg13cmos5l_decap_8
XFILLER_36_171 VPWR VGND sg13cmos5l_fill_1
X_1269_ _1269_/Q FrameData[26] VGND VPWR _1180_/X latch
X_3008_ _3008_/X E2MID[3] E2END[3] EE4END[1] S2MID[1] _2308_/Q _2309_/Q VPWR VGND
+ sg13cmos5l_mux4_1
XANTENNA__2629__X WW4BEG[2] VPWR VGND sg13cmos5l_antennanp
XFILLER_15_300 VPWR VGND sg13cmos5l_fill_1
Xclkbuf_0_Inst_LA_FLUT51PSDM_architecture.UserCLK clkbuf_0_Inst_LA_FLUT51PSDM_architecture.UserCLK/X
+ test/X VPWR VGND sg13cmos5l_buf_16
XFILLER_15_333 VPWR VGND sg13cmos5l_fill_1
XFILLER_15_355 VPWR VGND sg13cmos5l_decap_4
XFILLER_30_347 VPWR VGND sg13cmos5l_decap_4
X_0571_ _0571_/Y _2840_/X VPWR VGND sg13cmos5l_inv_1
X_0640_ _2597_/A _3283_/X _3284_/X _1699_/Q VPWR VGND sg13cmos5l_mux2_1
XANTENNA__2539__X S4BEG[8] VPWR VGND sg13cmos5l_antennanp
X_3290_ _3290_/X _3074_/X _3117_/X _0862_/X _1056_/Y _1688_/Q _1689_/Q VPWR VGND sg13cmos5l_mux4_1
X_2310_ _2310_/Q FrameData[11] VGND VPWR FrameStrobe[0] latch
X_2241_ _2241_/Q FrameData[6] VGND VPWR FrameStrobe[2] latch
X_2172_ _2172_/Q FrameData[1] VGND VPWR FrameStrobe[4] latch
XFILLER_18_160 VPWR VGND sg13cmos5l_fill_2
X_1054_ _1054_/X E2MID[6] S2MID[4] _2158_/Q VPWR VGND sg13cmos5l_mux2_1
X_1123_ _1123_/Y _1542_/Q _0794_/Y _1122_/Y VPWR VGND sg13cmos5l_o21ai_1
XFILLER_21_336 VPWR VGND sg13cmos5l_fill_1
X_0907_ _0907_/Y _2874_/X _1585_/Q VPWR VGND sg13cmos5l_nand2_1
X_1956_ _1956_/Q FrameData[9] VGND VPWR _1044_/X latch
X_1887_ _1887_/Q FrameData[4] VGND VPWR _1152_/X latch
X_0769_ _0769_/Y _0769_/A _0769_/B VPWR VGND sg13cmos5l_nor2_1
X_0838_ _0839_/B _1499_/Q _0836_/A _0837_/Y VPWR VGND sg13cmos5l_a21oi_1
X_2508_ NN4BEG[13] _2508_/A VPWR VGND sg13cmos5l_buf_1
XANTENNA__2449__X FrameStrobe_O[10] VPWR VGND sg13cmos5l_antennanp
X_2439_ FrameStrobe_O[0] FrameStrobe[0] VPWR VGND sg13cmos5l_buf_1
XANTENNA_70 W2MID[1] VPWR VGND sg13cmos5l_antennanp
XANTENNA_81 WW4END[1] VPWR VGND sg13cmos5l_antennanp
XANTENNA_92 W1END[3] VPWR VGND sg13cmos5l_antennanp
XFILLER_21_52 VPWR VGND sg13cmos5l_fill_2
XFILLER_15_196 VPWR VGND sg13cmos5l_fill_1
X_1741_ _1741_/Q FrameData[18] VGND VPWR _1177_/X latch
X_1810_ _1810_/Q FrameData[23] VGND VPWR _1138_/X latch
X_2790_ _2790_/X _1465_/Q _1473_/Q _1466_/Q _1474_/Q _2806_/X _3208_/X VPWR VGND sg13cmos5l_mux4_1
X_0623_ _2405_/A _3319_/X _3320_/X _1645_/Q VPWR VGND sg13cmos5l_mux2_1
X_1672_ _1672_/Q FrameData[13] VGND VPWR _1167_/X latch
X_3342_ _3342_/X _2903_/X _0870_/X _2899_/X _0840_/Y _1610_/Q _1611_/Q VPWR VGND sg13cmos5l_mux4_1
XFILLER_16_0 VPWR VGND sg13cmos5l_fill_2
XFILLER_26_417 VPWR VGND sg13cmos5l_fill_2
X_1106_ _1107_/B _0569_/Y _1582_/Q _1105_/Y VPWR VGND sg13cmos5l_a21oi_1
X_3273_ _3273_/X NN4END[0] S1END[0] _1065_/B _2924_/X _1712_/Q _1713_/Q VPWR VGND
+ sg13cmos5l_mux4_1
X_2224_ _2224_/Q FrameData[21] VGND VPWR FrameStrobe[3] latch
X_2155_ _2155_/Q FrameData[16] VGND VPWR FrameStrobe[5] latch
X_1037_ _1038_/A _2936_/X _2059_/Q _1036_/Y VPWR VGND sg13cmos5l_a21oi_1
X_2086_ _2086_/Q FrameData[11] VGND VPWR FrameStrobe[7] latch
X_2988_ _2988_/X _3050_/X _0628_/X _3150_/X _1061_/Y _1991_/Q _1992_/Q VPWR VGND sg13cmos5l_mux4_1
X_1939_ _1939_/Q FrameData[24] VGND VPWR _1137_/X latch
XFILLER_44_225 VPWR VGND sg13cmos5l_fill_1
XFILLER_57_542 VPWR VGND sg13cmos5l_fill_1
XANTENNA__2642__X WW4BEG[15] VPWR VGND sg13cmos5l_antennanp
XFILLER_12_166 VPWR VGND sg13cmos5l_fill_2
XFILLER_40_486 VPWR VGND sg13cmos5l_fill_1
XANTENNA__2552__X FrameData_O[5] VPWR VGND sg13cmos5l_antennanp
XFILLER_16_461 VPWR VGND sg13cmos5l_fill_2
X_2911_ _2911_/X N2END[5] E2MID[3] EE4END[1] S2MID[1] _2293_/Q _2294_/Q VPWR VGND
+ sg13cmos5l_mux4_1
X_1724_ _1724_/Q FrameData[1] VGND VPWR _1177_/X latch
X_2842_ _2842_/X _0653_/X _2910_/X _3144_/X _3139_/X _1929_/Q _1930_/Q VPWR VGND sg13cmos5l_mux4_1
X_2773_ _2773_/X _0629_/X _3043_/X _3136_/X _0655_/X _1861_/Q _1862_/Q VPWR VGND sg13cmos5l_mux4_1
X_0606_ _2435_/A _3331_/X _3332_/X _1627_/Q VPWR VGND sg13cmos5l_mux2_1
X_1586_ _1586_/Q FrameData[23] VGND VPWR _1166_/X latch
X_1655_ _1655_/Q FrameData[28] VGND VPWR _1171_/X latch
X_3256_ _3256_/X _3252_/X _3253_/X _3254_/X _3255_/X _1755_/Q _1756_/Q VPWR VGND sg13cmos5l_mux4_1
X_3325_ _3325_/X N2MID[0] S2END[4] _0797_/Y _0631_/X _1634_/Q _1635_/Q VPWR VGND sg13cmos5l_mux4_1
XFILLER_26_247 VPWR VGND sg13cmos5l_fill_1
XFILLER_41_206 VPWR VGND sg13cmos5l_decap_4
XFILLER_54_556 VPWR VGND sg13cmos5l_fill_1
X_3187_ _3187_/X _3006_/X _3036_/X _0657_/X _0655_/X _1917_/Q _1918_/Q VPWR VGND sg13cmos5l_mux4_1
X_2207_ _2207_/Q FrameData[4] VGND VPWR FrameStrobe[3] latch
X_2138_ _2138_/Q FrameData[31] VGND VPWR FrameStrobe[6] latch
X_2069_ _2069_/Q FrameData[26] VGND VPWR FrameStrobe[8] latch
XANTENNA__2462__X N1BEG[3] VPWR VGND sg13cmos5l_antennanp
XANTENNA__2637__X WW4BEG[10] VPWR VGND sg13cmos5l_antennanp
XFILLER_25_280 VPWR VGND sg13cmos5l_decap_8
XFILLER_13_453 VPWR VGND sg13cmos5l_fill_1
XFILLER_13_475 VPWR VGND sg13cmos5l_fill_1
XFILLER_13_497 VPWR VGND sg13cmos5l_fill_1
XFILLER_40_294 VPWR VGND sg13cmos5l_decap_8
X_1371_ _1371_/Q FrameData[0] VGND VPWR _1181_/X latch
X_1440_ _1440_/Q FrameData[5] VGND VPWR _1185_/X latch
X_3110_ _3110_/X S2MID[6] S2END[6] SS4END[2] W2MID[2] _2211_/Q _2212_/Q VPWR VGND
+ sg13cmos5l_mux4_1
XANTENNA__2547__X FrameData_O[0] VPWR VGND sg13cmos5l_antennanp
X_3041_ _3041_/X S2MID[2] S2END[2] S4END[2] W2MID[0] _2111_/Q _2112_/Q VPWR VGND sg13cmos5l_mux4_1
X_2825_ _2825_/X _1531_/Q _1532_/Q _1533_/Q _1534_/Q _3196_/X _3191_/X VPWR VGND sg13cmos5l_mux4_1
X_1638_ _1638_/Q FrameData[11] VGND VPWR _1171_/X latch
X_1707_ _1707_/Q FrameData[16] VGND VPWR _1133_/X latch
X_2756_ _2756_/X _0872_/X _0869_/X _3155_/X _0867_/X _1833_/Q _1834_/Q VPWR VGND sg13cmos5l_mux4_1
X_2687_ _2687_/X _3079_/X _3145_/X _3144_/X _0639_/X _1765_/Q _1766_/Q VPWR VGND sg13cmos5l_mux4_1
XANTENNA__2457__X FrameStrobe_O[18] VPWR VGND sg13cmos5l_antennanp
X_1569_ _1569_/Q FrameData[6] VGND VPWR _1166_/X latch
X_3239_ _3239_/X _3235_/X _3236_/X _3237_/X _3238_/X _1791_/Q _1792_/Q VPWR VGND sg13cmos5l_mux4_1
X_3308_ _3308_/X _3145_/X _3093_/X _0868_/X _1013_/Y _1661_/Q _1662_/Q VPWR VGND sg13cmos5l_mux4_1
XFILLER_54_386 VPWR VGND sg13cmos5l_fill_1
XFILLER_22_250 VPWR VGND sg13cmos5l_decap_4
XFILLER_18_512 VPWR VGND sg13cmos5l_decap_8
XFILLER_18_523 VPWR VGND sg13cmos5l_fill_1
XFILLER_33_504 VPWR VGND sg13cmos5l_fill_1
XFILLER_38_94 VPWR VGND sg13cmos5l_fill_1
XFILLER_45_364 VPWR VGND sg13cmos5l_decap_4
X_0940_ _0941_/A _3028_/X _2015_/Q _0939_/Y VPWR VGND sg13cmos5l_a21oi_1
XFILLER_5_471 VPWR VGND sg13cmos5l_decap_8
X_0871_ _0871_/X _2918_/X _2919_/X _2224_/Q VPWR VGND sg13cmos5l_mux2_1
X_2610_ W2BEGb[3] W2MID[3] VPWR VGND sg13cmos5l_buf_1
X_2541_ S4BEG[10] S4END[14] VPWR VGND sg13cmos5l_buf_1
X_2472_ N2BEGb[1] N2MID[1] VPWR VGND sg13cmos5l_buf_1
X_1285_ _1285_/Q FrameData[10] VGND VPWR _1197_/X latch
X_1354_ _1354_/Q FrameData[15] VGND VPWR _1183_/X latch
X_1423_ _1423_/Q FrameData[20] VGND VPWR _1186_/X latch
X_3024_ _3024_/X _0656_/X _3144_/X _2890_/X _0807_/B _2060_/Q _2061_/Q VPWR VGND sg13cmos5l_mux4_1
X_2808_ _2808_/X _3145_/X _2910_/X _3093_/X _0627_/X _1889_/Q _1890_/Q VPWR VGND sg13cmos5l_mux4_1
X_2739_ _2739_/X _0631_/X _0629_/X _0654_/X _3087_/X _1837_/Q _1838_/Q VPWR VGND sg13cmos5l_mux4_1
XFILLER_39_191 VPWR VGND sg13cmos5l_decap_8
XFILLER_40_73 VPWR VGND sg13cmos5l_fill_2
X_1070_ _1070_/Y _1458_/Q _0803_/B _1069_/Y VPWR VGND sg13cmos5l_o21ai_1
XANTENNA__2560__X FrameData_O[13] VPWR VGND sg13cmos5l_antennanp
X_0854_ _0854_/Y _0881_/B VPWR VGND sg13cmos5l_inv_1
X_0923_ _0923_/Y _1750_/Q _1226_/B VPWR VGND sg13cmos5l_nor2_1
X_1972_ _1972_/Q FrameData[25] VGND VPWR _1044_/X latch
XFILLER_46_0 VPWR VGND sg13cmos5l_fill_2
X_0785_ _0834_/B _1109_/A _1495_/Q _0782_/Y _0784_/Y VPWR VGND sg13cmos5l_a22oi_1
X_2524_ S2BEGb[1] S2MID[1] VPWR VGND sg13cmos5l_buf_1
X_2455_ FrameStrobe_O[16] FrameStrobe[16] VPWR VGND sg13cmos5l_buf_1
X_1268_ _1268_/Q FrameData[25] VGND VPWR _1180_/X latch
X_1337_ _1337_/Q FrameData[30] VGND VPWR _1184_/X latch
X_1406_ _1406_/Q FrameData[3] VGND VPWR _1186_/X latch
X_2386_ _2894_/A1 VPWR VGND sg13cmos5l_tielo
XFILLER_36_183 VPWR VGND sg13cmos5l_fill_2
X_1199_ _1200_/A _2969_/X _2041_/Q _1198_/Y VPWR VGND sg13cmos5l_a21oi_1
X_3007_ _3007_/X N1END[1] N2MID[5] N2END[5] NN4END[1] _2308_/Q _2309_/Q VPWR VGND
+ sg13cmos5l_mux4_1
XANTENNA__2470__X N2BEG[7] VPWR VGND sg13cmos5l_antennanp
XFILLER_27_183 VPWR VGND sg13cmos5l_fill_1
XFILLER_30_315 VPWR VGND sg13cmos5l_fill_1
XFILLER_30_326 VPWR VGND sg13cmos5l_decap_8
XFILLER_30_337 VPWR VGND sg13cmos5l_fill_2
X_0570_ _0570_/Y _2869_/X VPWR VGND sg13cmos5l_inv_1
X_1122_ _1122_/Y _1542_/Q _0795_/B _3186_/X VPWR VGND sg13cmos5l_a21oi_1
X_2240_ _2240_/Q FrameData[5] VGND VPWR FrameStrobe[2] latch
X_2171_ _2171_/Q FrameData[0] VGND VPWR FrameStrobe[4] latch
XANTENNA__2555__X FrameData_O[8] VPWR VGND sg13cmos5l_antennanp
XFILLER_18_194 VPWR VGND sg13cmos5l_fill_1
X_1053_ _1053_/X N2MID[0] N4END[0] _2158_/Q VPWR VGND sg13cmos5l_mux2_1
X_0837_ _0837_/Y _1499_/Q _0837_/B VPWR VGND sg13cmos5l_nor2_1
X_0906_ _0906_/X _0897_/Y _0898_/Y _0905_/Y VPWR VGND sg13cmos5l_a21o_1
X_1955_ _1955_/Q FrameData[8] VGND VPWR _1044_/X latch
X_1886_ _1886_/Q FrameData[3] VGND VPWR _1152_/X latch
X_0699_ _1009_/B _2763_/X _2787_/X _1459_/Q _0699_/D VPWR VGND sg13cmos5l_nor4_1
X_0768_ _0769_/B _1089_/A _1369_/Q _0763_/Y _0765_/Y _0887_/B VPWR VGND sg13cmos5l_a221oi_1
X_2507_ NN4BEG[12] _2507_/A VPWR VGND sg13cmos5l_buf_1
X_2438_ E1BEG[3] _2438_/A VPWR VGND sg13cmos5l_buf_1
XANTENNA__2465__X N2BEG[2] VPWR VGND sg13cmos5l_antennanp
XFILLER_56_245 VPWR VGND sg13cmos5l_fill_2
XFILLER_56_289 VPWR VGND sg13cmos5l_fill_2
X_2369_ _3102_/A1 VPWR VGND sg13cmos5l_tielo
XANTENNA_60 W2END[1] VPWR VGND sg13cmos5l_antennanp
XANTENNA_71 W2MID[1] VPWR VGND sg13cmos5l_antennanp
XANTENNA_82 WW4END[1] VPWR VGND sg13cmos5l_antennanp
XANTENNA_93 W1END[3] VPWR VGND sg13cmos5l_antennanp
XFILLER_46_61 VPWR VGND sg13cmos5l_fill_2
X_1671_ _1671_/Q FrameData[12] VGND VPWR _1167_/X latch
X_1740_ _1740_/Q FrameData[17] VGND VPWR _1177_/X latch
XFILLER_7_385 VPWR VGND sg13cmos5l_decap_4
X_0622_ _2406_/A _3317_/X _3318_/X _1648_/Q VPWR VGND sg13cmos5l_mux2_1
X_3341_ _3341_/X E6END[0] W1END[0] _1241_/Q _0657_/X _1610_/Q _1611_/Q VPWR VGND sg13cmos5l_mux4_1
X_3272_ _3272_/X _2910_/X _0627_/X _2917_/X _0807_/B _1715_/Q _1716_/Q VPWR VGND sg13cmos5l_mux4_1
XFILLER_53_248 VPWR VGND sg13cmos5l_fill_1
X_1105_ _1105_/Y _2850_/X _1582_/Q VPWR VGND sg13cmos5l_nor2_1
X_2223_ _2223_/Q FrameData[20] VGND VPWR FrameStrobe[3] latch
X_2154_ _2154_/Q FrameData[15] VGND VPWR FrameStrobe[5] latch
X_2085_ _2085_/Q FrameData[10] VGND VPWR FrameStrobe[7] latch
XFILLER_21_156 VPWR VGND sg13cmos5l_fill_1
X_1036_ _1036_/Y _2059_/Q _2935_/X VPWR VGND sg13cmos5l_nor2b_1
X_2987_ _2987_/X E2END[3] W2MID[7] _1010_/Y _0631_/X _1991_/Q _1992_/Q VPWR VGND sg13cmos5l_mux4_1
X_1938_ _1938_/Q FrameData[23] VGND VPWR _1137_/X latch
X_1869_ _1869_/Q FrameData[18] VGND VPWR _1157_/X latch
XFILLER_29_223 VPWR VGND sg13cmos5l_decap_4
XFILLER_12_134 VPWR VGND sg13cmos5l_fill_1
XFILLER_32_96 VPWR VGND sg13cmos5l_fill_1
XFILLER_35_237 VPWR VGND sg13cmos5l_fill_1
XFILLER_31_487 VPWR VGND sg13cmos5l_fill_1
X_2910_ _2910_/X _2906_/X _2907_/X _2908_/X _2909_/X _2173_/Q _2174_/Q VPWR VGND sg13cmos5l_mux4_1
X_2841_ _2841_/X _3006_/X _3036_/X _0657_/X _3059_/X _1929_/Q _1930_/Q VPWR VGND sg13cmos5l_mux4_1
X_1654_ _1654_/Q FrameData[27] VGND VPWR _1171_/X latch
X_1723_ _1723_/Q FrameData[0] VGND VPWR _1177_/X latch
X_2772_ _2772_/X _2768_/X _2769_/X _2770_/X _2771_/X _1871_/Q _1872_/Q VPWR VGND sg13cmos5l_mux4_1
XFILLER_39_521 VPWR VGND sg13cmos5l_fill_1
X_0605_ _2436_/A _3329_/X _3330_/X _1630_/Q VPWR VGND sg13cmos5l_mux2_1
X_1585_ _1585_/Q FrameData[22] VGND VPWR _1166_/X latch
X_3255_ _3255_/X _3170_/X _0862_/X _2885_/X _0857_/X _1753_/Q _1754_/Q VPWR VGND sg13cmos5l_mux4_1
X_3324_ _3324_/X _3001_/X _0639_/X _0863_/X _0833_/Y _1637_/Q _1638_/Q VPWR VGND sg13cmos5l_mux4_1
X_2206_ _2206_/Q FrameData[3] VGND VPWR FrameStrobe[3] latch
X_1019_ _1019_/Y _1875_/Q _2465_/A VPWR VGND sg13cmos5l_nor2_1
X_3186_ _3186_/X _1196_/Y _1213_/X _1939_/Q _1215_/Y _1940_/Q _1941_/Q VPWR VGND sg13cmos5l_mux4_1
X_2137_ _2137_/Q FrameData[30] VGND VPWR FrameStrobe[6] latch
X_2068_ _2068_/Q FrameData[25] VGND VPWR FrameStrobe[8] latch
XFILLER_4_152 VPWR VGND sg13cmos5l_fill_1
XFILLER_4_174 VPWR VGND sg13cmos5l_fill_1
X_1370_ _1370_/Q FrameData[31] VGND VPWR _1183_/X latch
XANTENNA__2563__X FrameData_O[16] VPWR VGND sg13cmos5l_antennanp
XFILLER_48_362 VPWR VGND sg13cmos5l_fill_1
XFILLER_48_384 VPWR VGND sg13cmos5l_fill_2
X_3040_ _3040_/X E1END[0] E2MID[4] E2END[4] EE4END[2] _2111_/Q _2112_/Q VPWR VGND
+ sg13cmos5l_mux4_1
X_2824_ _2824_/X _1527_/Q _1528_/Q _1529_/Q _1530_/Q _3196_/X _3191_/X VPWR VGND sg13cmos5l_mux4_1
X_1637_ _1637_/Q FrameData[10] VGND VPWR _1171_/X latch
X_1706_ _1706_/Q FrameData[15] VGND VPWR _1133_/X latch
X_2755_ _2755_/X _3145_/X _3050_/X _0628_/X _2903_/X _1833_/Q _1834_/Q VPWR VGND sg13cmos5l_mux4_1
X_2686_ _2686_/X _0629_/X _3043_/X _0654_/X _3087_/X _1765_/Q _1766_/Q VPWR VGND sg13cmos5l_mux4_1
X_1499_ _1499_/Q FrameData[0] VGND VPWR _1188_/X latch
X_1568_ _1568_/Q FrameData[5] VGND VPWR _1166_/X latch
X_3169_ _3169_/X W2MID[4] W2END[4] WW4END[2] _0848_/Y _2265_/Q _2266_/Q VPWR VGND
+ sg13cmos5l_mux4_1
X_3238_ _3238_/X _0863_/X _3127_/X _2929_/X _0857_/X _1789_/Q _1790_/Q VPWR VGND sg13cmos5l_mux4_1
X_3307_ _3307_/X E2MID[7] W2END[3] _0971_/Y _3006_/X _1661_/Q _1662_/Q VPWR VGND sg13cmos5l_mux4_1
XANTENNA__2473__X N2BEGb[2] VPWR VGND sg13cmos5l_antennanp
XFILLER_54_398 VPWR VGND sg13cmos5l_fill_2
XFILLER_13_87 VPWR VGND sg13cmos5l_fill_2
X_0870_ _0870_/X _3013_/X _3014_/X _2227_/Q VPWR VGND sg13cmos5l_mux2_1
X_1422_ _1422_/Q FrameData[19] VGND VPWR _1186_/X latch
X_2540_ S4BEG[9] S4END[13] VPWR VGND sg13cmos5l_buf_1
X_2471_ N2BEGb[0] N2MID[0] VPWR VGND sg13cmos5l_buf_1
XANTENNA__2558__X FrameData_O[11] VPWR VGND sg13cmos5l_antennanp
XFILLER_48_170 VPWR VGND sg13cmos5l_fill_1
X_1284_ _1284_/Q FrameData[9] VGND VPWR _1197_/X latch
X_1353_ _1353_/Q FrameData[14] VGND VPWR _1183_/X latch
X_3023_ _3023_/X N1END[1] S2END[5] W2END[1] _0658_/X _2060_/Q _2061_/Q VPWR VGND sg13cmos5l_mux4_1
XFILLER_51_313 VPWR VGND sg13cmos5l_fill_2
X_0999_ _1000_/A _2940_/X _2031_/Q _0998_/Y VPWR VGND sg13cmos5l_a21oi_1
X_2807_ _2807_/X _0630_/X _0658_/X _0657_/X _0655_/X _1889_/Q _1890_/Q VPWR VGND sg13cmos5l_mux4_1
X_2738_ _2738_/X _1405_/Q _1406_/Q _1407_/Q _1408_/Q _3232_/X _3227_/X VPWR VGND sg13cmos5l_mux4_1
XANTENNA__2468__X N2BEG[5] VPWR VGND sg13cmos5l_antennanp
X_2669_ _2669_/X _3117_/X _0872_/X _3155_/X _0867_/X _1737_/Q _1738_/Q VPWR VGND sg13cmos5l_mux4_1
XFILLER_6_0 VPWR VGND sg13cmos5l_decap_8
XFILLER_18_310 VPWR VGND sg13cmos5l_fill_2
XFILLER_2_486 VPWR VGND sg13cmos5l_decap_8
XFILLER_2_497 VPWR VGND sg13cmos5l_fill_2
XFILLER_18_365 VPWR VGND sg13cmos5l_fill_1
XFILLER_18_376 VPWR VGND sg13cmos5l_decap_4
XFILLER_45_195 VPWR VGND sg13cmos5l_fill_2
X_0853_ _0881_/B _1289_/Q _0851_/A _0852_/Y VPWR VGND sg13cmos5l_a21oi_1
X_0922_ _1226_/B _3021_/X _3022_/X _2090_/Q VPWR VGND sg13cmos5l_mux2_1
X_1971_ _1971_/Q FrameData[24] VGND VPWR _1044_/X latch
XFILLER_39_0 VPWR VGND sg13cmos5l_fill_1
X_0784_ _0784_/Y _1495_/Q _0783_/Y VPWR VGND sg13cmos5l_nor2b_1
X_1405_ _1405_/Q FrameData[2] VGND VPWR _1186_/X latch
X_2523_ S2BEGb[0] S2MID[0] VPWR VGND sg13cmos5l_buf_1
X_2454_ FrameStrobe_O[15] FrameStrobe[15] VPWR VGND sg13cmos5l_buf_1
X_2385_ _3138_/A1 VPWR VGND sg13cmos5l_tielo
X_1198_ _1198_/Y _2041_/Q _2968_/X VPWR VGND sg13cmos5l_nor2b_1
X_1267_ _1267_/Q FrameData[24] VGND VPWR _1180_/X latch
X_1336_ _1336_/Q FrameData[29] VGND VPWR _1184_/X latch
X_3006_ _3006_/X _3002_/X _3003_/X _3004_/X _3005_/X _2109_/Q _2110_/Q VPWR VGND sg13cmos5l_mux4_1
XFILLER_19_42 VPWR VGND sg13cmos5l_fill_1
XFILLER_42_176 VPWR VGND sg13cmos5l_decap_4
XFILLER_42_187 VPWR VGND sg13cmos5l_decap_8
XFILLER_7_556 VPWR VGND sg13cmos5l_fill_1
XFILLER_2_261 VPWR VGND sg13cmos5l_fill_1
X_1052_ _1052_/Y _1051_/B _1050_/Y _1051_/Y VPWR VGND sg13cmos5l_a21oi_1
X_1121_ _1247_/D _0591_/Y _1116_/Y _1117_/Y _1120_/X VPWR VGND sg13cmos5l_a22oi_1
X_2170_ _2170_/Q FrameData[31] VGND VPWR FrameStrobe[5] latch
XANTENNA__2571__X FrameData_O[24] VPWR VGND sg13cmos5l_antennanp
XFILLER_33_132 VPWR VGND sg13cmos5l_fill_2
XFILLER_33_198 VPWR VGND sg13cmos5l_decap_4
X_1954_ _1954_/Q FrameData[7] VGND VPWR _1044_/X latch
X_0767_ _0767_/Y _2714_/X _1369_/Q _0766_/Y VPWR VGND sg13cmos5l_a21oi_1
X_0836_ _0837_/B _0836_/A _0836_/B VPWR VGND sg13cmos5l_xnor2_1
X_0905_ _0905_/Y _2875_/X _0896_/X _0904_/Y VPWR VGND sg13cmos5l_a21oi_1
X_1885_ _1885_/Q FrameData[2] VGND VPWR _1152_/X latch
X_0698_ _0700_/B _2787_/X _1459_/Q VPWR VGND sg13cmos5l_nor2_1
X_2506_ NN4BEG[11] NN4END[15] VPWR VGND sg13cmos5l_buf_1
X_2437_ E1BEG[2] _2437_/A VPWR VGND sg13cmos5l_buf_1
X_2368_ _2368_/L_HI VPWR VGND sg13cmos5l_tiehi
X_1319_ _1319_/Q FrameData[12] VGND VPWR _1184_/X latch
X_2299_ _2299_/Q FrameData[0] VGND VPWR FrameStrobe[0] latch
XANTENNA_50 W2END[1] VPWR VGND sg13cmos5l_antennanp
XANTENNA_61 W2END[2] VPWR VGND sg13cmos5l_antennanp
XANTENNA_72 W2MID[1] VPWR VGND sg13cmos5l_antennanp
XANTENNA_83 WW4END[1] VPWR VGND sg13cmos5l_antennanp
XANTENNA__2481__X N4BEG[2] VPWR VGND sg13cmos5l_antennanp
XFILLER_20_382 VPWR VGND sg13cmos5l_fill_1
XANTENNA_94 W1END[3] VPWR VGND sg13cmos5l_antennanp
XFILLER_4_504 VPWR VGND sg13cmos5l_decap_8
XFILLER_47_257 VPWR VGND sg13cmos5l_decap_8
XANTENNA__2391__X EE4BEG[0] VPWR VGND sg13cmos5l_antennanp
XFILLER_30_135 VPWR VGND sg13cmos5l_fill_1
X_0621_ _2417_/A _3315_/X _3316_/X _1651_/Q VPWR VGND sg13cmos5l_mux2_1
X_1670_ _1670_/Q FrameData[11] VGND VPWR _1167_/X latch
X_3340_ _3340_/X _3112_/X _3155_/X _0857_/X _0921_/Y _1613_/Q _1614_/Q VPWR VGND sg13cmos5l_mux4_1
X_3271_ _3271_/X N4END[1] SS4END[1] WW4END[3] _0630_/X _1715_/Q _1716_/Q VPWR VGND
+ sg13cmos5l_mux4_1
X_2222_ _2222_/Q FrameData[19] VGND VPWR FrameStrobe[3] latch
XANTENNA__2566__X FrameData_O[19] VPWR VGND sg13cmos5l_antennanp
XFILLER_19_482 VPWR VGND sg13cmos5l_fill_1
X_1035_ _1035_/Y _1843_/Q _1130_/C _1034_/Y VPWR VGND sg13cmos5l_a21oi_1
X_1104_ _1104_/Y _3174_/X _1586_/Q _1103_/Y VPWR VGND sg13cmos5l_a21oi_1
X_2153_ _2153_/Q FrameData[14] VGND VPWR FrameStrobe[5] latch
X_2084_ _2084_/Q FrameData[9] VGND VPWR FrameStrobe[7] latch
XFILLER_21_113 VPWR VGND sg13cmos5l_fill_1
X_2986_ _2986_/X _0639_/X _3159_/X _0863_/X _1013_/Y _2069_/Q _2070_/Q VPWR VGND sg13cmos5l_mux4_1
X_1937_ _1937_/Q FrameData[22] VGND VPWR _1137_/X latch
XFILLER_1_518 VPWR VGND sg13cmos5l_fill_2
X_0819_ _0820_/A _0811_/B _1216_/A _0811_/Y VPWR VGND sg13cmos5l_a21oi_1
X_1799_ _1799_/Q FrameData[12] VGND VPWR _1138_/X latch
X_1868_ _1868_/Q FrameData[17] VGND VPWR _1157_/X latch
XANTENNA__2476__X N2BEGb[5] VPWR VGND sg13cmos5l_antennanp
XFILLER_16_54 VPWR VGND sg13cmos5l_fill_1
XFILLER_12_168 VPWR VGND sg13cmos5l_fill_1
XFILLER_16_463 VPWR VGND sg13cmos5l_fill_1
XFILLER_31_466 VPWR VGND sg13cmos5l_decap_8
X_2840_ _2840_/X _2836_/X _2837_/X _2838_/X _2839_/X _1923_/Q _1924_/Q VPWR VGND sg13cmos5l_mux4_1
X_2771_ _2771_/X _2899_/X _0861_/X _0858_/X _3010_/X _1869_/Q _1870_/Q VPWR VGND sg13cmos5l_mux4_1
X_0604_ _2437_/A _3327_/X _3328_/X _1633_/Q VPWR VGND sg13cmos5l_mux2_1
X_1584_ _1584_/Q FrameData[21] VGND VPWR _1166_/X latch
X_1653_ _1653_/Q FrameData[26] VGND VPWR _1171_/X latch
X_1722_ _1722_/Q FrameData[31] VGND VPWR _1133_/X latch
XFILLER_21_0 VPWR VGND sg13cmos5l_fill_2
X_3185_ _3185_/X _1212_/Y _1203_/Y _1942_/Q _1210_/Y _1943_/Q _1944_/Q VPWR VGND sg13cmos5l_mux4_1
X_3254_ _3254_/X _3159_/X _0870_/X _3155_/X _3150_/X _1753_/Q _1754_/Q VPWR VGND sg13cmos5l_mux4_1
X_3323_ _3323_/X NN4END[1] E2MID[3] S4END[1] _3036_/X _1637_/Q _1638_/Q VPWR VGND
+ sg13cmos5l_mux4_1
X_2205_ _2205_/Q FrameData[2] VGND VPWR FrameStrobe[3] latch
X_1018_ _2432_/A _1018_/A VPWR VGND sg13cmos5l_inv_1
X_2136_ _2136_/Q FrameData[29] VGND VPWR FrameStrobe[6] latch
X_2067_ _2067_/Q FrameData[24] VGND VPWR FrameStrobe[8] latch
X_2969_ _2969_/X _0653_/X _3112_/X _0857_/X _0840_/Y _2039_/Q _2040_/Q VPWR VGND sg13cmos5l_mux4_1
XFILLER_13_422 VPWR VGND sg13cmos5l_fill_1
XFILLER_40_252 VPWR VGND sg13cmos5l_fill_1
XFILLER_40_263 VPWR VGND sg13cmos5l_fill_2
XFILLER_43_52 VPWR VGND sg13cmos5l_fill_2
XFILLER_9_459 VPWR VGND sg13cmos5l_fill_2
X_1705_ _1705_/Q FrameData[14] VGND VPWR _1133_/X latch
X_2823_ _2823_/X _1523_/Q _1524_/Q _1525_/Q _1526_/Q _3196_/X _3191_/X VPWR VGND sg13cmos5l_mux4_1
X_2754_ _2754_/X _2924_/X _3043_/X _0657_/X _0655_/X _1833_/Q _1834_/Q VPWR VGND sg13cmos5l_mux4_1
X_1567_ _1567_/Q FrameData[4] VGND VPWR _1166_/X latch
X_1636_ _1636_/Q FrameData[9] VGND VPWR _1171_/X latch
Xclkbuf_2_0__f_Inst_LA_FLUT51PSDM_architecture.UserCLK _1246_/CLK clkbuf_0_Inst_LA_FLUT51PSDM_architecture.UserCLK/X
+ VPWR VGND sg13cmos5l_buf_16
X_3306_ _3306_/X _0627_/X _0871_/X _3127_/X _0808_/B _1664_/Q _1665_/Q VPWR VGND sg13cmos5l_mux4_1
X_2685_ _2685_/X _2681_/X _2682_/X _2683_/X _2684_/X _1775_/Q _1776_/Q VPWR VGND sg13cmos5l_mux4_1
XFILLER_39_330 VPWR VGND sg13cmos5l_fill_2
XFILLER_54_300 VPWR VGND sg13cmos5l_fill_1
X_1498_ _1498_/Q FrameData[31] VGND VPWR _1182_/X latch
X_3168_ _3168_/X S2END[0] S2END[4] S4END[0] W1END[0] _2265_/Q _2266_/Q VPWR VGND sg13cmos5l_mux4_1
X_3237_ _3237_/X _3112_/X _0870_/X _0868_/X _2917_/X _1789_/Q _1790_/Q VPWR VGND sg13cmos5l_mux4_1
X_2119_ _2119_/Q FrameData[12] VGND VPWR FrameStrobe[6] latch
XFILLER_22_263 VPWR VGND sg13cmos5l_fill_1
XFILLER_22_285 VPWR VGND sg13cmos5l_fill_2
X_3099_ _3099_/X _0832_/B _0899_/B _0921_/Y _1027_/Y _2151_/Q _2152_/Q VPWR VGND sg13cmos5l_mux4_1
XFILLER_10_469 VPWR VGND sg13cmos5l_decap_4
XFILLER_54_84 VPWR VGND sg13cmos5l_fill_2
X_1421_ _1421_/Q FrameData[18] VGND VPWR _1186_/X latch
X_2470_ N2BEG[7] _2967_/X VPWR VGND sg13cmos5l_buf_1
XANTENNA__2574__X FrameData_O[27] VPWR VGND sg13cmos5l_antennanp
X_1283_ _1283_/Q FrameData[8] VGND VPWR _1197_/X latch
X_1352_ _1352_/Q FrameData[13] VGND VPWR _1183_/X latch
X_3022_ _3022_/X S2MID[5] S4END[0] W2MID[7] WW4END[0] _2088_/Q _2089_/Q VPWR VGND
+ sg13cmos5l_mux4_1
X_0998_ _0998_/Y _2031_/Q _2939_/X VPWR VGND sg13cmos5l_nor2b_1
X_2806_ _2806_/X _2802_/X _2803_/X _2804_/X _2805_/X _1895_/Q _1896_/Q VPWR VGND sg13cmos5l_mux4_1
X_2737_ _2737_/X _1401_/Q _1402_/Q _1403_/Q _1404_/Q _3232_/X _3227_/X VPWR VGND sg13cmos5l_mux4_1
X_2668_ _2668_/X _0653_/X _3050_/X _3144_/X _0639_/X _1737_/Q _1738_/Q VPWR VGND sg13cmos5l_mux4_1
X_1619_ _1619_/Q FrameData[24] VGND VPWR _1189_/X latch
X_2599_ W2BEG[0] _2599_/A VPWR VGND sg13cmos5l_buf_1
XANTENNA__2484__X N4BEG[5] VPWR VGND sg13cmos5l_antennanp
XFILLER_42_325 VPWR VGND sg13cmos5l_fill_2
XFILLER_10_255 VPWR VGND sg13cmos5l_fill_2
XFILLER_40_42 VPWR VGND sg13cmos5l_fill_1
XANTENNA__2394__X EE4BEG[3] VPWR VGND sg13cmos5l_antennanp
XFILLER_21_509 VPWR VGND sg13cmos5l_fill_2
X_0921_ _0921_/Y _0921_/A VPWR VGND sg13cmos5l_inv_1
X_1970_ _1970_/Q FrameData[23] VGND VPWR _1044_/X latch
X_0783_ _0783_/Y _1906_/Q _2468_/A _1905_/Q VPWR VGND sg13cmos5l_o21ai_1
X_0852_ _0852_/Y _1289_/Q _0852_/B VPWR VGND sg13cmos5l_nor2_1
X_2522_ S2BEG[7] _2522_/A VPWR VGND sg13cmos5l_buf_1
XANTENNA__2569__X FrameData_O[22] VPWR VGND sg13cmos5l_antennanp
X_1335_ _1335_/Q FrameData[28] VGND VPWR _1184_/X latch
X_1404_ _1404_/Q FrameData[1] VGND VPWR _1186_/X latch
X_2453_ FrameStrobe_O[14] FrameStrobe[14] VPWR VGND sg13cmos5l_buf_1
X_2384_ _3052_/A1 VPWR VGND sg13cmos5l_tielo
XFILLER_24_303 VPWR VGND sg13cmos5l_fill_2
XFILLER_24_325 VPWR VGND sg13cmos5l_fill_2
X_1197_ _1197_/X FrameStrobe[14] FrameStrobe[15] VPWR VGND sg13cmos5l_and2_1
X_1266_ _1266_/Q FrameData[23] VGND VPWR _1180_/X latch
X_3005_ _3005_/X W2MID[6] W2END[6] _1056_/Y _0808_/B _2107_/Q _2108_/Q VPWR VGND sg13cmos5l_mux4_1
XFILLER_20_553 VPWR VGND sg13cmos5l_decap_4
XFILLER_24_347 VPWR VGND sg13cmos5l_decap_8
XFILLER_24_358 VPWR VGND sg13cmos5l_fill_2
XANTENNA__2479__X N4BEG[0] VPWR VGND sg13cmos5l_antennanp
XFILLER_10_45 VPWR VGND sg13cmos5l_fill_1
XFILLER_10_78 VPWR VGND sg13cmos5l_fill_2
XFILLER_35_86 VPWR VGND sg13cmos5l_fill_2
XFILLER_30_339 VPWR VGND sg13cmos5l_fill_1
X_1051_ _1051_/Y _2184_/Q _1051_/B _1051_/C VPWR VGND sg13cmos5l_nor3_1
X_1120_ _1120_/X _3186_/X _1120_/B VPWR VGND sg13cmos5l_or2_1
X_0904_ _0904_/Y _2875_/X _0903_/Y _1588_/Q VPWR VGND sg13cmos5l_o21ai_1
X_1953_ _1953_/Q FrameData[6] VGND VPWR _1044_/X latch
X_1884_ _1884_/Q FrameData[1] VGND VPWR _1152_/X latch
X_0697_ _0699_/D _0692_/Y _0693_/X _0696_/Y VPWR VGND sg13cmos5l_a21oi_1
X_0766_ _0766_/Y _0763_/Y _0764_/Y _1369_/Q VPWR VGND sg13cmos5l_a21oi_1
X_0835_ _0836_/B _1109_/A _1496_/Q _0834_/Y VPWR VGND sg13cmos5l_a21oi_1
X_2505_ NN4BEG[10] NN4END[14] VPWR VGND sg13cmos5l_buf_1
X_1318_ _1318_/Q FrameData[11] VGND VPWR _1184_/X latch
X_2436_ E1BEG[1] _2436_/A VPWR VGND sg13cmos5l_buf_1
X_2367_ _2367_/L_HI VPWR VGND sg13cmos5l_tiehi
X_2298_ _2298_/Q FrameData[31] VGND VPWR FrameStrobe[1] latch
XFILLER_37_483 VPWR VGND sg13cmos5l_fill_2
X_1249_ _1249_/Q _1250_/CLK _1249_/D _2362_/L_HI VPWR VGND sg13cmos5l_dfrbpq_1
XANTENNA_40 S2END[6] VPWR VGND sg13cmos5l_antennanp
XANTENNA_51 W2END[1] VPWR VGND sg13cmos5l_antennanp
XANTENNA_62 W2END[2] VPWR VGND sg13cmos5l_antennanp
XANTENNA_73 W2MID[1] VPWR VGND sg13cmos5l_antennanp
XANTENNA_84 S2MID[3] VPWR VGND sg13cmos5l_antennanp
XANTENNA_95 FrameStrobe[2] VPWR VGND sg13cmos5l_antennanp
XFILLER_46_30 VPWR VGND sg13cmos5l_fill_2
XFILLER_47_225 VPWR VGND sg13cmos5l_decap_4
XFILLER_11_350 VPWR VGND sg13cmos5l_fill_2
XFILLER_15_166 VPWR VGND sg13cmos5l_fill_2
X_0620_ _2418_/A _3313_/X _3314_/X _1654_/Q VPWR VGND sg13cmos5l_mux2_1
X_3270_ _3270_/X _3093_/X _3163_/X _0861_/X _1223_/Y _1718_/Q _1719_/Q VPWR VGND sg13cmos5l_mux4_1
X_2221_ _2221_/Q FrameData[18] VGND VPWR FrameStrobe[3] latch
X_2152_ _2152_/Q FrameData[13] VGND VPWR FrameStrobe[5] latch
XANTENNA__2582__X SS4BEG[3] VPWR VGND sg13cmos5l_antennanp
XFILLER_34_431 VPWR VGND sg13cmos5l_fill_1
X_1034_ _1034_/Y _1843_/Q _1224_/B VPWR VGND sg13cmos5l_nor2_1
X_1103_ _1103_/Y _3174_/X _3173_/X VPWR VGND sg13cmos5l_nor2_1
X_2083_ _2083_/Q FrameData[8] VGND VPWR FrameStrobe[7] latch
X_2985_ _2985_/X N2END[4] S2MID[0] _0832_/B _3001_/X _2069_/Q _2070_/Q VPWR VGND sg13cmos5l_mux4_1
X_1936_ _1936_/Q FrameData[21] VGND VPWR _1137_/X latch
X_1867_ _1867_/Q FrameData[16] VGND VPWR _1157_/X latch
X_0749_ _0755_/B _0749_/A _0749_/B _0749_/C VPWR VGND sg13cmos5l_nor3_1
X_0818_ _1216_/A _0813_/Y _0814_/X _0817_/Y VPWR VGND sg13cmos5l_a21oi_1
X_1798_ _1798_/Q FrameData[11] VGND VPWR _1138_/X latch
XFILLER_29_236 VPWR VGND sg13cmos5l_decap_4
X_2419_ E2BEGb[0] E2MID[0] VPWR VGND sg13cmos5l_buf_1
XANTENNA__2492__X N4BEG[13] VPWR VGND sg13cmos5l_antennanp
XFILLER_25_431 VPWR VGND sg13cmos5l_decap_4
XFILLER_52_283 VPWR VGND sg13cmos5l_fill_1
XFILLER_32_32 VPWR VGND sg13cmos5l_fill_2
XFILLER_32_87 VPWR VGND sg13cmos5l_fill_2
X_1721_ _1721_/Q FrameData[30] VGND VPWR _1133_/X latch
X_2770_ _2770_/X _3163_/X _3159_/X _3150_/X _0865_/X _1869_/Q _1870_/Q VPWR VGND sg13cmos5l_mux4_1
XFILLER_7_151 VPWR VGND sg13cmos5l_fill_1
XFILLER_7_184 VPWR VGND sg13cmos5l_fill_2
X_0603_ _2512_/A _3309_/X _3310_/X _1660_/Q VPWR VGND sg13cmos5l_mux2_1
X_1583_ _1583_/Q FrameData[20] VGND VPWR _1166_/X latch
X_1652_ _1652_/Q FrameData[25] VGND VPWR _1171_/X latch
X_3322_ _3322_/X _3100_/X _0869_/X _2885_/X _0986_/Y _1640_/Q _1641_/Q VPWR VGND sg13cmos5l_mux4_1
XANTENNA__2577__X FrameData_O[30] VPWR VGND sg13cmos5l_antennanp
XFILLER_14_0 VPWR VGND sg13cmos5l_fill_1
X_3184_ _3184_/X _3180_/X _3181_/X _3182_/X _3183_/X _1947_/Q _1948_/Q VPWR VGND sg13cmos5l_mux4_1
X_3253_ _3253_/X _3145_/X _0650_/X _3093_/X _0628_/X _1753_/Q _1754_/Q VPWR VGND sg13cmos5l_mux4_1
X_2204_ _2204_/Q FrameData[1] VGND VPWR FrameStrobe[3] latch
X_2135_ _2135_/Q FrameData[28] VGND VPWR FrameStrobe[6] latch
XFILLER_34_261 VPWR VGND sg13cmos5l_decap_8
XFILLER_34_272 VPWR VGND sg13cmos5l_fill_1
X_1017_ _1018_/A _2949_/X _2028_/Q _1016_/Y VPWR VGND sg13cmos5l_a21oi_1
X_2066_ _2066_/Q FrameData[23] VGND VPWR FrameStrobe[8] latch
X_2968_ _2968_/X E2END[6] S4END[3] W1END[2] _3059_/X _2039_/Q _2040_/Q VPWR VGND sg13cmos5l_mux4_1
X_2899_ _2899_/X _2895_/X _2896_/X _2897_/X _2898_/X _2275_/Q _2276_/Q VPWR VGND sg13cmos5l_mux4_1
X_1919_ _1919_/Q FrameData[4] VGND VPWR _1137_/X latch
XANTENNA__2487__X N4BEG[8] VPWR VGND sg13cmos5l_antennanp
XFILLER_57_386 VPWR VGND sg13cmos5l_fill_1
XFILLER_40_220 VPWR VGND sg13cmos5l_decap_8
XANTENNA__2397__X EE4BEG[6] VPWR VGND sg13cmos5l_antennanp
XFILLER_48_353 VPWR VGND sg13cmos5l_fill_2
XFILLER_16_261 VPWR VGND sg13cmos5l_fill_2
XFILLER_23_209 VPWR VGND sg13cmos5l_decap_8
XFILLER_51_507 VPWR VGND sg13cmos5l_fill_2
X_1704_ _1704_/Q FrameData[13] VGND VPWR _1133_/X latch
X_2822_ _2822_/X _1519_/Q _1520_/Q _1521_/Q _1522_/Q _3196_/X _3191_/X VPWR VGND sg13cmos5l_mux4_1
X_2753_ _2753_/X _2749_/X _2750_/X _2751_/X _2752_/X _1827_/Q _1828_/Q VPWR VGND sg13cmos5l_mux4_1
X_2684_ _2684_/X _0863_/X _2890_/X _0860_/X _0858_/X _1773_/Q _1774_/Q VPWR VGND sg13cmos5l_mux4_1
X_1497_ _1497_/Q FrameData[30] VGND VPWR _1182_/X latch
X_1566_ _1566_/Q FrameData[3] VGND VPWR _1166_/X latch
X_1635_ _1635_/Q FrameData[8] VGND VPWR _1171_/X latch
X_3305_ _3305_/X E2MID[0] W2END[4] _1024_/Y _3136_/X _1664_/Q _1665_/Q VPWR VGND sg13cmos5l_mux4_1
XFILLER_39_386 VPWR VGND sg13cmos5l_fill_2
X_3098_ _3098_/X SS4END[0] W2MID[1] W2MID[7] W6END[1] _2151_/Q _2152_/Q VPWR VGND
+ sg13cmos5l_mux4_1
X_3167_ _3167_/X E2MID[2] E2END[2] EE4END[0] S2MID[0] _2265_/Q _2266_/Q VPWR VGND
+ sg13cmos5l_mux4_1
X_3236_ _3236_/X _3100_/X _0650_/X _3074_/X _0628_/X _1789_/Q _1790_/Q VPWR VGND sg13cmos5l_mux4_1
X_2118_ _2118_/Q FrameData[11] VGND VPWR FrameStrobe[6] latch
X_2049_ _2049_/Q FrameData[6] VGND VPWR FrameStrobe[8] latch
X_1351_ _1351_/Q FrameData[12] VGND VPWR _1183_/X latch
X_1420_ _1420_/Q FrameData[17] VGND VPWR _1186_/X latch
X_1282_ _1282_/Q FrameData[7] VGND VPWR _1197_/X latch
X_3021_ _3021_/X N2MID[1] N4END[0] E2MID[3] EE4END[0] _2088_/Q _2089_/Q VPWR VGND
+ sg13cmos5l_mux4_1
XANTENNA__2590__X SS4BEG[11] VPWR VGND sg13cmos5l_antennanp
XFILLER_51_348 VPWR VGND sg13cmos5l_fill_2
X_2805_ _2805_/X _3127_/X _0862_/X _3122_/X _3010_/X _1893_/Q _1894_/Q VPWR VGND sg13cmos5l_mux4_1
X_0997_ _0997_/Y _1811_/Q _0986_/A _0996_/Y VPWR VGND sg13cmos5l_a21oi_1
X_1618_ _1618_/Q FrameData[23] VGND VPWR _1189_/X latch
X_2736_ _2736_/X _1397_/Q _1398_/Q _1399_/Q _1400_/Q _3232_/X _3227_/X VPWR VGND sg13cmos5l_mux4_1
X_2667_ _2667_/X _2924_/X _3043_/X _3136_/X _0656_/X _1737_/Q _1738_/Q VPWR VGND sg13cmos5l_mux4_1
X_1549_ _1549_/Q FrameData[18] VGND VPWR _1187_/X latch
X_3219_ _3219_/X _3127_/X _0862_/X _0859_/X _3122_/X _1849_/Q _1850_/Q VPWR VGND sg13cmos5l_mux4_1
X_2598_ W1BEG[3] _2598_/A VPWR VGND sg13cmos5l_buf_1
XFILLER_27_312 VPWR VGND sg13cmos5l_decap_8
XFILLER_27_345 VPWR VGND sg13cmos5l_decap_8
XFILLER_6_249 VPWR VGND sg13cmos5l_fill_1
X_0920_ _0921_/A _2315_/Q _0918_/Y _0919_/Y VPWR VGND sg13cmos5l_o21ai_1
X_0782_ _0782_/Y _1009_/B _1009_/C _0781_/Y VPWR VGND sg13cmos5l_o21ai_1
X_0851_ _0852_/B _0851_/A _0851_/B VPWR VGND sg13cmos5l_xnor2_1
X_2521_ S2BEG[6] _2521_/A VPWR VGND sg13cmos5l_buf_1
XANTENNA__2585__X SS4BEG[6] VPWR VGND sg13cmos5l_antennanp
X_1265_ _1265_/Q FrameData[22] VGND VPWR _1180_/X latch
X_1334_ _1334_/Q FrameData[27] VGND VPWR _1184_/X latch
X_1403_ _1403_/Q FrameData[0] VGND VPWR _1186_/X latch
X_2452_ FrameStrobe_O[13] FrameStrobe[13] VPWR VGND sg13cmos5l_buf_1
X_2383_ _3095_/A1 VPWR VGND sg13cmos5l_tielo
X_1196_ _1196_/Y _1939_/Q _1174_/A _1195_/Y VPWR VGND sg13cmos5l_a21oi_1
X_3004_ _3004_/X S2MID[2] S2END[2] S4END[2] W1END[2] _2107_/Q _2108_/Q VPWR VGND sg13cmos5l_mux4_1
X_2719_ _2719_/X _2715_/X _2716_/X _2717_/X _2718_/X _1799_/Q _1800_/Q VPWR VGND sg13cmos5l_mux4_1
XANTENNA__2495__X NN4BEG[0] VPWR VGND sg13cmos5l_antennanp
XFILLER_23_370 VPWR VGND sg13cmos5l_decap_4
XFILLER_30_307 VPWR VGND sg13cmos5l_fill_1
XFILLER_51_31 VPWR VGND sg13cmos5l_fill_1
XFILLER_18_186 VPWR VGND sg13cmos5l_decap_4
XFILLER_33_134 VPWR VGND sg13cmos5l_fill_1
X_1050_ _1050_/Y _2184_/Q _1247_/Q VPWR VGND sg13cmos5l_nand2b_1
XFILLER_21_307 VPWR VGND sg13cmos5l_decap_4
X_0834_ _0834_/Y _1496_/Q _0834_/B VPWR VGND sg13cmos5l_nor2_1
X_0903_ _0903_/Y _2876_/X _1048_/B _0899_/Y VPWR VGND sg13cmos5l_a21oi_1
X_1952_ _1952_/Q FrameData[5] VGND VPWR _1044_/X latch
X_1883_ _1883_/Q FrameData[0] VGND VPWR _1152_/X latch
X_0696_ _0696_/Y _1079_/A _1451_/Q _0694_/Y _0695_/Y _0692_/Y VPWR VGND sg13cmos5l_a221oi_1
X_0765_ _0765_/Y _1369_/Q _0764_/Y VPWR VGND sg13cmos5l_nor2b_1
X_2504_ NN4BEG[9] NN4END[13] VPWR VGND sg13cmos5l_buf_1
X_2435_ E1BEG[0] _2435_/A VPWR VGND sg13cmos5l_buf_1
XFILLER_56_215 VPWR VGND sg13cmos5l_fill_2
X_1248_ _1248_/Q _1248_/CLK _1248_/D _2358_/L_HI VPWR VGND sg13cmos5l_dfrbpq_1
X_1317_ _1317_/Q FrameData[10] VGND VPWR _1184_/X latch
X_2366_ _2366_/L_HI VPWR VGND sg13cmos5l_tiehi
X_2297_ _2297_/Q FrameData[30] VGND VPWR FrameStrobe[1] latch
X_1179_ _1179_/Y _1907_/Q _1038_/A _1178_/Y VPWR VGND sg13cmos5l_o21ai_1
XANTENNA_30 S2END[6] VPWR VGND sg13cmos5l_antennanp
XANTENNA_41 S2END[6] VPWR VGND sg13cmos5l_antennanp
XANTENNA_52 W2END[1] VPWR VGND sg13cmos5l_antennanp
XANTENNA_63 W2END[2] VPWR VGND sg13cmos5l_antennanp
XANTENNA_74 W2MID[1] VPWR VGND sg13cmos5l_antennanp
XANTENNA_85 S2MID[3] VPWR VGND sg13cmos5l_antennanp
XANTENNA_96 FrameStrobe[2] VPWR VGND sg13cmos5l_antennanp
XFILLER_28_451 VPWR VGND sg13cmos5l_fill_2
XFILLER_7_366 VPWR VGND sg13cmos5l_fill_2
X_1102_ _1246_/D _0564_/Y _1098_/Y _1099_/Y _1101_/Y VPWR VGND sg13cmos5l_a22oi_1
X_2220_ _2220_/Q FrameData[17] VGND VPWR FrameStrobe[3] latch
X_2151_ _2151_/Q FrameData[12] VGND VPWR FrameStrobe[5] latch
X_2082_ _2082_/Q FrameData[7] VGND VPWR FrameStrobe[7] latch
X_1033_ _1033_/Y _1843_/Q _0958_/A _1032_/Y VPWR VGND sg13cmos5l_o21ai_1
X_2984_ _2984_/X _3074_/X _3117_/X _0862_/X _0833_/Y _1994_/Q _1995_/Q VPWR VGND sg13cmos5l_mux4_1
X_0817_ _0817_/Y _0569_/Y _1577_/Q _0815_/Y _0816_/Y _0813_/Y VPWR VGND sg13cmos5l_a221oi_1
X_1797_ _1797_/Q FrameData[10] VGND VPWR _1138_/X latch
X_1935_ _1935_/Q FrameData[20] VGND VPWR _1137_/X latch
X_1866_ _1866_/Q FrameData[15] VGND VPWR _1157_/X latch
X_0679_ _0688_/B _2816_/X _1501_/Q VPWR VGND sg13cmos5l_nor2_1
X_0748_ _0917_/B _0748_/A _0755_/A VPWR VGND sg13cmos5l_nor2b_1
X_2418_ E6BEG[11] _2418_/A VPWR VGND sg13cmos5l_buf_1
X_2349_ _3069_/A2 VPWR VGND sg13cmos5l_tiehi
XFILLER_0_520 VPWR VGND sg13cmos5l_decap_8
XFILLER_57_41 VPWR VGND sg13cmos5l_fill_2
XFILLER_35_218 VPWR VGND sg13cmos5l_decap_4
X_1651_ _1651_/Q FrameData[24] VGND VPWR _1171_/X latch
X_1720_ _1720_/Q FrameData[29] VGND VPWR _1133_/X latch
X_0602_ _2513_/A _3307_/X _3308_/X _1663_/Q VPWR VGND sg13cmos5l_mux2_1
X_1582_ _1582_/Q FrameData[19] VGND VPWR _1166_/X latch
X_3252_ _3252_/X _0629_/X _2924_/X _0657_/X _0655_/X _1753_/Q _1754_/Q VPWR VGND sg13cmos5l_mux4_1
X_3321_ _3321_/X NN4END[2] E2MID[2] S4END[2] _0656_/X _1640_/Q _1641_/Q VPWR VGND
+ sg13cmos5l_mux4_1
XANTENNA__2593__X SS4BEG[14] VPWR VGND sg13cmos5l_antennanp
XFILLER_19_281 VPWR VGND sg13cmos5l_decap_8
X_3183_ _3183_/X _0864_/X _2899_/X _2885_/X _0857_/X _1945_/Q _1946_/Q VPWR VGND sg13cmos5l_mux4_1
X_2203_ _2203_/Q FrameData[0] VGND VPWR FrameStrobe[3] latch
X_2134_ _2134_/Q FrameData[27] VGND VPWR FrameStrobe[6] latch
X_2065_ _2065_/Q FrameData[22] VGND VPWR FrameStrobe[8] latch
X_1016_ _1016_/Y _2028_/Q _2948_/X VPWR VGND sg13cmos5l_nor2b_1
X_2967_ _2967_/X _2963_/X _2964_/X _2965_/X _2966_/X _2008_/Q _2009_/Q VPWR VGND sg13cmos5l_mux4_1
X_2898_ _2898_/X W2MID[4] W2END[4] WW4END[2] _0921_/Y _2273_/Q _2274_/Q VPWR VGND
+ sg13cmos5l_mux4_1
X_1918_ _1918_/Q FrameData[3] VGND VPWR _1137_/X latch
X_1849_ _1849_/Q FrameData[30] VGND VPWR _1136_/X latch
XFILLER_25_251 VPWR VGND sg13cmos5l_decap_8
XFILLER_25_262 VPWR VGND sg13cmos5l_fill_1
XFILLER_40_265 VPWR VGND sg13cmos5l_fill_1
XFILLER_36_516 VPWR VGND sg13cmos5l_fill_2
XFILLER_31_210 VPWR VGND sg13cmos5l_fill_2
X_2821_ _2821_/X _2817_/X _2818_/X _2819_/X _2820_/X _3191_/X _0910_/Y VPWR VGND sg13cmos5l_mux4_1
X_1634_ _1634_/Q FrameData[7] VGND VPWR _1171_/X latch
X_1703_ _1703_/Q FrameData[12] VGND VPWR _1133_/X latch
X_2752_ _2752_/X _0864_/X _3170_/X _0859_/X _2929_/X _1825_/Q _1826_/Q VPWR VGND sg13cmos5l_mux4_1
X_2683_ _2683_/X _0872_/X _0870_/X _3155_/X _0867_/X _1773_/Q _1774_/Q VPWR VGND sg13cmos5l_mux4_1
XANTENNA__2588__X SS4BEG[9] VPWR VGND sg13cmos5l_antennanp
X_1496_ _1496_/Q FrameData[29] VGND VPWR _1182_/X latch
X_1565_ _1565_/Q FrameData[2] VGND VPWR _1166_/X latch
X_3235_ _3235_/X _0631_/X _2924_/X _3136_/X _0656_/X _1789_/Q _1790_/Q VPWR VGND sg13cmos5l_mux4_1
X_3304_ _3304_/X _3159_/X _3107_/X _0860_/X _0974_/Y _1667_/Q _1668_/Q VPWR VGND sg13cmos5l_mux4_1
X_3097_ _3097_/X E2END[6] S1END[0] S2MID[4] S2END[4] _2151_/Q _2152_/Q VPWR VGND sg13cmos5l_mux4_1
X_3166_ _3166_/X N1END[0] N2MID[4] N2END[4] NN4END[0] _2265_/Q _2266_/Q VPWR VGND
+ sg13cmos5l_mux4_1
X_2117_ _2117_/Q FrameData[10] VGND VPWR FrameStrobe[6] latch
X_2048_ _2048_/Q FrameData[5] VGND VPWR FrameStrobe[8] latch
XFILLER_22_243 VPWR VGND sg13cmos5l_decap_8
XFILLER_22_254 VPWR VGND sg13cmos5l_fill_2
XFILLER_22_287 VPWR VGND sg13cmos5l_fill_1
XANTENNA__2498__X NN4BEG[3] VPWR VGND sg13cmos5l_antennanp
XFILLER_18_505 VPWR VGND sg13cmos5l_decap_8
XFILLER_38_98 VPWR VGND sg13cmos5l_fill_2
XFILLER_9_225 VPWR VGND sg13cmos5l_fill_2
X_1281_ _1281_/Q FrameData[6] VGND VPWR _1197_/X latch
X_1350_ _1350_/Q FrameData[11] VGND VPWR _1183_/X latch
X_3020_ _3020_/X _2910_/X _0627_/X _2917_/X _0808_/B _2016_/Q _2017_/Q VPWR VGND sg13cmos5l_mux4_1
X_0996_ _0996_/Y _1811_/Q _1224_/B VPWR VGND sg13cmos5l_nor2_1
X_2804_ _2804_/X _3117_/X _3112_/X _2917_/X _0866_/X _1893_/Q _1894_/Q VPWR VGND sg13cmos5l_mux4_1
X_1617_ _1617_/Q FrameData[22] VGND VPWR _1189_/X latch
X_2735_ _2735_/X _1393_/Q _1394_/Q _1395_/Q _1396_/Q _3232_/X _3227_/X VPWR VGND sg13cmos5l_mux4_1
X_2666_ _2666_/X _2662_/X _2663_/X _2664_/X _2665_/X _1731_/Q _1732_/Q VPWR VGND sg13cmos5l_mux4_1
X_2597_ W1BEG[2] _2597_/A VPWR VGND sg13cmos5l_buf_1
X_1479_ _1479_/Q FrameData[12] VGND VPWR _1182_/X latch
X_1548_ _1548_/Q FrameData[17] VGND VPWR _1187_/X latch
X_3149_ _3149_/X W2END[3] W2END[7] WW4END[1] _1239_/Q _2242_/Q _2243_/Q VPWR VGND
+ sg13cmos5l_mux4_1
X_3218_ _3218_/X _3117_/X _3112_/X _0868_/X _2917_/X _1849_/Q _1850_/Q VPWR VGND sg13cmos5l_mux4_1
XFILLER_50_360 VPWR VGND sg13cmos5l_fill_1
XANTENNA_120 FrameStrobe[2] VPWR VGND sg13cmos5l_antennanp
XFILLER_33_327 VPWR VGND sg13cmos5l_decap_4
XFILLER_33_349 VPWR VGND sg13cmos5l_fill_1
X_0850_ _0851_/B _1286_/Q _0755_/C _0849_/Y VPWR VGND sg13cmos5l_o21ai_1
X_0781_ _0781_/Y _1905_/Q _1906_/Q VPWR VGND sg13cmos5l_nor2_1
X_1402_ _1402_/Q FrameData[31] VGND VPWR _1181_/X latch
X_2520_ S2BEG[5] _2520_/A VPWR VGND sg13cmos5l_buf_1
X_2451_ FrameStrobe_O[12] FrameStrobe[12] VPWR VGND sg13cmos5l_buf_1
X_1264_ _1264_/Q FrameData[21] VGND VPWR _1180_/X latch
X_1333_ _1333_/Q FrameData[26] VGND VPWR _1184_/X latch
X_3003_ _3003_/X E1END[0] E2MID[4] E2END[4] EE4END[2] _2107_/Q _2108_/Q VPWR VGND
+ sg13cmos5l_mux4_1
X_2382_ _3083_/A1 VPWR VGND sg13cmos5l_tielo
XFILLER_24_327 VPWR VGND sg13cmos5l_fill_1
X_1195_ _1195_/Y _1939_/Q _2467_/A VPWR VGND sg13cmos5l_nor2_1
X_0979_ _0979_/Y _1779_/Q _0950_/A _0978_/Y VPWR VGND sg13cmos5l_o21ai_1
X_2718_ _2718_/X _0863_/X _2890_/X _0859_/X _2929_/X _1797_/Q _1798_/Q VPWR VGND sg13cmos5l_mux4_1
X_2649_ _2649_/X _1271_/Q _1272_/Q _1273_/Q _1274_/Q _3268_/X _3263_/X VPWR VGND sg13cmos5l_mux4_1
XFILLER_4_0 VPWR VGND sg13cmos5l_fill_2
X_0833_ _0833_/Y _0563_/Y _2330_/Q _0832_/Y VPWR VGND sg13cmos5l_a21oi_1
X_0902_ _1048_/B _0846_/Y _0901_/B _0901_/Y VPWR VGND sg13cmos5l_a21oi_1
X_1951_ _1951_/Q FrameData[4] VGND VPWR _1044_/X latch
X_1882_ _1882_/Q FrameData[31] VGND VPWR _1157_/X latch
XANTENNA__2596__X W1BEG[1] VPWR VGND sg13cmos5l_antennanp
XFILLER_37_0 VPWR VGND sg13cmos5l_fill_1
X_0695_ _0695_/Y _0573_/Y _2766_/X _1451_/Q VPWR VGND sg13cmos5l_a21oi_1
X_0764_ _0764_/Y _1810_/Q _2465_/A _1809_/Q VPWR VGND sg13cmos5l_o21ai_1
X_2503_ NN4BEG[8] NN4END[12] VPWR VGND sg13cmos5l_buf_1
X_2434_ E2BEG[7] _2434_/A VPWR VGND sg13cmos5l_buf_1
X_2365_ _2365_/L_HI VPWR VGND sg13cmos5l_tiehi
XFILLER_49_290 VPWR VGND sg13cmos5l_fill_2
X_1178_ _1178_/Y _1907_/Q _2604_/A VPWR VGND sg13cmos5l_nand2_1
X_1247_ _1247_/Q _1248_/CLK _1247_/D _2359_/L_HI VPWR VGND sg13cmos5l_dfrbpq_1
X_1316_ _1316_/Q FrameData[9] VGND VPWR _1184_/X latch
X_2296_ _2296_/Q FrameData[29] VGND VPWR FrameStrobe[1] latch
XANTENNA_20 S2END[6] VPWR VGND sg13cmos5l_antennanp
XANTENNA_31 S2END[6] VPWR VGND sg13cmos5l_antennanp
XFILLER_32_190 VPWR VGND sg13cmos5l_fill_2
XANTENNA_42 S2END[6] VPWR VGND sg13cmos5l_antennanp
XANTENNA_53 W2END[1] VPWR VGND sg13cmos5l_antennanp
XANTENNA_64 W2END[2] VPWR VGND sg13cmos5l_antennanp
XANTENNA_75 W2MID[1] VPWR VGND sg13cmos5l_antennanp
XANTENNA_86 S2MID[3] VPWR VGND sg13cmos5l_antennanp
XANTENNA_97 FrameStrobe[2] VPWR VGND sg13cmos5l_antennanp
XFILLER_20_352 VPWR VGND sg13cmos5l_fill_1
XFILLER_20_374 VPWR VGND sg13cmos5l_fill_1
XFILLER_4_518 VPWR VGND sg13cmos5l_fill_2
XFILLER_11_352 VPWR VGND sg13cmos5l_fill_1
XFILLER_7_48 VPWR VGND sg13cmos5l_fill_1
X_1032_ _1032_/Y _1843_/Q _2602_/A VPWR VGND sg13cmos5l_nand2_1
X_1101_ _1101_/Y _1500_/Q _0837_/B _1100_/Y VPWR VGND sg13cmos5l_o21ai_1
X_2150_ _2150_/Q FrameData[11] VGND VPWR FrameStrobe[5] latch
X_2081_ _2081_/Q FrameData[6] VGND VPWR FrameStrobe[7] latch
XFILLER_21_138 VPWR VGND sg13cmos5l_fill_2
XFILLER_34_499 VPWR VGND sg13cmos5l_fill_2
X_2983_ _2983_/X E2END[4] W2MID[0] _1205_/Y _0655_/X _1994_/Q _1995_/Q VPWR VGND sg13cmos5l_mux4_1
X_1934_ _1934_/Q FrameData[19] VGND VPWR _1137_/X latch
X_0747_ _0755_/A _2647_/X _2671_/X _1291_/Q VPWR VGND sg13cmos5l_nor3_1
X_0816_ _0816_/Y _0570_/Y _2853_/X _1577_/Q VPWR VGND sg13cmos5l_a21oi_1
X_1796_ _1796_/Q FrameData[9] VGND VPWR _1138_/X latch
X_1865_ _1865_/Q FrameData[14] VGND VPWR _1157_/X latch
XFILLER_29_227 VPWR VGND sg13cmos5l_fill_2
X_0678_ _0795_/B _0794_/A VPWR VGND sg13cmos5l_inv_1
X_2417_ E6BEG[10] _2417_/A VPWR VGND sg13cmos5l_buf_1
X_2348_ _2894_/A2 VPWR VGND sg13cmos5l_tiehi
X_2279_ _2279_/Q FrameData[12] VGND VPWR FrameStrobe[1] latch
XFILLER_16_79 VPWR VGND sg13cmos5l_fill_1
XFILLER_20_193 VPWR VGND sg13cmos5l_decap_4
XFILLER_0_554 VPWR VGND sg13cmos5l_fill_2
XFILLER_16_411 VPWR VGND sg13cmos5l_fill_1
XFILLER_43_230 VPWR VGND sg13cmos5l_decap_4
X_0601_ _0601_/Y _1290_/Q VPWR VGND sg13cmos5l_inv_1
X_1581_ _1581_/Q FrameData[18] VGND VPWR _1166_/X latch
X_1650_ _1650_/Q FrameData[23] VGND VPWR _1171_/X latch
X_3182_ _3182_/X _0871_/X _0869_/X _2917_/X _0865_/X _1945_/Q _1946_/Q VPWR VGND sg13cmos5l_mux4_1
X_3251_ _3251_/X _3247_/X _3248_/X _3249_/X _3250_/X _1759_/Q _1760_/Q VPWR VGND sg13cmos5l_mux4_1
X_3320_ _3320_/X _0650_/X _0639_/X _3107_/X _0807_/B _1643_/Q _1644_/Q VPWR VGND sg13cmos5l_mux4_1
X_2202_ _2202_/Q FrameData[31] VGND VPWR FrameStrobe[4] latch
X_1015_ _1015_/Y _1875_/Q _1013_/A _1014_/Y VPWR VGND sg13cmos5l_a21oi_1
X_2133_ _2133_/Q FrameData[26] VGND VPWR FrameStrobe[6] latch
X_2064_ _2064_/Q FrameData[21] VGND VPWR FrameStrobe[8] latch
X_2966_ _2966_/X _1013_/Y _0840_/Y _1208_/Y _0808_/B _2006_/Q _2007_/Q VPWR VGND sg13cmos5l_mux4_1
X_2897_ _2897_/X S2MID[4] S2END[0] S4END[0] W1END[0] _2273_/Q _2274_/Q VPWR VGND sg13cmos5l_mux4_1
X_1917_ _1917_/Q FrameData[2] VGND VPWR _1137_/X latch
X_1779_ _1779_/Q FrameData[24] VGND VPWR _1139_/X latch
X_1848_ _1848_/Q FrameData[29] VGND VPWR _1136_/X latch
XFILLER_25_274 VPWR VGND sg13cmos5l_fill_1
X_2820_ _2820_/X _1509_/Q _1517_/Q _1510_/Q _1518_/Q _2835_/X _3196_/X VPWR VGND sg13cmos5l_mux4_1
X_2751_ _2751_/X _3163_/X _0871_/X _3150_/X _0866_/X _1825_/Q _1826_/Q VPWR VGND sg13cmos5l_mux4_1
X_1564_ _1564_/Q FrameData[1] VGND VPWR _1166_/X latch
X_1633_ _1633_/Q FrameData[6] VGND VPWR _1171_/X latch
X_1702_ _1702_/Q FrameData[11] VGND VPWR _1133_/X latch
Xtest test/X UserCLK VPWR VGND sg13cmos5l_buf_16
X_2682_ _2682_/X _3079_/X _2932_/X _3074_/X _3139_/X _1773_/Q _1774_/Q VPWR VGND sg13cmos5l_mux4_1
X_1495_ _1495_/Q FrameData[28] VGND VPWR _1182_/X latch
X_3165_ _3165_/X W2END[1] _3165_/A1 _3165_/A2 _0808_/B _2287_/Q _2288_/Q VPWR VGND
+ sg13cmos5l_mux4_1
X_3234_ _3234_/X _0963_/X _0995_/Y _1811_/Q _0997_/Y _1812_/Q _1813_/Q VPWR VGND sg13cmos5l_mux4_1
X_3303_ _3303_/X E6END[1] WW4END[1] _1058_/Y _0650_/X _1667_/Q _1668_/Q VPWR VGND
+ sg13cmos5l_mux4_1
XFILLER_50_542 VPWR VGND sg13cmos5l_fill_1
X_3096_ _3096_/X N2MID[0] N2END[0] N4END[0] E2MID[6] _2151_/Q _2152_/Q VPWR VGND sg13cmos5l_mux4_1
X_2116_ _2116_/Q FrameData[9] VGND VPWR FrameStrobe[6] latch
X_2047_ _2047_/Q FrameData[4] VGND VPWR FrameStrobe[8] latch
X_2949_ _2949_/X _3093_/X _0868_/X _0861_/X _1208_/Y _2026_/Q _2027_/Q VPWR VGND sg13cmos5l_mux4_1
X_1280_ _1280_/Q FrameData[5] VGND VPWR _1197_/X latch
X_0995_ _0995_/Y _1811_/Q _0966_/A _0994_/Y VPWR VGND sg13cmos5l_o21ai_1
X_2803_ _2803_/X _0653_/X _2910_/X _0639_/X _0627_/X _1893_/Q _1894_/Q VPWR VGND sg13cmos5l_mux4_1
X_2734_ _2734_/X _2730_/X _2731_/X _2732_/X _2733_/X _3227_/X _0912_/Y VPWR VGND sg13cmos5l_mux4_1
XANTENNA__2599__X W2BEG[0] VPWR VGND sg13cmos5l_antennanp
X_1547_ _1547_/Q FrameData[16] VGND VPWR _1187_/X latch
X_1616_ _1616_/Q FrameData[21] VGND VPWR _1189_/X latch
X_2665_ _2665_/X _0863_/X _3127_/X _0859_/X _2885_/X _1729_/Q _1730_/Q VPWR VGND sg13cmos5l_mux4_1
X_2596_ W1BEG[1] _2596_/A VPWR VGND sg13cmos5l_buf_1
X_1478_ _1478_/Q FrameData[11] VGND VPWR _1182_/X latch
X_3148_ _3148_/X S2END[7] SS4END[3] W2MID[3] W2MID[4] _2242_/Q _2243_/Q VPWR VGND
+ sg13cmos5l_mux4_1
X_3217_ _3217_/X _0653_/X _3050_/X _3139_/X _2903_/X _1849_/Q _1850_/Q VPWR VGND sg13cmos5l_mux4_1
X_3079_ _3079_/X _3075_/X _3076_/X _3077_/X _3078_/X _2149_/Q _2150_/Q VPWR VGND sg13cmos5l_mux4_1
XFILLER_2_479 VPWR VGND sg13cmos5l_decap_8
XANTENNA_110 FrameStrobe[2] VPWR VGND sg13cmos5l_antennanp
XANTENNA_121 FrameStrobe[2] VPWR VGND sg13cmos5l_antennanp
XFILLER_18_303 VPWR VGND sg13cmos5l_decap_8
XFILLER_45_155 VPWR VGND sg13cmos5l_decap_4
XFILLER_41_350 VPWR VGND sg13cmos5l_decap_8
X_0780_ _1009_/C _1079_/A _1453_/Q _0777_/Y _0779_/Y _0702_/Y VPWR VGND sg13cmos5l_a221oi_1
X_1401_ _1401_/Q FrameData[30] VGND VPWR _1181_/X latch
X_2450_ FrameStrobe_O[11] FrameStrobe[11] VPWR VGND sg13cmos5l_buf_1
X_2381_ _3165_/A1 VPWR VGND sg13cmos5l_tielo
X_1194_ _1194_/Y _1971_/Q _1192_/A _1193_/Y VPWR VGND sg13cmos5l_a21oi_1
X_1263_ _1263_/Q FrameData[20] VGND VPWR _1180_/X latch
X_1332_ _1332_/Q FrameData[25] VGND VPWR _1184_/X latch
X_3002_ _3002_/X N1END[2] N2MID[6] N2END[6] NN4END[2] _2107_/Q _2108_/Q VPWR VGND
+ sg13cmos5l_mux4_1
X_0978_ _0978_/Y _1779_/Q _2600_/A VPWR VGND sg13cmos5l_nand2_1
X_2717_ _2717_/X _3159_/X _0870_/X _2917_/X _0866_/X _1797_/Q _1798_/Q VPWR VGND sg13cmos5l_mux4_1
X_2648_ _2648_/X _1267_/Q _1268_/Q _1269_/Q _1270_/Q _3268_/X _3263_/X VPWR VGND sg13cmos5l_mux4_1
X_2579_ SS4BEG[0] SS4END[4] VPWR VGND sg13cmos5l_buf_1
XFILLER_55_497 VPWR VGND sg13cmos5l_fill_1
X_1950_ _1950_/Q FrameData[3] VGND VPWR _1044_/X latch
X_0763_ _0763_/Y _0735_/Y _0761_/Y _0762_/Y VPWR VGND sg13cmos5l_o21ai_1
X_0832_ _0832_/Y _2330_/Q _0832_/B VPWR VGND sg13cmos5l_nor2_1
X_0901_ _0901_/Y _0901_/A _0901_/B VPWR VGND sg13cmos5l_nor2_1
X_2502_ NN4BEG[7] NN4END[11] VPWR VGND sg13cmos5l_buf_1
X_1881_ _1881_/Q FrameData[30] VGND VPWR _1157_/X latch
X_0694_ _0694_/Y _2782_/X _2767_/X VPWR VGND sg13cmos5l_nand2_1
X_1315_ _1315_/Q FrameData[8] VGND VPWR _1184_/X latch
X_2433_ E2BEG[6] _2433_/A VPWR VGND sg13cmos5l_buf_1
X_2364_ _2364_/L_HI VPWR VGND sg13cmos5l_tiehi
X_1177_ _1177_/X FrameStrobe[11] FrameStrobe[19] VPWR VGND sg13cmos5l_and2_1
X_1246_ _1246_/Q _1246_/CLK _1246_/D _2363_/L_HI VPWR VGND sg13cmos5l_dfrbpq_1
X_2295_ _2295_/Q FrameData[28] VGND VPWR FrameStrobe[1] latch
XANTENNA_10 FrameStrobe[15] VPWR VGND sg13cmos5l_antennanp
XANTENNA_21 S2END[6] VPWR VGND sg13cmos5l_antennanp
XANTENNA_32 S2END[6] VPWR VGND sg13cmos5l_antennanp
XANTENNA_43 S2END[6] VPWR VGND sg13cmos5l_antennanp
XANTENNA_54 W2END[1] VPWR VGND sg13cmos5l_antennanp
XANTENNA_65 W2END[2] VPWR VGND sg13cmos5l_antennanp
XANTENNA_76 WW4END[1] VPWR VGND sg13cmos5l_antennanp
XANTENNA_87 S2MID[3] VPWR VGND sg13cmos5l_antennanp
XANTENNA_98 FrameStrobe[2] VPWR VGND sg13cmos5l_antennanp
XFILLER_28_453 VPWR VGND sg13cmos5l_fill_1
XFILLER_28_475 VPWR VGND sg13cmos5l_fill_2
XFILLER_30_128 VPWR VGND sg13cmos5l_decap_8
XFILLER_7_324 VPWR VGND sg13cmos5l_fill_2
XFILLER_38_228 VPWR VGND sg13cmos5l_decap_4
XFILLER_46_261 VPWR VGND sg13cmos5l_fill_2
X_1031_ _1031_/Y _1846_/Q _1018_/A _1030_/Y VPWR VGND sg13cmos5l_a21oi_1
X_1100_ _1100_/Y _1500_/Q _0836_/A _3198_/X VPWR VGND sg13cmos5l_a21oi_1
X_2080_ _2080_/Q FrameData[5] VGND VPWR FrameStrobe[7] latch
X_2982_ _2982_/X _0872_/X _3150_/X _0859_/X _0986_/Y _1997_/Q _1998_/Q VPWR VGND sg13cmos5l_mux4_1
X_1933_ _1933_/Q FrameData[18] VGND VPWR _1137_/X latch
X_0746_ _0749_/C _2671_/X _1291_/Q VPWR VGND sg13cmos5l_nor2_1
X_0815_ _0815_/Y _2869_/X _2854_/X VPWR VGND sg13cmos5l_nand2_1
X_1795_ _1795_/Q FrameData[8] VGND VPWR _1138_/X latch
X_1864_ _1864_/Q FrameData[13] VGND VPWR _1157_/X latch
XANTENNA__2400__X EE4BEG[9] VPWR VGND sg13cmos5l_antennanp
X_0677_ _0794_/A _0669_/B _0821_/A _0669_/Y VPWR VGND sg13cmos5l_a21oi_1
X_2416_ E6BEG[9] E6END[11] VPWR VGND sg13cmos5l_buf_1
X_2347_ _3138_/A2 VPWR VGND sg13cmos5l_tiehi
X_2278_ _2278_/Q FrameData[11] VGND VPWR FrameStrobe[1] latch
XFILLER_52_220 VPWR VGND sg13cmos5l_fill_1
X_1229_ _1229_/Y _1974_/Q _0941_/A _1228_/Y VPWR VGND sg13cmos5l_a21oi_1
X_0600_ _1051_/B _2183_/Q VPWR VGND sg13cmos5l_inv_1
X_1580_ _1580_/Q FrameData[17] VGND VPWR _1166_/X latch
X_3181_ _3181_/X _3079_/X _3145_/X _3074_/X _0628_/X _1945_/Q _1946_/Q VPWR VGND sg13cmos5l_mux4_1
X_3250_ _3250_/X _0864_/X _3170_/X _0858_/X _3010_/X _1757_/Q _1758_/Q VPWR VGND sg13cmos5l_mux4_1
X_2201_ _2201_/Q FrameData[30] VGND VPWR FrameStrobe[4] latch
X_2132_ _2132_/Q FrameData[25] VGND VPWR FrameStrobe[6] latch
XFILLER_22_426 VPWR VGND sg13cmos5l_fill_2
XFILLER_34_253 VPWR VGND sg13cmos5l_fill_1
X_1014_ _1014_/Y _1875_/Q _1224_/B VPWR VGND sg13cmos5l_nor2_1
X_2063_ _2063_/Q FrameData[20] VGND VPWR FrameStrobe[8] latch
X_2965_ _2965_/X _0974_/Y _1066_/Y _1027_/Y _0848_/Y _2006_/Q _2007_/Q VPWR VGND sg13cmos5l_mux4_1
X_2896_ _2896_/X E2MID[2] E2END[2] EE4END[0] S2MID[0] _2273_/Q _2274_/Q VPWR VGND
+ sg13cmos5l_mux4_1
X_1916_ _1916_/Q FrameData[1] VGND VPWR _1137_/X latch
X_1847_ _1847_/Q FrameData[28] VGND VPWR _1136_/X latch
X_0729_ _0729_/X _2677_/X _2678_/X _2695_/X VPWR VGND sg13cmos5l_mux2_1
X_1778_ _1778_/Q FrameData[23] VGND VPWR _1139_/X latch
XFILLER_17_209 VPWR VGND sg13cmos5l_decap_4
XFILLER_40_234 VPWR VGND sg13cmos5l_decap_4
XFILLER_0_341 VPWR VGND sg13cmos5l_fill_1
XFILLER_16_253 VPWR VGND sg13cmos5l_fill_1
X_1701_ _1701_/Q FrameData[10] VGND VPWR _1133_/X latch
X_2750_ _2750_/X _3079_/X _2932_/X _3139_/X _2903_/X _1825_/Q _1826_/Q VPWR VGND sg13cmos5l_mux4_1
X_2681_ _2681_/X _0658_/X _3043_/X _3059_/X _3087_/X _1773_/Q _1774_/Q VPWR VGND sg13cmos5l_mux4_1
X_1494_ _1494_/Q FrameData[27] VGND VPWR _1182_/X latch
X_1563_ _1563_/Q FrameData[0] VGND VPWR _1166_/X latch
X_1632_ _1632_/Q FrameData[5] VGND VPWR _1171_/X latch
X_3302_ _3302_/X _3144_/X _0866_/X _2890_/X _0848_/Y _1670_/Q _1671_/Q VPWR VGND sg13cmos5l_mux4_1
XFILLER_12_0 VPWR VGND sg13cmos5l_fill_2
X_3095_ _3095_/X _0899_/B _3095_/A1 _3095_/A2 _1066_/Y _2164_/Q _2165_/Q VPWR VGND
+ sg13cmos5l_mux4_1
X_3164_ _3164_/X N1END[1] NN4END[1] E2MID[3] S2END[1] _2287_/Q _2288_/Q VPWR VGND
+ sg13cmos5l_mux4_1
X_3233_ _3233_/X _0993_/Y _0961_/Y _1814_/Q _0990_/Y _1815_/Q _1816_/Q VPWR VGND sg13cmos5l_mux4_1
X_2115_ _2115_/Q FrameData[8] VGND VPWR FrameStrobe[6] latch
XFILLER_22_223 VPWR VGND sg13cmos5l_fill_2
X_2046_ _2046_/Q FrameData[3] VGND VPWR FrameStrobe[8] latch
X_2948_ _2948_/X N1END[2] S2MID[6] _0854_/Y _3006_/X _2026_/Q _2027_/Q VPWR VGND sg13cmos5l_mux4_1
X_2879_ _2879_/X N1END[3] E1END[1] S2END[3] S4END[3] _2126_/Q _2127_/Q VPWR VGND sg13cmos5l_mux4_1
XFILLER_45_337 VPWR VGND sg13cmos5l_decap_4
XFILLER_13_223 VPWR VGND sg13cmos5l_fill_2
XFILLER_36_348 VPWR VGND sg13cmos5l_fill_2
X_0994_ _0994_/Y _1811_/Q _2601_/A VPWR VGND sg13cmos5l_nand2_1
X_2802_ _2802_/X _0630_/X _3006_/X _0655_/X _3001_/X _1893_/Q _1894_/Q VPWR VGND sg13cmos5l_mux4_1
X_2733_ _2733_/X _1383_/Q _1391_/Q _1384_/Q _1392_/Q _2748_/X _3232_/X VPWR VGND sg13cmos5l_mux4_1
X_2664_ _2664_/X _3117_/X _0872_/X _2917_/X _0865_/X _1729_/Q _1730_/Q VPWR VGND sg13cmos5l_mux4_1
X_1477_ _1477_/Q FrameData[10] VGND VPWR _1182_/X latch
X_1546_ _1546_/Q FrameData[15] VGND VPWR _1187_/X latch
X_1615_ _1615_/Q FrameData[20] VGND VPWR _1189_/X latch
X_2595_ W1BEG[0] _2595_/A VPWR VGND sg13cmos5l_buf_1
XFILLER_27_359 VPWR VGND sg13cmos5l_decap_8
X_3078_ _3078_/X W6END[1] _0899_/B _0921_/Y _0974_/Y _2147_/Q _2148_/Q VPWR VGND sg13cmos5l_mux4_1
X_3147_ _3147_/X E2END[1] E6END[1] S1END[3] S2MID[7] _2242_/Q _2243_/Q VPWR VGND sg13cmos5l_mux4_1
X_3216_ _3216_/X _0658_/X _3036_/X _0656_/X _3001_/X _1849_/Q _1850_/Q VPWR VGND sg13cmos5l_mux4_1
X_2029_ _2029_/Q FrameData[18] VGND VPWR FrameStrobe[9] latch
XANTENNA_100 FrameStrobe[2] VPWR VGND sg13cmos5l_antennanp
XANTENNA_111 FrameStrobe[2] VPWR VGND sg13cmos5l_antennanp
XANTENNA_122 FrameStrobe[2] VPWR VGND sg13cmos5l_antennanp
XFILLER_26_381 VPWR VGND sg13cmos5l_fill_2
X_1331_ _1331_/Q FrameData[24] VGND VPWR _1184_/X latch
X_1400_ _1400_/Q FrameData[29] VGND VPWR _1181_/X latch
X_2380_ _2990_/A1 VPWR VGND sg13cmos5l_tielo
XFILLER_36_156 VPWR VGND sg13cmos5l_fill_1
X_1193_ _1193_/Y _1971_/Q _2468_/A VPWR VGND sg13cmos5l_nor2_1
X_1262_ _1262_/Q FrameData[19] VGND VPWR _1180_/X latch
X_3001_ _3001_/X _2997_/X _2998_/X _2999_/X _3000_/X _2141_/Q _2142_/Q VPWR VGND sg13cmos5l_mux4_1
XFILLER_32_362 VPWR VGND sg13cmos5l_fill_1
XANTENNA__2403__X EE4BEG[12] VPWR VGND sg13cmos5l_antennanp
X_0977_ _0977_/X _2463_/A _2430_/A _1782_/Q VPWR VGND sg13cmos5l_mux2_1
X_2716_ _2716_/X _3100_/X _3145_/X _0639_/X _0627_/X _1797_/Q _1798_/Q VPWR VGND sg13cmos5l_mux4_1
X_2647_ _2647_/X _2643_/X _2644_/X _2645_/X _2646_/X _3263_/X _0991_/X VPWR VGND sg13cmos5l_mux4_1
X_1529_ _1529_/Q FrameData[30] VGND VPWR _1188_/X latch
X_2578_ FrameData_O[31] FrameData[31] VPWR VGND sg13cmos5l_buf_1
XFILLER_35_24 VPWR VGND sg13cmos5l_fill_1
XFILLER_55_454 VPWR VGND sg13cmos5l_fill_1
XFILLER_4_2 VPWR VGND sg13cmos5l_fill_1
XFILLER_18_134 VPWR VGND sg13cmos5l_decap_4
XFILLER_14_340 VPWR VGND sg13cmos5l_fill_2
XFILLER_14_395 VPWR VGND sg13cmos5l_fill_2
X_0900_ _0901_/B _2876_/X _2878_/X _1587_/Q VPWR VGND sg13cmos5l_mux2_1
X_1880_ _1880_/Q FrameData[29] VGND VPWR _1157_/X latch
X_0693_ _0693_/X _2764_/X _2765_/X _2782_/X VPWR VGND sg13cmos5l_mux2_1
X_0762_ _0762_/Y _1809_/Q _1810_/Q VPWR VGND sg13cmos5l_nor2_1
X_0831_ _0832_/B _0830_/Y _0820_/A _1583_/Q VPWR VGND sg13cmos5l_mux2_1
X_2501_ NN4BEG[6] NN4END[10] VPWR VGND sg13cmos5l_buf_1
X_1314_ _1314_/Q FrameData[7] VGND VPWR _1184_/X latch
X_2432_ E2BEG[5] _2432_/A VPWR VGND sg13cmos5l_buf_1
X_2363_ _2363_/L_HI VPWR VGND sg13cmos5l_tiehi
X_2294_ _2294_/Q FrameData[27] VGND VPWR FrameStrobe[1] latch
XFILLER_49_292 VPWR VGND sg13cmos5l_fill_1
X_1176_ _1176_/Y _1910_/Q _1174_/A _1175_/Y VPWR VGND sg13cmos5l_a21oi_1
X_1245_ _1245_/Q _1246_/CLK _1245_/D _2361_/L_HI VPWR VGND sg13cmos5l_dfrbpq_1
XANTENNA_11 N2END[0] VPWR VGND sg13cmos5l_antennanp
XANTENNA_22 S2END[6] VPWR VGND sg13cmos5l_antennanp
XANTENNA_33 S2END[6] VPWR VGND sg13cmos5l_antennanp
XANTENNA_44 S2END[6] VPWR VGND sg13cmos5l_antennanp
XANTENNA_55 W2END[1] VPWR VGND sg13cmos5l_antennanp
XANTENNA_66 W2END[2] VPWR VGND sg13cmos5l_antennanp
XANTENNA_77 WW4END[1] VPWR VGND sg13cmos5l_antennanp
XANTENNA_88 S2MID[3] VPWR VGND sg13cmos5l_antennanp
XANTENNA_99 FrameStrobe[2] VPWR VGND sg13cmos5l_antennanp
XFILLER_32_192 VPWR VGND sg13cmos5l_fill_1
XFILLER_52_479 VPWR VGND sg13cmos5l_fill_2
XFILLER_28_410 VPWR VGND sg13cmos5l_fill_1
XFILLER_15_126 VPWR VGND sg13cmos5l_fill_2
XFILLER_15_159 VPWR VGND sg13cmos5l_decap_8
XFILLER_23_192 VPWR VGND sg13cmos5l_fill_2
XFILLER_34_424 VPWR VGND sg13cmos5l_decap_8
XFILLER_46_284 VPWR VGND sg13cmos5l_fill_1
X_1030_ _1030_/Y _1846_/Q _2465_/A VPWR VGND sg13cmos5l_nor2_1
X_0814_ _0814_/X _2851_/X _2852_/X _2869_/X VPWR VGND sg13cmos5l_mux2_1
X_2981_ _2981_/X NN4END[0] E2MID[5] W1END[1] _3050_/X _1997_/Q _1998_/Q VPWR VGND
+ sg13cmos5l_mux4_1
X_1932_ _1932_/Q FrameData[17] VGND VPWR _1137_/X latch
X_1863_ _1863_/Q FrameData[12] VGND VPWR _1157_/X latch
XFILLER_42_0 VPWR VGND sg13cmos5l_fill_2
XFILLER_6_391 VPWR VGND sg13cmos5l_decap_4
X_0676_ _0821_/A _0671_/Y _0672_/X _0675_/Y VPWR VGND sg13cmos5l_a21oi_1
X_0745_ _0748_/A _0749_/A _0749_/B VPWR VGND sg13cmos5l_nor2_1
X_1794_ _1794_/Q FrameData[7] VGND VPWR _1138_/X latch
X_2415_ E6BEG[8] E6END[10] VPWR VGND sg13cmos5l_buf_1
X_1228_ _1228_/Y _1974_/Q _2469_/A VPWR VGND sg13cmos5l_nor2_1
X_2346_ _3052_/A2 VPWR VGND sg13cmos5l_tiehi
X_2277_ _2277_/Q FrameData[10] VGND VPWR FrameStrobe[1] latch
XFILLER_25_435 VPWR VGND sg13cmos5l_fill_1
XFILLER_37_273 VPWR VGND sg13cmos5l_fill_2
X_1159_ _1159_/X _2208_/Q _2207_/Q VPWR VGND sg13cmos5l_and2_1
XFILLER_0_501 VPWR VGND sg13cmos5l_fill_2
XFILLER_0_534 VPWR VGND sg13cmos5l_fill_1
XFILLER_0_556 VPWR VGND sg13cmos5l_fill_1
XANTENNA__2501__X NN4BEG[6] VPWR VGND sg13cmos5l_antennanp
X_3180_ _3180_/X _3006_/X _3036_/X _0654_/X _3001_/X _1945_/Q _1946_/Q VPWR VGND sg13cmos5l_mux4_1
X_2200_ _2200_/Q FrameData[29] VGND VPWR FrameStrobe[4] latch
X_2131_ _2131_/Q FrameData[24] VGND VPWR FrameStrobe[6] latch
X_2062_ _2062_/Q FrameData[19] VGND VPWR FrameStrobe[8] latch
XFILLER_19_295 VPWR VGND sg13cmos5l_fill_2
XFILLER_22_449 VPWR VGND sg13cmos5l_fill_1
XFILLER_34_210 VPWR VGND sg13cmos5l_fill_1
X_1013_ _1013_/Y _1013_/A VPWR VGND sg13cmos5l_inv_1
X_2964_ _2964_/X _2932_/X _0865_/X _2929_/X _0856_/Y _2006_/Q _2007_/Q VPWR VGND sg13cmos5l_mux4_1
XFILLER_30_482 VPWR VGND sg13cmos5l_fill_2
X_1777_ _1777_/Q FrameData[22] VGND VPWR _1139_/X latch
X_2895_ _2895_/X N1END[0] N2MID[4] N2END[4] NN4END[0] _2273_/Q _2274_/Q VPWR VGND
+ sg13cmos5l_mux4_1
X_1915_ _1915_/Q FrameData[0] VGND VPWR _1137_/X latch
X_1846_ _1846_/Q FrameData[27] VGND VPWR _1136_/X latch
XANTENNA__2411__X E6BEG[4] VPWR VGND sg13cmos5l_antennanp
X_0659_ _2463_/A _3031_/X _3032_/X _1987_/Q VPWR VGND sg13cmos5l_mux2_1
X_0728_ _0728_/Y _2685_/X _1326_/Q _0727_/Y VPWR VGND sg13cmos5l_a21oi_1
XFILLER_25_232 VPWR VGND sg13cmos5l_fill_1
X_2329_ _2329_/Q FrameData[30] VGND VPWR FrameStrobe[0] latch
XFILLER_21_482 VPWR VGND sg13cmos5l_fill_2
XFILLER_25_287 VPWR VGND sg13cmos5l_decap_8
XFILLER_12_493 VPWR VGND sg13cmos5l_decap_4
X_1631_ _1631_/Q FrameData[4] VGND VPWR _1171_/X latch
X_1700_ _1700_/Q FrameData[9] VGND VPWR _1133_/X latch
X_2680_ _2680_/X _1321_/Q _1322_/Q _1323_/Q _1324_/Q _3256_/X _3251_/X VPWR VGND sg13cmos5l_mux4_1
X_1493_ _1493_/Q FrameData[26] VGND VPWR _1182_/X latch
X_1562_ _1562_/Q FrameData[31] VGND VPWR _1187_/X latch
X_3232_ _3232_/X _3228_/X _3229_/X _3230_/X _3231_/X _1819_/Q _1820_/Q VPWR VGND sg13cmos5l_mux4_1
X_3301_ _3301_/X E6END[0] WW4END[2] _1220_/Y _0658_/X _1670_/Q _1671_/Q VPWR VGND
+ sg13cmos5l_mux4_1
XFILLER_27_508 VPWR VGND sg13cmos5l_decap_4
XFILLER_39_346 VPWR VGND sg13cmos5l_fill_1
X_3094_ _3094_/X N2MID[0] E2END[6] S1END[0] W6END[0] _2164_/Q _2165_/Q VPWR VGND sg13cmos5l_mux4_1
X_3163_ _3163_/X _3160_/X _3161_/X _3162_/X _1160_/Y _2209_/Q _2210_/Q VPWR VGND sg13cmos5l_mux4_1
X_2114_ _2114_/Q FrameData[7] VGND VPWR FrameStrobe[6] latch
X_2045_ _2045_/Q FrameData[2] VGND VPWR FrameStrobe[8] latch
XANTENNA__2406__X EE4BEG[15] VPWR VGND sg13cmos5l_antennanp
X_2947_ _2947_/X _2943_/X _2944_/X _2945_/X _2946_/X _2080_/Q _2081_/Q VPWR VGND sg13cmos5l_mux4_1
X_2878_ _2878_/X _2467_/A _2958_/X _2519_/A _2603_/A _1977_/Q _1978_/Q VPWR VGND sg13cmos5l_mux4_1
X_1829_ _1829_/Q FrameData[10] VGND VPWR _1136_/X latch
XFILLER_18_519 VPWR VGND sg13cmos5l_decap_4
XFILLER_53_393 VPWR VGND sg13cmos5l_fill_1
XFILLER_13_246 VPWR VGND sg13cmos5l_fill_2
XFILLER_41_555 VPWR VGND sg13cmos5l_fill_2
XFILLER_0_172 VPWR VGND sg13cmos5l_fill_2
XFILLER_36_316 VPWR VGND sg13cmos5l_fill_2
XFILLER_32_555 VPWR VGND sg13cmos5l_fill_2
X_0993_ _0993_/Y _1814_/Q _0662_/A _0992_/Y VPWR VGND sg13cmos5l_o21ai_1
X_2801_ _2801_/X _2797_/X _2798_/X _2799_/X _2800_/X _1903_/Q _1904_/Q VPWR VGND sg13cmos5l_mux4_1
X_1614_ _1614_/Q FrameData[19] VGND VPWR _1189_/X latch
X_2732_ _2732_/X _1381_/Q _1389_/Q _1382_/Q _1390_/Q _2748_/X _3232_/X VPWR VGND sg13cmos5l_mux4_1
X_2663_ _2663_/X _3079_/X _2932_/X _3074_/X _3139_/X _1729_/Q _1730_/Q VPWR VGND sg13cmos5l_mux4_1
X_2594_ SS4BEG[15] _2594_/A VPWR VGND sg13cmos5l_buf_1
X_1476_ _1476_/Q FrameData[9] VGND VPWR _1182_/X latch
X_1545_ _1545_/Q FrameData[14] VGND VPWR _1187_/X latch
X_3215_ _3215_/X _3211_/X _3212_/X _3213_/X _3214_/X _1855_/Q _1856_/Q VPWR VGND sg13cmos5l_mux4_1
XFILLER_27_327 VPWR VGND sg13cmos5l_fill_2
XFILLER_39_198 VPWR VGND sg13cmos5l_fill_1
XFILLER_54_157 VPWR VGND sg13cmos5l_fill_2
X_3077_ _3077_/X W2MID[2] W2MID[7] W2END[0] WW4END[3] _2147_/Q _2148_/Q VPWR VGND
+ sg13cmos5l_mux4_1
X_3146_ _3146_/X N2MID[3] N2END[3] N4END[3] E2MID[1] _2242_/Q _2243_/Q VPWR VGND sg13cmos5l_mux4_1
X_2028_ _2028_/Q FrameData[17] VGND VPWR FrameStrobe[9] latch
XFILLER_40_25 VPWR VGND sg13cmos5l_fill_2
XANTENNA_101 FrameStrobe[2] VPWR VGND sg13cmos5l_antennanp
XANTENNA_112 FrameStrobe[2] VPWR VGND sg13cmos5l_antennanp
XANTENNA_123 FrameStrobe[2] VPWR VGND sg13cmos5l_antennanp
XFILLER_14_500 VPWR VGND sg13cmos5l_decap_4
X_1261_ _1261_/Q FrameData[18] VGND VPWR _1180_/X latch
X_1330_ _1330_/Q FrameData[23] VGND VPWR _1184_/X latch
X_1192_ _2427_/A _1192_/A VPWR VGND sg13cmos5l_inv_1
X_3000_ _3000_/X WW4END[2] _1243_/Q _1061_/Y _0833_/Y _2139_/Q _2140_/Q VPWR VGND
+ sg13cmos5l_mux4_1
XFILLER_32_374 VPWR VGND sg13cmos5l_fill_2
X_0976_ _0976_/Y _1782_/Q _0974_/A _0975_/Y VPWR VGND sg13cmos5l_a21oi_1
XFILLER_10_39 VPWR VGND sg13cmos5l_fill_2
X_2715_ _2715_/X _0631_/X _0658_/X _0654_/X _3001_/X _1797_/Q _1798_/Q VPWR VGND sg13cmos5l_mux4_1
X_2646_ _2646_/X _1257_/Q _1265_/Q _1258_/Q _1266_/Q _2661_/X _3268_/X VPWR VGND sg13cmos5l_mux4_1
X_2577_ FrameData_O[30] FrameData[30] VPWR VGND sg13cmos5l_buf_1
XFILLER_27_124 VPWR VGND sg13cmos5l_fill_2
X_1459_ _1459_/Q FrameData[24] VGND VPWR _1185_/X latch
X_1528_ _1528_/Q FrameData[29] VGND VPWR _1188_/X latch
XFILLER_23_330 VPWR VGND sg13cmos5l_decap_8
XFILLER_23_374 VPWR VGND sg13cmos5l_fill_2
X_3129_ _3129_/X W1END[0] _3129_/A1 _3129_/A2 _0808_/B _2262_/Q _2263_/Q VPWR VGND
+ sg13cmos5l_mux4_1
XFILLER_18_146 VPWR VGND sg13cmos5l_decap_8
XANTENNA__2504__X NN4BEG[9] VPWR VGND sg13cmos5l_antennanp
XFILLER_41_171 VPWR VGND sg13cmos5l_decap_8
X_0830_ _0830_/Y _0830_/A _0830_/B VPWR VGND sg13cmos5l_xnor2_1
X_0692_ _0692_/Y _2772_/X _1452_/Q _0691_/Y VPWR VGND sg13cmos5l_a21oi_1
X_0761_ _0761_/Y _1145_/A _1327_/Q _0757_/Y _0759_/Y _0878_/A VPWR VGND sg13cmos5l_a221oi_1
X_2500_ NN4BEG[5] NN4END[9] VPWR VGND sg13cmos5l_buf_1
X_2431_ E2BEG[4] _2958_/X VPWR VGND sg13cmos5l_buf_1
XFILLER_37_400 VPWR VGND sg13cmos5l_decap_4
X_1244_ _1244_/Q _1244_/CLK _1244_/D _2353_/L_HI VPWR VGND sg13cmos5l_dfrbpq_1
X_1313_ _1313_/Q FrameData[6] VGND VPWR _1184_/X latch
X_2362_ _2362_/L_HI VPWR VGND sg13cmos5l_tiehi
X_2293_ _2293_/Q FrameData[26] VGND VPWR FrameStrobe[1] latch
X_1175_ _1175_/Y _1910_/Q _2467_/A VPWR VGND sg13cmos5l_nor2_1
XANTENNA_12 N2END[0] VPWR VGND sg13cmos5l_antennanp
XANTENNA_23 S2END[6] VPWR VGND sg13cmos5l_antennanp
XANTENNA_34 S2END[6] VPWR VGND sg13cmos5l_antennanp
XANTENNA_45 W2END[1] VPWR VGND sg13cmos5l_antennanp
XANTENNA_56 W2END[1] VPWR VGND sg13cmos5l_antennanp
XANTENNA_67 W2END[2] VPWR VGND sg13cmos5l_antennanp
XANTENNA_78 WW4END[1] VPWR VGND sg13cmos5l_antennanp
XANTENNA_89 S2MID[3] VPWR VGND sg13cmos5l_antennanp
XANTENNA__2414__X E6BEG[7] VPWR VGND sg13cmos5l_antennanp
XFILLER_20_311 VPWR VGND sg13cmos5l_fill_2
XFILLER_32_160 VPWR VGND sg13cmos5l_fill_2
X_0959_ _2602_/A _2985_/X _2986_/X _2071_/Q VPWR VGND sg13cmos5l_mux2_1
X_2629_ WW4BEG[2] WW4END[6] VPWR VGND sg13cmos5l_buf_1
XFILLER_2_0 VPWR VGND sg13cmos5l_fill_1
X_2980_ _2980_/X _3074_/X _0865_/X _0862_/X _0807_/B _2000_/Q _2001_/Q VPWR VGND sg13cmos5l_mux4_1
X_0813_ _0813_/Y _2859_/X _1578_/Q _0812_/Y VPWR VGND sg13cmos5l_a21oi_1
X_1793_ _1793_/Q FrameData[6] VGND VPWR _1138_/X latch
X_1931_ _1931_/Q FrameData[16] VGND VPWR _1137_/X latch
X_1862_ _1862_/Q FrameData[11] VGND VPWR _1157_/X latch
X_0675_ _0675_/Y _1118_/A _1535_/Q _0673_/Y _0674_/Y _0671_/Y VPWR VGND sg13cmos5l_a221oi_1
X_0744_ _0749_/B _0740_/A _0740_/B _0741_/Y _0742_/Y _0743_/Y VPWR VGND sg13cmos5l_a221oi_1
X_2414_ E6BEG[7] E6END[9] VPWR VGND sg13cmos5l_buf_1
XANTENNA__2409__X E6BEG[2] VPWR VGND sg13cmos5l_antennanp
X_1158_ _1158_/Y _2208_/Q _1013_/Y _2207_/Q VPWR VGND sg13cmos5l_a21oi_1
X_1227_ _1227_/Y _1974_/Q _1223_/A _1226_/Y VPWR VGND sg13cmos5l_a21oi_1
X_2345_ _3095_/A2 VPWR VGND sg13cmos5l_tiehi
X_2276_ _2276_/Q FrameData[9] VGND VPWR FrameStrobe[1] latch
X_1089_ _1089_/Y _1089_/A _1372_/Q VPWR VGND sg13cmos5l_nand2_1
XFILLER_0_513 VPWR VGND sg13cmos5l_decap_8
XFILLER_43_266 VPWR VGND sg13cmos5l_fill_2
X_1012_ _1013_/A _1243_/Q _2323_/Q _1011_/Y VPWR VGND sg13cmos5l_a21oi_1
X_2130_ _2130_/Q FrameData[23] VGND VPWR FrameStrobe[6] latch
X_2061_ _2061_/Q FrameData[18] VGND VPWR FrameStrobe[8] latch
X_2963_ _2963_/X N2END[7] E1END[0] W2END[4] _2924_/X _2006_/Q _2007_/Q VPWR VGND sg13cmos5l_mux4_1
X_1914_ _1914_/Q FrameData[31] VGND VPWR _1152_/X latch
XFILLER_30_472 VPWR VGND sg13cmos5l_fill_2
X_0727_ _0727_/Y _1326_/Q _2690_/X VPWR VGND sg13cmos5l_nor2b_1
X_1776_ _1776_/Q FrameData[21] VGND VPWR _1139_/X latch
X_2894_ _2894_/X _1024_/Y _2894_/A1 _2894_/A2 _0986_/Y _2097_/Q _2098_/Q VPWR VGND
+ sg13cmos5l_mux4_1
X_1845_ _1845_/Q FrameData[26] VGND VPWR _1136_/X latch
X_0589_ _0589_/Y _2647_/X VPWR VGND sg13cmos5l_inv_1
X_0658_ _0658_/X _3060_/X _3061_/X _2102_/Q VPWR VGND sg13cmos5l_mux2_1
X_2328_ _2328_/Q FrameData[29] VGND VPWR FrameStrobe[0] latch
X_2259_ _2259_/Q FrameData[24] VGND VPWR FrameStrobe[2] latch
XANTENNA__2602__X W2BEG[3] VPWR VGND sg13cmos5l_antennanp
XFILLER_31_247 VPWR VGND sg13cmos5l_fill_2
XANTENNA__2512__X S1BEG[1] VPWR VGND sg13cmos5l_antennanp
X_1630_ _1630_/Q FrameData[3] VGND VPWR _1171_/X latch
X_1492_ _1492_/Q FrameData[25] VGND VPWR _1182_/X latch
X_1561_ _1561_/Q FrameData[30] VGND VPWR _1187_/X latch
X_3162_ _3162_/X SS4END[2] W2END[2] _0846_/Y _0906_/X _2207_/Q _2208_/Q VPWR VGND
+ sg13cmos5l_mux4_1
X_3231_ _3231_/X _0863_/X _2899_/X _0858_/X _2885_/X _1817_/Q _1818_/Q VPWR VGND sg13cmos5l_mux4_1
X_3300_ _3300_/X _3159_/X _0863_/X _0860_/X _1208_/Y _1673_/Q _1674_/Q VPWR VGND sg13cmos5l_mux4_1
XFILLER_47_391 VPWR VGND sg13cmos5l_fill_1
X_3093_ _3093_/X _3090_/X _3091_/X _3092_/X _1052_/Y _2185_/Q _2186_/Q VPWR VGND sg13cmos5l_mux4_1
X_2113_ _2113_/Q FrameData[6] VGND VPWR FrameStrobe[6] latch
X_2044_ _2044_/Q FrameData[1] VGND VPWR FrameStrobe[8] latch
XFILLER_22_225 VPWR VGND sg13cmos5l_fill_1
XFILLER_50_556 VPWR VGND sg13cmos5l_fill_1
X_2946_ _2946_/X _0848_/Y _1061_/Y _0840_/Y _0833_/Y _2078_/Q _2079_/Q VPWR VGND sg13cmos5l_mux4_1
X_2877_ _2877_/X _2469_/A _2433_/A _2521_/A _2947_/X _1981_/Q _1982_/Q VPWR VGND sg13cmos5l_mux4_1
XANTENNA__2422__X E2BEGb[3] VPWR VGND sg13cmos5l_antennanp
X_1759_ _1759_/Q FrameData[4] VGND VPWR _1139_/X latch
X_1828_ _1828_/Q FrameData[9] VGND VPWR _1136_/X latch
XFILLER_38_36 VPWR VGND sg13cmos5l_fill_2
XFILLER_57_166 VPWR VGND sg13cmos5l_fill_2
XFILLER_5_402 VPWR VGND sg13cmos5l_fill_1
XANTENNA__2507__X NN4BEG[12] VPWR VGND sg13cmos5l_antennanp
XFILLER_48_199 VPWR VGND sg13cmos5l_decap_4
X_0992_ _0992_/Y _2958_/X _1814_/Q VPWR VGND sg13cmos5l_nand2_1
X_2800_ _2800_/X _2899_/X _0861_/X _0860_/X _0858_/X _1901_/Q _1902_/Q VPWR VGND sg13cmos5l_mux4_1
X_2731_ _2731_/X _1379_/Q _1387_/Q _1380_/Q _1388_/Q _2748_/X _3232_/X VPWR VGND sg13cmos5l_mux4_1
X_1544_ _1544_/Q FrameData[13] VGND VPWR _1187_/X latch
X_1613_ _1613_/Q FrameData[18] VGND VPWR _1189_/X latch
X_2662_ _2662_/X _0630_/X _2924_/X _0656_/X _0654_/X _1729_/Q _1730_/Q VPWR VGND sg13cmos5l_mux4_1
X_2593_ SS4BEG[14] _2593_/A VPWR VGND sg13cmos5l_buf_1
X_1475_ _1475_/Q FrameData[8] VGND VPWR _1182_/X latch
X_3145_ _3145_/X _1053_/X _1054_/X _1045_/X _2158_/Q _2159_/Q _2160_/Q VPWR VGND sg13cmos5l_mux4_1
X_3214_ _3214_/X _2899_/X _0861_/X _0860_/X _3122_/X _1853_/Q _1854_/Q VPWR VGND sg13cmos5l_mux4_1
XANTENNA__2417__X E6BEG[10] VPWR VGND sg13cmos5l_antennanp
XFILLER_23_523 VPWR VGND sg13cmos5l_fill_1
XFILLER_35_394 VPWR VGND sg13cmos5l_decap_4
X_3076_ _3076_/X E2MID[6] E2END[6] S1END[0] W2MID[1] _2147_/Q _2148_/Q VPWR VGND sg13cmos5l_mux4_1
X_2027_ _2027_/Q FrameData[16] VGND VPWR FrameStrobe[9] latch
X_2929_ _2929_/X _2925_/X _2926_/X _2927_/X _2928_/X _2306_/Q _2307_/Q VPWR VGND sg13cmos5l_mux4_1
XFILLER_6_7 VPWR VGND sg13cmos5l_fill_2
XANTENNA_102 FrameStrobe[2] VPWR VGND sg13cmos5l_antennanp
XANTENNA_113 FrameStrobe[2] VPWR VGND sg13cmos5l_antennanp
XANTENNA_124 FrameStrobe[2] VPWR VGND sg13cmos5l_antennanp
XFILLER_14_556 VPWR VGND sg13cmos5l_fill_1
XFILLER_26_383 VPWR VGND sg13cmos5l_fill_1
X_1191_ _1192_/A _2971_/X _2012_/Q _1190_/Y VPWR VGND sg13cmos5l_a21oi_1
X_1260_ _1260_/Q FrameData[17] VGND VPWR _1180_/X latch
XFILLER_17_372 VPWR VGND sg13cmos5l_fill_2
XFILLER_32_320 VPWR VGND sg13cmos5l_fill_2
XFILLER_36_103 VPWR VGND sg13cmos5l_fill_1
XFILLER_36_169 VPWR VGND sg13cmos5l_fill_2
XFILLER_51_128 VPWR VGND sg13cmos5l_fill_2
X_0975_ _0975_/Y _1782_/Q _1226_/B VPWR VGND sg13cmos5l_nor2_1
X_2714_ _2714_/X _2710_/X _2711_/X _2712_/X _2713_/X _1807_/Q _1808_/Q VPWR VGND sg13cmos5l_mux4_1
X_1527_ _1527_/Q FrameData[28] VGND VPWR _1188_/X latch
X_2645_ _2645_/X _1255_/Q _1263_/Q _1256_/Q _1264_/Q _2661_/X _3268_/X VPWR VGND sg13cmos5l_mux4_1
X_2576_ FrameData_O[29] FrameData[29] VPWR VGND sg13cmos5l_buf_1
X_1389_ _1389_/Q FrameData[18] VGND VPWR _1181_/X latch
X_1458_ _1458_/Q FrameData[23] VGND VPWR _1185_/X latch
X_3128_ _3128_/X N2END[4] NN4END[0] E2END[2] S2END[4] _2262_/Q _2263_/Q VPWR VGND
+ sg13cmos5l_mux4_1
XFILLER_23_353 VPWR VGND sg13cmos5l_fill_2
X_3059_ _3059_/X _3055_/X _3056_/X _3057_/X _3058_/X _2137_/Q _2138_/Q VPWR VGND sg13cmos5l_mux4_1
XANTENNA__2610__X W2BEGb[3] VPWR VGND sg13cmos5l_antennanp
XFILLER_18_125 VPWR VGND sg13cmos5l_fill_2
XFILLER_14_342 VPWR VGND sg13cmos5l_fill_1
XFILLER_14_397 VPWR VGND sg13cmos5l_fill_1
X_0760_ _0876_/B _1145_/A _1327_/Q _0757_/Y _0759_/Y VPWR VGND sg13cmos5l_a22oi_1
XANTENNA__2520__X S2BEG[5] VPWR VGND sg13cmos5l_antennanp
X_0691_ _0691_/Y _1452_/Q _2777_/X VPWR VGND sg13cmos5l_nor2b_1
X_2430_ E2BEG[3] _2430_/A VPWR VGND sg13cmos5l_buf_1
X_2361_ _2361_/L_HI VPWR VGND sg13cmos5l_tiehi
XFILLER_2_52 VPWR VGND sg13cmos5l_fill_1
X_1174_ _2434_/A _1174_/A VPWR VGND sg13cmos5l_inv_1
X_1243_ _1243_/Q _1244_/CLK _1243_/D _2367_/L_HI VPWR VGND sg13cmos5l_dfrbpq_1
X_1312_ _1312_/Q FrameData[5] VGND VPWR _1184_/X latch
X_2292_ _2292_/Q FrameData[25] VGND VPWR FrameStrobe[1] latch
XANTENNA_13 N2END[0] VPWR VGND sg13cmos5l_antennanp
XFILLER_17_180 VPWR VGND sg13cmos5l_fill_1
XFILLER_32_183 VPWR VGND sg13cmos5l_decap_8
XANTENNA_24 S2END[6] VPWR VGND sg13cmos5l_antennanp
XANTENNA_35 S2END[6] VPWR VGND sg13cmos5l_antennanp
XANTENNA_46 W2END[1] VPWR VGND sg13cmos5l_antennanp
XANTENNA_57 W2END[1] VPWR VGND sg13cmos5l_antennanp
XANTENNA_68 W2MID[1] VPWR VGND sg13cmos5l_antennanp
XANTENNA_79 WW4END[1] VPWR VGND sg13cmos5l_antennanp
XANTENNA__2430__X E2BEG[3] VPWR VGND sg13cmos5l_antennanp
X_0889_ _0889_/Y _0901_/A VPWR VGND sg13cmos5l_inv_1
X_0958_ _2520_/A _0958_/A VPWR VGND sg13cmos5l_inv_1
X_2628_ WW4BEG[1] WW4END[5] VPWR VGND sg13cmos5l_buf_1
X_2559_ FrameData_O[12] FrameData[12] VPWR VGND sg13cmos5l_buf_1
XFILLER_55_220 VPWR VGND sg13cmos5l_fill_2
XANTENNA__2605__X W2BEG[6] VPWR VGND sg13cmos5l_antennanp
XFILLER_11_94 VPWR VGND sg13cmos5l_fill_1
XANTENNA__2515__X S2BEG[0] VPWR VGND sg13cmos5l_antennanp
X_1930_ _1930_/Q FrameData[15] VGND VPWR _1137_/X latch
X_0743_ _0743_/Y _2656_/X _1283_/Q VPWR VGND sg13cmos5l_nor2b_1
X_0812_ _0812_/Y _1578_/Q _2864_/X VPWR VGND sg13cmos5l_nor2b_1
X_1792_ _1792_/Q FrameData[5] VGND VPWR _1138_/X latch
X_1861_ _1861_/Q FrameData[10] VGND VPWR _1157_/X latch
X_0674_ _0674_/Y _0571_/Y _2824_/X _1535_/Q VPWR VGND sg13cmos5l_a21oi_1
X_2413_ E6BEG[6] E6END[8] VPWR VGND sg13cmos5l_buf_1
X_2344_ _3083_/A2 VPWR VGND sg13cmos5l_tiehi
XFILLER_37_231 VPWR VGND sg13cmos5l_decap_4
X_1157_ _1157_/X FrameStrobe[11] FrameStrobe[15] VPWR VGND sg13cmos5l_and2_1
X_1226_ _1226_/Y _1974_/Q _1226_/B VPWR VGND sg13cmos5l_nor2_1
X_2275_ _2275_/Q FrameData[8] VGND VPWR FrameStrobe[1] latch
XANTENNA__2425__X E2BEGb[6] VPWR VGND sg13cmos5l_antennanp
X_1088_ _1088_/Y _3234_/X _1376_/Q _1087_/Y VPWR VGND sg13cmos5l_a21oi_1
XFILLER_20_197 VPWR VGND sg13cmos5l_fill_1
XFILLER_24_492 VPWR VGND sg13cmos5l_decap_8
XFILLER_3_352 VPWR VGND sg13cmos5l_fill_1
XFILLER_34_234 VPWR VGND sg13cmos5l_fill_1
X_1011_ _1011_/Y _2323_/Q _1010_/Y VPWR VGND sg13cmos5l_nor2b_1
X_2060_ _2060_/Q FrameData[17] VGND VPWR FrameStrobe[8] latch
XFILLER_15_470 VPWR VGND sg13cmos5l_fill_2
X_2962_ _2962_/X _0869_/X _0866_/X _2885_/X _0808_/B _2072_/Q _2073_/Q VPWR VGND sg13cmos5l_mux4_1
X_2893_ _2893_/X NN4END[2] E2END[4] S2MID[2] W1END[2] _2097_/Q _2098_/Q VPWR VGND
+ sg13cmos5l_mux4_1
X_1913_ _1913_/Q FrameData[30] VGND VPWR _1152_/X latch
XFILLER_30_484 VPWR VGND sg13cmos5l_fill_1
X_0726_ _0887_/B _0726_/A VPWR VGND sg13cmos5l_inv_1
X_1775_ _1775_/Q FrameData[20] VGND VPWR _1139_/X latch
X_1844_ _1844_/Q FrameData[25] VGND VPWR _1136_/X latch
XFILLER_57_348 VPWR VGND sg13cmos5l_fill_1
X_0588_ _0984_/A _1239_/Q VPWR VGND sg13cmos5l_inv_1
X_0657_ _0657_/X _2904_/X _2905_/X _2125_/Q VPWR VGND sg13cmos5l_mux2_1
X_2327_ _2327_/Q FrameData[28] VGND VPWR FrameStrobe[0] latch
X_2258_ _2258_/Q FrameData[23] VGND VPWR FrameStrobe[2] latch
XFILLER_43_37 VPWR VGND sg13cmos5l_fill_1
XFILLER_53_543 VPWR VGND sg13cmos5l_fill_1
X_1209_ _1209_/Y _1942_/Q _1226_/B VPWR VGND sg13cmos5l_nor2_1
X_2189_ _2189_/Q FrameData[18] VGND VPWR FrameStrobe[4] latch
XANTENNA__1218__Y Co VPWR VGND sg13cmos5l_antennanp
XFILLER_48_315 VPWR VGND sg13cmos5l_decap_8
XFILLER_8_422 VPWR VGND sg13cmos5l_fill_2
X_1560_ _1560_/Q FrameData[29] VGND VPWR _1187_/X latch
X_1491_ _1491_/Q FrameData[24] VGND VPWR _1182_/X latch
X_3161_ _3161_/X E6END[0] S1END[2] S2MID[6] S2END[6] _2207_/Q _2208_/Q VPWR VGND sg13cmos5l_mux4_1
X_3230_ _3230_/X _3117_/X _0872_/X _0868_/X _3107_/X _1817_/Q _1818_/Q VPWR VGND sg13cmos5l_mux4_1
X_2112_ _2112_/Q FrameData[5] VGND VPWR FrameStrobe[6] latch
XFILLER_54_329 VPWR VGND sg13cmos5l_fill_2
X_3092_ _3092_/X SS4END[1] W2MID[1] W2END[1] W6END[1] _2183_/Q _2184_/Q VPWR VGND
+ sg13cmos5l_mux4_1
X_2043_ _2043_/Q FrameData[0] VGND VPWR FrameStrobe[8] latch
X_1827_ _1827_/Q FrameData[8] VGND VPWR _1136_/X latch
X_2945_ _2945_/X _0856_/Y _0986_/Y _1056_/Y _1027_/Y _2078_/Q _2079_/Q VPWR VGND sg13cmos5l_mux4_1
X_2876_ _2876_/X _2468_/A _2432_/A _2520_/A _2604_/A _1979_/Q _1980_/Q VPWR VGND sg13cmos5l_mux4_1
X_0709_ _0711_/D _0704_/Y _0705_/X _0708_/Y VPWR VGND sg13cmos5l_a21oi_1
X_1689_ _1689_/Q FrameData[30] VGND VPWR _1167_/X latch
X_1758_ _1758_/Q FrameData[3] VGND VPWR _1139_/X latch
XFILLER_57_134 VPWR VGND sg13cmos5l_fill_1
XANTENNA__2613__X W2BEGb[6] VPWR VGND sg13cmos5l_antennanp
XFILLER_0_185 VPWR VGND sg13cmos5l_fill_2
XFILLER_17_554 VPWR VGND sg13cmos5l_fill_2
XFILLER_32_502 VPWR VGND sg13cmos5l_fill_1
XANTENNA__2523__X S2BEGb[0] VPWR VGND sg13cmos5l_antennanp
X_0991_ _0991_/X _2666_/X _2671_/X _1291_/Q VPWR VGND sg13cmos5l_mux2_1
X_2730_ _2730_/X _1377_/Q _1385_/Q _1378_/Q _1386_/Q _2748_/X _3232_/X VPWR VGND sg13cmos5l_mux4_1
X_2661_ _2661_/X _2657_/X _2658_/X _2659_/X _2660_/X _1735_/Q _1736_/Q VPWR VGND sg13cmos5l_mux4_1
X_1474_ _1474_/Q FrameData[7] VGND VPWR _1182_/X latch
X_1543_ _1543_/Q FrameData[12] VGND VPWR _1187_/X latch
X_1612_ _1612_/Q FrameData[17] VGND VPWR _1189_/X latch
X_2592_ SS4BEG[13] _2592_/A VPWR VGND sg13cmos5l_buf_1
XFILLER_39_112 VPWR VGND sg13cmos5l_fill_2
X_3075_ _3075_/X N2MID[0] N2END[0] N4END[0] E1END[2] _2147_/Q _2148_/Q VPWR VGND sg13cmos5l_mux4_1
X_3144_ _3144_/X _3140_/X _3141_/X _3142_/X _3143_/X _2177_/Q _2178_/Q VPWR VGND sg13cmos5l_mux4_1
X_3213_ _3213_/X _3117_/X _3159_/X _0868_/X _3107_/X _1853_/Q _1854_/Q VPWR VGND sg13cmos5l_mux4_1
XFILLER_35_351 VPWR VGND sg13cmos5l_fill_1
X_2026_ _2026_/Q FrameData[15] VGND VPWR FrameStrobe[9] latch
XANTENNA__2433__X E2BEG[6] VPWR VGND sg13cmos5l_antennanp
X_2928_ _2928_/X W2END[5] WW4END[3] _0807_/B _1208_/Y _2304_/Q _2305_/Q VPWR VGND
+ sg13cmos5l_mux4_1
X_2859_ _2859_/X _2855_/X _2856_/X _2857_/X _2858_/X _1967_/Q _1968_/Q VPWR VGND sg13cmos5l_mux4_1
XFILLER_49_47 VPWR VGND sg13cmos5l_fill_2
XANTENNA_103 FrameStrobe[2] VPWR VGND sg13cmos5l_antennanp
XANTENNA_114 FrameStrobe[2] VPWR VGND sg13cmos5l_antennanp
XANTENNA_125 FrameStrobe[2] VPWR VGND sg13cmos5l_antennanp
XANTENNA__2608__X W2BEGb[1] VPWR VGND sg13cmos5l_antennanp
XFILLER_45_104 VPWR VGND sg13cmos5l_fill_2
XFILLER_45_159 VPWR VGND sg13cmos5l_fill_1
XANTENNA__2518__X S2BEG[3] VPWR VGND sg13cmos5l_antennanp
X_1190_ _1190_/Y _2012_/Q _2970_/X VPWR VGND sg13cmos5l_nor2b_1
X_0974_ _0974_/Y _0974_/A VPWR VGND sg13cmos5l_inv_1
X_2713_ _2713_/X _3127_/X _0862_/X _0860_/X _0858_/X _1805_/Q _1806_/Q VPWR VGND sg13cmos5l_mux4_1
X_2644_ _2644_/X _1253_/Q _1261_/Q _1254_/Q _1262_/Q _2661_/X _3268_/X VPWR VGND sg13cmos5l_mux4_1
X_1457_ _1457_/Q FrameData[22] VGND VPWR _1185_/X latch
X_1526_ _1526_/Q FrameData[27] VGND VPWR _1188_/X latch
X_2575_ FrameData_O[28] FrameData[28] VPWR VGND sg13cmos5l_buf_1
XANTENNA__2428__X E2BEG[1] VPWR VGND sg13cmos5l_antennanp
XFILLER_27_126 VPWR VGND sg13cmos5l_fill_1
XFILLER_27_137 VPWR VGND sg13cmos5l_fill_2
X_1388_ _1388_/Q FrameData[17] VGND VPWR _1181_/X latch
X_3058_ _3058_/X W2END[7] _0805_/B _1208_/Y _0833_/Y _2135_/Q _2136_/Q VPWR VGND sg13cmos5l_mux4_1
X_3127_ _3127_/X _3123_/X _3124_/X _3125_/X _3126_/X _2271_/Q _2272_/Q VPWR VGND sg13cmos5l_mux4_1
X_2009_ _2009_/Q FrameData[30] VGND VPWR FrameStrobe[10] latch
XFILLER_6_520 VPWR VGND sg13cmos5l_fill_2
X_0690_ _0836_/A _0690_/A VPWR VGND sg13cmos5l_inv_1
X_1311_ _1311_/Q FrameData[4] VGND VPWR _1184_/X latch
X_2360_ _2360_/L_HI VPWR VGND sg13cmos5l_tiehi
X_2291_ _2291_/Q FrameData[24] VGND VPWR FrameStrobe[1] latch
X_1173_ _1174_/A _2934_/X _2034_/Q _1172_/Y VPWR VGND sg13cmos5l_a21oi_1
X_1242_ _1242_/Q _1244_/CLK _1242_/D _2364_/L_HI VPWR VGND sg13cmos5l_dfrbpq_1
XANTENNA_14 N2END[0] VPWR VGND sg13cmos5l_antennanp
XANTENNA_25 S2END[6] VPWR VGND sg13cmos5l_antennanp
XANTENNA_36 S2END[6] VPWR VGND sg13cmos5l_antennanp
XANTENNA_47 W2END[1] VPWR VGND sg13cmos5l_antennanp
XANTENNA_58 W2END[1] VPWR VGND sg13cmos5l_antennanp
XANTENNA_69 W2MID[1] VPWR VGND sg13cmos5l_antennanp
X_0888_ _0901_/A _1373_/Q _0886_/Y _0887_/Y VPWR VGND sg13cmos5l_o21ai_1
X_0957_ _0958_/A _2951_/X _2053_/Q _0956_/Y VPWR VGND sg13cmos5l_a21oi_1
X_2627_ WW4BEG[0] WW4END[4] VPWR VGND sg13cmos5l_buf_1
X_1509_ _1509_/Q FrameData[10] VGND VPWR _1188_/X latch
X_2558_ FrameData_O[11] FrameData[11] VPWR VGND sg13cmos5l_buf_1
X_2489_ N4BEG[10] N4END[14] VPWR VGND sg13cmos5l_buf_1
XFILLER_23_140 VPWR VGND sg13cmos5l_fill_1
XFILLER_55_287 VPWR VGND sg13cmos5l_fill_1
XANTENNA__2621__X W6BEG[6] VPWR VGND sg13cmos5l_antennanp
XFILLER_11_40 VPWR VGND sg13cmos5l_fill_2
XFILLER_3_556 VPWR VGND sg13cmos5l_fill_1
X_1860_ _1860_/Q FrameData[9] VGND VPWR _1157_/X latch
XANTENNA__2531__X S4BEG[0] VPWR VGND sg13cmos5l_antennanp
X_0673_ _0673_/Y _2840_/X _2825_/X VPWR VGND sg13cmos5l_nand2_1
X_0742_ _0742_/Y _2666_/X _2651_/X _1283_/Q VPWR VGND sg13cmos5l_a21oi_1
X_0811_ _0811_/Y _2850_/X _0811_/B VPWR VGND sg13cmos5l_nor2_1
X_1791_ _1791_/Q FrameData[4] VGND VPWR _1138_/X latch
X_2412_ E6BEG[5] E6END[7] VPWR VGND sg13cmos5l_buf_1
X_2343_ _3165_/A2 VPWR VGND sg13cmos5l_tiehi
X_2274_ _2274_/Q FrameData[7] VGND VPWR FrameStrobe[1] latch
X_1087_ _1087_/Y _3234_/X _3233_/X VPWR VGND sg13cmos5l_nor2_1
X_1156_ _1241_/D _1025_/A _1093_/Y _1094_/Y _1155_/X VPWR VGND sg13cmos5l_a22oi_1
X_1225_ _1225_/Y _1971_/Q _1223_/A _1224_/Y VPWR VGND sg13cmos5l_a21oi_1
XANTENNA__2441__X FrameStrobe_O[2] VPWR VGND sg13cmos5l_antennanp
XFILLER_20_154 VPWR VGND sg13cmos5l_decap_4
XFILLER_33_493 VPWR VGND sg13cmos5l_fill_1
X_1989_ _1989_/Q FrameData[10] VGND VPWR FrameStrobe[10] latch
XFILLER_28_221 VPWR VGND sg13cmos5l_decap_8
XANTENNA__2616__X W6BEG[1] VPWR VGND sg13cmos5l_antennanp
XFILLER_3_320 VPWR VGND sg13cmos5l_fill_1
XANTENNA__2526__X S2BEGb[3] VPWR VGND sg13cmos5l_antennanp
X_1010_ _1010_/Y _0577_/Y _1455_/Q _1009_/Y VPWR VGND sg13cmos5l_a21oi_1
XFILLER_15_493 VPWR VGND sg13cmos5l_fill_2
XFILLER_30_474 VPWR VGND sg13cmos5l_fill_1
XFILLER_34_268 VPWR VGND sg13cmos5l_decap_4
X_2961_ _2961_/X N2MID[5] S1END[1] W2END[2] _3100_/X _2072_/Q _2073_/Q VPWR VGND sg13cmos5l_mux4_1
X_2892_ _2892_/X W2END[2] _1241_/Q _0906_/X _1013_/Y _2228_/Q _2229_/Q VPWR VGND sg13cmos5l_mux4_1
X_1912_ _1912_/Q FrameData[29] VGND VPWR _1152_/X latch
X_1843_ _1843_/Q FrameData[24] VGND VPWR _1136_/X latch
XFILLER_40_0 VPWR VGND sg13cmos5l_fill_1
X_0656_ _0656_/X _2879_/X _2880_/X _2128_/Q VPWR VGND sg13cmos5l_mux2_1
X_0725_ _0726_/A _0723_/D _0724_/B _0724_/Y VPWR VGND sg13cmos5l_o21ai_1
X_1774_ _1774_/Q FrameData[19] VGND VPWR _1139_/X latch
XFILLER_27_17 VPWR VGND sg13cmos5l_fill_1
X_0587_ _0972_/A _1237_/Q VPWR VGND sg13cmos5l_inv_1
X_1208_ _1208_/Y _1208_/A VPWR VGND sg13cmos5l_inv_1
X_2326_ _2326_/Q FrameData[27] VGND VPWR FrameStrobe[0] latch
X_2257_ _2257_/Q FrameData[22] VGND VPWR FrameStrobe[2] latch
XANTENNA__2436__X E1BEG[1] VPWR VGND sg13cmos5l_antennanp
XFILLER_40_227 VPWR VGND sg13cmos5l_decap_8
XFILLER_40_238 VPWR VGND sg13cmos5l_fill_2
X_1139_ _1139_/X FrameStrobe[11] FrameStrobe[18] VPWR VGND sg13cmos5l_and2_1
X_2188_ _2188_/Q FrameData[17] VGND VPWR FrameStrobe[4] latch
XFILLER_3_172 VPWR VGND sg13cmos5l_fill_1
X_1490_ _1490_/Q FrameData[23] VGND VPWR _1182_/X latch
X_3091_ _3091_/X E2END[7] S1END[1] S2MID[5] S2END[5] _2183_/Q _2184_/Q VPWR VGND sg13cmos5l_mux4_1
X_3160_ _3160_/X N2MID[2] N2END[2] N4END[2] E2MID[0] _2207_/Q _2208_/Q VPWR VGND sg13cmos5l_mux4_1
X_2111_ _2111_/Q FrameData[4] VGND VPWR FrameStrobe[6] latch
X_2042_ _2042_/Q FrameData[31] VGND VPWR FrameStrobe[9] latch
XFILLER_22_216 VPWR VGND sg13cmos5l_decap_8
XFILLER_35_555 VPWR VGND sg13cmos5l_fill_2
XFILLER_50_547 VPWR VGND sg13cmos5l_fill_1
X_1826_ _1826_/Q FrameData[7] VGND VPWR _1136_/X latch
X_2944_ _2944_/X _0869_/X _2890_/X _2885_/X _0921_/Y _2078_/Q _2079_/Q VPWR VGND sg13cmos5l_mux4_1
X_2875_ _2875_/X _2967_/X _2434_/A _2522_/A _2606_/A _1983_/Q _1984_/Q VPWR VGND sg13cmos5l_mux4_1
X_0639_ _0639_/X _3044_/X _3045_/X _2192_/Q VPWR VGND sg13cmos5l_mux2_1
X_0708_ _0708_/Y _1153_/A _1409_/Q _0706_/Y _0707_/Y _0704_/Y VPWR VGND sg13cmos5l_a221oi_1
X_1688_ _1688_/Q FrameData[29] VGND VPWR _1167_/X latch
X_1757_ _1757_/Q FrameData[2] VGND VPWR _1139_/X latch
XFILLER_26_500 VPWR VGND sg13cmos5l_decap_8
XFILLER_54_37 VPWR VGND sg13cmos5l_fill_1
X_3289_ _3289_/X E1END[0] S2MID[4] W6END[0] _0655_/X _1688_/Q _1689_/Q VPWR VGND sg13cmos5l_mux4_1
X_2309_ _2309_/Q FrameData[10] VGND VPWR FrameStrobe[0] latch
XFILLER_48_168 VPWR VGND sg13cmos5l_fill_2
XFILLER_29_393 VPWR VGND sg13cmos5l_fill_1
X_0990_ _0990_/Y _1814_/Q _0986_/A _0989_/Y VPWR VGND sg13cmos5l_a21oi_1
X_1611_ _1611_/Q FrameData[16] VGND VPWR _1189_/X latch
X_2660_ _2660_/X _0863_/X _2899_/X _2929_/X _0857_/X _1733_/Q _1734_/Q VPWR VGND sg13cmos5l_mux4_1
XFILLER_4_470 VPWR VGND sg13cmos5l_decap_8
XFILLER_5_97 VPWR VGND sg13cmos5l_fill_2
X_1473_ _1473_/Q FrameData[6] VGND VPWR _1182_/X latch
X_1542_ _1542_/Q FrameData[11] VGND VPWR _1187_/X latch
X_3212_ _3212_/X _3145_/X _3050_/X _3074_/X _3139_/X _1853_/Q _1854_/Q VPWR VGND sg13cmos5l_mux4_1
X_2591_ SS4BEG[12] _2591_/A VPWR VGND sg13cmos5l_buf_1
XFILLER_27_319 VPWR VGND sg13cmos5l_fill_1
XFILLER_39_168 VPWR VGND sg13cmos5l_fill_2
X_3074_ _3074_/X _3070_/X _3071_/X _3072_/X _3073_/X _2181_/Q _2182_/Q VPWR VGND sg13cmos5l_mux4_1
X_3143_ _3143_/X _1245_/Q _1051_/C _0807_/B _0840_/Y _2175_/Q _2176_/Q VPWR VGND sg13cmos5l_mux4_1
X_2025_ _2025_/Q FrameData[14] VGND VPWR FrameStrobe[9] latch
XFILLER_10_219 VPWR VGND sg13cmos5l_fill_2
X_2927_ _2927_/X S2END[1] S4END[1] W1END[1] W2MID[5] _2304_/Q _2305_/Q VPWR VGND sg13cmos5l_mux4_1
XFILLER_2_418 VPWR VGND sg13cmos5l_fill_2
XFILLER_40_17 VPWR VGND sg13cmos5l_fill_1
X_1809_ _1809_/Q FrameData[22] VGND VPWR _1138_/X latch
X_2858_ _2858_/X _2899_/X _0861_/X _0860_/X _2885_/X _1965_/Q _1966_/Q VPWR VGND sg13cmos5l_mux4_1
X_2789_ _2789_/X _1463_/Q _1471_/Q _1464_/Q _1472_/Q _2806_/X _3208_/X VPWR VGND sg13cmos5l_mux4_1
XANTENNA_104 FrameStrobe[2] VPWR VGND sg13cmos5l_antennanp
XANTENNA_115 FrameStrobe[2] VPWR VGND sg13cmos5l_antennanp
XANTENNA_126 FrameStrobe[2] VPWR VGND sg13cmos5l_antennanp
XFILLER_26_330 VPWR VGND sg13cmos5l_fill_1
XFILLER_26_352 VPWR VGND sg13cmos5l_decap_8
XFILLER_41_322 VPWR VGND sg13cmos5l_decap_8
XANTENNA__2624__X W6BEG[9] VPWR VGND sg13cmos5l_antennanp
XANTENNA__2534__X S4BEG[3] VPWR VGND sg13cmos5l_antennanp
XFILLER_17_341 VPWR VGND sg13cmos5l_decap_8
XFILLER_17_363 VPWR VGND sg13cmos5l_fill_2
XFILLER_17_374 VPWR VGND sg13cmos5l_fill_1
X_0973_ _0974_/A _2317_/Q _0971_/Y _0972_/Y VPWR VGND sg13cmos5l_o21ai_1
X_2712_ _2712_/X _3159_/X _0869_/X _2917_/X _0866_/X _1805_/Q _1806_/Q VPWR VGND sg13cmos5l_mux4_1
X_2643_ _2643_/X _1251_/Q _1259_/Q _1252_/Q _1260_/Q _2661_/X _3268_/X VPWR VGND sg13cmos5l_mux4_1
X_2574_ FrameData_O[27] FrameData[27] VPWR VGND sg13cmos5l_buf_1
X_1387_ _1387_/Q FrameData[16] VGND VPWR _1181_/X latch
X_1456_ _1456_/Q FrameData[21] VGND VPWR _1185_/X latch
X_1525_ _1525_/Q FrameData[26] VGND VPWR _1188_/X latch
XFILLER_55_425 VPWR VGND sg13cmos5l_fill_1
X_3057_ _3057_/X S2MID[3] S2END[3] W1END[3] W2MID[7] _2135_/Q _2136_/Q VPWR VGND sg13cmos5l_mux4_1
X_3126_ _3126_/X W2MID[4] W2END[4] WW4END[2] _0971_/Y _2269_/Q _2270_/Q VPWR VGND
+ sg13cmos5l_mux4_1
X_2008_ _2008_/Q FrameData[29] VGND VPWR FrameStrobe[10] latch
XANTENNA__2444__X FrameStrobe_O[5] VPWR VGND sg13cmos5l_antennanp
XFILLER_23_355 VPWR VGND sg13cmos5l_fill_1
Xclkbuf_2_1__f_Inst_LA_FLUT51PSDM_architecture.UserCLK _1244_/CLK clkbuf_0_Inst_LA_FLUT51PSDM_architecture.UserCLK/X
+ VPWR VGND sg13cmos5l_buf_16
XANTENNA__2619__X W6BEG[4] VPWR VGND sg13cmos5l_antennanp
XFILLER_18_127 VPWR VGND sg13cmos5l_fill_1
XFILLER_18_138 VPWR VGND sg13cmos5l_fill_1
XFILLER_14_311 VPWR VGND sg13cmos5l_fill_1
XFILLER_26_182 VPWR VGND sg13cmos5l_fill_2
XFILLER_6_532 VPWR VGND sg13cmos5l_fill_1
XANTENNA__2529__X S2BEGb[6] VPWR VGND sg13cmos5l_antennanp
X_1241_ _1241_/Q _1244_/CLK _1241_/D _2354_/L_HI VPWR VGND sg13cmos5l_dfrbpq_1
X_1310_ _1310_/Q FrameData[3] VGND VPWR _1184_/X latch
X_2290_ _2290_/Q FrameData[23] VGND VPWR FrameStrobe[1] latch
XFILLER_37_425 VPWR VGND sg13cmos5l_fill_1
X_1172_ _1172_/Y _2034_/Q _2933_/X VPWR VGND sg13cmos5l_nor2b_1
XANTENNA_15 N2END[0] VPWR VGND sg13cmos5l_antennanp
XANTENNA_26 S2END[6] VPWR VGND sg13cmos5l_antennanp
XANTENNA_37 S2END[6] VPWR VGND sg13cmos5l_antennanp
XANTENNA_48 W2END[1] VPWR VGND sg13cmos5l_antennanp
XANTENNA_59 W2END[1] VPWR VGND sg13cmos5l_antennanp
XFILLER_32_130 VPWR VGND sg13cmos5l_fill_2
X_0956_ _0956_/Y _2053_/Q _2950_/X VPWR VGND sg13cmos5l_nor2b_1
X_0887_ _0887_/Y _1373_/Q _0887_/B VPWR VGND sg13cmos5l_nand2_1
X_2626_ W6BEG[11] _2626_/A VPWR VGND sg13cmos5l_buf_1
X_2557_ FrameData_O[10] FrameData[10] VPWR VGND sg13cmos5l_buf_1
XANTENNA__2439__X FrameStrobe_O[0] VPWR VGND sg13cmos5l_antennanp
X_1439_ _1439_/Q FrameData[4] VGND VPWR _1185_/X latch
X_1508_ _1508_/Q FrameData[9] VGND VPWR _1188_/X latch
X_2488_ N4BEG[9] N4END[13] VPWR VGND sg13cmos5l_buf_1
X_3109_ _3109_/X E2MID[4] E2END[0] E6END[0] S1END[2] _2211_/Q _2212_/Q VPWR VGND sg13cmos5l_mux4_1
XFILLER_36_71 VPWR VGND sg13cmos5l_fill_1
XFILLER_46_277 VPWR VGND sg13cmos5l_decap_8
X_0810_ _0811_/B _2874_/X _1585_/Q VPWR VGND sg13cmos5l_or2_1
X_1790_ _1790_/Q FrameData[3] VGND VPWR _1138_/X latch
XFILLER_6_340 VPWR VGND sg13cmos5l_fill_1
XFILLER_6_395 VPWR VGND sg13cmos5l_fill_1
X_0672_ _0672_/X _2822_/X _2823_/X _2840_/X VPWR VGND sg13cmos5l_mux2_1
X_0741_ _0741_/Y _2666_/X _2650_/X VPWR VGND sg13cmos5l_nand2b_1
X_2411_ E6BEG[4] E6END[6] VPWR VGND sg13cmos5l_buf_1
XFILLER_37_200 VPWR VGND sg13cmos5l_decap_4
X_1224_ _1224_/Y _1971_/Q _1224_/B VPWR VGND sg13cmos5l_nor2_1
X_2342_ _2990_/A2 VPWR VGND sg13cmos5l_tiehi
X_2273_ _2273_/Q FrameData[6] VGND VPWR FrameStrobe[1] latch
X_1086_ _1235_/D _0919_/A _1074_/Y _1075_/Y _1085_/Y VPWR VGND sg13cmos5l_a22oi_1
X_1155_ _1155_/X _3222_/X _1155_/B VPWR VGND sg13cmos5l_or2_1
X_0939_ _0939_/Y _2015_/Q _3027_/X VPWR VGND sg13cmos5l_nor2b_1
X_1988_ _1988_/Q FrameData[9] VGND VPWR FrameStrobe[10] latch
XFILLER_0_527 VPWR VGND sg13cmos5l_decap_8
X_2609_ W2BEGb[2] W2MID[2] VPWR VGND sg13cmos5l_buf_1
XFILLER_28_266 VPWR VGND sg13cmos5l_fill_1
XFILLER_28_288 VPWR VGND sg13cmos5l_fill_2
XANTENNA__2632__X WW4BEG[5] VPWR VGND sg13cmos5l_antennanp
XFILLER_51_291 VPWR VGND sg13cmos5l_fill_1
XFILLER_22_51 VPWR VGND sg13cmos5l_fill_1
XFILLER_0_0 VPWR VGND sg13cmos5l_fill_1
XFILLER_19_288 VPWR VGND sg13cmos5l_decap_8
X_2960_ _2960_/X _0870_/X _0867_/X _3122_/X _1061_/Y _2048_/Q _2049_/Q VPWR VGND sg13cmos5l_mux4_1
XANTENNA__2542__X S4BEG[11] VPWR VGND sg13cmos5l_antennanp
X_1773_ _1773_/Q FrameData[18] VGND VPWR _1139_/X latch
X_2891_ _2891_/X N2END[2] N4END[2] E2MID[0] SS4END[2] _2228_/Q _2229_/Q VPWR VGND
+ sg13cmos5l_mux4_1
X_1911_ _1911_/Q FrameData[28] VGND VPWR _1152_/X latch
X_1842_ _1842_/Q FrameData[23] VGND VPWR _1136_/X latch
X_0586_ _0919_/A _1235_/Q VPWR VGND sg13cmos5l_inv_1
X_0655_ _0655_/X _3130_/X _3131_/X _2131_/Q VPWR VGND sg13cmos5l_mux2_1
X_0724_ _0724_/Y _2705_/X _0724_/B VPWR VGND sg13cmos5l_nand2_1
X_1207_ _1208_/A _2327_/Q _1205_/Y _1206_/Y VPWR VGND sg13cmos5l_o21ai_1
X_2325_ _2325_/Q FrameData[26] VGND VPWR FrameStrobe[0] latch
X_2256_ _2256_/Q FrameData[21] VGND VPWR FrameStrobe[2] latch
X_2187_ _2187_/Q FrameData[16] VGND VPWR FrameStrobe[4] latch
XANTENNA__2452__X FrameStrobe_O[13] VPWR VGND sg13cmos5l_antennanp
XFILLER_25_225 VPWR VGND sg13cmos5l_decap_8
XFILLER_25_258 VPWR VGND sg13cmos5l_decap_4
XFILLER_43_28 VPWR VGND sg13cmos5l_fill_1
XFILLER_53_556 VPWR VGND sg13cmos5l_fill_1
X_1069_ _1069_/Y _1458_/Q _0702_/Y _3210_/X VPWR VGND sg13cmos5l_a21oi_1
X_1138_ _1138_/X FrameStrobe[11] FrameStrobe[17] VPWR VGND sg13cmos5l_and2_1
XANTENNA__2627__X WW4BEG[0] VPWR VGND sg13cmos5l_antennanp
XFILLER_12_497 VPWR VGND sg13cmos5l_fill_2
XFILLER_24_280 VPWR VGND sg13cmos5l_fill_2
XANTENNA__2537__X S4BEG[6] VPWR VGND sg13cmos5l_antennanp
X_3090_ _3090_/X N2MID[1] N2END[1] N4END[1] E1END[3] _2183_/Q _2184_/Q VPWR VGND sg13cmos5l_mux4_1
X_2110_ _2110_/Q FrameData[3] VGND VPWR FrameStrobe[6] latch
X_2041_ _2041_/Q FrameData[30] VGND VPWR FrameStrobe[9] latch
X_2943_ _2943_/X N1END[3] S2END[3] W2MID[1] _0656_/X _2078_/Q _2079_/Q VPWR VGND sg13cmos5l_mux4_1
XFILLER_7_490 VPWR VGND sg13cmos5l_fill_1
X_0707_ _0707_/Y _0572_/Y _2737_/X _1409_/Q VPWR VGND sg13cmos5l_a21oi_1
X_1756_ _1756_/Q FrameData[1] VGND VPWR _1139_/X latch
X_1825_ _1825_/Q FrameData[6] VGND VPWR _1136_/X latch
X_2874_ _2874_/X _2870_/X _2871_/X _2872_/X _2873_/X _1963_/Q _1964_/Q VPWR VGND sg13cmos5l_mux4_1
XFILLER_57_103 VPWR VGND sg13cmos5l_fill_2
X_0569_ _0569_/Y _2859_/X VPWR VGND sg13cmos5l_inv_1
X_0638_ _2598_/A _3281_/X _3282_/X _1702_/Q VPWR VGND sg13cmos5l_mux2_1
X_1687_ _1687_/Q FrameData[28] VGND VPWR _1167_/X latch
X_2308_ _2308_/Q FrameData[9] VGND VPWR FrameStrobe[0] latch
XANTENNA__2447__X FrameStrobe_O[8] VPWR VGND sg13cmos5l_antennanp
X_3288_ _3288_/X _3163_/X _0868_/X _3010_/X _0856_/Y _1691_/Q _1692_/Q VPWR VGND sg13cmos5l_mux4_1
X_2239_ _2239_/Q FrameData[4] VGND VPWR FrameStrobe[2] latch
XFILLER_5_438 VPWR VGND sg13cmos5l_fill_2
XFILLER_17_523 VPWR VGND sg13cmos5l_fill_1
XFILLER_17_556 VPWR VGND sg13cmos5l_fill_1
XFILLER_12_250 VPWR VGND sg13cmos5l_decap_8
X_1610_ _1610_/Q FrameData[15] VGND VPWR _1189_/X latch
X_2590_ SS4BEG[11] SS4END[15] VPWR VGND sg13cmos5l_buf_1
X_1472_ _1472_/Q FrameData[5] VGND VPWR _1182_/X latch
X_1541_ _1541_/Q FrameData[10] VGND VPWR _1187_/X latch
X_3142_ _3142_/X SS4END[1] W2END[5] WW4END[1] W6END[0] _2175_/Q _2176_/Q VPWR VGND
+ sg13cmos5l_mux4_1
X_3211_ _3211_/X _0631_/X _0629_/X _3059_/X _3087_/X _1853_/Q _1854_/Q VPWR VGND sg13cmos5l_mux4_1
XFILLER_35_342 VPWR VGND sg13cmos5l_decap_8
X_3073_ _3073_/X WW4END[1] _1051_/C _0986_/Y _1027_/Y _2179_/Q _2180_/Q VPWR VGND
+ sg13cmos5l_mux4_1
X_2024_ _2024_/Q FrameData[13] VGND VPWR FrameStrobe[9] latch
X_2926_ _2926_/X E2MID[3] E2END[3] EE4END[1] S2MID[1] _2304_/Q _2305_/Q VPWR VGND
+ sg13cmos5l_mux4_1
X_2857_ _2857_/X _0871_/X _0869_/X _3150_/X _0865_/X _1965_/Q _1966_/Q VPWR VGND sg13cmos5l_mux4_1
X_1739_ _1739_/Q FrameData[16] VGND VPWR _1177_/X latch
X_1808_ _1808_/Q FrameData[21] VGND VPWR _1138_/X latch
X_2788_ _2788_/X _1461_/Q _1469_/Q _1462_/Q _1470_/Q _2806_/X _3208_/X VPWR VGND sg13cmos5l_mux4_1
XANTENNA_105 FrameStrobe[2] VPWR VGND sg13cmos5l_antennanp
XANTENNA_116 FrameStrobe[2] VPWR VGND sg13cmos5l_antennanp
XANTENNA_127 FrameStrobe[2] VPWR VGND sg13cmos5l_antennanp
XANTENNA__2640__X WW4BEG[13] VPWR VGND sg13cmos5l_antennanp
XFILLER_17_320 VPWR VGND sg13cmos5l_decap_8
X_0972_ _0972_/Y _0972_/A _2317_/Q VPWR VGND sg13cmos5l_nand2_1
X_2711_ _2711_/X _2932_/X _3050_/X _3144_/X _0639_/X _1805_/Q _1806_/Q VPWR VGND sg13cmos5l_mux4_1
XANTENNA__2550__X FrameData_O[3] VPWR VGND sg13cmos5l_antennanp
X_1524_ _1524_/Q FrameData[25] VGND VPWR _1188_/X latch
X_2642_ WW4BEG[15] _2642_/A VPWR VGND sg13cmos5l_buf_1
X_2573_ FrameData_O[26] FrameData[26] VPWR VGND sg13cmos5l_buf_1
X_1386_ _1386_/Q FrameData[15] VGND VPWR _1181_/X latch
X_1455_ _1455_/Q FrameData[20] VGND VPWR _1185_/X latch
X_3125_ _3125_/X S2END[0] S2END[7] S4END[0] W1END[0] _2269_/Q _2270_/Q VPWR VGND sg13cmos5l_mux4_1
XFILLER_23_312 VPWR VGND sg13cmos5l_decap_4
XFILLER_27_139 VPWR VGND sg13cmos5l_fill_1
X_3056_ _3056_/X E1END[1] E2MID[5] E2END[5] EE4END[3] _2135_/Q _2136_/Q VPWR VGND
+ sg13cmos5l_mux4_1
X_2007_ _2007_/Q FrameData[28] VGND VPWR FrameStrobe[10] latch
XANTENNA__2460__X N1BEG[1] VPWR VGND sg13cmos5l_antennanp
XFILLER_11_518 VPWR VGND sg13cmos5l_fill_2
X_2909_ _2909_/X _0889_/Y _0899_/B _0856_/Y _0974_/Y _2171_/Q _2172_/Q VPWR VGND sg13cmos5l_mux4_1
XANTENNA__2635__X WW4BEG[8] VPWR VGND sg13cmos5l_antennanp
XFILLER_41_153 VPWR VGND sg13cmos5l_fill_2
XFILLER_41_164 VPWR VGND sg13cmos5l_fill_2
XFILLER_54_492 VPWR VGND sg13cmos5l_fill_2
X_1171_ _1171_/X FrameStrobe[12] FrameStrobe[15] VPWR VGND sg13cmos5l_and2_1
X_1240_ _1240_/Q _1246_/CLK _1240_/D _2357_/L_HI VPWR VGND sg13cmos5l_dfrbpq_1
XANTENNA__2545__X S4BEG[14] VPWR VGND sg13cmos5l_antennanp
XFILLER_2_88 VPWR VGND sg13cmos5l_fill_2
XANTENNA_16 N2END[0] VPWR VGND sg13cmos5l_antennanp
XANTENNA_27 S2END[6] VPWR VGND sg13cmos5l_antennanp
XANTENNA_38 S2END[6] VPWR VGND sg13cmos5l_antennanp
XANTENNA_49 W2END[1] VPWR VGND sg13cmos5l_antennanp
XFILLER_20_348 VPWR VGND sg13cmos5l_decap_4
X_0886_ _0886_/Y _0887_/B _0886_/B VPWR VGND sg13cmos5l_xnor2_1
X_0955_ _0955_/Y _1843_/Q _0662_/A _0954_/Y VPWR VGND sg13cmos5l_o21ai_1
X_1507_ _1507_/Q FrameData[8] VGND VPWR _1188_/X latch
X_2625_ W6BEG[10] _2625_/A VPWR VGND sg13cmos5l_buf_1
X_2556_ FrameData_O[9] FrameData[9] VPWR VGND sg13cmos5l_buf_1
X_2487_ N4BEG[8] N4END[12] VPWR VGND sg13cmos5l_buf_1
XFILLER_28_404 VPWR VGND sg13cmos5l_fill_2
X_1369_ _1369_/Q FrameData[30] VGND VPWR _1183_/X latch
X_1438_ _1438_/Q FrameData[3] VGND VPWR _1185_/X latch
X_3108_ _3108_/X N2MID[2] N2END[2] N4END[2] E2MID[0] _2211_/Q _2212_/Q VPWR VGND sg13cmos5l_mux4_1
XANTENNA__2455__X FrameStrobe_O[16] VPWR VGND sg13cmos5l_antennanp
X_3039_ _3039_/X N1END[2] N2MID[6] N2END[6] NN4END[2] _2111_/Q _2112_/Q VPWR VGND
+ sg13cmos5l_mux4_1
XFILLER_27_481 VPWR VGND sg13cmos5l_fill_2
XFILLER_10_370 VPWR VGND sg13cmos5l_fill_1
X_0740_ _0749_/A _0740_/A _0740_/B _0740_/C VPWR VGND sg13cmos5l_and3_1
X_0671_ _0671_/Y _2830_/X _1536_/Q _0670_/Y VPWR VGND sg13cmos5l_a21oi_1
X_2410_ E6BEG[3] E6END[5] VPWR VGND sg13cmos5l_buf_1
X_2341_ _3045_/A2 VPWR VGND sg13cmos5l_tiehi
XFILLER_25_407 VPWR VGND sg13cmos5l_decap_8
X_1154_ _1155_/B _2734_/X _1414_/Q _1153_/Y VPWR VGND sg13cmos5l_o21ai_1
X_1223_ _1223_/Y _1223_/A VPWR VGND sg13cmos5l_inv_1
X_2272_ _2272_/Q FrameData[5] VGND VPWR FrameStrobe[1] latch
X_1085_ _1085_/Y _3258_/X _1085_/B VPWR VGND sg13cmos5l_nand2b_1
X_0869_ _0869_/X _2891_/X _2892_/X _2230_/Q VPWR VGND sg13cmos5l_mux2_1
X_0938_ _0938_/Y _1747_/Q _0921_/A _0937_/Y VPWR VGND sg13cmos5l_a21oi_1
X_1987_ _1987_/Q FrameData[8] VGND VPWR FrameStrobe[10] latch
XFILLER_0_506 VPWR VGND sg13cmos5l_decap_8
X_2608_ W2BEGb[1] W2MID[1] VPWR VGND sg13cmos5l_buf_1
X_2539_ S4BEG[8] S4END[12] VPWR VGND sg13cmos5l_buf_1
XFILLER_16_407 VPWR VGND sg13cmos5l_decap_4
XFILLER_51_281 VPWR VGND sg13cmos5l_fill_2
XFILLER_19_234 VPWR VGND sg13cmos5l_fill_2
XFILLER_19_256 VPWR VGND sg13cmos5l_decap_4
X_2890_ _2890_/X _2886_/X _2887_/X _2888_/X _2889_/X _2279_/Q _2280_/Q VPWR VGND sg13cmos5l_mux4_1
X_1910_ _1910_/Q FrameData[27] VGND VPWR _1152_/X latch
X_0723_ _0769_/A _2705_/X _2729_/X _1375_/Q _0723_/D VPWR VGND sg13cmos5l_nor4_1
X_1772_ _1772_/Q FrameData[17] VGND VPWR _1139_/X latch
X_1841_ _1841_/Q FrameData[22] VGND VPWR _1136_/X latch
XFILLER_57_307 VPWR VGND sg13cmos5l_fill_1
X_0585_ _1145_/A _2685_/X VPWR VGND sg13cmos5l_inv_1
X_0654_ _0654_/X _3066_/X _3067_/X _2134_/Q VPWR VGND sg13cmos5l_mux2_1
X_2324_ _2324_/Q FrameData[25] VGND VPWR FrameStrobe[0] latch
X_1137_ _1137_/X FrameStrobe[11] FrameStrobe[13] VPWR VGND sg13cmos5l_and2_1
X_1206_ _1206_/Y _1247_/Q _2327_/Q VPWR VGND sg13cmos5l_nand2b_1
X_2255_ _2255_/Q FrameData[20] VGND VPWR FrameStrobe[2] latch
X_2186_ _2186_/Q FrameData[15] VGND VPWR FrameStrobe[4] latch
X_1068_ _1068_/Y _3210_/X _1460_/Q _1067_/Y VPWR VGND sg13cmos5l_a21oi_1
XFILLER_16_226 VPWR VGND sg13cmos5l_fill_2
X_2040_ _2040_/Q FrameData[29] VGND VPWR FrameStrobe[9] latch
XANTENNA__2553__X FrameData_O[6] VPWR VGND sg13cmos5l_antennanp
XFILLER_22_229 VPWR VGND sg13cmos5l_fill_2
XFILLER_30_262 VPWR VGND sg13cmos5l_fill_1
X_2942_ _2942_/X _0870_/X _2899_/X _3122_/X _0986_/Y _2054_/Q _2055_/Q VPWR VGND sg13cmos5l_mux4_1
X_2873_ _2873_/X _3127_/X _0861_/X _0860_/X _3122_/X _1961_/Q _1962_/Q VPWR VGND sg13cmos5l_mux4_1
XFILLER_7_480 VPWR VGND sg13cmos5l_fill_2
X_0706_ _0706_/Y _2753_/X _2738_/X VPWR VGND sg13cmos5l_nand2_1
X_1686_ _1686_/Q FrameData[27] VGND VPWR _1167_/X latch
X_1755_ _1755_/Q FrameData[0] VGND VPWR _1139_/X latch
X_1824_ _1824_/Q FrameData[5] VGND VPWR _1136_/X latch
X_0568_ _0568_/Y _1248_/Q VPWR VGND sg13cmos5l_inv_1
X_0637_ _2639_/A _3279_/X _3280_/X _1705_/Q VPWR VGND sg13cmos5l_mux2_1
X_3356_ _3356_/X _0655_/X _3074_/X _0862_/X _1013_/Y _1589_/Q _1590_/Q VPWR VGND sg13cmos5l_mux4_1
X_3287_ _3287_/X N1END[1] S2END[5] W2MID[2] _3145_/X _1691_/Q _1692_/Q VPWR VGND sg13cmos5l_mux4_1
X_2307_ _2307_/Q FrameData[8] VGND VPWR FrameStrobe[0] latch
X_2238_ _2238_/Q FrameData[3] VGND VPWR FrameStrobe[2] latch
XANTENNA__2463__X N2BEG[0] VPWR VGND sg13cmos5l_antennanp
X_2169_ _2169_/Q FrameData[30] VGND VPWR FrameStrobe[5] latch
XFILLER_21_251 VPWR VGND sg13cmos5l_decap_8
XANTENNA__2638__X WW4BEG[11] VPWR VGND sg13cmos5l_antennanp
X_1540_ _1540_/Q FrameData[9] VGND VPWR _1187_/X latch
XANTENNA__2548__X FrameData_O[1] VPWR VGND sg13cmos5l_antennanp
XFILLER_39_104 VPWR VGND sg13cmos5l_fill_1
X_1471_ _1471_/Q FrameData[4] VGND VPWR _1182_/X latch
X_3141_ _3141_/X E2MID[7] E2END[7] S1END[1] S2MID[5] _2175_/Q _2176_/Q VPWR VGND sg13cmos5l_mux4_1
X_3210_ _3210_/X _1020_/Y _1008_/Y _1875_/Q _1015_/Y _1876_/Q _1877_/Q VPWR VGND sg13cmos5l_mux4_1
X_3072_ _3072_/X S2END[5] SS4END[1] W2MID[4] W2END[4] _2179_/Q _2180_/Q VPWR VGND
+ sg13cmos5l_mux4_1
X_2023_ _2023_/Q FrameData[12] VGND VPWR FrameStrobe[9] latch
X_1807_ _1807_/Q FrameData[20] VGND VPWR _1138_/X latch
X_2925_ _2925_/X N1END[1] N2MID[5] N2END[5] NN4END[1] _2304_/Q _2305_/Q VPWR VGND
+ sg13cmos5l_mux4_1
X_2856_ _2856_/X _0650_/X _2910_/X _3093_/X _0628_/X _1965_/Q _1966_/Q VPWR VGND sg13cmos5l_mux4_1
X_1669_ _1669_/Q FrameData[10] VGND VPWR _1167_/X latch
X_1738_ _1738_/Q FrameData[15] VGND VPWR _1177_/X latch
X_2787_ _2787_/X _2783_/X _2784_/X _2785_/X _2786_/X _1867_/Q _1868_/Q VPWR VGND sg13cmos5l_mux4_1
XANTENNA_106 FrameStrobe[2] VPWR VGND sg13cmos5l_antennanp
XANTENNA__2458__X FrameStrobe_O[19] VPWR VGND sg13cmos5l_antennanp
XFILLER_26_310 VPWR VGND sg13cmos5l_fill_2
X_3339_ _3339_/X EE4END[1] W6END[1] _1249_/Q _0653_/X _1613_/Q _1614_/Q VPWR VGND
+ sg13cmos5l_mux4_1
XANTENNA_117 FrameStrobe[2] VPWR VGND sg13cmos5l_antennanp
XANTENNA_128 FrameStrobe[2] VPWR VGND sg13cmos5l_antennanp
XFILLER_1_486 VPWR VGND sg13cmos5l_fill_1
X_0971_ _0971_/Y _0584_/Y _0599_/Y _0970_/Y VPWR VGND sg13cmos5l_o21ai_1
X_2710_ _2710_/X _0658_/X _3043_/X _3059_/X _3087_/X _1805_/Q _1806_/Q VPWR VGND sg13cmos5l_mux4_1
X_1454_ _1454_/Q FrameData[19] VGND VPWR _1185_/X latch
X_1523_ _1523_/Q FrameData[24] VGND VPWR _1188_/X latch
X_2641_ WW4BEG[14] _2641_/A VPWR VGND sg13cmos5l_buf_1
X_2572_ FrameData_O[25] FrameData[25] VPWR VGND sg13cmos5l_buf_1
X_1385_ _1385_/Q FrameData[14] VGND VPWR _1181_/X latch
X_3055_ _3055_/X N1END[3] N2MID[7] N2END[7] NN4END[3] _2135_/Q _2136_/Q VPWR VGND
+ sg13cmos5l_mux4_1
X_3124_ _3124_/X E2MID[2] E2END[2] EE4END[0] S2MID[0] _2269_/Q _2270_/Q VPWR VGND
+ sg13cmos5l_mux4_1
XFILLER_23_346 VPWR VGND sg13cmos5l_decap_8
XFILLER_35_162 VPWR VGND sg13cmos5l_decap_4
X_2006_ _2006_/Q FrameData[27] VGND VPWR FrameStrobe[10] latch
X_2908_ _2908_/X SS4END[0] W2MID[7] W2END[0] W6END[1] _2171_/Q _2172_/Q VPWR VGND
+ sg13cmos5l_mux4_1
X_2839_ _2839_/X _2890_/X _0861_/X _0860_/X _2885_/X _1921_/Q _1922_/Q VPWR VGND sg13cmos5l_mux4_1
XFILLER_2_239 VPWR VGND sg13cmos5l_fill_1
XFILLER_26_184 VPWR VGND sg13cmos5l_fill_1
X_1170_ _1170_/Y _1910_/Q _1061_/A _1169_/Y VPWR VGND sg13cmos5l_a21oi_1
XANTENNA_17 S2END[6] VPWR VGND sg13cmos5l_antennanp
XANTENNA_28 S2END[6] VPWR VGND sg13cmos5l_antennanp
XANTENNA_39 S2END[6] VPWR VGND sg13cmos5l_antennanp
XANTENNA__2561__X FrameData_O[14] VPWR VGND sg13cmos5l_antennanp
X_0885_ _0886_/B _1370_/Q _0767_/Y _0884_/Y VPWR VGND sg13cmos5l_o21ai_1
X_0954_ _0954_/Y _2958_/X _1843_/Q VPWR VGND sg13cmos5l_nand2_1
X_2624_ W6BEG[9] W6END[11] VPWR VGND sg13cmos5l_buf_1
XFILLER_56_0 VPWR VGND sg13cmos5l_fill_2
X_1437_ _1437_/Q FrameData[2] VGND VPWR _1185_/X latch
X_1506_ _1506_/Q FrameData[7] VGND VPWR _1188_/X latch
X_2555_ FrameData_O[8] FrameData[8] VPWR VGND sg13cmos5l_buf_1
X_2486_ N4BEG[7] N4END[11] VPWR VGND sg13cmos5l_buf_1
X_1299_ _1299_/Q FrameData[24] VGND VPWR _1197_/X latch
X_1368_ _1368_/Q FrameData[29] VGND VPWR _1183_/X latch
X_3038_ _3038_/X W1END[0] _3038_/A1 _3038_/A2 _0921_/Y _2281_/Q _2282_/Q VPWR VGND
+ sg13cmos5l_mux4_1
X_3107_ _3107_/X _3103_/X _3104_/X _3105_/X _3106_/X _2240_/Q _2241_/Q VPWR VGND sg13cmos5l_mux4_1
XANTENNA__2471__X N2BEGb[0] VPWR VGND sg13cmos5l_antennanp
XFILLER_51_496 VPWR VGND sg13cmos5l_fill_1
X_0670_ _0670_/Y _1536_/Q _2835_/X VPWR VGND sg13cmos5l_nor2b_1
XFILLER_6_375 VPWR VGND sg13cmos5l_fill_2
X_2340_ _2919_/A2 VPWR VGND sg13cmos5l_tiehi
X_2271_ _2271_/Q FrameData[4] VGND VPWR FrameStrobe[1] latch
XANTENNA__2556__X FrameData_O[9] VPWR VGND sg13cmos5l_antennanp
XFILLER_18_460 VPWR VGND sg13cmos5l_fill_1
XFILLER_37_235 VPWR VGND sg13cmos5l_fill_2
X_1084_ _1085_/B _0589_/Y _1288_/Q _1083_/Y VPWR VGND sg13cmos5l_o21ai_1
X_1153_ _1153_/Y _1153_/A _1414_/Q VPWR VGND sg13cmos5l_nand2_1
X_1222_ _1223_/A _2329_/Q _1220_/Y _1221_/Y VPWR VGND sg13cmos5l_o21ai_1
X_1986_ _1986_/Q FrameData[7] VGND VPWR FrameStrobe[10] latch
X_0799_ _0808_/B _2328_/Q _0894_/A _0798_/Y VPWR VGND sg13cmos5l_o21ai_1
X_0868_ _0868_/X _3062_/X _3063_/X _2233_/Q VPWR VGND sg13cmos5l_mux2_1
X_0937_ _0937_/Y _1747_/Q _1224_/B VPWR VGND sg13cmos5l_nor2_1
X_2607_ W2BEGb[0] W2MID[0] VPWR VGND sg13cmos5l_buf_1
X_2538_ S4BEG[7] S4END[11] VPWR VGND sg13cmos5l_buf_1
X_2469_ N2BEG[6] _2469_/A VPWR VGND sg13cmos5l_buf_1
XANTENNA__2466__X N2BEG[3] VPWR VGND sg13cmos5l_antennanp
XFILLER_28_235 VPWR VGND sg13cmos5l_fill_2
XFILLER_11_124 VPWR VGND sg13cmos5l_fill_2
XFILLER_22_75 VPWR VGND sg13cmos5l_fill_1
XANTENNA_test1_X UserCLKo VPWR VGND sg13cmos5l_antennanp
XFILLER_34_238 VPWR VGND sg13cmos5l_fill_1
X_1840_ _1840_/Q FrameData[21] VGND VPWR _1136_/X latch
X_0653_ _0653_/X _3051_/X _3052_/X _2163_/Q VPWR VGND sg13cmos5l_mux2_1
X_0722_ _0724_/B _2729_/X _1375_/Q VPWR VGND sg13cmos5l_nor2_1
X_1771_ _1771_/Q FrameData[16] VGND VPWR _1139_/X latch
X_0584_ _0584_/Y _2676_/X VPWR VGND sg13cmos5l_inv_1
X_2323_ _2323_/Q FrameData[24] VGND VPWR FrameStrobe[0] latch
X_2254_ _2254_/Q FrameData[19] VGND VPWR FrameStrobe[2] latch
X_1067_ _1067_/Y _3210_/X _3209_/X VPWR VGND sg13cmos5l_nor2_1
X_1136_ _1136_/X FrameStrobe[11] FrameStrobe[16] VPWR VGND sg13cmos5l_and2_1
X_1205_ _1205_/Y _1539_/Q _0823_/Y _1204_/Y VPWR VGND sg13cmos5l_o21ai_1
X_2185_ _2185_/Q FrameData[14] VGND VPWR FrameStrobe[4] latch
XFILLER_21_499 VPWR VGND sg13cmos5l_decap_4
X_1969_ _1969_/Q FrameData[22] VGND VPWR _1044_/X latch
XFILLER_16_249 VPWR VGND sg13cmos5l_decap_4
XFILLER_24_293 VPWR VGND sg13cmos5l_decap_4
XFILLER_8_459 VPWR VGND sg13cmos5l_fill_2
XFILLER_3_142 VPWR VGND sg13cmos5l_fill_2
XFILLER_47_330 VPWR VGND sg13cmos5l_decap_4
XFILLER_47_341 VPWR VGND sg13cmos5l_fill_1
XFILLER_50_506 VPWR VGND sg13cmos5l_fill_1
X_1823_ _1823_/Q FrameData[4] VGND VPWR _1136_/X latch
X_2941_ _2941_/X E2END[3] W1END[3] _1247_/Q _0657_/X _2054_/Q _2055_/Q VPWR VGND sg13cmos5l_mux4_1
X_2872_ _2872_/X _0872_/X _0869_/X _3107_/X _0867_/X _1961_/Q _1962_/Q VPWR VGND sg13cmos5l_mux4_1
X_0636_ _2640_/A _3277_/X _3278_/X _1708_/Q VPWR VGND sg13cmos5l_mux2_1
X_0705_ _0705_/X _2735_/X _2736_/X _2753_/X VPWR VGND sg13cmos5l_mux2_1
X_1685_ _1685_/Q FrameData[26] VGND VPWR _1167_/X latch
X_1754_ _1754_/Q FrameData[31] VGND VPWR _1177_/X latch
XFILLER_38_352 VPWR VGND sg13cmos5l_fill_2
X_0567_ _0567_/Y _1244_/Q VPWR VGND sg13cmos5l_inv_1
X_3355_ _3355_/X N4END[3] E1END[1] W2END[5] _2924_/X _1589_/Q _1590_/Q VPWR VGND sg13cmos5l_mux4_1
X_3286_ _3286_/X _0627_/X _2917_/X _3127_/X _1027_/Y _1694_/Q _1695_/Q VPWR VGND sg13cmos5l_mux4_1
X_2306_ _2306_/Q FrameData[7] VGND VPWR FrameStrobe[0] latch
X_2237_ _2237_/Q FrameData[2] VGND VPWR FrameStrobe[2] latch
XFILLER_38_385 VPWR VGND sg13cmos5l_fill_1
XFILLER_53_355 VPWR VGND sg13cmos5l_fill_2
X_1119_ _1120_/B _2821_/X _1540_/Q _1118_/Y VPWR VGND sg13cmos5l_o21ai_1
X_2168_ _2168_/Q FrameData[29] VGND VPWR FrameStrobe[5] latch
X_2099_ _2099_/Q FrameData[24] VGND VPWR FrameStrobe[7] latch
XFILLER_44_355 VPWR VGND sg13cmos5l_decap_4
XFILLER_56_160 VPWR VGND sg13cmos5l_fill_2
XFILLER_12_285 VPWR VGND sg13cmos5l_decap_4
X_1470_ _1470_/Q FrameData[3] VGND VPWR _1182_/X latch
XFILLER_39_149 VPWR VGND sg13cmos5l_fill_1
X_3071_ _3071_/X E2MID[7] E2END[7] S1END[1] S2MID[5] _2179_/Q _2180_/Q VPWR VGND sg13cmos5l_mux4_1
X_3140_ _3140_/X N2MID[1] N2END[1] N4END[1] E1END[3] _2175_/Q _2176_/Q VPWR VGND sg13cmos5l_mux4_1
XANTENNA__2564__X FrameData_O[17] VPWR VGND sg13cmos5l_antennanp
XFILLER_35_333 VPWR VGND sg13cmos5l_fill_2
X_2022_ _2022_/Q FrameData[11] VGND VPWR FrameStrobe[9] latch
X_1806_ _1806_/Q FrameData[19] VGND VPWR _1138_/X latch
X_2924_ _2924_/X _2920_/X _2921_/X _2922_/X _2923_/X _2105_/Q _2106_/Q VPWR VGND sg13cmos5l_mux4_1
X_2855_ _2855_/X _0629_/X _3043_/X _0656_/X _3001_/X _1965_/Q _1966_/Q VPWR VGND sg13cmos5l_mux4_1
X_2786_ _2786_/X _2899_/X _0862_/X _2885_/X _3010_/X _1865_/Q _1866_/Q VPWR VGND sg13cmos5l_mux4_1
X_0619_ _2459_/A _3355_/X _3356_/X _1591_/Q VPWR VGND sg13cmos5l_mux2_1
X_1599_ _1599_/Q FrameData[4] VGND VPWR _1189_/X latch
X_1668_ _1668_/Q FrameData[9] VGND VPWR _1167_/X latch
X_1737_ _1737_/Q FrameData[14] VGND VPWR _1177_/X latch
X_3338_ _3338_/X _2903_/X _0867_/X _2899_/X _1056_/Y _1616_/Q _1617_/Q VPWR VGND sg13cmos5l_mux4_1
XANTENNA_107 FrameStrobe[2] VPWR VGND sg13cmos5l_antennanp
XANTENNA_118 FrameStrobe[2] VPWR VGND sg13cmos5l_antennanp
XANTENNA__2474__X N2BEGb[3] VPWR VGND sg13cmos5l_antennanp
X_3269_ _3269_/X N4END[2] SS4END[2] _0846_/Y _0654_/X _1718_/Q _1719_/Q VPWR VGND
+ sg13cmos5l_mux4_1
XFILLER_53_163 VPWR VGND sg13cmos5l_fill_2
XFILLER_30_75 VPWR VGND sg13cmos5l_fill_1
XFILLER_29_182 VPWR VGND sg13cmos5l_fill_1
XFILLER_44_163 VPWR VGND sg13cmos5l_fill_1
XFILLER_44_185 VPWR VGND sg13cmos5l_decap_4
X_0970_ _0970_/Y _0735_/Y _0761_/Y _0599_/Y VPWR VGND sg13cmos5l_o21ai_1
X_2640_ WW4BEG[13] _2640_/A VPWR VGND sg13cmos5l_buf_1
XANTENNA__2559__X FrameData_O[12] VPWR VGND sg13cmos5l_antennanp
X_1453_ _1453_/Q FrameData[18] VGND VPWR _1185_/X latch
X_1522_ _1522_/Q FrameData[23] VGND VPWR _1188_/X latch
X_2571_ FrameData_O[24] FrameData[24] VPWR VGND sg13cmos5l_buf_1
X_1384_ _1384_/Q FrameData[13] VGND VPWR _1181_/X latch
X_3054_ _3054_/X _0875_/A _3054_/A1 _3054_/A2 _0986_/Y _2250_/Q _2251_/Q VPWR VGND
+ sg13cmos5l_mux4_1
X_3123_ _3123_/X N1END[0] N2MID[4] N2END[4] NN4END[0] _2269_/Q _2270_/Q VPWR VGND
+ sg13cmos5l_mux4_1
X_2005_ _2005_/Q FrameData[26] VGND VPWR FrameStrobe[10] latch
XFILLER_50_166 VPWR VGND sg13cmos5l_fill_1
X_2907_ _2907_/X E2END[6] S1END[0] S2MID[4] S2END[4] _2171_/Q _2172_/Q VPWR VGND sg13cmos5l_mux4_1
X_2838_ _2838_/X _3112_/X _0870_/X _3107_/X _0867_/X _1921_/Q _1922_/Q VPWR VGND sg13cmos5l_mux4_1
X_2769_ _2769_/X _3100_/X _0650_/X _3093_/X _0627_/X _1869_/Q _1870_/Q VPWR VGND sg13cmos5l_mux4_1
XANTENNA__2469__X N2BEG[6] VPWR VGND sg13cmos5l_antennanp
XFILLER_46_439 VPWR VGND sg13cmos5l_fill_2
XFILLER_10_531 VPWR VGND sg13cmos5l_fill_2
XANTENNA_18 S2END[6] VPWR VGND sg13cmos5l_antennanp
XANTENNA_29 S2END[6] VPWR VGND sg13cmos5l_antennanp
XFILLER_32_111 VPWR VGND sg13cmos5l_fill_2
X_0884_ _0884_/Y _2714_/X _1370_/Q VPWR VGND sg13cmos5l_nand2_1
X_0953_ _0953_/Y _1750_/Q _0950_/A _0952_/Y VPWR VGND sg13cmos5l_o21ai_1
X_2623_ W6BEG[8] W6END[10] VPWR VGND sg13cmos5l_buf_1
X_2554_ FrameData_O[7] FrameData[7] VPWR VGND sg13cmos5l_buf_1
XFILLER_49_0 VPWR VGND sg13cmos5l_fill_2
X_1367_ _1367_/Q FrameData[28] VGND VPWR _1183_/X latch
X_1436_ _1436_/Q FrameData[1] VGND VPWR _1185_/X latch
X_1505_ _1505_/Q FrameData[6] VGND VPWR _1188_/X latch
X_2485_ N4BEG[6] N4END[10] VPWR VGND sg13cmos5l_buf_1
X_1298_ _1298_/Q FrameData[23] VGND VPWR _1197_/X latch
X_3037_ _3037_/X N1END[0] N2MID[4] EE4END[0] S4END[0] _2281_/Q _2282_/Q VPWR VGND
+ sg13cmos5l_mux4_1
X_3106_ _3106_/X W2END[3] WW4END[1] _0875_/A _0856_/Y _2238_/Q _2239_/Q VPWR VGND
+ sg13cmos5l_mux4_1
XFILLER_11_22 VPWR VGND sg13cmos5l_fill_1
X_1221_ _1221_/Y _1249_/Q _2329_/Q VPWR VGND sg13cmos5l_nand2b_1
X_2270_ _2270_/Q FrameData[3] VGND VPWR FrameStrobe[1] latch
XFILLER_37_269 VPWR VGND sg13cmos5l_decap_4
X_1083_ _1083_/Y _2656_/X _1288_/Q VPWR VGND sg13cmos5l_nand2_1
X_1152_ _1152_/X FrameStrobe[11] FrameStrobe[14] VPWR VGND sg13cmos5l_and2_1
XANTENNA__2572__X FrameData_O[25] VPWR VGND sg13cmos5l_antennanp
XFILLER_33_431 VPWR VGND sg13cmos5l_fill_2
X_0936_ _1224_/B _3029_/X _3030_/X _2087_/Q VPWR VGND sg13cmos5l_mux2_1
X_1985_ _1985_/Q FrameData[6] VGND VPWR FrameStrobe[10] latch
X_0798_ _0798_/Y _1248_/Q _2328_/Q VPWR VGND sg13cmos5l_nand2_1
X_0867_ _0867_/X _3053_/X _3054_/X _2252_/Q VPWR VGND sg13cmos5l_mux2_1
X_2606_ W2BEG[7] _2606_/A VPWR VGND sg13cmos5l_buf_1
X_2537_ S4BEG[6] S4END[10] VPWR VGND sg13cmos5l_buf_1
XFILLER_28_214 VPWR VGND sg13cmos5l_decap_8
XFILLER_56_556 VPWR VGND sg13cmos5l_fill_1
X_1419_ _1419_/Q FrameData[16] VGND VPWR _1186_/X latch
X_2468_ N2BEG[5] _2468_/A VPWR VGND sg13cmos5l_buf_1
X_2399_ EE4BEG[8] EE4END[12] VPWR VGND sg13cmos5l_buf_1
XANTENNA__2482__X N4BEG[3] VPWR VGND sg13cmos5l_antennanp
XFILLER_36_291 VPWR VGND sg13cmos5l_fill_1
XFILLER_51_272 VPWR VGND sg13cmos5l_fill_2
XFILLER_51_283 VPWR VGND sg13cmos5l_fill_1
XFILLER_19_236 VPWR VGND sg13cmos5l_fill_1
XFILLER_47_556 VPWR VGND sg13cmos5l_fill_1
XFILLER_47_62 VPWR VGND sg13cmos5l_fill_2
XANTENNA__2392__X EE4BEG[1] VPWR VGND sg13cmos5l_antennanp
XFILLER_42_250 VPWR VGND sg13cmos5l_fill_2
X_1770_ _1770_/Q FrameData[15] VGND VPWR _1139_/X latch
X_0583_ _1153_/A _2743_/X VPWR VGND sg13cmos5l_inv_1
X_0652_ _2514_/A _3305_/X _3306_/X _1666_/Q VPWR VGND sg13cmos5l_mux2_1
X_0721_ _0723_/D _0716_/Y _0717_/X _0720_/Y VPWR VGND sg13cmos5l_a21oi_1
XANTENNA__2567__X FrameData_O[20] VPWR VGND sg13cmos5l_antennanp
XFILLER_38_556 VPWR VGND sg13cmos5l_fill_1
X_1204_ _1204_/Y _2821_/X _1539_/Q VPWR VGND sg13cmos5l_nand2_1
X_2322_ _2322_/Q FrameData[23] VGND VPWR FrameStrobe[0] latch
X_2253_ _2253_/Q FrameData[18] VGND VPWR FrameStrobe[2] latch
X_2184_ _2184_/Q FrameData[13] VGND VPWR FrameStrobe[4] latch
X_1066_ _1066_/Y _0590_/Y _2318_/Q _1065_/Y VPWR VGND sg13cmos5l_a21oi_1
X_1135_ _1135_/Y _1907_/Q _1000_/A _1134_/Y VPWR VGND sg13cmos5l_a21oi_1
XFILLER_21_489 VPWR VGND sg13cmos5l_fill_1
X_0919_ _0919_/Y _0919_/A _2315_/Q VPWR VGND sg13cmos5l_nand2_1
X_1968_ _1968_/Q FrameData[21] VGND VPWR _1044_/X latch
X_1899_ _1899_/Q FrameData[16] VGND VPWR _1152_/X latch
XANTENNA__2477__X N2BEGb[6] VPWR VGND sg13cmos5l_antennanp
X_2940_ _2940_/X _0871_/X _3127_/X _0858_/X _0856_/Y _2029_/Q _2030_/Q VPWR VGND sg13cmos5l_mux4_1
X_1753_ _1753_/Q FrameData[30] VGND VPWR _1177_/X latch
X_1822_ _1822_/Q FrameData[3] VGND VPWR _1136_/X latch
X_2871_ _2871_/X _3079_/X _2932_/X _3074_/X _0639_/X _1961_/Q _1962_/Q VPWR VGND sg13cmos5l_mux4_1
XFILLER_31_0 VPWR VGND sg13cmos5l_fill_2
XFILLER_7_482 VPWR VGND sg13cmos5l_fill_1
X_0566_ _0566_/Y _1236_/Q VPWR VGND sg13cmos5l_inv_1
X_0635_ _2641_/A _3275_/X _3276_/X _1711_/Q VPWR VGND sg13cmos5l_mux2_1
X_0704_ _0704_/Y _2743_/X _1410_/Q _0703_/Y VPWR VGND sg13cmos5l_a21oi_1
X_1684_ _1684_/Q FrameData[25] VGND VPWR _1167_/X latch
X_3354_ _3354_/X _3050_/X _0872_/X _0859_/X _0808_/B _1592_/Q _1593_/Q VPWR VGND sg13cmos5l_mux4_1
XFILLER_38_320 VPWR VGND sg13cmos5l_fill_1
X_3285_ _3285_/X N1END[2] S2END[6] _1236_/Q _0630_/X _1694_/Q _1695_/Q VPWR VGND sg13cmos5l_mux4_1
X_2305_ _2305_/Q FrameData[6] VGND VPWR FrameStrobe[0] latch
X_2236_ _2236_/Q FrameData[1] VGND VPWR FrameStrobe[2] latch
X_2167_ _2167_/Q FrameData[28] VGND VPWR FrameStrobe[5] latch
X_1049_ _1051_/C _1587_/Q _0903_/Y _1048_/Y VPWR VGND sg13cmos5l_a21o_1
X_1118_ _1118_/Y _1118_/A _1540_/Q VPWR VGND sg13cmos5l_nand2_1
X_2098_ _2098_/Q FrameData[23] VGND VPWR FrameStrobe[7] latch
XFILLER_29_320 VPWR VGND sg13cmos5l_fill_1
XFILLER_8_213 VPWR VGND sg13cmos5l_fill_1
X_3070_ _3070_/X N2MID[1] N2END[1] N4END[1] E1END[3] _2179_/Q _2180_/Q VPWR VGND sg13cmos5l_mux4_1
X_2021_ _2021_/Q FrameData[10] VGND VPWR FrameStrobe[9] latch
X_2923_ _2923_/X W2MID[6] W2END[6] _1246_/Q _1056_/Y _2103_/Q _2104_/Q VPWR VGND sg13cmos5l_mux4_1
XANTENNA__2580__X SS4BEG[1] VPWR VGND sg13cmos5l_antennanp
X_1736_ _1736_/Q FrameData[13] VGND VPWR _1177_/X latch
X_1805_ _1805_/Q FrameData[18] VGND VPWR _1138_/X latch
X_2854_ _2854_/X _1573_/Q _1574_/Q _1575_/Q _1576_/Q _3184_/X _3179_/X VPWR VGND sg13cmos5l_mux4_1
X_2785_ _2785_/X _3112_/X _0871_/X _3155_/X _0867_/X _1865_/Q _1866_/Q VPWR VGND sg13cmos5l_mux4_1
X_0618_ _2460_/A _3353_/X _3354_/X _1594_/Q VPWR VGND sg13cmos5l_mux2_1
X_1598_ _1598_/Q FrameData[3] VGND VPWR _1189_/X latch
X_1667_ _1667_/Q FrameData[8] VGND VPWR _1167_/X latch
X_3337_ _3337_/X N2MID[3] EE4END[2] W6END[0] _0629_/X _1616_/Q _1617_/Q VPWR VGND
+ sg13cmos5l_mux4_1
XANTENNA_108 FrameStrobe[2] VPWR VGND sg13cmos5l_antennanp
XANTENNA_119 FrameStrobe[2] VPWR VGND sg13cmos5l_antennanp
XFILLER_14_518 VPWR VGND sg13cmos5l_fill_2
XFILLER_38_194 VPWR VGND sg13cmos5l_fill_2
XFILLER_41_315 VPWR VGND sg13cmos5l_decap_8
X_3199_ _3199_/X _3006_/X _3036_/X _3136_/X _0656_/X _1885_/Q _1886_/Q VPWR VGND sg13cmos5l_mux4_1
X_3268_ _3268_/X _3264_/X _3265_/X _3266_/X _3267_/X _1723_/Q _1724_/Q VPWR VGND sg13cmos5l_mux4_1
X_2219_ _2219_/Q FrameData[16] VGND VPWR FrameStrobe[3] latch
XANTENNA__2490__X N4BEG[11] VPWR VGND sg13cmos5l_antennanp
XFILLER_14_33 VPWR VGND sg13cmos5l_fill_2
XFILLER_22_551 VPWR VGND sg13cmos5l_fill_2
XFILLER_1_422 VPWR VGND sg13cmos5l_fill_2
XFILLER_17_356 VPWR VGND sg13cmos5l_decap_8
XFILLER_44_142 VPWR VGND sg13cmos5l_decap_4
XFILLER_55_95 VPWR VGND sg13cmos5l_fill_1
X_2570_ FrameData_O[23] FrameData[23] VPWR VGND sg13cmos5l_buf_1
X_1383_ _1383_/Q FrameData[12] VGND VPWR _1181_/X latch
X_1452_ _1452_/Q FrameData[17] VGND VPWR _1185_/X latch
X_1521_ _1521_/Q FrameData[22] VGND VPWR _1188_/X latch
X_3122_ _3122_/X _3118_/X _3119_/X _3120_/X _3121_/X _2298_/Q _2299_/Q VPWR VGND sg13cmos5l_mux4_1
XANTENNA__2575__X FrameData_O[28] VPWR VGND sg13cmos5l_antennanp
X_3053_ _3053_/X N2END[3] E6END[1] S2MID[7] W2MID[3] _2250_/Q _2251_/Q VPWR VGND sg13cmos5l_mux4_1
X_2004_ _2004_/Q FrameData[25] VGND VPWR FrameStrobe[10] latch
XFILLER_23_337 VPWR VGND sg13cmos5l_fill_2
XFILLER_31_392 VPWR VGND sg13cmos5l_decap_4
X_2906_ _2906_/X N2MID[0] N2END[0] N4END[0] E2MID[6] _2171_/Q _2172_/Q VPWR VGND sg13cmos5l_mux4_1
X_1719_ _1719_/Q FrameData[28] VGND VPWR _1133_/X latch
X_2837_ _2837_/X _3100_/X _0653_/X _3139_/X _0627_/X _1921_/Q _1922_/Q VPWR VGND sg13cmos5l_mux4_1
X_2768_ _2768_/X _0630_/X _0658_/X _3136_/X _0654_/X _1869_/Q _1870_/Q VPWR VGND sg13cmos5l_mux4_1
X_2699_ _2699_/X _3170_/X _2899_/X _3122_/X _3010_/X _1769_/Q _1770_/Q VPWR VGND sg13cmos5l_mux4_1
XANTENNA__2485__X N4BEG[6] VPWR VGND sg13cmos5l_antennanp
XFILLER_41_178 VPWR VGND sg13cmos5l_decap_8
XFILLER_41_97 VPWR VGND sg13cmos5l_fill_1
XFILLER_9_0 VPWR VGND sg13cmos5l_fill_1
XANTENNA__2395__X EE4BEG[4] VPWR VGND sg13cmos5l_antennanp
XANTENNA_19 S2END[6] VPWR VGND sg13cmos5l_antennanp
X_0952_ _0952_/Y _1750_/Q _2600_/A VPWR VGND sg13cmos5l_nand2_1
X_0883_ _0899_/B _0883_/A VPWR VGND sg13cmos5l_inv_1
X_1504_ _1504_/Q FrameData[5] VGND VPWR _1188_/X latch
X_2622_ W6BEG[7] W6END[9] VPWR VGND sg13cmos5l_buf_1
X_2553_ FrameData_O[6] FrameData[6] VPWR VGND sg13cmos5l_buf_1
X_1366_ _1366_/Q FrameData[27] VGND VPWR _1183_/X latch
X_1435_ _1435_/Q FrameData[0] VGND VPWR _1185_/X latch
X_3105_ _3105_/X S2END[7] SS4END[3] W1END[2] W2MID[3] _2238_/Q _2239_/Q VPWR VGND
+ sg13cmos5l_mux4_1
X_2484_ N4BEG[5] N4END[9] VPWR VGND sg13cmos5l_buf_1
X_1297_ _1297_/Q FrameData[22] VGND VPWR _1197_/X latch
X_3036_ _3036_/X _3033_/X _3034_/X _3035_/X _1163_/Y _2117_/Q _2118_/Q VPWR VGND sg13cmos5l_mux4_1
XFILLER_23_167 VPWR VGND sg13cmos5l_decap_4
XFILLER_42_421 VPWR VGND sg13cmos5l_fill_2
XFILLER_54_281 VPWR VGND sg13cmos5l_fill_2
XFILLER_37_204 VPWR VGND sg13cmos5l_fill_1
X_1151_ _1238_/D _0590_/Y _1143_/Y _1144_/Y _1150_/Y VPWR VGND sg13cmos5l_a22oi_1
X_1220_ _1220_/Y _1581_/Q _1218_/A _1219_/Y VPWR VGND sg13cmos5l_o21ai_1
X_1082_ _1243_/D _0592_/Y _1067_/Y _1068_/Y _1081_/X VPWR VGND sg13cmos5l_a22oi_1
X_0866_ _0866_/X _3101_/X _3102_/X _2255_/Q VPWR VGND sg13cmos5l_mux2_1
X_0935_ _0935_/Y _1747_/Q _0932_/A _0934_/Y VPWR VGND sg13cmos5l_o21ai_1
X_1984_ _1984_/Q FrameData[5] VGND VPWR FrameStrobe[10] latch
X_0797_ _0797_/Y _0894_/A VPWR VGND sg13cmos5l_inv_1
X_2605_ W2BEG[6] _2947_/X VPWR VGND sg13cmos5l_buf_1
X_2536_ S4BEG[5] S4END[9] VPWR VGND sg13cmos5l_buf_1
X_2467_ N2BEG[4] _2467_/A VPWR VGND sg13cmos5l_buf_1
XFILLER_28_237 VPWR VGND sg13cmos5l_fill_1
X_1349_ _1349_/Q FrameData[10] VGND VPWR _1183_/X latch
X_1418_ _1418_/Q FrameData[15] VGND VPWR _1186_/X latch
X_2398_ EE4BEG[7] EE4END[11] VPWR VGND sg13cmos5l_buf_1
X_3019_ _3019_/X N2MID[7] S2END[3] _1242_/Q _0630_/X _2016_/Q _2017_/Q VPWR VGND sg13cmos5l_mux4_1
XFILLER_34_218 VPWR VGND sg13cmos5l_decap_8
X_0720_ _0720_/Y _1089_/A _1367_/Q _0718_/Y _0719_/Y _0716_/Y VPWR VGND sg13cmos5l_a221oi_1
X_0582_ _0582_/Y _2734_/X VPWR VGND sg13cmos5l_inv_1
X_0651_ _2543_/A _3303_/X _3304_/X _1669_/Q VPWR VGND sg13cmos5l_mux2_1
X_2321_ _2321_/Q FrameData[22] VGND VPWR FrameStrobe[0] latch
X_1134_ _1134_/Y _1907_/Q _2466_/A VPWR VGND sg13cmos5l_nor2_1
X_1203_ _1203_/Y _1942_/Q _1200_/A _1202_/Y VPWR VGND sg13cmos5l_o21ai_1
X_2252_ _2252_/Q FrameData[17] VGND VPWR FrameStrobe[2] latch
X_2183_ _2183_/Q FrameData[12] VGND VPWR FrameStrobe[4] latch
XANTENNA__2583__X SS4BEG[4] VPWR VGND sg13cmos5l_antennanp
XFILLER_18_270 VPWR VGND sg13cmos5l_fill_2
XFILLER_21_424 VPWR VGND sg13cmos5l_decap_4
XFILLER_25_218 VPWR VGND sg13cmos5l_decap_8
X_1065_ _1065_/Y _2318_/Q _1065_/B VPWR VGND sg13cmos5l_nor2_1
X_0849_ _0849_/Y _2656_/X _1286_/Q VPWR VGND sg13cmos5l_nand2_1
X_0918_ _0918_/Y _0589_/Y _1287_/Q _0917_/Y VPWR VGND sg13cmos5l_a21oi_1
X_1967_ _1967_/Q FrameData[20] VGND VPWR _1044_/X latch
X_1898_ _1898_/Q FrameData[15] VGND VPWR _1152_/X latch
X_2519_ S2BEG[4] _2519_/A VPWR VGND sg13cmos5l_buf_1
XANTENNA__2493__X N4BEG[14] VPWR VGND sg13cmos5l_antennanp
XFILLER_35_505 VPWR VGND sg13cmos5l_fill_1
X_2870_ _2870_/X _3006_/X _3036_/X _3059_/X _3087_/X _1961_/Q _1962_/Q VPWR VGND sg13cmos5l_mux4_1
XFILLER_7_450 VPWR VGND sg13cmos5l_fill_2
X_0703_ _0703_/Y _1410_/Q _2748_/X VPWR VGND sg13cmos5l_nor2b_1
X_1683_ _1683_/Q FrameData[24] VGND VPWR _1167_/X latch
X_1752_ _1752_/Q FrameData[29] VGND VPWR _1177_/X latch
X_1821_ _1821_/Q FrameData[2] VGND VPWR _1136_/X latch
XANTENNA__2578__X FrameData_O[31] VPWR VGND sg13cmos5l_antennanp
XFILLER_24_0 VPWR VGND sg13cmos5l_fill_1
X_0565_ _0565_/Y _1242_/Q VPWR VGND sg13cmos5l_inv_1
X_0634_ _2642_/A _3273_/X _3274_/X _1714_/Q VPWR VGND sg13cmos5l_mux2_1
X_3353_ _3353_/X N2END[1] E1END[2] W2END[6] _3087_/X _1592_/Q _1593_/Q VPWR VGND sg13cmos5l_mux4_1
X_3284_ _3284_/X _3163_/X _0861_/X _3010_/X _0840_/Y _1697_/Q _1698_/Q VPWR VGND sg13cmos5l_mux4_1
X_2304_ _2304_/Q FrameData[5] VGND VPWR FrameStrobe[0] latch
XFILLER_38_354 VPWR VGND sg13cmos5l_fill_1
XFILLER_38_376 VPWR VGND sg13cmos5l_fill_2
X_1117_ _1117_/Y _3186_/X _1544_/Q _1116_/Y VPWR VGND sg13cmos5l_a21oi_1
X_2235_ _2235_/Q FrameData[0] VGND VPWR FrameStrobe[2] latch
X_2166_ _2166_/Q FrameData[27] VGND VPWR FrameStrobe[5] latch
X_2097_ _2097_/Q FrameData[22] VGND VPWR FrameStrobe[7] latch
XFILLER_0_91 VPWR VGND sg13cmos5l_fill_2
X_1048_ _1048_/Y _1587_/Q _1048_/B VPWR VGND sg13cmos5l_nor2_1
X_2999_ _2999_/X S2END[3] S4END[3] SS4END[2] W2END[3] _2139_/Q _2140_/Q VPWR VGND
+ sg13cmos5l_mux4_1
XANTENNA__2488__X N4BEG[9] VPWR VGND sg13cmos5l_antennanp
XFILLER_40_541 VPWR VGND sg13cmos5l_fill_2
XFILLER_52_390 VPWR VGND sg13cmos5l_fill_2
XANTENNA__2398__X EE4BEG[7] VPWR VGND sg13cmos5l_antennanp
X_2020_ _2020_/Q FrameData[9] VGND VPWR FrameStrobe[9] latch
X_2922_ _2922_/X S2MID[2] S2END[2] S4END[2] W1END[2] _2103_/Q _2104_/Q VPWR VGND sg13cmos5l_mux4_1
X_2853_ _2853_/X _1569_/Q _1570_/Q _1571_/Q _1572_/Q _3184_/X _3179_/X VPWR VGND sg13cmos5l_mux4_1
X_1666_ _1666_/Q FrameData[7] VGND VPWR _1167_/X latch
X_1735_ _1735_/Q FrameData[12] VGND VPWR _1177_/X latch
X_1804_ _1804_/Q FrameData[17] VGND VPWR _1138_/X latch
X_2784_ _2784_/X _3100_/X _0650_/X _3144_/X _3093_/X _1865_/Q _1866_/Q VPWR VGND sg13cmos5l_mux4_1
X_0617_ _2461_/A _3351_/X _3352_/X _1597_/Q VPWR VGND sg13cmos5l_mux2_1
X_1597_ _1597_/Q FrameData[2] VGND VPWR _1189_/X latch
X_3267_ _3267_/X _0864_/X _3170_/X _0860_/X _0858_/X _1721_/Q _1722_/Q VPWR VGND sg13cmos5l_mux4_1
X_3336_ _3336_/X _3112_/X _0864_/X _0857_/X _1061_/Y _1619_/Q _1620_/Q VPWR VGND sg13cmos5l_mux4_1
XANTENNA_109 FrameStrobe[2] VPWR VGND sg13cmos5l_antennanp
XFILLER_26_368 VPWR VGND sg13cmos5l_fill_1
X_3198_ _3198_/X _1135_/Y _1179_/Y _1907_/Q _1127_/Y _1908_/Q _1909_/Q VPWR VGND sg13cmos5l_mux4_1
X_2218_ _2218_/Q FrameData[15] VGND VPWR FrameStrobe[3] latch
X_2149_ _2149_/Q FrameData[10] VGND VPWR FrameStrobe[5] latch
XFILLER_30_33 VPWR VGND sg13cmos5l_fill_1
XFILLER_17_313 VPWR VGND sg13cmos5l_decap_8
XFILLER_17_335 VPWR VGND sg13cmos5l_fill_2
XFILLER_32_327 VPWR VGND sg13cmos5l_fill_2
XFILLER_44_154 VPWR VGND sg13cmos5l_decap_4
X_1520_ _1520_/Q FrameData[21] VGND VPWR _1188_/X latch
X_1382_ _1382_/Q FrameData[11] VGND VPWR _1181_/X latch
X_1451_ _1451_/Q FrameData[16] VGND VPWR _1185_/X latch
X_3121_ _3121_/X W2MID[5] W2END[5] WW4END[3] _1220_/Y _2296_/Q _2297_/Q VPWR VGND
+ sg13cmos5l_mux4_1
XANTENNA__2591__X SS4BEG[12] VPWR VGND sg13cmos5l_antennanp
XFILLER_23_305 VPWR VGND sg13cmos5l_decap_8
X_3052_ _3052_/X _1238_/Q _3052_/A1 _3052_/A2 _0986_/Y _2161_/Q _2162_/Q VPWR VGND
+ sg13cmos5l_mux4_1
X_2003_ _2003_/Q FrameData[24] VGND VPWR FrameStrobe[10] latch
X_2905_ _2905_/X _1065_/B _2905_/A1 _2905_/A2 _0856_/Y _2123_/Q _2124_/Q VPWR VGND
+ sg13cmos5l_mux4_1
X_2836_ _2836_/X _2924_/X _3036_/X _3136_/X _0654_/X _1921_/Q _1922_/Q VPWR VGND sg13cmos5l_mux4_1
X_1649_ _1649_/Q FrameData[22] VGND VPWR _1171_/X latch
X_1718_ _1718_/Q FrameData[27] VGND VPWR _1133_/X latch
X_2767_ _2767_/X _1447_/Q _1448_/Q _1449_/Q _1450_/Q _3220_/X _3215_/X VPWR VGND sg13cmos5l_mux4_1
X_2698_ _2698_/X _3159_/X _0870_/X _3107_/X _0866_/X _1769_/Q _1770_/Q VPWR VGND sg13cmos5l_mux4_1
X_3319_ _3319_/X N1END[3] EE4END[0] SS4END[3] _3036_/X _1643_/Q _1644_/Q VPWR VGND
+ sg13cmos5l_mux4_1
XFILLER_22_382 VPWR VGND sg13cmos5l_fill_2
XFILLER_41_32 VPWR VGND sg13cmos5l_fill_2
XFILLER_17_110 VPWR VGND sg13cmos5l_fill_1
XFILLER_40_190 VPWR VGND sg13cmos5l_fill_1
X_0882_ _0883_/A _2878_/X _1065_/B _0881_/Y VPWR VGND sg13cmos5l_a21oi_1
X_0951_ _2600_/A _3015_/X _3016_/X _2065_/Q VPWR VGND sg13cmos5l_mux2_1
X_1503_ _1503_/Q FrameData[4] VGND VPWR _1188_/X latch
X_2621_ W6BEG[6] W6END[8] VPWR VGND sg13cmos5l_buf_1
X_2552_ FrameData_O[5] FrameData[5] VPWR VGND sg13cmos5l_buf_1
X_2483_ N4BEG[4] N4END[8] VPWR VGND sg13cmos5l_buf_1
XANTENNA__2586__X SS4BEG[7] VPWR VGND sg13cmos5l_antennanp
X_1296_ _1296_/Q FrameData[21] VGND VPWR _1197_/X latch
X_1365_ _1365_/Q FrameData[26] VGND VPWR _1183_/X latch
X_1434_ _1434_/Q FrameData[31] VGND VPWR _1186_/X latch
X_3035_ _3035_/X S2END[2] S4END[2] W2MID[0] _0918_/Y _2115_/Q _2116_/Q VPWR VGND sg13cmos5l_mux4_1
X_3104_ _3104_/X E2END[1] E6END[1] S1END[3] S2MID[7] _2238_/Q _2239_/Q VPWR VGND sg13cmos5l_mux4_1
X_2819_ _2819_/X _1507_/Q _1515_/Q _1508_/Q _1516_/Q _2835_/X _3196_/X VPWR VGND sg13cmos5l_mux4_1
XANTENNA__2496__X NN4BEG[1] VPWR VGND sg13cmos5l_antennanp
XFILLER_19_408 VPWR VGND sg13cmos5l_decap_4
XFILLER_54_293 VPWR VGND sg13cmos5l_fill_2
XFILLER_10_363 VPWR VGND sg13cmos5l_decap_8
XFILLER_10_385 VPWR VGND sg13cmos5l_decap_4
X_1150_ _1150_/Y _1332_/Q _0879_/B _1149_/Y VPWR VGND sg13cmos5l_o21ai_1
XFILLER_18_496 VPWR VGND sg13cmos5l_fill_1
XFILLER_33_433 VPWR VGND sg13cmos5l_fill_1
XFILLER_45_293 VPWR VGND sg13cmos5l_fill_2
X_1081_ _1081_/X _3210_/X _1081_/B VPWR VGND sg13cmos5l_or2_1
X_0865_ _0865_/X _2930_/X _2931_/X _2258_/Q VPWR VGND sg13cmos5l_mux2_1
X_0934_ _0934_/Y _1747_/Q _2599_/A VPWR VGND sg13cmos5l_nand2_1
X_2604_ W2BEG[5] _2604_/A VPWR VGND sg13cmos5l_buf_1
X_1983_ _1983_/Q FrameData[4] VGND VPWR FrameStrobe[10] latch
XFILLER_54_0 VPWR VGND sg13cmos5l_fill_2
X_0796_ _0894_/A _1541_/Q _0794_/Y _0795_/Y VPWR VGND sg13cmos5l_o21ai_1
X_1417_ _1417_/Q FrameData[14] VGND VPWR _1186_/X latch
X_2535_ S4BEG[4] S4END[8] VPWR VGND sg13cmos5l_buf_1
X_2466_ N2BEG[3] _2466_/A VPWR VGND sg13cmos5l_buf_1
X_1279_ _1279_/Q FrameData[4] VGND VPWR _1197_/X latch
X_1348_ _1348_/Q FrameData[9] VGND VPWR _1183_/X latch
X_3018_ _3018_/X _3139_/X _3112_/X _0864_/X _1056_/Y _2045_/Q _2046_/Q VPWR VGND sg13cmos5l_mux4_1
X_2397_ EE4BEG[6] EE4END[10] VPWR VGND sg13cmos5l_buf_1
XFILLER_24_499 VPWR VGND sg13cmos5l_decap_4
XFILLER_19_249 VPWR VGND sg13cmos5l_decap_8
XFILLER_34_208 VPWR VGND sg13cmos5l_fill_2
XFILLER_42_263 VPWR VGND sg13cmos5l_fill_1
XFILLER_42_274 VPWR VGND sg13cmos5l_decap_4
X_0581_ _0581_/Y _2724_/X VPWR VGND sg13cmos5l_inv_1
X_0650_ _0650_/X _3094_/X _3095_/X _2166_/Q VPWR VGND sg13cmos5l_mux2_1
X_2320_ _2320_/Q FrameData[21] VGND VPWR FrameStrobe[0] latch
X_2251_ _2251_/Q FrameData[16] VGND VPWR FrameStrobe[2] latch
X_1064_ _1064_/Y _1061_/A _1063_/X _1062_/Y VPWR VGND sg13cmos5l_a21oi_1
X_1133_ _1133_/X FrameStrobe[12] FrameStrobe[13] VPWR VGND sg13cmos5l_and2_1
X_1202_ _1202_/Y _1942_/Q _2606_/A VPWR VGND sg13cmos5l_nand2_1
X_2182_ _2182_/Q FrameData[11] VGND VPWR FrameStrobe[4] latch
XFILLER_18_293 VPWR VGND sg13cmos5l_fill_2
XFILLER_33_230 VPWR VGND sg13cmos5l_decap_8
X_1966_ _1966_/Q FrameData[19] VGND VPWR _1044_/X latch
X_0779_ _0779_/Y _1453_/Q _0778_/Y VPWR VGND sg13cmos5l_nor2b_1
X_0848_ _0848_/Y _2322_/Q _0846_/A _0847_/Y VPWR VGND sg13cmos5l_o21ai_1
X_0917_ _0917_/Y _1287_/Q _0917_/B _0917_/C VPWR VGND sg13cmos5l_nor3_1
X_1897_ _1897_/Q FrameData[14] VGND VPWR _1152_/X latch
XFILLER_29_514 VPWR VGND sg13cmos5l_fill_2
X_2518_ S2BEG[3] _2518_/A VPWR VGND sg13cmos5l_buf_1
X_2449_ FrameStrobe_O[10] FrameStrobe[10] VPWR VGND sg13cmos5l_buf_1
XFILLER_16_219 VPWR VGND sg13cmos5l_decap_8
XFILLER_8_418 VPWR VGND sg13cmos5l_decap_4
X_1820_ _1820_/Q FrameData[1] VGND VPWR _1136_/X latch
X_0633_ _2625_/A _3271_/X _3272_/X _1717_/Q VPWR VGND sg13cmos5l_mux2_1
X_0702_ _0702_/Y _0802_/A VPWR VGND sg13cmos5l_inv_1
X_1682_ _1682_/Q FrameData[23] VGND VPWR _1167_/X latch
X_1751_ _1751_/Q FrameData[28] VGND VPWR _1177_/X latch
XFILLER_57_119 VPWR VGND sg13cmos5l_fill_1
X_0564_ _0564_/Y _1246_/Q VPWR VGND sg13cmos5l_inv_1
X_3352_ _3352_/X _2932_/X _3074_/X _0865_/X _0974_/Y _1595_/Q _1596_/Q VPWR VGND sg13cmos5l_mux4_1
X_3283_ _3283_/X N2END[3] S2MID[7] _1240_/Q _0654_/X _1697_/Q _1698_/Q VPWR VGND sg13cmos5l_mux4_1
X_2303_ _2303_/Q FrameData[4] VGND VPWR FrameStrobe[0] latch
X_2234_ _2234_/Q FrameData[31] VGND VPWR FrameStrobe[3] latch
XANTENNA__2594__X SS4BEG[15] VPWR VGND sg13cmos5l_antennanp
X_1047_ _1047_/X SS4END[0] W2END[0] _2155_/Q VPWR VGND sg13cmos5l_mux2_1
X_1116_ _1116_/Y _3186_/X _3185_/X VPWR VGND sg13cmos5l_nor2_1
X_2165_ _2165_/Q FrameData[26] VGND VPWR FrameStrobe[5] latch
X_2096_ _2096_/Q FrameData[21] VGND VPWR FrameStrobe[7] latch
X_2998_ _2998_/X E1END[1] E2MID[5] E2END[5] EE4END[3] _2139_/Q _2140_/Q VPWR VGND
+ sg13cmos5l_mux4_1
X_1949_ _1949_/Q FrameData[2] VGND VPWR _1044_/X latch
XFILLER_44_65 VPWR VGND sg13cmos5l_fill_1
XFILLER_47_141 VPWR VGND sg13cmos5l_fill_2
XFILLER_47_185 VPWR VGND sg13cmos5l_decap_4
X_1803_ _1803_/Q FrameData[16] VGND VPWR _1138_/X latch
X_2921_ _2921_/X E1END[0] E2MID[4] E2END[4] EE4END[2] _2103_/Q _2104_/Q VPWR VGND
+ sg13cmos5l_mux4_1
X_2852_ _2852_/X _1565_/Q _1566_/Q _1567_/Q _1568_/Q _3184_/X _3179_/X VPWR VGND sg13cmos5l_mux4_1
X_2783_ _2783_/X _0630_/X _3006_/X _0654_/X _3001_/X _1865_/Q _1866_/Q VPWR VGND sg13cmos5l_mux4_1
XANTENNA__2589__X SS4BEG[10] VPWR VGND sg13cmos5l_antennanp
X_0616_ _2462_/A _3349_/X _3350_/X _1600_/Q VPWR VGND sg13cmos5l_mux2_1
X_1596_ _1596_/Q FrameData[1] VGND VPWR _1189_/X latch
X_1665_ _1665_/Q FrameData[6] VGND VPWR _1167_/X latch
X_1734_ _1734_/Q FrameData[11] VGND VPWR _1177_/X latch
X_3197_ _3197_/X _1176_/Y _1168_/X _1910_/Q _1170_/Y _1911_/Q _1912_/Q VPWR VGND sg13cmos5l_mux4_1
X_3266_ _3266_/X _3163_/X _3159_/X _3155_/X _3150_/X _1721_/Q _1722_/Q VPWR VGND sg13cmos5l_mux4_1
X_3335_ _3335_/X NN4END[3] E6END[1] W1END[3] _3059_/X _1619_/Q _1620_/Q VPWR VGND
+ sg13cmos5l_mux4_1
X_2217_ _2217_/Q FrameData[14] VGND VPWR FrameStrobe[3] latch
X_2148_ _2148_/Q FrameData[9] VGND VPWR FrameStrobe[5] latch
X_2079_ _2079_/Q FrameData[4] VGND VPWR FrameStrobe[7] latch
XANTENNA__2499__X NN4BEG[4] VPWR VGND sg13cmos5l_antennanp
X_1450_ _1450_/Q FrameData[15] VGND VPWR _1185_/X latch
XFILLER_0_490 VPWR VGND sg13cmos5l_decap_8
X_1381_ _1381_/Q FrameData[10] VGND VPWR _1181_/X latch
X_3051_ _3051_/X N2MID[0] E1END[2] SS4END[0] W2MID[0] _2161_/Q _2162_/Q VPWR VGND
+ sg13cmos5l_mux4_1
X_3120_ _3120_/X S2END[1] S4END[1] SS4END[0] W1END[1] _2296_/Q _2297_/Q VPWR VGND
+ sg13cmos5l_mux4_1
XFILLER_35_166 VPWR VGND sg13cmos5l_fill_2
XFILLER_35_188 VPWR VGND sg13cmos5l_fill_2
X_2002_ _2002_/Q FrameData[23] VGND VPWR FrameStrobe[10] latch
X_2904_ _2904_/X N2END[7] E2MID[5] EE4END[3] S2END[3] _2123_/Q _2124_/Q VPWR VGND
+ sg13cmos5l_mux4_1
X_2835_ _2835_/X _2831_/X _2832_/X _2833_/X _2834_/X _1927_/Q _1928_/Q VPWR VGND sg13cmos5l_mux4_1
X_2766_ _2766_/X _1443_/Q _1444_/Q _1445_/Q _1446_/Q _3220_/X _3215_/X VPWR VGND sg13cmos5l_mux4_1
X_1579_ _1579_/Q FrameData[16] VGND VPWR _1166_/X latch
X_1648_ _1648_/Q FrameData[21] VGND VPWR _1171_/X latch
X_1717_ _1717_/Q FrameData[26] VGND VPWR _1133_/X latch
X_3318_ _3318_/X _3144_/X _0869_/X _2890_/X _1223_/Y _1646_/Q _1647_/Q VPWR VGND sg13cmos5l_mux4_1
X_2697_ _2697_/X _3079_/X _0653_/X _0628_/X _2903_/X _1769_/Q _1770_/Q VPWR VGND sg13cmos5l_mux4_1
XFILLER_54_464 VPWR VGND sg13cmos5l_fill_2
X_3249_ _3249_/X _0871_/X _0869_/X _0867_/X _0865_/X _1757_/Q _1758_/Q VPWR VGND sg13cmos5l_mux4_1
XFILLER_10_523 VPWR VGND sg13cmos5l_fill_1
XFILLER_17_155 VPWR VGND sg13cmos5l_decap_4
XFILLER_57_280 VPWR VGND sg13cmos5l_fill_1
XFILLER_13_361 VPWR VGND sg13cmos5l_fill_1
X_0881_ _0881_/Y _2878_/X _0881_/B VPWR VGND sg13cmos5l_nor2_1
X_0950_ _2518_/A _0950_/A VPWR VGND sg13cmos5l_inv_1
X_2620_ W6BEG[5] W6END[7] VPWR VGND sg13cmos5l_buf_1
X_1433_ _1433_/Q FrameData[30] VGND VPWR _1186_/X latch
X_1502_ _1502_/Q FrameData[3] VGND VPWR _1188_/X latch
X_2551_ FrameData_O[4] FrameData[4] VPWR VGND sg13cmos5l_buf_1
X_2482_ N4BEG[3] N4END[7] VPWR VGND sg13cmos5l_buf_1
X_1295_ _1295_/Q FrameData[20] VGND VPWR _1197_/X latch
X_1364_ _1364_/Q FrameData[25] VGND VPWR _1183_/X latch
X_3034_ _3034_/X E1END[0] E2END[4] EE4END[2] S2MID[2] _2115_/Q _2116_/Q VPWR VGND
+ sg13cmos5l_mux4_1
X_3103_ _3103_/X N2MID[3] N2END[3] N4END[3] E2MID[1] _2238_/Q _2239_/Q VPWR VGND sg13cmos5l_mux4_1
XFILLER_23_136 VPWR VGND sg13cmos5l_decap_4
XFILLER_3_508 VPWR VGND sg13cmos5l_decap_8
X_2818_ _2818_/X _1505_/Q _1513_/Q _1506_/Q _1514_/Q _2835_/X _3196_/X VPWR VGND sg13cmos5l_mux4_1
X_2749_ _2749_/X _0630_/X _2924_/X _3136_/X _0655_/X _1825_/Q _1826_/Q VPWR VGND sg13cmos5l_mux4_1
XFILLER_27_475 VPWR VGND sg13cmos5l_fill_1
X_1080_ _1081_/B _2763_/X _1456_/Q _1079_/Y VPWR VGND sg13cmos5l_o21ai_1
X_1982_ _1982_/Q FrameData[3] VGND VPWR FrameStrobe[10] latch
X_0795_ _0795_/Y _1541_/Q _0795_/B VPWR VGND sg13cmos5l_nand2_1
X_0864_ _0864_/X _3171_/X _3172_/X _2261_/Q VPWR VGND sg13cmos5l_mux2_1
X_0933_ _2599_/A _3023_/X _3024_/X _2062_/Q VPWR VGND sg13cmos5l_mux2_1
X_2603_ W2BEG[4] _2603_/A VPWR VGND sg13cmos5l_buf_1
X_2534_ S4BEG[3] S4END[7] VPWR VGND sg13cmos5l_buf_1
XANTENNA__2597__X W1BEG[2] VPWR VGND sg13cmos5l_antennanp
X_1347_ _1347_/Q FrameData[8] VGND VPWR _1183_/X latch
X_1416_ _1416_/Q FrameData[13] VGND VPWR _1186_/X latch
X_2465_ N2BEG[2] _2465_/A VPWR VGND sg13cmos5l_buf_1
X_2396_ EE4BEG[5] EE4END[9] VPWR VGND sg13cmos5l_buf_1
X_1278_ _1278_/Q FrameData[3] VGND VPWR _1197_/X latch
X_3017_ _3017_/X E2MID[0] W2END[4] _1235_/Q _3059_/X _2045_/Q _2046_/Q VPWR VGND sg13cmos5l_mux4_1
XFILLER_24_467 VPWR VGND sg13cmos5l_decap_8
XFILLER_51_253 VPWR VGND sg13cmos5l_fill_2
XFILLER_12_90 VPWR VGND sg13cmos5l_fill_1
X_0580_ _1089_/A _2714_/X VPWR VGND sg13cmos5l_inv_1
X_1201_ _2606_/A _2937_/X _2938_/X _2084_/Q VPWR VGND sg13cmos5l_mux2_1
X_2250_ _2250_/Q FrameData[15] VGND VPWR FrameStrobe[2] latch
X_1063_ _1063_/X _2144_/Q _2143_/Q VPWR VGND sg13cmos5l_and2_1
X_1132_ _1132_/X N2END[1] N4END[1] _2187_/Q VPWR VGND sg13cmos5l_mux2_1
X_2181_ _2181_/Q FrameData[10] VGND VPWR FrameStrobe[4] latch
XFILLER_33_253 VPWR VGND sg13cmos5l_fill_2
X_0916_ _0916_/Y _0575_/Y _1501_/Q _0915_/Y VPWR VGND sg13cmos5l_o21ai_1
X_1965_ _1965_/Q FrameData[18] VGND VPWR _1044_/X latch
X_0778_ _0778_/Y _1874_/Q _2467_/A _1873_/Q VPWR VGND sg13cmos5l_o21ai_1
X_0847_ _0847_/Y _1242_/Q _2322_/Q VPWR VGND sg13cmos5l_nand2_1
X_2517_ S2BEG[2] _2517_/A VPWR VGND sg13cmos5l_buf_1
X_1896_ _1896_/Q FrameData[13] VGND VPWR _1152_/X latch
X_2448_ FrameStrobe_O[9] FrameStrobe[9] VPWR VGND sg13cmos5l_buf_1
X_2379_ _3045_/A1 VPWR VGND sg13cmos5l_tielo
XFILLER_17_57 VPWR VGND sg13cmos5l_fill_1
XFILLER_17_79 VPWR VGND sg13cmos5l_fill_1
XFILLER_24_286 VPWR VGND sg13cmos5l_decap_8
XFILLER_24_297 VPWR VGND sg13cmos5l_fill_1
XFILLER_33_45 VPWR VGND sg13cmos5l_fill_1
XFILLER_35_518 VPWR VGND sg13cmos5l_fill_1
X_1750_ _1750_/Q FrameData[27] VGND VPWR _1177_/X latch
X_0563_ _0563_/Y _1250_/Q VPWR VGND sg13cmos5l_inv_1
X_0632_ _2626_/A _3269_/X _3270_/X _1720_/Q VPWR VGND sg13cmos5l_mux2_1
X_0701_ _0802_/A _0699_/D _0700_/B _0700_/Y VPWR VGND sg13cmos5l_o21ai_1
X_1681_ _1681_/Q FrameData[22] VGND VPWR _1167_/X latch
X_3351_ _3351_/X N2MID[2] E2END[3] W2MID[7] _2924_/X _1595_/Q _1596_/Q VPWR VGND sg13cmos5l_mux4_1
XFILLER_38_301 VPWR VGND sg13cmos5l_decap_4
XFILLER_38_345 VPWR VGND sg13cmos5l_decap_8
X_3282_ _3282_/X _2910_/X _2917_/X _0858_/X _0921_/Y _1700_/Q _1701_/Q VPWR VGND sg13cmos5l_mux4_1
X_2302_ _2302_/Q FrameData[3] VGND VPWR FrameStrobe[0] latch
X_2233_ _2233_/Q FrameData[30] VGND VPWR FrameStrobe[3] latch
X_2164_ _2164_/Q FrameData[25] VGND VPWR FrameStrobe[5] latch
X_1046_ _1046_/X N2END[0] E2MID[6] _2155_/Q VPWR VGND sg13cmos5l_mux2_1
X_1115_ _1250_/D _0563_/Y _1103_/Y _1104_/Y _1114_/Y VPWR VGND sg13cmos5l_a22oi_1
X_2095_ _2095_/Q FrameData[20] VGND VPWR FrameStrobe[7] latch
X_2997_ _2997_/X N1END[3] N2MID[7] N2END[7] NN4END[3] _2139_/Q _2140_/Q VPWR VGND
+ sg13cmos5l_mux4_1
X_1948_ _1948_/Q FrameData[1] VGND VPWR _1044_/X latch
X_1879_ _1879_/Q FrameData[28] VGND VPWR _1157_/X latch
XFILLER_29_356 VPWR VGND sg13cmos5l_fill_2
XFILLER_29_389 VPWR VGND sg13cmos5l_decap_4
XFILLER_44_359 VPWR VGND sg13cmos5l_fill_1
XFILLER_52_370 VPWR VGND sg13cmos5l_fill_2
XFILLER_12_289 VPWR VGND sg13cmos5l_fill_2
XFILLER_4_477 VPWR VGND sg13cmos5l_fill_2
XFILLER_8_238 VPWR VGND sg13cmos5l_fill_2
X_2920_ _2920_/X N1END[2] N2MID[6] N2END[6] NN4END[2] _2103_/Q _2104_/Q VPWR VGND
+ sg13cmos5l_mux4_1
X_1733_ _1733_/Q FrameData[10] VGND VPWR _1177_/X latch
X_1802_ _1802_/Q FrameData[15] VGND VPWR _1138_/X latch
X_2851_ _2851_/X _1561_/Q _1562_/Q _1563_/Q _1564_/Q _3184_/X _3179_/X VPWR VGND sg13cmos5l_mux4_1
X_2782_ _2782_/X _2778_/X _2779_/X _2780_/X _2781_/X _1859_/Q _1860_/Q VPWR VGND sg13cmos5l_mux4_1
X_0615_ _2491_/A _3347_/X _3348_/X _1603_/Q VPWR VGND sg13cmos5l_mux2_1
X_1595_ _1595_/Q FrameData[0] VGND VPWR _1189_/X latch
X_1664_ _1664_/Q FrameData[5] VGND VPWR _1167_/X latch
X_3334_ _3334_/X _3079_/X _0867_/X _3122_/X _0833_/Y _1622_/Q _1623_/Q VPWR VGND sg13cmos5l_mux4_1
XFILLER_26_315 VPWR VGND sg13cmos5l_decap_4
XFILLER_38_142 VPWR VGND sg13cmos5l_decap_8
X_3196_ _3196_/X _3192_/X _3193_/X _3194_/X _3195_/X _1915_/Q _1916_/Q VPWR VGND sg13cmos5l_mux4_1
X_3265_ _3265_/X _3145_/X _2910_/X _3144_/X _3139_/X _1721_/Q _1722_/Q VPWR VGND sg13cmos5l_mux4_1
X_2216_ _2216_/Q FrameData[13] VGND VPWR FrameStrobe[3] latch
X_2147_ _2147_/Q FrameData[8] VGND VPWR FrameStrobe[5] latch
XFILLER_22_510 VPWR VGND sg13cmos5l_fill_1
XFILLER_26_359 VPWR VGND sg13cmos5l_fill_2
X_1029_ _1029_/Y _1846_/Q _1130_/C _1028_/Y VPWR VGND sg13cmos5l_a21oi_1
X_2078_ _2078_/Q FrameData[3] VGND VPWR FrameStrobe[7] latch
XFILLER_29_120 VPWR VGND sg13cmos5l_fill_2
XFILLER_17_337 VPWR VGND sg13cmos5l_fill_1
XFILLER_17_348 VPWR VGND sg13cmos5l_fill_1
XFILLER_32_307 VPWR VGND sg13cmos5l_fill_2
XFILLER_25_392 VPWR VGND sg13cmos5l_fill_1
XFILLER_9_514 VPWR VGND sg13cmos5l_fill_2
X_1380_ _1380_/Q FrameData[9] VGND VPWR _1181_/X latch
X_3050_ _3050_/X _3046_/X _3047_/X _3048_/X _3049_/X _2169_/Q _2170_/Q VPWR VGND sg13cmos5l_mux4_1
X_2001_ _2001_/Q FrameData[22] VGND VPWR FrameStrobe[10] latch
XFILLER_31_340 VPWR VGND sg13cmos5l_fill_2
X_2903_ _2903_/X _2900_/X _2901_/X _2902_/X _1131_/Y _2201_/Q _2202_/Q VPWR VGND sg13cmos5l_mux4_1
X_1716_ _1716_/Q FrameData[25] VGND VPWR _1133_/X latch
X_2834_ _2834_/X _0864_/X _2899_/X _0859_/X _2885_/X _1925_/Q _1926_/Q VPWR VGND sg13cmos5l_mux4_1
X_2765_ _2765_/X _1439_/Q _1440_/Q _1441_/Q _1442_/Q _3220_/X _3215_/X VPWR VGND sg13cmos5l_mux4_1
X_2696_ _2696_/X _0630_/X _0658_/X _0657_/X _0654_/X _1769_/Q _1770_/Q VPWR VGND sg13cmos5l_mux4_1
X_1578_ _1578_/Q FrameData[15] VGND VPWR _1166_/X latch
X_1647_ _1647_/Q FrameData[20] VGND VPWR _1171_/X latch
X_3317_ _3317_/X N1END[0] E2MID[4] SS4END[0] _0656_/X _1646_/Q _1647_/Q VPWR VGND
+ sg13cmos5l_mux4_1
XFILLER_54_410 VPWR VGND sg13cmos5l_fill_1
X_3179_ _3179_/X _3175_/X _3176_/X _3177_/X _3178_/X _1951_/Q _1952_/Q VPWR VGND sg13cmos5l_mux4_1
X_3248_ _3248_/X _3079_/X _2932_/X _3074_/X _3139_/X _1757_/Q _1758_/Q VPWR VGND sg13cmos5l_mux4_1
XFILLER_41_23 VPWR VGND sg13cmos5l_fill_2
X_0880_ _1065_/B _1331_/Q _0878_/A _0879_/Y VPWR VGND sg13cmos5l_a21oi_1
X_2550_ FrameData_O[3] FrameData[3] VPWR VGND sg13cmos5l_buf_1
X_1363_ _1363_/Q FrameData[24] VGND VPWR _1183_/X latch
X_1432_ _1432_/Q FrameData[29] VGND VPWR _1186_/X latch
X_1501_ _1501_/Q FrameData[2] VGND VPWR _1188_/X latch
X_2481_ N4BEG[2] N4END[6] VPWR VGND sg13cmos5l_buf_1
X_1294_ _1294_/Q FrameData[19] VGND VPWR _1197_/X latch
X_3033_ _3033_/X N1END[2] N2MID[6] N2END[6] NN4END[2] _2115_/Q _2116_/Q VPWR VGND
+ sg13cmos5l_mux4_1
X_3102_ _3102_/X _0875_/A _3102_/A1 _3102_/A2 _1223_/Y _2253_/Q _2254_/Q VPWR VGND
+ sg13cmos5l_mux4_1
X_2817_ _2817_/X _1503_/Q _1511_/Q _1504_/Q _1512_/Q _2835_/X _3196_/X VPWR VGND sg13cmos5l_mux4_1
X_2748_ _2748_/X _2744_/X _2745_/X _2746_/X _2747_/X _1831_/Q _1832_/Q VPWR VGND sg13cmos5l_mux4_1
X_2679_ _2679_/X _1317_/Q _1318_/Q _1319_/Q _1320_/Q _3256_/X _3251_/X VPWR VGND sg13cmos5l_mux4_1
XFILLER_14_126 VPWR VGND sg13cmos5l_fill_2
XFILLER_10_321 VPWR VGND sg13cmos5l_decap_8
XFILLER_10_332 VPWR VGND sg13cmos5l_fill_1
XFILLER_10_343 VPWR VGND sg13cmos5l_decap_4
XFILLER_7_0 VPWR VGND sg13cmos5l_decap_4
XFILLER_18_410 VPWR VGND sg13cmos5l_fill_1
XFILLER_33_402 VPWR VGND sg13cmos5l_fill_1
XFILLER_20_107 VPWR VGND sg13cmos5l_fill_1
X_0932_ _2517_/A _0932_/A VPWR VGND sg13cmos5l_inv_1
X_1981_ _1981_/Q FrameData[2] VGND VPWR FrameStrobe[10] latch
X_0794_ _0794_/Y _0794_/A _0794_/B VPWR VGND sg13cmos5l_xnor2_1
X_0863_ _0863_/X _3128_/X _3129_/X _2264_/Q VPWR VGND sg13cmos5l_mux2_1
X_2602_ W2BEG[3] _2602_/A VPWR VGND sg13cmos5l_buf_1
X_2533_ S4BEG[2] S4END[6] VPWR VGND sg13cmos5l_buf_1
X_1346_ _1346_/Q FrameData[7] VGND VPWR _1183_/X latch
X_1415_ _1415_/Q FrameData[12] VGND VPWR _1186_/X latch
X_2464_ N2BEG[1] _2464_/A VPWR VGND sg13cmos5l_buf_1
X_2395_ EE4BEG[4] EE4END[8] VPWR VGND sg13cmos5l_buf_1
X_1277_ _1277_/Q FrameData[2] VGND VPWR _1197_/X latch
X_3016_ _3016_/X _0650_/X _3159_/X _0860_/X _1223_/Y _2063_/Q _2064_/Q VPWR VGND sg13cmos5l_mux4_1
XFILLER_15_424 VPWR VGND sg13cmos5l_decap_4
X_1200_ _2516_/A _1200_/A VPWR VGND sg13cmos5l_inv_1
X_2180_ _2180_/Q FrameData[9] VGND VPWR FrameStrobe[4] latch
XFILLER_18_262 VPWR VGND sg13cmos5l_fill_1
XFILLER_18_295 VPWR VGND sg13cmos5l_fill_1
X_1062_ _1062_/Y _2144_/Q _1056_/Y _2143_/Q VPWR VGND sg13cmos5l_a21oi_1
X_1131_ _1131_/Y _1131_/A _1130_/Y VPWR VGND sg13cmos5l_nor2b_1
X_0915_ _0915_/Y _2816_/X _1501_/Q VPWR VGND sg13cmos5l_nand2_1
X_1964_ _1964_/Q FrameData[17] VGND VPWR _1044_/X latch
X_1895_ _1895_/Q FrameData[12] VGND VPWR _1152_/X latch
XANTENNA__2401__X EE4BEG[10] VPWR VGND sg13cmos5l_antennanp
X_0777_ _0777_/Y _1023_/B _1023_/C _0776_/Y VPWR VGND sg13cmos5l_o21ai_1
X_0846_ _0846_/Y _0846_/A VPWR VGND sg13cmos5l_inv_1
X_2516_ S2BEG[1] _2516_/A VPWR VGND sg13cmos5l_buf_1
X_2447_ FrameStrobe_O[8] FrameStrobe[8] VPWR VGND sg13cmos5l_buf_1
X_1329_ _1329_/Q FrameData[22] VGND VPWR _1184_/X latch
X_2378_ _2919_/A1 VPWR VGND sg13cmos5l_tielo
XFILLER_24_276 VPWR VGND sg13cmos5l_decap_4
XFILLER_11_493 VPWR VGND sg13cmos5l_decap_4
XFILLER_15_254 VPWR VGND sg13cmos5l_decap_4
XFILLER_15_276 VPWR VGND sg13cmos5l_decap_4
XFILLER_15_287 VPWR VGND sg13cmos5l_decap_4
XFILLER_15_298 VPWR VGND sg13cmos5l_fill_2
X_0700_ _0700_/Y _2763_/X _0700_/B VPWR VGND sg13cmos5l_nand2_1
X_0631_ _0631_/X _3137_/X _3138_/X _2093_/Q VPWR VGND sg13cmos5l_mux2_1
X_1680_ _1680_/Q FrameData[21] VGND VPWR _1167_/X latch
X_3350_ _3350_/X _0628_/X _0872_/X _3170_/X _0848_/Y _1598_/Q _1599_/Q VPWR VGND sg13cmos5l_mux4_1
X_2301_ _2301_/Q FrameData[2] VGND VPWR FrameStrobe[0] latch
XFILLER_26_519 VPWR VGND sg13cmos5l_fill_1
X_1114_ _1114_/Y _1584_/Q _0830_/Y _1113_/Y VPWR VGND sg13cmos5l_o21ai_1
X_3281_ _3281_/X N2END[4] S2MID[0] W2MID[4] _0630_/X _1700_/Q _1701_/Q VPWR VGND sg13cmos5l_mux4_1
X_2232_ _2232_/Q FrameData[29] VGND VPWR FrameStrobe[3] latch
X_2163_ _2163_/Q FrameData[24] VGND VPWR FrameStrobe[5] latch
X_1045_ _1045_/X W2END[0] W6END[0] _2158_/Q VPWR VGND sg13cmos5l_mux2_1
X_2094_ _2094_/Q FrameData[19] VGND VPWR FrameStrobe[7] latch
X_0829_ _0830_/B _0828_/Y _2859_/X _1580_/Q VPWR VGND sg13cmos5l_mux2_1
X_2996_ _2996_/X _2932_/X _3117_/X _2929_/X _1056_/Y _1988_/Q _1989_/Q VPWR VGND sg13cmos5l_mux4_1
X_1947_ _1947_/Q FrameData[0] VGND VPWR _1044_/X latch
X_1878_ _1878_/Q FrameData[27] VGND VPWR _1157_/X latch
XFILLER_12_257 VPWR VGND sg13cmos5l_decap_8
XFILLER_40_555 VPWR VGND sg13cmos5l_fill_2
XFILLER_28_390 VPWR VGND sg13cmos5l_fill_1
XFILLER_35_349 VPWR VGND sg13cmos5l_fill_2
X_2850_ _2850_/X _2846_/X _2847_/X _2848_/X _2849_/X _3179_/X _0908_/Y VPWR VGND sg13cmos5l_mux4_1
X_1663_ _1663_/Q FrameData[4] VGND VPWR _1167_/X latch
X_1732_ _1732_/Q FrameData[9] VGND VPWR _1177_/X latch
X_1801_ _1801_/Q FrameData[14] VGND VPWR _1138_/X latch
X_2781_ _2781_/X _0864_/X _3127_/X _0858_/X _3010_/X _1857_/Q _1858_/Q VPWR VGND sg13cmos5l_mux4_1
X_0614_ _2511_/A _3311_/X _3312_/X _1657_/Q VPWR VGND sg13cmos5l_mux2_1
X_1594_ _1594_/Q FrameData[31] VGND VPWR _1166_/X latch
X_3264_ _3264_/X _0631_/X _0629_/X _3136_/X _0655_/X _1721_/Q _1722_/Q VPWR VGND sg13cmos5l_mux4_1
X_3333_ _3333_/X N2MID[4] E6END[0] W1END[0] _0629_/X _1622_/Q _1623_/Q VPWR VGND sg13cmos5l_mux4_1
X_3195_ _3195_/X _0864_/X _3170_/X _0859_/X _3122_/X _1913_/Q _1914_/Q VPWR VGND sg13cmos5l_mux4_1
X_2215_ _2215_/Q FrameData[12] VGND VPWR FrameStrobe[3] latch
X_2146_ _2146_/Q FrameData[7] VGND VPWR FrameStrobe[5] latch
X_2077_ _2077_/Q FrameData[2] VGND VPWR FrameStrobe[7] latch
XFILLER_41_308 VPWR VGND sg13cmos5l_decap_8
XFILLER_53_179 VPWR VGND sg13cmos5l_fill_1
X_1028_ _1028_/Y _1846_/Q _1226_/B VPWR VGND sg13cmos5l_nor2_1
X_2979_ _2979_/X N4END[0] E2MID[6] W1END[2] _2924_/X _2000_/Q _2001_/Q VPWR VGND sg13cmos5l_mux4_1
XFILLER_17_327 VPWR VGND sg13cmos5l_fill_1
XFILLER_44_146 VPWR VGND sg13cmos5l_fill_1
XFILLER_4_231 VPWR VGND sg13cmos5l_fill_2
XFILLER_0_481 VPWR VGND sg13cmos5l_fill_2
X_2000_ _2000_/Q FrameData[21] VGND VPWR FrameStrobe[10] latch
X_2902_ _2902_/X S2END[5] SS4END[1] WW4END[1] _1051_/C _2199_/Q _2200_/Q VPWR VGND
+ sg13cmos5l_mux4_1
X_2833_ _2833_/X _0872_/X _0870_/X _2917_/X _0866_/X _1925_/Q _1926_/Q VPWR VGND sg13cmos5l_mux4_1
X_1646_ _1646_/Q FrameData[19] VGND VPWR _1171_/X latch
X_1715_ _1715_/Q FrameData[24] VGND VPWR _1133_/X latch
X_2764_ _2764_/X _1435_/Q _1436_/Q _1437_/Q _1438_/Q _3220_/X _3215_/X VPWR VGND sg13cmos5l_mux4_1
X_2695_ _2695_/X _2691_/X _2692_/X _2693_/X _2694_/X _1763_/Q _1764_/Q VPWR VGND sg13cmos5l_mux4_1
X_1577_ _1577_/Q FrameData[14] VGND VPWR _1166_/X latch
X_3247_ _3247_/X _0658_/X _3006_/X _0654_/X _3001_/X _1757_/Q _1758_/Q VPWR VGND sg13cmos5l_mux4_1
X_3316_ _3316_/X _3136_/X _0627_/X _3127_/X _1066_/Y _1649_/Q _1650_/Q VPWR VGND sg13cmos5l_mux4_1
XFILLER_41_105 VPWR VGND sg13cmos5l_fill_2
XFILLER_41_138 VPWR VGND sg13cmos5l_decap_4
XFILLER_54_499 VPWR VGND sg13cmos5l_fill_1
X_3178_ _3178_/X _0864_/X _3170_/X _0859_/X _2929_/X _1949_/Q _1950_/Q VPWR VGND sg13cmos5l_mux4_1
X_2129_ _2129_/Q FrameData[22] VGND VPWR FrameStrobe[6] latch
XFILLER_22_374 VPWR VGND sg13cmos5l_fill_1
XFILLER_41_149 VPWR VGND sg13cmos5l_decap_4
XFILLER_25_190 VPWR VGND sg13cmos5l_fill_2
X_1500_ _1500_/Q FrameData[1] VGND VPWR _1188_/X latch
X_2480_ N4BEG[1] N4END[5] VPWR VGND sg13cmos5l_buf_1
X_1293_ _1293_/Q FrameData[18] VGND VPWR _1197_/X latch
X_1362_ _1362_/Q FrameData[23] VGND VPWR _1183_/X latch
X_1431_ _1431_/Q FrameData[28] VGND VPWR _1186_/X latch
X_3101_ _3101_/X N4END[3] E2MID[1] SS4END[3] W2MID[5] _2253_/Q _2254_/Q VPWR VGND
+ sg13cmos5l_mux4_1
XFILLER_51_425 VPWR VGND sg13cmos5l_fill_1
X_3032_ _3032_/X _3087_/X _0628_/X _3170_/X _0921_/Y _1985_/Q _1986_/Q VPWR VGND sg13cmos5l_mux4_1
XANTENNA__2404__X EE4BEG[13] VPWR VGND sg13cmos5l_antennanp
X_2816_ _2816_/X _2812_/X _2813_/X _2814_/X _2815_/X _1899_/Q _1900_/Q VPWR VGND sg13cmos5l_mux4_1
X_1629_ _1629_/Q FrameData[2] VGND VPWR _1171_/X latch
X_2747_ _2747_/X _0864_/X _3127_/X _0858_/X _2929_/X _1829_/Q _1830_/Q VPWR VGND sg13cmos5l_mux4_1
X_2678_ _2678_/X _1313_/Q _1314_/Q _1315_/Q _1316_/Q _3256_/X _3251_/X VPWR VGND sg13cmos5l_mux4_1
XFILLER_14_138 VPWR VGND sg13cmos5l_fill_1
XFILLER_27_466 VPWR VGND sg13cmos5l_fill_2
XFILLER_10_355 VPWR VGND sg13cmos5l_fill_1
XFILLER_9_153 VPWR VGND sg13cmos5l_fill_2
X_0862_ _0862_/X _3037_/X _3038_/X _2283_/Q VPWR VGND sg13cmos5l_mux2_1
X_0931_ _0932_/A _3026_/X _2044_/Q _0930_/Y VPWR VGND sg13cmos5l_a21oi_1
X_1980_ _1980_/Q FrameData[1] VGND VPWR FrameStrobe[10] latch
X_0793_ _0794_/B _2830_/X _1538_/Q _0792_/Y VPWR VGND sg13cmos5l_a21oi_1
X_2601_ W2BEG[2] _2601_/A VPWR VGND sg13cmos5l_buf_1
X_2532_ S4BEG[1] S4END[5] VPWR VGND sg13cmos5l_buf_1
X_2463_ N2BEG[0] _2463_/A VPWR VGND sg13cmos5l_buf_1
X_1276_ _1276_/Q FrameData[1] VGND VPWR _1197_/X latch
X_1345_ _1345_/Q FrameData[6] VGND VPWR _1183_/X latch
X_1414_ _1414_/Q FrameData[11] VGND VPWR _1186_/X latch
X_3015_ _3015_/X N1END[2] S2END[6] _0839_/B _3001_/X _2063_/Q _2064_/Q VPWR VGND sg13cmos5l_mux4_1
X_2394_ EE4BEG[3] EE4END[7] VPWR VGND sg13cmos5l_buf_1
XFILLER_27_263 VPWR VGND sg13cmos5l_decap_4
Xclkbuf_2_2__f_Inst_LA_FLUT51PSDM_architecture.UserCLK _1250_/CLK clkbuf_0_Inst_LA_FLUT51PSDM_architecture.UserCLK/X
+ VPWR VGND sg13cmos5l_buf_16
XFILLER_30_417 VPWR VGND sg13cmos5l_fill_1
X_1130_ _1130_/Y _2200_/Q _2199_/Q _1130_/C VPWR VGND sg13cmos5l_nand3_1
XFILLER_33_244 VPWR VGND sg13cmos5l_decap_4
XFILLER_33_255 VPWR VGND sg13cmos5l_fill_1
X_1061_ _1061_/Y _1061_/A VPWR VGND sg13cmos5l_inv_1
X_0845_ _0846_/A _1415_/Q _0843_/Y _0844_/Y VPWR VGND sg13cmos5l_o21ai_1
X_0914_ _0914_/Y _0573_/Y _1459_/Q _0913_/Y VPWR VGND sg13cmos5l_o21ai_1
X_1963_ _1963_/Q FrameData[16] VGND VPWR _1044_/X latch
X_1894_ _1894_/Q FrameData[11] VGND VPWR _1152_/X latch
X_0776_ _0776_/Y _1873_/Q _1874_/Q VPWR VGND sg13cmos5l_nor2_1
X_2515_ S2BEG[0] _2978_/X VPWR VGND sg13cmos5l_buf_1
X_2446_ FrameStrobe_O[7] FrameStrobe[7] VPWR VGND sg13cmos5l_buf_1
XFILLER_24_211 VPWR VGND sg13cmos5l_fill_2
X_1259_ _1259_/Q FrameData[16] VGND VPWR _1180_/X latch
X_1328_ _1328_/Q FrameData[21] VGND VPWR _1184_/X latch
X_2377_ _3065_/A1 VPWR VGND sg13cmos5l_tielo
XFILLER_12_428 VPWR VGND sg13cmos5l_fill_2
XFILLER_20_472 VPWR VGND sg13cmos5l_fill_1
XFILLER_11_472 VPWR VGND sg13cmos5l_fill_1
XFILLER_30_225 VPWR VGND sg13cmos5l_fill_1
XANTENNA__2502__X NN4BEG[7] VPWR VGND sg13cmos5l_antennanp
XFILLER_7_498 VPWR VGND sg13cmos5l_fill_2
X_0630_ _0630_/X _3068_/X _3069_/X _2096_/Q VPWR VGND sg13cmos5l_mux2_1
X_3280_ _3280_/X _0872_/X _3150_/X _0859_/X _1056_/Y _1703_/Q _1704_/Q VPWR VGND sg13cmos5l_mux4_1
X_2300_ _2300_/Q FrameData[1] VGND VPWR FrameStrobe[0] latch
X_2231_ _2231_/Q FrameData[28] VGND VPWR FrameStrobe[3] latch
X_1044_ _1044_/X FrameStrobe[12] FrameStrobe[11] VPWR VGND sg13cmos5l_and2_1
X_1113_ _1113_/Y _1584_/Q _0830_/A _3174_/X VPWR VGND sg13cmos5l_a21oi_1
X_2162_ _2162_/Q FrameData[23] VGND VPWR FrameStrobe[5] latch
X_2093_ _2093_/Q FrameData[18] VGND VPWR FrameStrobe[7] latch
X_2995_ _2995_/X E1END[2] W2END[6] _0918_/Y _0655_/X _1988_/Q _1989_/Q VPWR VGND sg13cmos5l_mux4_1
XANTENNA__2412__X E6BEG[5] VPWR VGND sg13cmos5l_antennanp
X_0759_ _0759_/Y _1327_/Q _0758_/Y VPWR VGND sg13cmos5l_nor2b_1
X_0828_ _0828_/Y _0569_/Y _1579_/Q _0825_/Y _0827_/Y VPWR VGND sg13cmos5l_a22oi_1
X_1946_ _1946_/Q FrameData[31] VGND VPWR _1137_/X latch
X_1877_ _1877_/Q FrameData[26] VGND VPWR _1157_/X latch
X_2429_ E2BEG[2] _2429_/A VPWR VGND sg13cmos5l_buf_1
XFILLER_40_534 VPWR VGND sg13cmos5l_fill_2
XFILLER_4_479 VPWR VGND sg13cmos5l_fill_1
XFILLER_5_29 VPWR VGND sg13cmos5l_fill_2
XFILLER_31_556 VPWR VGND sg13cmos5l_fill_1
X_1800_ _1800_/Q FrameData[13] VGND VPWR _1138_/X latch
X_0613_ _2492_/A _3345_/X _3346_/X _1606_/Q VPWR VGND sg13cmos5l_mux2_1
X_1662_ _1662_/Q FrameData[3] VGND VPWR _1167_/X latch
X_1731_ _1731_/Q FrameData[8] VGND VPWR _1177_/X latch
X_2780_ _2780_/X _3112_/X _0871_/X _0868_/X _3107_/X _1857_/Q _1858_/Q VPWR VGND sg13cmos5l_mux4_1
X_1593_ _1593_/Q FrameData[30] VGND VPWR _1166_/X latch
X_3194_ _3194_/X _3117_/X _3112_/X _0868_/X _2917_/X _1913_/Q _1914_/Q VPWR VGND sg13cmos5l_mux4_1
X_3263_ _3263_/X _3259_/X _3260_/X _3261_/X _3262_/X _1727_/Q _1728_/Q VPWR VGND sg13cmos5l_mux4_1
X_3332_ _3332_/X _3117_/X _0865_/X _2929_/X _0840_/Y _1625_/Q _1626_/Q VPWR VGND sg13cmos5l_mux4_1
X_2214_ _2214_/Q FrameData[11] VGND VPWR FrameStrobe[3] latch
XANTENNA__2407__X E6BEG[0] VPWR VGND sg13cmos5l_antennanp
XFILLER_26_328 VPWR VGND sg13cmos5l_fill_2
X_1027_ _1027_/Y _1130_/C VPWR VGND sg13cmos5l_inv_1
X_2145_ _2145_/Q FrameData[6] VGND VPWR FrameStrobe[5] latch
X_2076_ _2076_/Q FrameData[1] VGND VPWR FrameStrobe[7] latch
XFILLER_22_556 VPWR VGND sg13cmos5l_fill_1
X_2978_ _2978_/X _2974_/X _2975_/X _2976_/X _2977_/X _2037_/Q _2038_/Q VPWR VGND sg13cmos5l_mux4_1
X_1929_ _1929_/Q FrameData[14] VGND VPWR _1137_/X latch
XFILLER_1_449 VPWR VGND sg13cmos5l_fill_2
XFILLER_17_306 VPWR VGND sg13cmos5l_decap_8
XFILLER_29_122 VPWR VGND sg13cmos5l_fill_1
XFILLER_32_309 VPWR VGND sg13cmos5l_fill_1
XFILLER_43_180 VPWR VGND sg13cmos5l_fill_1
X_2901_ _2901_/X E2MID[7] E2END[7] S1END[1] S2MID[5] _2199_/Q _2200_/Q VPWR VGND sg13cmos5l_mux4_1
X_2832_ _2832_/X _3145_/X _2910_/X _0628_/X _2903_/X _1925_/Q _1926_/Q VPWR VGND sg13cmos5l_mux4_1
X_2763_ _2763_/X _2759_/X _2760_/X _2761_/X _2762_/X _3215_/X _0914_/Y VPWR VGND sg13cmos5l_mux4_1
X_1576_ _1576_/Q FrameData[13] VGND VPWR _1166_/X latch
X_1645_ _1645_/Q FrameData[18] VGND VPWR _1171_/X latch
X_1714_ _1714_/Q FrameData[23] VGND VPWR _1133_/X latch
X_2694_ _2694_/X _3170_/X _0862_/X _0859_/X _2929_/X _1761_/Q _1762_/Q VPWR VGND sg13cmos5l_mux4_1
X_3177_ _3177_/X _3163_/X _0871_/X _0868_/X _3107_/X _1949_/Q _1950_/Q VPWR VGND sg13cmos5l_mux4_1
X_3246_ _3246_/X _0988_/Y _0979_/Y _1779_/Q _0981_/Y _1780_/Q _1781_/Q VPWR VGND sg13cmos5l_mux4_1
X_3315_ _3315_/X NN4END[1] E2END[0] S4END[1] _0630_/X _1649_/Q _1650_/Q VPWR VGND
+ sg13cmos5l_mux4_1
XFILLER_14_309 VPWR VGND sg13cmos5l_fill_2
XFILLER_22_342 VPWR VGND sg13cmos5l_fill_1
XFILLER_25_15 VPWR VGND sg13cmos5l_fill_1
XFILLER_25_37 VPWR VGND sg13cmos5l_fill_2
XFILLER_26_147 VPWR VGND sg13cmos5l_fill_2
X_2128_ _2128_/Q FrameData[21] VGND VPWR FrameStrobe[6] latch
X_2059_ _2059_/Q FrameData[16] VGND VPWR FrameStrobe[8] latch
XANTENNA__2600__X W2BEG[1] VPWR VGND sg13cmos5l_antennanp
XFILLER_17_125 VPWR VGND sg13cmos5l_fill_2
XANTENNA__2510__X NN4BEG[15] VPWR VGND sg13cmos5l_antennanp
XFILLER_5_530 VPWR VGND sg13cmos5l_fill_2
X_1430_ _1430_/Q FrameData[27] VGND VPWR _1186_/X latch
X_1292_ _1292_/Q FrameData[17] VGND VPWR _1197_/X latch
X_1361_ _1361_/Q FrameData[22] VGND VPWR _1183_/X latch
X_3031_ _3031_/X E1END[1] W2END[5] _0983_/Y _0631_/X _1985_/Q _1986_/Q VPWR VGND sg13cmos5l_mux4_1
X_3100_ _3100_/X _3096_/X _3097_/X _3098_/X _3099_/X _2153_/Q _2154_/Q VPWR VGND sg13cmos5l_mux4_1
X_2815_ _2815_/X _2890_/X _0861_/X _2929_/X _0857_/X _1897_/Q _1898_/Q VPWR VGND sg13cmos5l_mux4_1
X_2746_ _2746_/X _0872_/X _0870_/X _0867_/X _0865_/X _1829_/Q _1830_/Q VPWR VGND sg13cmos5l_mux4_1
XANTENNA__2420__X E2BEGb[1] VPWR VGND sg13cmos5l_antennanp
X_1559_ _1559_/Q FrameData[28] VGND VPWR _1187_/X latch
X_1628_ _1628_/Q FrameData[1] VGND VPWR _1171_/X latch
X_2677_ _2677_/X _1309_/Q _1310_/Q _1311_/Q _1312_/Q _3256_/X _3251_/X VPWR VGND sg13cmos5l_mux4_1
XFILLER_54_220 VPWR VGND sg13cmos5l_fill_2
X_3229_ _3229_/X _2932_/X _3050_/X _0628_/X _2903_/X _1817_/Q _1818_/Q VPWR VGND sg13cmos5l_mux4_1
XFILLER_10_301 VPWR VGND sg13cmos5l_fill_2
XFILLER_22_161 VPWR VGND sg13cmos5l_decap_8
XFILLER_10_389 VPWR VGND sg13cmos5l_fill_1
XANTENNA__2505__X NN4BEG[10] VPWR VGND sg13cmos5l_antennanp
XFILLER_41_492 VPWR VGND sg13cmos5l_fill_1
XFILLER_9_110 VPWR VGND sg13cmos5l_fill_1
X_0792_ _0792_/Y _1118_/A _1537_/Q _0789_/Y _0791_/Y _1538_/Q VPWR VGND sg13cmos5l_a221oi_1
X_0861_ _0861_/X _2989_/X _2990_/X _2286_/Q VPWR VGND sg13cmos5l_mux2_1
X_0930_ _0930_/Y _2044_/Q _3025_/X VPWR VGND sg13cmos5l_nor2b_1
X_2600_ W2BEG[1] _2600_/A VPWR VGND sg13cmos5l_buf_1
X_1413_ _1413_/Q FrameData[10] VGND VPWR _1186_/X latch
X_2531_ S4BEG[0] S4END[4] VPWR VGND sg13cmos5l_buf_1
X_2462_ N1BEG[3] _2462_/A VPWR VGND sg13cmos5l_buf_1
X_2393_ EE4BEG[2] EE4END[6] VPWR VGND sg13cmos5l_buf_1
X_1275_ _1275_/Q FrameData[0] VGND VPWR _1197_/X latch
X_1344_ _1344_/Q FrameData[5] VGND VPWR _1183_/X latch
X_3014_ _3014_/X SS4END[2] W2MID[2] _0906_/X _0974_/Y _2225_/Q _2226_/Q VPWR VGND
+ sg13cmos5l_mux4_1
XANTENNA__2415__X E6BEG[8] VPWR VGND sg13cmos5l_antennanp
XFILLER_36_275 VPWR VGND sg13cmos5l_decap_4
X_2729_ _2729_/X _2725_/X _2726_/X _2727_/X _2728_/X _1803_/Q _1804_/Q VPWR VGND sg13cmos5l_mux4_1
XFILLER_42_223 VPWR VGND sg13cmos5l_fill_2
XFILLER_42_278 VPWR VGND sg13cmos5l_fill_1
X_1060_ _1061_/A _2325_/Q _1058_/Y _1059_/Y VPWR VGND sg13cmos5l_o21ai_1
XFILLER_33_223 VPWR VGND sg13cmos5l_decap_8
X_1962_ _1962_/Q FrameData[15] VGND VPWR _1044_/X latch
X_0775_ _1023_/C _1153_/A _1411_/Q _0771_/Y _0773_/Y _0844_/B VPWR VGND sg13cmos5l_a221oi_1
X_0844_ _0844_/Y _1415_/Q _0844_/B VPWR VGND sg13cmos5l_nand2_1
X_0913_ _0913_/Y _2787_/X _1459_/Q VPWR VGND sg13cmos5l_nand2_1
X_1893_ _1893_/Q FrameData[10] VGND VPWR _1152_/X latch
XFILLER_45_0 VPWR VGND sg13cmos5l_fill_2
XFILLER_5_190 VPWR VGND sg13cmos5l_fill_1
X_2514_ S1BEG[3] _2514_/A VPWR VGND sg13cmos5l_buf_1
X_2445_ FrameStrobe_O[6] FrameStrobe[6] VPWR VGND sg13cmos5l_buf_1
X_2376_ _3038_/A1 VPWR VGND sg13cmos5l_tielo
XFILLER_24_245 VPWR VGND sg13cmos5l_fill_2
X_1189_ _1189_/X FrameStrobe[12] FrameStrobe[16] VPWR VGND sg13cmos5l_and2_1
X_1258_ _1258_/Q FrameData[15] VGND VPWR _1180_/X latch
X_1327_ _1327_/Q FrameData[20] VGND VPWR _1184_/X latch
X_2230_ _2230_/Q FrameData[27] VGND VPWR FrameStrobe[3] latch
XFILLER_53_329 VPWR VGND sg13cmos5l_fill_1
X_1043_ _1043_/Y _1878_/Q _1013_/A _1042_/Y VPWR VGND sg13cmos5l_a21oi_1
X_1112_ _1245_/D _1059_/A _1098_/Y _1099_/Y _1111_/X VPWR VGND sg13cmos5l_a22oi_1
X_2161_ _2161_/Q FrameData[22] VGND VPWR FrameStrobe[5] latch
X_2092_ _2092_/Q FrameData[17] VGND VPWR FrameStrobe[7] latch
XFILLER_21_215 VPWR VGND sg13cmos5l_fill_2
X_2994_ _2994_/X _3093_/X _3163_/X _0861_/X _0974_/Y _2019_/Q _2020_/Q VPWR VGND sg13cmos5l_mux4_1
X_1945_ _1945_/Q FrameData[30] VGND VPWR _1137_/X latch
X_0758_ _0758_/Y _1778_/Q _2464_/A _1777_/Q VPWR VGND sg13cmos5l_o21ai_1
X_0827_ _0827_/Y _1579_/Q _0826_/Y VPWR VGND sg13cmos5l_nor2b_1
X_1876_ _1876_/Q FrameData[25] VGND VPWR _1157_/X latch
XFILLER_28_48 VPWR VGND sg13cmos5l_fill_1
X_0689_ _0690_/A _0688_/B _0687_/D _0688_/Y VPWR VGND sg13cmos5l_o21ai_1
X_2428_ E2BEG[1] _2428_/A VPWR VGND sg13cmos5l_buf_1
X_2359_ _2359_/L_HI VPWR VGND sg13cmos5l_tiehi
XFILLER_37_381 VPWR VGND sg13cmos5l_fill_1
XFILLER_44_318 VPWR VGND sg13cmos5l_fill_2
XANTENNA__2603__X W2BEG[4] VPWR VGND sg13cmos5l_antennanp
XFILLER_47_189 VPWR VGND sg13cmos5l_fill_1
XANTENNA__2513__X S1BEG[2] VPWR VGND sg13cmos5l_antennanp
X_0612_ _2493_/A _3343_/X _3344_/X _1609_/Q VPWR VGND sg13cmos5l_mux2_1
X_1592_ _1592_/Q FrameData[29] VGND VPWR _1166_/X latch
X_1661_ _1661_/Q FrameData[2] VGND VPWR _1167_/X latch
X_1730_ _1730_/Q FrameData[7] VGND VPWR _1177_/X latch
X_3331_ _3331_/X N2END[5] E2END[7] S1END[1] _2932_/X _1625_/Q _1626_/Q VPWR VGND sg13cmos5l_mux4_1
X_3193_ _3193_/X _3100_/X _0650_/X _3144_/X _3139_/X _1913_/Q _1914_/Q VPWR VGND sg13cmos5l_mux4_1
X_3262_ _3262_/X _0863_/X _3127_/X _0860_/X _3122_/X _1725_/Q _1726_/Q VPWR VGND sg13cmos5l_mux4_1
X_2213_ _2213_/Q FrameData[10] VGND VPWR FrameStrobe[3] latch
X_2144_ _2144_/Q FrameData[5] VGND VPWR FrameStrobe[5] latch
X_1026_ _1130_/C _2321_/Q _1024_/Y _1025_/Y VPWR VGND sg13cmos5l_o21ai_1
X_2075_ _2075_/Q FrameData[0] VGND VPWR FrameStrobe[7] latch
XANTENNA__2423__X E2BEGb[4] VPWR VGND sg13cmos5l_antennanp
X_2977_ _2977_/X _0807_/B _1208_/Y _0808_/B _1223_/Y _2035_/Q _2036_/Q VPWR VGND sg13cmos5l_mux4_1
X_1928_ _1928_/Q FrameData[13] VGND VPWR _1137_/X latch
X_1859_ _1859_/Q FrameData[8] VGND VPWR _1157_/X latch
XFILLER_1_428 VPWR VGND sg13cmos5l_fill_2
XFILLER_29_156 VPWR VGND sg13cmos5l_fill_1
XFILLER_29_178 VPWR VGND sg13cmos5l_decap_4
XFILLER_55_68 VPWR VGND sg13cmos5l_fill_2
XFILLER_9_506 VPWR VGND sg13cmos5l_fill_1
XANTENNA__2508__X NN4BEG[13] VPWR VGND sg13cmos5l_antennanp
X_2900_ _2900_/X N2MID[1] N2END[1] N4END[1] E1END[3] _2199_/Q _2200_/Q VPWR VGND sg13cmos5l_mux4_1
XFILLER_31_332 VPWR VGND sg13cmos5l_fill_1
XFILLER_31_354 VPWR VGND sg13cmos5l_fill_2
X_1713_ _1713_/Q FrameData[22] VGND VPWR _1133_/X latch
X_2831_ _2831_/X _0630_/X _3006_/X _3136_/X _0654_/X _1925_/Q _1926_/Q VPWR VGND sg13cmos5l_mux4_1
X_2762_ _2762_/X _1425_/Q _1433_/Q _1426_/Q _1434_/Q _2777_/X _3220_/X VPWR VGND sg13cmos5l_mux4_1
X_1575_ _1575_/Q FrameData[12] VGND VPWR _1166_/X latch
X_1644_ _1644_/Q FrameData[17] VGND VPWR _1171_/X latch
X_3314_ _3314_/X _3145_/X _3163_/X _3010_/X _1013_/Y _1652_/Q _1653_/Q VPWR VGND sg13cmos5l_mux4_1
X_2693_ _2693_/X _3112_/X _0870_/X _3155_/X _2917_/X _1761_/Q _1762_/Q VPWR VGND sg13cmos5l_mux4_1
XANTENNA__2418__X E6BEG[11] VPWR VGND sg13cmos5l_antennanp
X_3176_ _3176_/X _3100_/X _0650_/X _3144_/X _3093_/X _1949_/Q _1950_/Q VPWR VGND sg13cmos5l_mux4_1
X_3245_ _3245_/X _0977_/X _0969_/Y _1782_/Q _0976_/Y _1783_/Q _1784_/Q VPWR VGND sg13cmos5l_mux4_1
X_2127_ _2127_/Q FrameData[20] VGND VPWR FrameStrobe[6] latch
X_1009_ _1009_/Y _1455_/Q _1009_/B _1009_/C VPWR VGND sg13cmos5l_nor3_1
X_2058_ _2058_/Q FrameData[15] VGND VPWR FrameStrobe[8] latch
XFILLER_41_15 VPWR VGND sg13cmos5l_fill_1
XFILLER_13_387 VPWR VGND sg13cmos5l_decap_8
XFILLER_25_192 VPWR VGND sg13cmos5l_fill_1
X_1360_ _1360_/Q FrameData[21] VGND VPWR _1183_/X latch
X_1291_ _1291_/Q FrameData[16] VGND VPWR _1197_/X latch
X_3030_ _3030_/X S2MID[4] S4END[0] W2MID[6] WW4END[0] _2085_/Q _2086_/Q VPWR VGND
+ sg13cmos5l_mux4_1
XFILLER_31_151 VPWR VGND sg13cmos5l_decap_8
XFILLER_11_18 VPWR VGND sg13cmos5l_fill_1
X_2814_ _2814_/X _0872_/X _0869_/X _0868_/X _3107_/X _1897_/Q _1898_/Q VPWR VGND sg13cmos5l_mux4_1
X_2745_ _2745_/X _3100_/X _3145_/X _0639_/X _2903_/X _1829_/Q _1830_/Q VPWR VGND sg13cmos5l_mux4_1
X_2676_ _2676_/X _2672_/X _2673_/X _2674_/X _2675_/X _3251_/X _0945_/Y VPWR VGND sg13cmos5l_mux4_1
X_1489_ _1489_/Q FrameData[22] VGND VPWR _1182_/X latch
X_1558_ _1558_/Q FrameData[27] VGND VPWR _1187_/X latch
X_1627_ _1627_/Q FrameData[0] VGND VPWR _1171_/X latch
XFILLER_54_232 VPWR VGND sg13cmos5l_fill_2
X_3159_ _3159_/X _3156_/X _3157_/X _3158_/X _1234_/Y _2217_/Q _2218_/Q VPWR VGND sg13cmos5l_mux4_1
X_3228_ _3228_/X _0631_/X _0629_/X _0654_/X _3001_/X _1817_/Q _1818_/Q VPWR VGND sg13cmos5l_mux4_1
XANTENNA__2611__X W2BEGb[4] VPWR VGND sg13cmos5l_antennanp
XFILLER_6_328 VPWR VGND sg13cmos5l_fill_2
XFILLER_45_232 VPWR VGND sg13cmos5l_fill_2
XANTENNA__2521__X S2BEG[6] VPWR VGND sg13cmos5l_antennanp
X_0791_ _0791_/Y _1537_/Q _0790_/Y VPWR VGND sg13cmos5l_nor2b_1
X_0860_ _0860_/X _3164_/X _3165_/X _2289_/Q VPWR VGND sg13cmos5l_mux2_1
X_2530_ S2BEGb[7] S2MID[7] VPWR VGND sg13cmos5l_buf_1
X_1343_ _1343_/Q FrameData[4] VGND VPWR _1183_/X latch
X_1412_ _1412_/Q FrameData[9] VGND VPWR _1186_/X latch
X_2461_ N1BEG[2] _2461_/A VPWR VGND sg13cmos5l_buf_1
X_2392_ EE4BEG[1] EE4END[5] VPWR VGND sg13cmos5l_buf_1
XFILLER_36_265 VPWR VGND sg13cmos5l_fill_2
X_1274_ _1274_/Q FrameData[31] VGND VPWR _1180_/X latch
X_3013_ _3013_/X N2END[2] E6END[0] S1END[2] S2END[6] _2225_/Q _2226_/Q VPWR VGND sg13cmos5l_mux4_1
XANTENNA__2431__X E2BEG[4] VPWR VGND sg13cmos5l_antennanp
X_0989_ _0989_/Y _1814_/Q _1226_/B VPWR VGND sg13cmos5l_nor2_1
X_2728_ _2728_/X _3170_/X _2890_/X _2885_/X _3010_/X _1801_/Q _1802_/Q VPWR VGND sg13cmos5l_mux4_1
X_2659_ _2659_/X _3163_/X _0871_/X _0868_/X _3107_/X _1733_/Q _1734_/Q VPWR VGND sg13cmos5l_mux4_1
XFILLER_47_519 VPWR VGND sg13cmos5l_fill_2
XANTENNA__2606__X W2BEG[7] VPWR VGND sg13cmos5l_antennanp
XFILLER_27_276 VPWR VGND sg13cmos5l_fill_1
XFILLER_55_552 VPWR VGND sg13cmos5l_fill_1
XFILLER_23_460 VPWR VGND sg13cmos5l_decap_8
XFILLER_23_493 VPWR VGND sg13cmos5l_fill_1
XFILLER_6_125 VPWR VGND sg13cmos5l_fill_1
XFILLER_6_147 VPWR VGND sg13cmos5l_fill_1
XFILLER_12_94 VPWR VGND sg13cmos5l_fill_1
XFILLER_5_0 VPWR VGND sg13cmos5l_fill_1
XFILLER_33_202 VPWR VGND sg13cmos5l_fill_2
XFILLER_38_508 VPWR VGND sg13cmos5l_fill_1
XANTENNA__2516__X S2BEG[1] VPWR VGND sg13cmos5l_antennanp
X_0912_ _0912_/Y _0572_/Y _1417_/Q _0911_/Y VPWR VGND sg13cmos5l_o21ai_1
X_1961_ _1961_/Q FrameData[14] VGND VPWR _1044_/X latch
X_1892_ _1892_/Q FrameData[9] VGND VPWR _1152_/X latch
X_0774_ _0774_/Y _1153_/A _1411_/Q _0771_/Y _0773_/Y VPWR VGND sg13cmos5l_a22oi_1
X_0843_ _0843_/Y _0843_/A _0843_/B VPWR VGND sg13cmos5l_xnor2_1
X_2513_ S1BEG[2] _2513_/A VPWR VGND sg13cmos5l_buf_1
XFILLER_38_0 VPWR VGND sg13cmos5l_fill_2
X_1326_ _1326_/Q FrameData[19] VGND VPWR _1184_/X latch
X_2444_ FrameStrobe_O[5] FrameStrobe[5] VPWR VGND sg13cmos5l_buf_1
X_2375_ _3063_/A1 VPWR VGND sg13cmos5l_tielo
XANTENNA__2426__X E2BEGb[7] VPWR VGND sg13cmos5l_antennanp
XFILLER_52_544 VPWR VGND sg13cmos5l_fill_1
X_1188_ _1188_/X FrameStrobe[12] FrameStrobe[19] VPWR VGND sg13cmos5l_and2_1
X_1257_ _1257_/Q FrameData[14] VGND VPWR _1180_/X latch
XFILLER_38_305 VPWR VGND sg13cmos5l_fill_1
X_2160_ _2160_/Q FrameData[21] VGND VPWR FrameStrobe[5] latch
X_1042_ _1042_/Y _1878_/Q _1226_/B VPWR VGND sg13cmos5l_nor2_1
X_1111_ _1111_/X _3198_/X _1111_/B VPWR VGND sg13cmos5l_or2_1
X_2091_ _2091_/Q FrameData[16] VGND VPWR FrameStrobe[7] latch
X_2993_ _2993_/X N2MID[0] E2END[1] S2END[4] _0654_/X _2019_/Q _2020_/Q VPWR VGND sg13cmos5l_mux4_1
X_1944_ _1944_/Q FrameData[29] VGND VPWR _1137_/X latch
X_1875_ _1875_/Q FrameData[24] VGND VPWR _1157_/X latch
X_0688_ _0688_/Y _2792_/X _0688_/B VPWR VGND sg13cmos5l_nand2_1
X_0757_ _0757_/Y _0917_/B _0917_/C _0756_/Y VPWR VGND sg13cmos5l_o21ai_1
X_0826_ _0826_/Y _1970_/Q _2967_/X _1969_/Q VPWR VGND sg13cmos5l_o21ai_1
X_2427_ E2BEG[0] _2427_/A VPWR VGND sg13cmos5l_buf_1
X_1309_ _1309_/Q FrameData[2] VGND VPWR _1184_/X latch
X_2358_ _2358_/L_HI VPWR VGND sg13cmos5l_tiehi
X_2289_ _2289_/Q FrameData[22] VGND VPWR FrameStrobe[1] latch
XFILLER_16_555 VPWR VGND sg13cmos5l_fill_2
XFILLER_28_371 VPWR VGND sg13cmos5l_fill_2
X_0611_ _2494_/A _3341_/X _3342_/X _1612_/Q VPWR VGND sg13cmos5l_mux2_1
X_1591_ _1591_/Q FrameData[28] VGND VPWR _1166_/X latch
X_1660_ _1660_/Q FrameData[1] VGND VPWR _1167_/X latch
X_3330_ _3330_/X _0628_/X _3150_/X _3170_/X _0921_/Y _1628_/Q _1629_/Q VPWR VGND sg13cmos5l_mux4_1
X_3192_ _3192_/X _0631_/X _0629_/X _3059_/X _3087_/X _1913_/Q _1914_/Q VPWR VGND sg13cmos5l_mux4_1
X_3261_ _3261_/X _3117_/X _3112_/X _3107_/X _0866_/X _1725_/Q _1726_/Q VPWR VGND sg13cmos5l_mux4_1
X_2212_ _2212_/Q FrameData[9] VGND VPWR FrameStrobe[3] latch
X_2143_ _2143_/Q FrameData[4] VGND VPWR FrameStrobe[5] latch
XFILLER_22_525 VPWR VGND sg13cmos5l_fill_1
X_1025_ _1025_/Y _1025_/A _2321_/Q VPWR VGND sg13cmos5l_nand2_1
X_2074_ _2074_/Q FrameData[31] VGND VPWR FrameStrobe[8] latch
X_0809_ _0809_/Y _0808_/A _0807_/Y _0808_/Y _2309_/Q VPWR VGND sg13cmos5l_a22oi_1
X_2976_ _2976_/X _1066_/Y _1027_/Y _0848_/Y _1013_/Y _2035_/Q _2036_/Q VPWR VGND sg13cmos5l_mux4_1
X_1927_ _1927_/Q FrameData[12] VGND VPWR _1137_/X latch
X_1858_ _1858_/Q FrameData[7] VGND VPWR _1157_/X latch
XFILLER_29_102 VPWR VGND sg13cmos5l_fill_1
XFILLER_39_48 VPWR VGND sg13cmos5l_fill_1
X_1789_ _1789_/Q FrameData[2] VGND VPWR _1138_/X latch
XANTENNA__2614__X W2BEGb[7] VPWR VGND sg13cmos5l_antennanp
XFILLER_40_311 VPWR VGND sg13cmos5l_fill_2
XFILLER_40_322 VPWR VGND sg13cmos5l_fill_2
XANTENNA__2524__X S2BEGb[1] VPWR VGND sg13cmos5l_antennanp
X_2830_ _2830_/X _2826_/X _2827_/X _2828_/X _2829_/X _1935_/Q _1936_/Q VPWR VGND sg13cmos5l_mux4_1
XANTENNA_1 FrameStrobe[15] VPWR VGND sg13cmos5l_antennanp
X_1643_ _1643_/Q FrameData[16] VGND VPWR _1171_/X latch
X_1712_ _1712_/Q FrameData[21] VGND VPWR _1133_/X latch
X_2761_ _2761_/X _1423_/Q _1431_/Q _1424_/Q _1432_/Q _2777_/X _3220_/X VPWR VGND sg13cmos5l_mux4_1
X_2692_ _2692_/X _3079_/X _2932_/X _0628_/X _2903_/X _1761_/Q _1762_/Q VPWR VGND sg13cmos5l_mux4_1
X_1574_ _1574_/Q FrameData[11] VGND VPWR _1166_/X latch
X_3244_ _3244_/X _3240_/X _3241_/X _3242_/X _3243_/X _1787_/Q _1788_/Q VPWR VGND sg13cmos5l_mux4_1
X_3313_ _3313_/X NN4END[2] E2END[2] S4END[2] _0654_/X _1652_/Q _1653_/Q VPWR VGND
+ sg13cmos5l_mux4_1
XFILLER_20_0 VPWR VGND sg13cmos5l_fill_2
XFILLER_26_149 VPWR VGND sg13cmos5l_fill_1
X_3175_ _3175_/X _0658_/X _3043_/X _0656_/X _3001_/X _1949_/Q _1950_/Q VPWR VGND sg13cmos5l_mux4_1
X_2126_ _2126_/Q FrameData[19] VGND VPWR FrameStrobe[6] latch
X_2057_ _2057_/Q FrameData[14] VGND VPWR FrameStrobe[8] latch
XANTENNA__2434__X E2BEG[7] VPWR VGND sg13cmos5l_antennanp
X_1008_ _1008_/Y _1875_/Q _1005_/A _1007_/Y VPWR VGND sg13cmos5l_o21ai_1
X_2959_ _2959_/X E1END[1] W2MID[5] _1239_/Q _3079_/X _2048_/Q _2049_/Q VPWR VGND sg13cmos5l_mux4_1
XANTENNA__2609__X W2BEGb[2] VPWR VGND sg13cmos5l_antennanp
XFILLER_57_252 VPWR VGND sg13cmos5l_decap_4
XFILLER_31_82 VPWR VGND sg13cmos5l_fill_2
XANTENNA__2519__X S2BEG[4] VPWR VGND sg13cmos5l_antennanp
XFILLER_36_403 VPWR VGND sg13cmos5l_fill_2
X_1290_ _1290_/Q FrameData[15] VGND VPWR _1197_/X latch
X_2813_ _2813_/X _0653_/X _2910_/X _0639_/X _2903_/X _1897_/Q _1898_/Q VPWR VGND sg13cmos5l_mux4_1
X_1626_ _1626_/Q FrameData[31] VGND VPWR _1189_/X latch
X_2744_ _2744_/X _0630_/X _3006_/X _0655_/X _3087_/X _1829_/Q _1830_/Q VPWR VGND sg13cmos5l_mux4_1
X_2675_ _2675_/X _1299_/Q _1307_/Q _1300_/Q _1308_/Q _2690_/X _3256_/X VPWR VGND sg13cmos5l_mux4_1
XANTENNA__2429__X E2BEG[2] VPWR VGND sg13cmos5l_antennanp
X_1488_ _1488_/Q FrameData[21] VGND VPWR _1182_/X latch
X_1557_ _1557_/Q FrameData[26] VGND VPWR _1187_/X latch
X_3227_ _3227_/X _3223_/X _3224_/X _3225_/X _3226_/X _1823_/Q _1824_/Q VPWR VGND sg13cmos5l_mux4_1
X_3089_ _3089_/X SS4END[1] W2END[5] _1051_/C _0840_/Y _2196_/Q _2197_/Q VPWR VGND
+ sg13cmos5l_mux4_1
X_3158_ _3158_/X S2END[6] SS4END[2] W2MID[2] W2END[2] _2215_/Q _2216_/Q VPWR VGND
+ sg13cmos5l_mux4_1
X_2109_ _2109_/Q FrameData[2] VGND VPWR FrameStrobe[6] latch
XFILLER_10_303 VPWR VGND sg13cmos5l_fill_1
XFILLER_10_314 VPWR VGND sg13cmos5l_fill_2
XFILLER_10_336 VPWR VGND sg13cmos5l_decap_8
XFILLER_10_347 VPWR VGND sg13cmos5l_fill_1
XFILLER_7_4 VPWR VGND sg13cmos5l_fill_2
XFILLER_26_82 VPWR VGND sg13cmos5l_fill_2
X_0790_ _0790_/Y _1938_/Q _2469_/A _1937_/Q VPWR VGND sg13cmos5l_o21ai_1
X_2460_ N1BEG[1] _2460_/A VPWR VGND sg13cmos5l_buf_1
X_1273_ _1273_/Q FrameData[30] VGND VPWR _1180_/X latch
X_1342_ _1342_/Q FrameData[3] VGND VPWR _1183_/X latch
X_1411_ _1411_/Q FrameData[8] VGND VPWR _1186_/X latch
X_2391_ EE4BEG[0] EE4END[4] VPWR VGND sg13cmos5l_buf_1
XFILLER_36_233 VPWR VGND sg13cmos5l_decap_4
X_3012_ _3012_/X W6END[1] _0854_/Y _1051_/C _1013_/Y _2193_/Q _2194_/Q VPWR VGND sg13cmos5l_mux4_1
X_0988_ _0988_/Y _1779_/Q _0927_/A _0987_/Y VPWR VGND sg13cmos5l_a21oi_1
X_1609_ _1609_/Q FrameData[14] VGND VPWR _1189_/X latch
X_2727_ _2727_/X _3163_/X _3159_/X _3107_/X _0866_/X _1801_/Q _1802_/Q VPWR VGND sg13cmos5l_mux4_1
X_2658_ _2658_/X _3079_/X _2932_/X _3144_/X _3139_/X _1733_/Q _1734_/Q VPWR VGND sg13cmos5l_mux4_1
X_2589_ SS4BEG[10] SS4END[14] VPWR VGND sg13cmos5l_buf_1
XANTENNA__2622__X W6BEG[7] VPWR VGND sg13cmos5l_antennanp
XFILLER_18_255 VPWR VGND sg13cmos5l_decap_8
XANTENNA__2532__X S4BEG[1] VPWR VGND sg13cmos5l_antennanp
XFILLER_41_280 VPWR VGND sg13cmos5l_decap_8
X_0842_ _0843_/B _1412_/Q _0774_/Y _0841_/Y VPWR VGND sg13cmos5l_o21ai_1
X_0911_ _0911_/Y _2758_/X _1417_/Q VPWR VGND sg13cmos5l_nand2_1
X_1960_ _1960_/Q FrameData[13] VGND VPWR _1044_/X latch
X_1891_ _1891_/Q FrameData[8] VGND VPWR _1152_/X latch
X_0773_ _0773_/Y _1411_/Q _0772_/Y VPWR VGND sg13cmos5l_nor2b_1
X_2512_ S1BEG[1] _2512_/A VPWR VGND sg13cmos5l_buf_1
X_2443_ FrameStrobe_O[4] FrameStrobe[4] VPWR VGND sg13cmos5l_buf_1
X_1256_ _1256_/Q FrameData[13] VGND VPWR _1180_/X latch
X_1325_ _1325_/Q FrameData[18] VGND VPWR _1184_/X latch
X_2374_ _3081_/A1 VPWR VGND sg13cmos5l_tielo
XFILLER_24_247 VPWR VGND sg13cmos5l_fill_1
X_1187_ _1187_/X FrameStrobe[12] FrameStrobe[18] VPWR VGND sg13cmos5l_and2_1
XANTENNA__2442__X FrameStrobe_O[3] VPWR VGND sg13cmos5l_antennanp
XANTENNA__2617__X W6BEG[2] VPWR VGND sg13cmos5l_antennanp
XFILLER_15_258 VPWR VGND sg13cmos5l_fill_1
XFILLER_23_72 VPWR VGND sg13cmos5l_fill_2
XFILLER_43_556 VPWR VGND sg13cmos5l_fill_1
X_1110_ _1111_/B _2792_/X _1498_/Q _1109_/Y VPWR VGND sg13cmos5l_o21ai_1
X_2090_ _2090_/Q FrameData[15] VGND VPWR FrameStrobe[7] latch
XANTENNA__2527__X S2BEGb[4] VPWR VGND sg13cmos5l_antennanp
XFILLER_21_217 VPWR VGND sg13cmos5l_fill_1
XFILLER_34_556 VPWR VGND sg13cmos5l_fill_1
X_1041_ _1041_/Y _1878_/Q _1038_/A _1040_/Y VPWR VGND sg13cmos5l_o21ai_1
X_2992_ _2992_/X _3100_/X _3144_/X _0866_/X _1066_/Y _2066_/Q _2067_/Q VPWR VGND sg13cmos5l_mux4_1
X_0825_ _0825_/Y _0823_/A _0823_/B _0824_/Y VPWR VGND sg13cmos5l_o21ai_1
X_1943_ _1943_/Q FrameData[28] VGND VPWR _1137_/X latch
X_1874_ _1874_/Q FrameData[23] VGND VPWR _1157_/X latch
X_0687_ _0787_/A _2792_/X _2816_/X _1501_/Q _0687_/D VPWR VGND sg13cmos5l_nor4_1
X_0756_ _0756_/Y _1777_/Q _1778_/Q VPWR VGND sg13cmos5l_nor2_1
X_2426_ E2BEGb[7] E2MID[7] VPWR VGND sg13cmos5l_buf_1
XANTENNA__2437__X E1BEG[2] VPWR VGND sg13cmos5l_antennanp
XFILLER_25_523 VPWR VGND sg13cmos5l_fill_1
XFILLER_56_136 VPWR VGND sg13cmos5l_fill_1
X_1239_ _1239_/Q _1246_/CLK _1239_/D _2365_/L_HI VPWR VGND sg13cmos5l_dfrbpq_1
X_1308_ _1308_/Q FrameData[1] VGND VPWR _1184_/X latch
X_2357_ _2357_/L_HI VPWR VGND sg13cmos5l_tiehi
X_2288_ _2288_/Q FrameData[21] VGND VPWR FrameStrobe[1] latch
XFILLER_25_556 VPWR VGND sg13cmos5l_fill_1
XFILLER_44_27 VPWR VGND sg13cmos5l_fill_2
XFILLER_20_261 VPWR VGND sg13cmos5l_fill_1
XFILLER_28_394 VPWR VGND sg13cmos5l_decap_4
XFILLER_3_482 VPWR VGND sg13cmos5l_decap_4
X_0610_ _2507_/A _3339_/X _3340_/X _1615_/Q VPWR VGND sg13cmos5l_mux2_1
X_1590_ _1590_/Q FrameData[27] VGND VPWR _1166_/X latch
X_3260_ _3260_/X _3100_/X _0650_/X _3093_/X _0627_/X _1725_/Q _1726_/Q VPWR VGND sg13cmos5l_mux4_1
XFILLER_19_350 VPWR VGND sg13cmos5l_fill_2
X_1024_ _1024_/Y _0582_/Y _1413_/Q _1023_/Y VPWR VGND sg13cmos5l_a21oi_1
X_3191_ _3191_/X _3187_/X _3188_/X _3189_/X _3190_/X _1919_/Q _1920_/Q VPWR VGND sg13cmos5l_mux4_1
X_2211_ _2211_/Q FrameData[8] VGND VPWR FrameStrobe[3] latch
X_2142_ _2142_/Q FrameData[3] VGND VPWR FrameStrobe[5] latch
X_2073_ _2073_/Q FrameData[30] VGND VPWR FrameStrobe[8] latch
X_2975_ _2975_/X _0657_/X _2903_/X _2899_/X _0974_/Y _2035_/Q _2036_/Q VPWR VGND sg13cmos5l_mux4_1
X_0808_ _0808_/Y _0808_/A _0808_/B VPWR VGND sg13cmos5l_nor2_1
X_1788_ _1788_/Q FrameData[1] VGND VPWR _1138_/X latch
X_1926_ _1926_/Q FrameData[11] VGND VPWR _1137_/X latch
X_1857_ _1857_/Q FrameData[6] VGND VPWR _1157_/X latch
X_0739_ _0740_/C _2648_/X _2649_/X _2666_/X VPWR VGND sg13cmos5l_mux2_1
X_2409_ E6BEG[2] E6END[4] VPWR VGND sg13cmos5l_buf_1
XFILLER_40_301 VPWR VGND sg13cmos5l_decap_4
XFILLER_57_489 VPWR VGND sg13cmos5l_fill_1
XANTENNA__2630__X WW4BEG[3] VPWR VGND sg13cmos5l_antennanp
XFILLER_43_172 VPWR VGND sg13cmos5l_fill_1
XANTENNA_2 FrameStrobe[15] VPWR VGND sg13cmos5l_antennanp
XANTENNA__2540__X S4BEG[9] VPWR VGND sg13cmos5l_antennanp
X_1642_ _1642_/Q FrameData[15] VGND VPWR _1171_/X latch
X_1711_ _1711_/Q FrameData[20] VGND VPWR _1133_/X latch
X_2760_ _2760_/X _1421_/Q _1429_/Q _1422_/Q _1430_/Q _2777_/X _3220_/X VPWR VGND sg13cmos5l_mux4_1
X_2691_ _2691_/X _0631_/X _0629_/X _0656_/X _3001_/X _1761_/Q _1762_/Q VPWR VGND sg13cmos5l_mux4_1
X_1573_ _1573_/Q FrameData[10] VGND VPWR _1166_/X latch
X_3243_ _3243_/X _2890_/X _0861_/X _0859_/X _2885_/X _1785_/Q _1786_/Q VPWR VGND sg13cmos5l_mux4_1
X_3312_ _3312_/X _0654_/X _3093_/X _0861_/X _1223_/Y _1655_/Q _1656_/Q VPWR VGND sg13cmos5l_mux4_1
XFILLER_13_0 VPWR VGND sg13cmos5l_fill_2
X_1007_ _1007_/Y _1875_/Q _2603_/A VPWR VGND sg13cmos5l_nand2_1
X_3174_ _3174_/X _1194_/Y _1231_/Y _1971_/Q _1225_/Y _1972_/Q _1973_/Q VPWR VGND sg13cmos5l_mux4_1
X_2125_ _2125_/Q FrameData[18] VGND VPWR FrameStrobe[6] latch
X_2056_ _2056_/Q FrameData[13] VGND VPWR FrameStrobe[8] latch
XFILLER_34_194 VPWR VGND sg13cmos5l_decap_4
X_2958_ _2958_/X _2954_/X _2955_/X _2956_/X _2957_/X _2024_/Q _2025_/Q VPWR VGND sg13cmos5l_mux4_1
X_1909_ _1909_/Q FrameData[26] VGND VPWR _1152_/X latch
XANTENNA__2450__X FrameStrobe_O[11] VPWR VGND sg13cmos5l_antennanp
X_2889_ _2889_/X W2END[4] WW4END[2] _0921_/Y _1013_/Y _2277_/Q _2278_/Q VPWR VGND
+ sg13cmos5l_mux4_1
XANTENNA__2625__X W6BEG[10] VPWR VGND sg13cmos5l_antennanp
XFILLER_13_334 VPWR VGND sg13cmos5l_fill_2
XFILLER_25_172 VPWR VGND sg13cmos5l_decap_4
XFILLER_5_555 VPWR VGND sg13cmos5l_fill_2
XANTENNA__2535__X S4BEG[4] VPWR VGND sg13cmos5l_antennanp
X_2812_ _2812_/X _2924_/X _3043_/X _0656_/X _3001_/X _1897_/Q _1898_/Q VPWR VGND sg13cmos5l_mux4_1
X_2743_ _2743_/X _2739_/X _2740_/X _2741_/X _2742_/X _1839_/Q _1840_/Q VPWR VGND sg13cmos5l_mux4_1
XFILLER_8_360 VPWR VGND sg13cmos5l_fill_2
X_1556_ _1556_/Q FrameData[25] VGND VPWR _1187_/X latch
X_1625_ _1625_/Q FrameData[30] VGND VPWR _1189_/X latch
X_2674_ _2674_/X _1297_/Q _1305_/Q _1298_/Q _1306_/Q _2690_/X _3256_/X VPWR VGND sg13cmos5l_mux4_1
X_1487_ _1487_/Q FrameData[20] VGND VPWR _1182_/X latch
X_3157_ _3157_/X E2END[0] E6END[0] S1END[2] S2MID[6] _2215_/Q _2216_/Q VPWR VGND sg13cmos5l_mux4_1
X_3226_ _3226_/X _3170_/X _0862_/X _0859_/X _3122_/X _1821_/Q _1822_/Q VPWR VGND sg13cmos5l_mux4_1
XANTENNA__2445__X FrameStrobe_O[6] VPWR VGND sg13cmos5l_antennanp
XFILLER_27_459 VPWR VGND sg13cmos5l_decap_8
X_3088_ _3088_/X N4END[1] E1END[3] S1END[1] S2MID[5] _2196_/Q _2197_/Q VPWR VGND sg13cmos5l_mux4_1
X_2108_ _2108_/Q FrameData[1] VGND VPWR FrameStrobe[6] latch
X_2039_ _2039_/Q FrameData[28] VGND VPWR FrameStrobe[9] latch
XFILLER_22_175 VPWR VGND sg13cmos5l_decap_4
XFILLER_22_186 VPWR VGND sg13cmos5l_fill_2
XFILLER_13_164 VPWR VGND sg13cmos5l_fill_2
XFILLER_5_352 VPWR VGND sg13cmos5l_fill_1
X_1410_ _1410_/Q FrameData[7] VGND VPWR _1186_/X latch
X_1272_ _1272_/Q FrameData[29] VGND VPWR _1180_/X latch
X_1341_ _1341_/Q FrameData[2] VGND VPWR _1183_/X latch
X_3011_ _3011_/X N2MID[1] E2MID[7] SS4END[1] W2MID[1] _2193_/Q _2194_/Q VPWR VGND
+ sg13cmos5l_mux4_1
X_2390_ _2880_/A1 VPWR VGND sg13cmos5l_tielo
XFILLER_17_470 VPWR VGND sg13cmos5l_fill_1
XFILLER_36_267 VPWR VGND sg13cmos5l_fill_1
X_0987_ _0987_/Y _2967_/X _1779_/Q VPWR VGND sg13cmos5l_nor2_1
X_2726_ _2726_/X _3100_/X _0653_/X _3144_/X _3093_/X _1801_/Q _1802_/Q VPWR VGND sg13cmos5l_mux4_1
X_1539_ _1539_/Q FrameData[8] VGND VPWR _1187_/X latch
X_1608_ _1608_/Q FrameData[13] VGND VPWR _1189_/X latch
X_2657_ _2657_/X _0631_/X _0658_/X _0656_/X _3059_/X _1733_/Q _1734_/Q VPWR VGND sg13cmos5l_mux4_1
X_2588_ SS4BEG[9] SS4END[13] VPWR VGND sg13cmos5l_buf_1
XFILLER_27_256 VPWR VGND sg13cmos5l_decap_8
X_3209_ _3209_/X _1002_/Y _1041_/Y _1878_/Q _1043_/Y _1879_/Q _1880_/Q VPWR VGND sg13cmos5l_mux4_1
XFILLER_12_52 VPWR VGND sg13cmos5l_fill_1
XFILLER_18_212 VPWR VGND sg13cmos5l_decap_8
XFILLER_18_223 VPWR VGND sg13cmos5l_fill_1
XFILLER_18_245 VPWR VGND sg13cmos5l_fill_2
XFILLER_33_237 VPWR VGND sg13cmos5l_decap_8
XFILLER_33_248 VPWR VGND sg13cmos5l_fill_1
X_0772_ _0772_/Y _1842_/Q _2466_/A _1841_/Q VPWR VGND sg13cmos5l_o21ai_1
X_0841_ _0841_/Y _1153_/A _1412_/Q VPWR VGND sg13cmos5l_nand2_1
X_0910_ _0910_/Y _0571_/Y _1543_/Q _0909_/Y VPWR VGND sg13cmos5l_o21ai_1
X_1890_ _1890_/Q FrameData[7] VGND VPWR _1152_/X latch
X_2511_ S1BEG[0] _2511_/A VPWR VGND sg13cmos5l_buf_1
X_2442_ FrameStrobe_O[3] FrameStrobe[3] VPWR VGND sg13cmos5l_buf_1
X_2373_ _3129_/A1 VPWR VGND sg13cmos5l_tielo
X_1186_ _1186_/X FrameStrobe[13] FrameStrobe[16] VPWR VGND sg13cmos5l_and2_1
X_1255_ _1255_/Q FrameData[12] VGND VPWR _1180_/X latch
X_1324_ _1324_/Q FrameData[17] VGND VPWR _1184_/X latch
X_2709_ _2709_/X _1363_/Q _1364_/Q _1365_/Q _1366_/Q _3244_/X _3239_/X VPWR VGND sg13cmos5l_mux4_1
XFILLER_15_204 VPWR VGND sg13cmos5l_fill_2
XANTENNA__2633__X WW4BEG[6] VPWR VGND sg13cmos5l_antennanp
XFILLER_19_510 VPWR VGND sg13cmos5l_fill_1
X_1040_ _1040_/Y _1878_/Q _2604_/A VPWR VGND sg13cmos5l_nand2_1
XANTENNA__2543__X S4BEG[12] VPWR VGND sg13cmos5l_antennanp
XFILLER_14_270 VPWR VGND sg13cmos5l_fill_1
X_2991_ _2991_/X N2END[3] S2MID[7] W2END[7] _0658_/X _2066_/Q _2067_/Q VPWR VGND sg13cmos5l_mux4_1
X_1942_ _1942_/Q FrameData[27] VGND VPWR _1137_/X latch
X_0755_ _0917_/C _0755_/A _0755_/B _0755_/C VPWR VGND sg13cmos5l_nor3_1
X_0824_ _0824_/Y _1969_/Q _1970_/Q VPWR VGND sg13cmos5l_nor2_1
X_1873_ _1873_/Q FrameData[22] VGND VPWR _1157_/X latch
XFILLER_6_491 VPWR VGND sg13cmos5l_decap_8
X_0686_ _0687_/D _0681_/Y _0682_/X _0685_/Y VPWR VGND sg13cmos5l_a21oi_1
X_2425_ E2BEGb[6] E2MID[6] VPWR VGND sg13cmos5l_buf_1
X_2356_ _2356_/L_HI VPWR VGND sg13cmos5l_tiehi
XFILLER_37_340 VPWR VGND sg13cmos5l_decap_4
X_1169_ _1169_/Y _1910_/Q _1226_/B VPWR VGND sg13cmos5l_nor2_1
X_1238_ _1238_/Q _1248_/CLK _1238_/D _2355_/L_HI VPWR VGND sg13cmos5l_dfrbpq_1
X_1307_ _1307_/Q FrameData[0] VGND VPWR _1184_/X latch
X_2287_ _2287_/Q FrameData[20] VGND VPWR FrameStrobe[1] latch
XANTENNA__2453__X FrameStrobe_O[14] VPWR VGND sg13cmos5l_antennanp
XFILLER_40_505 VPWR VGND sg13cmos5l_fill_2
XANTENNA__2628__X WW4BEG[1] VPWR VGND sg13cmos5l_antennanp
XFILLER_28_373 VPWR VGND sg13cmos5l_fill_1
XFILLER_7_288 VPWR VGND sg13cmos5l_fill_2
XFILLER_3_450 VPWR VGND sg13cmos5l_decap_8
X_3190_ _3190_/X _0864_/X _3127_/X _2885_/X _0857_/X _1917_/Q _1918_/Q VPWR VGND sg13cmos5l_mux4_1
X_2210_ _2210_/Q FrameData[7] VGND VPWR FrameStrobe[3] latch
XANTENNA__2538__X S4BEG[7] VPWR VGND sg13cmos5l_antennanp
XFILLER_34_332 VPWR VGND sg13cmos5l_decap_8
X_1023_ _1023_/Y _1413_/Q _1023_/B _1023_/C VPWR VGND sg13cmos5l_nor3_1
X_2141_ _2141_/Q FrameData[2] VGND VPWR FrameStrobe[5] latch
X_2072_ _2072_/Q FrameData[29] VGND VPWR FrameStrobe[8] latch
XFILLER_22_516 VPWR VGND sg13cmos5l_fill_2
XFILLER_34_376 VPWR VGND sg13cmos5l_fill_1
X_2974_ _2974_/X E2END[5] S2MID[1] W1END[1] _0629_/X _2035_/Q _2036_/Q VPWR VGND sg13cmos5l_mux4_1
X_1925_ _1925_/Q FrameData[10] VGND VPWR _1137_/X latch
X_0738_ _0740_/B _1284_/Q _2661_/X VPWR VGND sg13cmos5l_nand2b_1
X_0807_ _0807_/Y _2309_/Q _0807_/B VPWR VGND sg13cmos5l_nand2_1
X_1787_ _1787_/Q FrameData[0] VGND VPWR _1138_/X latch
X_1856_ _1856_/Q FrameData[5] VGND VPWR _1157_/X latch
XANTENNA__2448__X FrameStrobe_O[9] VPWR VGND sg13cmos5l_antennanp
XFILLER_39_17 VPWR VGND sg13cmos5l_fill_2
X_0669_ _0669_/Y _2821_/X _0669_/B VPWR VGND sg13cmos5l_nor2_1
X_2408_ E6BEG[1] E6END[3] VPWR VGND sg13cmos5l_buf_1
X_2339_ _3065_/A2 VPWR VGND sg13cmos5l_tiehi
XFILLER_25_354 VPWR VGND sg13cmos5l_fill_2
XFILLER_0_497 VPWR VGND sg13cmos5l_decap_4
XFILLER_28_170 VPWR VGND sg13cmos5l_decap_4
XFILLER_56_490 VPWR VGND sg13cmos5l_fill_2
XANTENNA_3 FrameStrobe[15] VPWR VGND sg13cmos5l_antennanp
X_1572_ _1572_/Q FrameData[9] VGND VPWR _1166_/X latch
X_1641_ _1641_/Q FrameData[14] VGND VPWR _1171_/X latch
X_1710_ _1710_/Q FrameData[19] VGND VPWR _1133_/X latch
X_3311_ _3311_/X E2END[5] S2END[7] W1END[1] _3006_/X _1655_/Q _1656_/Q VPWR VGND sg13cmos5l_mux4_1
X_2690_ _2690_/X _2686_/X _2687_/X _2688_/X _2689_/X _1767_/Q _1768_/Q VPWR VGND sg13cmos5l_mux4_1
X_3173_ _3173_/X _1229_/Y _1165_/Y _1974_/Q _1227_/Y _1975_/Q _1976_/Q VPWR VGND sg13cmos5l_mux4_1
X_3242_ _3242_/X _3163_/X _0871_/X _3155_/X _3150_/X _1785_/Q _1786_/Q VPWR VGND sg13cmos5l_mux4_1
X_2124_ _2124_/Q FrameData[17] VGND VPWR FrameStrobe[6] latch
XFILLER_34_162 VPWR VGND sg13cmos5l_decap_8
XFILLER_39_479 VPWR VGND sg13cmos5l_fill_1
X_1006_ _2603_/A _2961_/X _2962_/X _2074_/Q VPWR VGND sg13cmos5l_mux2_1
X_2055_ _2055_/Q FrameData[12] VGND VPWR FrameStrobe[8] latch
X_2957_ _2957_/X _0807_/B _1061_/Y _1223_/Y _0833_/Y _2022_/Q _2023_/Q VPWR VGND sg13cmos5l_mux4_1
X_2888_ _2888_/X S2END[0] S4END[0] W1END[0] W2MID[4] _2277_/Q _2278_/Q VPWR VGND sg13cmos5l_mux4_1
X_1908_ _1908_/Q FrameData[25] VGND VPWR _1152_/X latch
X_1839_ _1839_/Q FrameData[20] VGND VPWR _1136_/X latch
XFILLER_57_210 VPWR VGND sg13cmos5l_fill_2
XFILLER_13_379 VPWR VGND sg13cmos5l_fill_1
XANTENNA__2641__X WW4BEG[14] VPWR VGND sg13cmos5l_antennanp
XFILLER_40_198 VPWR VGND sg13cmos5l_fill_1
XFILLER_16_151 VPWR VGND sg13cmos5l_decap_8
XFILLER_16_184 VPWR VGND sg13cmos5l_fill_2
XFILLER_44_493 VPWR VGND sg13cmos5l_fill_2
XANTENNA__2551__X FrameData_O[4] VPWR VGND sg13cmos5l_antennanp
X_2811_ _2811_/X _2807_/X _2808_/X _2809_/X _2810_/X _1891_/Q _1892_/Q VPWR VGND sg13cmos5l_mux4_1
X_2742_ _2742_/X _3170_/X _2890_/X _3122_/X _0857_/X _1837_/Q _1838_/Q VPWR VGND sg13cmos5l_mux4_1
XFILLER_8_383 VPWR VGND sg13cmos5l_decap_4
X_1555_ _1555_/Q FrameData[24] VGND VPWR _1187_/X latch
X_1624_ _1624_/Q FrameData[29] VGND VPWR _1189_/X latch
X_2673_ _2673_/X _1295_/Q _1303_/Q _1296_/Q _1304_/Q _2690_/X _3256_/X VPWR VGND sg13cmos5l_mux4_1
X_1486_ _1486_/Q FrameData[19] VGND VPWR _1182_/X latch
X_3087_ _3087_/X _3084_/X _3085_/X _3086_/X _1064_/Y _2145_/Q _2146_/Q VPWR VGND sg13cmos5l_mux4_1
X_3156_ _3156_/X N2MID[2] N2END[2] N4END[2] E2MID[0] _2215_/Q _2216_/Q VPWR VGND sg13cmos5l_mux4_1
X_3225_ _3225_/X _3117_/X _3159_/X _3150_/X _0865_/X _1821_/Q _1822_/Q VPWR VGND sg13cmos5l_mux4_1
X_2107_ _2107_/Q FrameData[0] VGND VPWR FrameStrobe[6] latch
XFILLER_10_316 VPWR VGND sg13cmos5l_fill_1
X_2038_ _2038_/Q FrameData[27] VGND VPWR FrameStrobe[9] latch
XANTENNA__2461__X N1BEG[2] VPWR VGND sg13cmos5l_antennanp
XANTENNA__2636__X WW4BEG[9] VPWR VGND sg13cmos5l_antennanp
XFILLER_41_430 VPWR VGND sg13cmos5l_fill_2
X_1340_ _1340_/Q FrameData[1] VGND VPWR _1183_/X latch
XANTENNA__2546__X S4BEG[15] VPWR VGND sg13cmos5l_antennanp
XFILLER_3_33 VPWR VGND sg13cmos5l_fill_2
X_1271_ _1271_/Q FrameData[28] VGND VPWR _1180_/X latch
X_3010_ _3010_/X _3007_/X _3008_/X _3009_/X _0809_/Y _2310_/Q _2311_/Q VPWR VGND sg13cmos5l_mux4_1
XFILLER_17_493 VPWR VGND sg13cmos5l_fill_2
XFILLER_36_279 VPWR VGND sg13cmos5l_fill_1
XFILLER_51_238 VPWR VGND sg13cmos5l_fill_1
X_0986_ _0986_/Y _0986_/A VPWR VGND sg13cmos5l_inv_1
X_2725_ _2725_/X _0630_/X _2924_/X _0657_/X _3059_/X _1801_/Q _1802_/Q VPWR VGND sg13cmos5l_mux4_1
X_2656_ _2656_/X _2652_/X _2653_/X _2654_/X _2655_/X _1743_/Q _1744_/Q VPWR VGND sg13cmos5l_mux4_1
X_1469_ _1469_/Q FrameData[2] VGND VPWR _1182_/X latch
X_1538_ _1538_/Q FrameData[7] VGND VPWR _1187_/X latch
X_1607_ _1607_/Q FrameData[12] VGND VPWR _1189_/X latch
X_2587_ SS4BEG[8] SS4END[12] VPWR VGND sg13cmos5l_buf_1
XANTENNA__2456__X FrameStrobe_O[17] VPWR VGND sg13cmos5l_antennanp
X_3139_ _3139_/X _1132_/X _1128_/X _1125_/X _2187_/Q _2188_/Q _2189_/Q VPWR VGND sg13cmos5l_mux4_1
X_3208_ _3208_/X _3204_/X _3205_/X _3206_/X _3207_/X _1883_/Q _1884_/Q VPWR VGND sg13cmos5l_mux4_1
XFILLER_23_474 VPWR VGND sg13cmos5l_fill_1
XFILLER_14_463 VPWR VGND sg13cmos5l_decap_8
XFILLER_33_216 VPWR VGND sg13cmos5l_decap_8
XFILLER_46_555 VPWR VGND sg13cmos5l_fill_2
XFILLER_53_71 VPWR VGND sg13cmos5l_fill_1
X_0771_ _0771_/Y _0769_/A _0769_/B _0770_/Y VPWR VGND sg13cmos5l_o21ai_1
X_0840_ _0840_/Y _0564_/Y _2326_/Q _0839_/Y VPWR VGND sg13cmos5l_a21oi_1
X_2510_ NN4BEG[15] _2510_/A VPWR VGND sg13cmos5l_buf_1
X_1323_ _1323_/Q FrameData[16] VGND VPWR _1184_/X latch
X_2441_ FrameStrobe_O[2] FrameStrobe[2] VPWR VGND sg13cmos5l_buf_1
X_2372_ _3172_/A1 VPWR VGND sg13cmos5l_tielo
XFILLER_24_216 VPWR VGND sg13cmos5l_fill_1
XFILLER_37_555 VPWR VGND sg13cmos5l_fill_2
X_1185_ _1185_/X FrameStrobe[13] FrameStrobe[15] VPWR VGND sg13cmos5l_and2_1
X_1254_ _1254_/Q FrameData[11] VGND VPWR _1180_/X latch
XFILLER_20_411 VPWR VGND sg13cmos5l_fill_1
X_0969_ _0969_/Y _1782_/Q _0966_/A _0968_/Y VPWR VGND sg13cmos5l_o21ai_1
X_2708_ _2708_/X _1359_/Q _1360_/Q _1361_/Q _1362_/Q _3244_/X _3239_/X VPWR VGND sg13cmos5l_mux4_1
X_2639_ WW4BEG[12] _2639_/A VPWR VGND sg13cmos5l_buf_1
XFILLER_28_555 VPWR VGND sg13cmos5l_fill_2
XFILLER_23_271 VPWR VGND sg13cmos5l_decap_4
XFILLER_2_142 VPWR VGND sg13cmos5l_fill_1
XFILLER_3_0 VPWR VGND sg13cmos5l_decap_8
XFILLER_21_208 VPWR VGND sg13cmos5l_decap_8
X_2990_ _2990_/X W1END[0] _2990_/A1 _2990_/A2 _1223_/Y _2284_/Q _2285_/Q VPWR VGND
+ sg13cmos5l_mux4_1
X_1941_ _1941_/Q FrameData[26] VGND VPWR _1137_/X latch
X_1872_ _1872_/Q FrameData[21] VGND VPWR _1157_/X latch
X_0685_ _0685_/Y _1109_/A _1493_/Q _0683_/Y _0684_/Y _0681_/Y VPWR VGND sg13cmos5l_a221oi_1
X_0754_ _0755_/C _2656_/X _1285_/Q _0751_/X _0753_/Y VPWR VGND sg13cmos5l_a22oi_1
X_0823_ _0823_/Y _0823_/A _0823_/B VPWR VGND sg13cmos5l_nor2_1
XFILLER_36_0 VPWR VGND sg13cmos5l_fill_2
X_1306_ _1306_/Q FrameData[31] VGND VPWR _1197_/X latch
X_2424_ E2BEGb[5] E2MID[5] VPWR VGND sg13cmos5l_buf_1
X_2355_ _2355_/L_HI VPWR VGND sg13cmos5l_tiehi
X_2286_ _2286_/Q FrameData[19] VGND VPWR FrameStrobe[1] latch
X_1099_ _1099_/Y _3198_/X _1502_/Q _1098_/Y VPWR VGND sg13cmos5l_a21oi_1
X_1168_ _1168_/X _2978_/X _2947_/X _1910_/Q VPWR VGND sg13cmos5l_mux2_1
X_1237_ _1237_/Q _1248_/CLK _1237_/D _2356_/L_HI VPWR VGND sg13cmos5l_dfrbpq_1
XFILLER_55_171 VPWR VGND sg13cmos5l_fill_2
X_2140_ _2140_/Q FrameData[1] VGND VPWR FrameStrobe[5] latch
XANTENNA__2554__X FrameData_O[7] VPWR VGND sg13cmos5l_antennanp
XFILLER_38_149 VPWR VGND sg13cmos5l_fill_1
X_1022_ _1022_/Y _1846_/Q _1005_/A _1021_/Y VPWR VGND sg13cmos5l_o21ai_1
X_2071_ _2071_/Q FrameData[28] VGND VPWR FrameStrobe[8] latch
X_2973_ _2973_/X _0872_/X _3170_/X _0859_/X _1223_/Y _2003_/Q _2004_/Q VPWR VGND sg13cmos5l_mux4_1
X_1924_ _1924_/Q FrameData[9] VGND VPWR _1137_/X latch
X_1855_ _1855_/Q FrameData[4] VGND VPWR _1157_/X latch
X_0668_ _0669_/B _2845_/X _1543_/Q VPWR VGND sg13cmos5l_or2_1
X_0737_ _0740_/A _2656_/X _1284_/Q VPWR VGND sg13cmos5l_nand2_1
X_0806_ _0807_/B _0567_/Y _2324_/Q _0805_/Y VPWR VGND sg13cmos5l_a21oi_1
X_1786_ _1786_/Q FrameData[31] VGND VPWR _1139_/X latch
X_0599_ _0599_/Y _1329_/Q VPWR VGND sg13cmos5l_inv_1
X_2407_ E6BEG[0] E6END[2] VPWR VGND sg13cmos5l_buf_1
X_2338_ _3038_/A2 VPWR VGND sg13cmos5l_tiehi
X_2269_ _2269_/Q FrameData[2] VGND VPWR FrameStrobe[1] latch
XANTENNA__2464__X N2BEG[1] VPWR VGND sg13cmos5l_antennanp
XFILLER_25_311 VPWR VGND sg13cmos5l_fill_1
XFILLER_25_388 VPWR VGND sg13cmos5l_decap_4
XANTENNA__2639__X WW4BEG[12] VPWR VGND sg13cmos5l_antennanp
XFILLER_31_314 VPWR VGND sg13cmos5l_fill_1
XFILLER_31_325 VPWR VGND sg13cmos5l_decap_8
XFILLER_8_510 VPWR VGND sg13cmos5l_fill_1
XANTENNA_4 FrameStrobe[15] VPWR VGND sg13cmos5l_antennanp
XFILLER_3_270 VPWR VGND sg13cmos5l_fill_1
X_1571_ _1571_/Q FrameData[8] VGND VPWR _1166_/X latch
X_1640_ _1640_/Q FrameData[13] VGND VPWR _1171_/X latch
X_3310_ _3310_/X _2910_/X _0871_/X _0858_/X _1066_/Y _1658_/Q _1659_/Q VPWR VGND sg13cmos5l_mux4_1
XANTENNA__2549__X FrameData_O[2] VPWR VGND sg13cmos5l_antennanp
XFILLER_13_2 VPWR VGND sg13cmos5l_fill_1
X_3172_ _3172_/X _1248_/Q _3172_/A1 _3172_/A2 _0921_/Y _2259_/Q _2260_/Q VPWR VGND
+ sg13cmos5l_mux4_1
X_3241_ _3241_/X _0650_/X _2910_/X _3074_/X _0639_/X _1785_/Q _1786_/Q VPWR VGND sg13cmos5l_mux4_1
X_2123_ _2123_/Q FrameData[16] VGND VPWR FrameStrobe[6] latch
X_1005_ _2521_/A _1005_/A VPWR VGND sg13cmos5l_inv_1
X_2054_ _2054_/Q FrameData[11] VGND VPWR FrameStrobe[8] latch
XFILLER_41_19 VPWR VGND sg13cmos5l_fill_1
X_2956_ _2956_/X _1066_/Y _0986_/Y _1056_/Y _0848_/Y _2022_/Q _2023_/Q VPWR VGND sg13cmos5l_mux4_1
X_2887_ _2887_/X E2MID[2] E2END[2] EE4END[0] S2MID[0] _2277_/Q _2278_/Q VPWR VGND
+ sg13cmos5l_mux4_1
X_1907_ _1907_/Q FrameData[24] VGND VPWR _1152_/X latch
X_1838_ _1838_/Q FrameData[19] VGND VPWR _1136_/X latch
XANTENNA__2459__X N1BEG[0] VPWR VGND sg13cmos5l_antennanp
XFILLER_1_229 VPWR VGND sg13cmos5l_fill_1
X_1769_ _1769_/Q FrameData[14] VGND VPWR _1139_/X latch
XFILLER_17_108 VPWR VGND sg13cmos5l_fill_2
XFILLER_13_336 VPWR VGND sg13cmos5l_fill_1
XFILLER_40_188 VPWR VGND sg13cmos5l_fill_2
X_2810_ _2810_/X _0863_/X _2890_/X _2885_/X _0857_/X _1889_/Q _1890_/Q VPWR VGND sg13cmos5l_mux4_1
X_2741_ _2741_/X _3117_/X _0872_/X _0867_/X _0865_/X _1837_/Q _1838_/Q VPWR VGND sg13cmos5l_mux4_1
X_2672_ _2672_/X _1293_/Q _1301_/Q _1294_/Q _1302_/Q _2690_/X _3256_/X VPWR VGND sg13cmos5l_mux4_1
X_1485_ _1485_/Q FrameData[18] VGND VPWR _1182_/X latch
X_1554_ _1554_/Q FrameData[23] VGND VPWR _1187_/X latch
X_1623_ _1623_/Q FrameData[28] VGND VPWR _1189_/X latch
X_3224_ _3224_/X _0650_/X _2910_/X _0639_/X _0627_/X _1821_/Q _1822_/Q VPWR VGND sg13cmos5l_mux4_1
.ends
