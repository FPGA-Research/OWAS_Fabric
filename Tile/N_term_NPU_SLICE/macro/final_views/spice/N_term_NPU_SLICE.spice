* NGSPICE file created from N_term_NPU_SLICE.ext - technology: ihp-sg13cmos5l

* Black-box entry subcircuit for sg13cmos5l_buf_1 abstract view
.subckt sg13cmos5l_buf_1 X A VDD VSS
.ends

* Black-box entry subcircuit for sg13cmos5l_decap_8 abstract view
.subckt sg13cmos5l_decap_8 VDD VSS
.ends

* Black-box entry subcircuit for sg13cmos5l_fill_1 abstract view
.subckt sg13cmos5l_fill_1 VDD VSS
.ends

* Black-box entry subcircuit for sg13cmos5l_decap_4 abstract view
.subckt sg13cmos5l_decap_4 VDD VSS
.ends

* Black-box entry subcircuit for sg13cmos5l_fill_2 abstract view
.subckt sg13cmos5l_fill_2 VDD VSS
.ends

* Black-box entry subcircuit for sg13cmos5l_antennanp abstract view
.subckt sg13cmos5l_antennanp A VDD VSS
.ends

* Black-box entry subcircuit for sg13cmos5l_inv_1 abstract view
.subckt sg13cmos5l_inv_1 Y A VDD VSS
.ends

* Black-box entry subcircuit for sg13cmos5l_buf_16 abstract view
.subckt sg13cmos5l_buf_16 X A VDD VSS
.ends

.subckt N_term_NPU_SLICE FrameData[0] FrameData[10] FrameData[11] FrameData[12] FrameData[13]
+ FrameData[14] FrameData[15] FrameData[16] FrameData[17] FrameData[18] FrameData[19]
+ FrameData[1] FrameData[20] FrameData[21] FrameData[22] FrameData[23] FrameData[24]
+ FrameData[25] FrameData[26] FrameData[27] FrameData[28] FrameData[29] FrameData[2]
+ FrameData[30] FrameData[31] FrameData[3] FrameData[4] FrameData[5] FrameData[6]
+ FrameData[7] FrameData[8] FrameData[9] FrameData_O[0] FrameData_O[10] FrameData_O[11]
+ FrameData_O[12] FrameData_O[13] FrameData_O[14] FrameData_O[15] FrameData_O[16]
+ FrameData_O[17] FrameData_O[18] FrameData_O[19] FrameData_O[1] FrameData_O[20] FrameData_O[21]
+ FrameData_O[22] FrameData_O[23] FrameData_O[24] FrameData_O[25] FrameData_O[26]
+ FrameData_O[27] FrameData_O[28] FrameData_O[29] FrameData_O[2] FrameData_O[30] FrameData_O[31]
+ FrameData_O[3] FrameData_O[4] FrameData_O[5] FrameData_O[6] FrameData_O[7] FrameData_O[8]
+ FrameData_O[9] FrameStrobe[0] FrameStrobe[10] FrameStrobe[11] FrameStrobe[12] FrameStrobe[13]
+ FrameStrobe[14] FrameStrobe[15] FrameStrobe[16] FrameStrobe[17] FrameStrobe[18]
+ FrameStrobe[19] FrameStrobe[1] FrameStrobe[2] FrameStrobe[3] FrameStrobe[4] FrameStrobe[5]
+ FrameStrobe[6] FrameStrobe[7] FrameStrobe[8] FrameStrobe[9] FrameStrobe_O[0] FrameStrobe_O[10]
+ FrameStrobe_O[11] FrameStrobe_O[12] FrameStrobe_O[13] FrameStrobe_O[14] FrameStrobe_O[15]
+ FrameStrobe_O[16] FrameStrobe_O[17] FrameStrobe_O[18] FrameStrobe_O[19] FrameStrobe_O[1]
+ FrameStrobe_O[2] FrameStrobe_O[3] FrameStrobe_O[4] FrameStrobe_O[5] FrameStrobe_O[6]
+ FrameStrobe_O[7] FrameStrobe_O[8] FrameStrobe_O[9] N1END[0] N1END[1] N1END[2] N1END[3]
+ N2END[0] N2END[1] N2END[2] N2END[3] N2END[4] N2END[5] N2END[6] N2END[7] N2MID[0]
+ N2MID[1] N2MID[2] N2MID[3] N2MID[4] N2MID[5] N2MID[6] N2MID[7] N4END[0] N4END[10]
+ N4END[11] N4END[12] N4END[13] N4END[14] N4END[15] N4END[1] N4END[2] N4END[3] N4END[4]
+ N4END[5] N4END[6] N4END[7] N4END[8] N4END[9] S1BEG[0] S1BEG[1] S1BEG[2] S1BEG[3]
+ S2BEG[0] S2BEG[1] S2BEG[2] S2BEG[3] S2BEG[4] S2BEG[5] S2BEG[6] S2BEG[7] S2BEGb[0]
+ S2BEGb[1] S2BEGb[2] S2BEGb[3] S2BEGb[4] S2BEGb[5] S2BEGb[6] S2BEGb[7] S4BEG[0] S4BEG[10]
+ S4BEG[11] S4BEG[12] S4BEG[13] S4BEG[14] S4BEG[15] S4BEG[1] S4BEG[2] S4BEG[3] S4BEG[4]
+ S4BEG[5] S4BEG[6] S4BEG[7] S4BEG[8] S4BEG[9] UserCLK UserCLKo VGND VPWR
X_83_ FrameData_O[26] FrameData[26] VPWR VGND sg13cmos5l_buf_1
XFILLER_9_126 VPWR VGND sg13cmos5l_decap_8
XFILLER_3_12 VPWR VGND sg13cmos5l_decap_8
XFILLER_10_114 VPWR VGND sg13cmos5l_decap_8
XFILLER_12_54 VPWR VGND sg13cmos5l_decap_8
X_66_ FrameData_O[9] FrameData[9] VPWR VGND sg13cmos5l_buf_1
XFILLER_0_46 VPWR VGND sg13cmos5l_fill_1
XFILLER_9_77 VPWR VGND sg13cmos5l_decap_8
XFILLER_2_165 VPWR VGND sg13cmos5l_fill_1
X_49_ S2BEG[4] N2MID[3] VPWR VGND sg13cmos5l_buf_1
XFILLER_6_34 VPWR VGND sg13cmos5l_decap_8
XFILLER_6_23 VPWR VGND sg13cmos5l_decap_8
XFILLER_15_87 VPWR VGND sg13cmos5l_decap_8
XFILLER_15_65 VPWR VGND sg13cmos5l_decap_4
XFILLER_16_120 VPWR VGND sg13cmos5l_fill_1
XFILLER_11_0 VPWR VGND sg13cmos5l_fill_1
XFILLER_9_105 VPWR VGND sg13cmos5l_decap_8
XFILLER_3_79 VPWR VGND sg13cmos5l_fill_1
XFILLER_3_68 VPWR VGND sg13cmos5l_decap_8
X_82_ FrameData_O[25] FrameData[25] VPWR VGND sg13cmos5l_buf_1
XFILLER_12_33 VPWR VGND sg13cmos5l_decap_8
XFILLER_6_108 VPWR VGND sg13cmos5l_fill_2
X_65_ FrameData_O[8] FrameData[8] VPWR VGND sg13cmos5l_buf_1
XFILLER_5_141 VPWR VGND sg13cmos5l_decap_8
XFILLER_5_130 VPWR VGND sg13cmos5l_fill_1
XANTENNA__02__X S4BEG[1] VPWR VGND sg13cmos5l_antennanp
XFILLER_0_36 VPWR VGND sg13cmos5l_fill_1
XFILLER_0_69 VPWR VGND sg13cmos5l_fill_1
XFILLER_9_56 VPWR VGND sg13cmos5l_decap_8
XFILLER_3_2 VPWR VGND sg13cmos5l_fill_1
XFILLER_2_177 VPWR VGND sg13cmos5l_fill_2
XFILLER_2_144 VPWR VGND sg13cmos5l_decap_8
XFILLER_2_111 VPWR VGND sg13cmos5l_decap_8
XFILLER_2_100 VPWR VGND sg13cmos5l_fill_1
X_48_ S2BEG[3] N2MID[4] VPWR VGND sg13cmos5l_buf_1
XFILLER_15_22 VPWR VGND sg13cmos5l_fill_1
XANTENNA__10__X S4BEG[9] VPWR VGND sg13cmos5l_antennanp
XFILLER_16_143 VPWR VGND sg13cmos5l_fill_1
XFILLER_16_132 VPWR VGND sg13cmos5l_decap_4
XANTENNA__05__X S4BEG[4] VPWR VGND sg13cmos5l_antennanp
XFILLER_13_102 VPWR VGND sg13cmos5l_decap_8
XFILLER_13_135 VPWR VGND sg13cmos5l_decap_8
XFILLER_7_9 VPWR VGND sg13cmos5l_decap_8
X_81_ FrameData_O[24] FrameData[24] VPWR VGND sg13cmos5l_buf_1
XFILLER_8_150 VPWR VGND sg13cmos5l_decap_8
XFILLER_3_47 VPWR VGND sg13cmos5l_decap_8
XANTENNA__01__A N4END[15] VPWR VGND sg13cmos5l_antennanp
XFILLER_10_149 VPWR VGND sg13cmos5l_decap_8
XFILLER_12_12 VPWR VGND sg13cmos5l_decap_8
XFILLER_12_89 VPWR VGND sg13cmos5l_decap_8
X_64_ FrameData_O[7] FrameData[7] VPWR VGND sg13cmos5l_buf_1
XFILLER_9_35 VPWR VGND sg13cmos5l_decap_8
XFILLER_2_134 VPWR VGND sg13cmos5l_fill_1
X_47_ S2BEG[2] N2MID[5] VPWR VGND sg13cmos5l_buf_1
XANTENNA__13__X S4BEG[12] VPWR VGND sg13cmos5l_antennanp
XFILLER_1_0 VPWR VGND sg13cmos5l_fill_1
XANTENNA__08__X S4BEG[7] VPWR VGND sg13cmos5l_antennanp
XFILLER_6_69 VPWR VGND sg13cmos5l_decap_8
XANTENNA__04__A N4END[12] VPWR VGND sg13cmos5l_antennanp
XFILLER_15_45 VPWR VGND sg13cmos5l_fill_1
XANTENNA__21__X S2BEGb[4] VPWR VGND sg13cmos5l_antennanp
X_80_ FrameData_O[23] FrameData[23] VPWR VGND sg13cmos5l_buf_1
XFILLER_3_26 VPWR VGND sg13cmos5l_decap_8
XFILLER_10_128 VPWR VGND sg13cmos5l_decap_8
XFILLER_12_68 VPWR VGND sg13cmos5l_decap_8
XANTENNA__16__X S4BEG[15] VPWR VGND sg13cmos5l_antennanp
X_63_ FrameData_O[6] FrameData[6] VPWR VGND sg13cmos5l_buf_1
XANTENNA__12__A N4END[4] VPWR VGND sg13cmos5l_antennanp
XFILLER_2_179 VPWR VGND sg13cmos5l_fill_1
X_46_ S2BEG[1] N2MID[6] VPWR VGND sg13cmos5l_buf_1
XANTENNA__07__A N4END[9] VPWR VGND sg13cmos5l_antennanp
X_29_ FrameStrobe_O[4] FrameStrobe[4] VPWR VGND sg13cmos5l_buf_1
XANTENNA__24__X S2BEGb[7] VPWR VGND sg13cmos5l_antennanp
XFILLER_6_48 VPWR VGND sg13cmos5l_decap_8
XANTENNA__19__X S2BEGb[2] VPWR VGND sg13cmos5l_antennanp
XANTENNA__20__A N2END[4] VPWR VGND sg13cmos5l_antennanp
XFILLER_15_35 VPWR VGND sg13cmos5l_fill_2
XFILLER_16_101 VPWR VGND sg13cmos5l_decap_4
XFILLER_13_115 VPWR VGND sg13cmos5l_fill_2
XANTENNA__15__A N4END[1] VPWR VGND sg13cmos5l_antennanp
XFILLER_9_119 VPWR VGND sg13cmos5l_decap_8
XFILLER_10_107 VPWR VGND sg13cmos5l_decap_8
XFILLER_8_174 VPWR VGND sg13cmos5l_decap_4
XANTENNA__32__X FrameStrobe_O[7] VPWR VGND sg13cmos5l_antennanp
XFILLER_12_47 VPWR VGND sg13cmos5l_decap_8
XFILLER_5_155 VPWR VGND sg13cmos5l_decap_4
X_62_ FrameData_O[5] FrameData[5] VPWR VGND sg13cmos5l_buf_1
XFILLER_2_158 VPWR VGND sg13cmos5l_decap_8
XFILLER_2_125 VPWR VGND sg13cmos5l_fill_2
XANTENNA__27__X FrameStrobe_O[2] VPWR VGND sg13cmos5l_antennanp
XFILLER_0_17 VPWR VGND sg13cmos5l_fill_2
X_45_ S2BEG[0] N2MID[7] VPWR VGND sg13cmos5l_buf_1
XANTENNA__23__A N2END[1] VPWR VGND sg13cmos5l_antennanp
Xclkload0 clkload0/Y clkload0/A VPWR VGND sg13cmos5l_inv_1
X_28_ FrameStrobe_O[3] FrameStrobe[3] VPWR VGND sg13cmos5l_buf_1
XANTENNA__18__A N2END[6] VPWR VGND sg13cmos5l_antennanp
XANTENNA__40__X FrameStrobe_O[15] VPWR VGND sg13cmos5l_antennanp
XFILLER_15_58 VPWR VGND sg13cmos5l_fill_2
XANTENNA__35__X FrameStrobe_O[10] VPWR VGND sg13cmos5l_antennanp
XFILLER_16_157 VPWR VGND sg13cmos5l_fill_2
XFILLER_16_124 VPWR VGND sg13cmos5l_decap_4
XFILLER_7_92 VPWR VGND sg13cmos5l_fill_2
XFILLER_7_70 VPWR VGND sg13cmos5l_fill_1
XANTENNA__31__A FrameStrobe[6] VPWR VGND sg13cmos5l_antennanp
XFILLER_13_149 VPWR VGND sg13cmos5l_fill_1
XFILLER_8_164 VPWR VGND sg13cmos5l_fill_1
XANTENNA__26__A FrameStrobe[1] VPWR VGND sg13cmos5l_antennanp
XFILLER_12_26 VPWR VGND sg13cmos5l_decap_8
XFILLER_5_9 VPWR VGND sg13cmos5l_decap_8
X_61_ FrameData_O[4] FrameData[4] VPWR VGND sg13cmos5l_buf_1
XFILLER_5_134 VPWR VGND sg13cmos5l_decap_8
XFILLER_5_112 VPWR VGND sg13cmos5l_decap_8
XFILLER_4_71 VPWR VGND sg13cmos5l_fill_1
XFILLER_2_104 VPWR VGND sg13cmos5l_decap_8
XANTENNA__43__X FrameStrobe_O[18] VPWR VGND sg13cmos5l_antennanp
XFILLER_9_49 VPWR VGND sg13cmos5l_decap_8
X_44_ FrameStrobe_O[19] FrameStrobe[19] VPWR VGND sg13cmos5l_buf_1
XANTENNA__38__X FrameStrobe_O[13] VPWR VGND sg13cmos5l_antennanp
X_27_ FrameStrobe_O[2] FrameStrobe[2] VPWR VGND sg13cmos5l_buf_1
XANTENNA__34__A FrameStrobe[9] VPWR VGND sg13cmos5l_antennanp
XFILLER_15_15 VPWR VGND sg13cmos5l_decap_8
XANTENNA__29__A FrameStrobe[4] VPWR VGND sg13cmos5l_antennanp
XANTENNA__51__X S2BEG[6] VPWR VGND sg13cmos5l_antennanp
XFILLER_16_147 VPWR VGND sg13cmos5l_decap_8
XFILLER_13_117 VPWR VGND sg13cmos5l_fill_1
XFILLER_13_128 VPWR VGND sg13cmos5l_decap_8
XANTENNA__46__X S2BEG[1] VPWR VGND sg13cmos5l_antennanp
XFILLER_8_143 VPWR VGND sg13cmos5l_decap_8
XANTENNA__42__A FrameStrobe[17] VPWR VGND sg13cmos5l_antennanp
X_60_ FrameData_O[3] FrameData[3] VPWR VGND sg13cmos5l_buf_1
XFILLER_5_179 VPWR VGND sg13cmos5l_fill_1
XFILLER_4_83 VPWR VGND sg13cmos5l_decap_8
XANTENNA__37__A FrameStrobe[12] VPWR VGND sg13cmos5l_antennanp
XFILLER_13_81 VPWR VGND sg13cmos5l_decap_8
XFILLER_9_28 VPWR VGND sg13cmos5l_decap_8
X_43_ FrameStrobe_O[18] FrameStrobe[18] VPWR VGND sg13cmos5l_buf_1
XFILLER_1_171 VPWR VGND sg13cmos5l_decap_8
XANTENNA__54__X S1BEG[1] VPWR VGND sg13cmos5l_antennanp
X_26_ FrameStrobe_O[1] FrameStrobe[1] VPWR VGND sg13cmos5l_buf_1
XFILLER_1_40 VPWR VGND sg13cmos5l_decap_8
XANTENNA__49__X S2BEG[4] VPWR VGND sg13cmos5l_antennanp
XANTENNA__50__A N2MID[2] VPWR VGND sg13cmos5l_antennanp
XFILLER_10_93 VPWR VGND sg13cmos5l_decap_8
XFILLER_6_18 VPWR VGND sg13cmos5l_fill_2
X_09_ S4BEG[8] N4END[7] VPWR VGND sg13cmos5l_buf_1
XFILLER_15_27 VPWR VGND sg13cmos5l_decap_4
XANTENNA__45__A N2MID[7] VPWR VGND sg13cmos5l_antennanp
XFILLER_16_159 VPWR VGND sg13cmos5l_fill_1
XFILLER_7_94 VPWR VGND sg13cmos5l_fill_1
XANTENNA__62__X FrameData_O[5] VPWR VGND sg13cmos5l_antennanp
XFILLER_8_122 VPWR VGND sg13cmos5l_decap_8
XFILLER_3_19 VPWR VGND sg13cmos5l_decap_8
XFILLER_16_81 VPWR VGND sg13cmos5l_fill_1
XANTENNA__57__X FrameData_O[0] VPWR VGND sg13cmos5l_antennanp
XANTENNA__53__A N1END[3] VPWR VGND sg13cmos5l_antennanp
XFILLER_13_60 VPWR VGND sg13cmos5l_decap_8
X_42_ FrameStrobe_O[17] FrameStrobe[17] VPWR VGND sg13cmos5l_buf_1
XANTENNA__48__A N2MID[4] VPWR VGND sg13cmos5l_antennanp
XANTENNA__70__X FrameData_O[13] VPWR VGND sg13cmos5l_antennanp
X_25_ FrameStrobe_O[0] FrameStrobe[0] VPWR VGND sg13cmos5l_buf_1
XFILLER_10_72 VPWR VGND sg13cmos5l_decap_8
XANTENNA__65__X FrameData_O[8] VPWR VGND sg13cmos5l_antennanp
X_08_ S4BEG[7] N4END[8] VPWR VGND sg13cmos5l_buf_1
XFILLER_16_116 VPWR VGND sg13cmos5l_decap_4
XFILLER_16_105 VPWR VGND sg13cmos5l_fill_1
XANTENNA__61__A FrameData[4] VPWR VGND sg13cmos5l_antennanp
XANTENNA__56__A N1END[0] VPWR VGND sg13cmos5l_antennanp
XFILLER_12_152 VPWR VGND sg13cmos5l_decap_8
XFILLER_8_178 VPWR VGND sg13cmos5l_fill_2
XFILLER_8_101 VPWR VGND sg13cmos5l_decap_8
XFILLER_16_93 VPWR VGND sg13cmos5l_decap_4
XFILLER_5_159 VPWR VGND sg13cmos5l_fill_2
XFILLER_5_148 VPWR VGND sg13cmos5l_decap_8
XFILLER_5_126 VPWR VGND sg13cmos5l_decap_4
XANTENNA__73__X FrameData_O[16] VPWR VGND sg13cmos5l_antennanp
XFILLER_2_118 VPWR VGND sg13cmos5l_decap_8
XANTENNA__68__X FrameData_O[11] VPWR VGND sg13cmos5l_antennanp
X_41_ FrameStrobe_O[16] FrameStrobe[16] VPWR VGND sg13cmos5l_buf_1
XANTENNA__64__A FrameData[7] VPWR VGND sg13cmos5l_antennanp
X_24_ S2BEGb[7] N2END[0] VPWR VGND sg13cmos5l_buf_1
XFILLER_10_51 VPWR VGND sg13cmos5l_decap_8
XANTENNA__59__A FrameData[2] VPWR VGND sg13cmos5l_antennanp
XANTENNA__81__X FrameData_O[24] VPWR VGND sg13cmos5l_antennanp
X_07_ S4BEG[6] N4END[9] VPWR VGND sg13cmos5l_buf_1
XANTENNA__76__X FrameData_O[19] VPWR VGND sg13cmos5l_antennanp
XFILLER_16_139 VPWR VGND sg13cmos5l_decap_4
XFILLER_16_128 VPWR VGND sg13cmos5l_fill_1
XFILLER_13_109 VPWR VGND sg13cmos5l_fill_2
XFILLER_7_85 VPWR VGND sg13cmos5l_fill_2
XFILLER_7_74 VPWR VGND sg13cmos5l_fill_1
XFILLER_7_63 VPWR VGND sg13cmos5l_decap_8
XFILLER_7_41 VPWR VGND sg13cmos5l_decap_4
XFILLER_7_30 VPWR VGND sg13cmos5l_decap_4
XANTENNA__72__A FrameData[15] VPWR VGND sg13cmos5l_antennanp
XFILLER_12_131 VPWR VGND sg13cmos5l_decap_8
XFILLER_16_72 VPWR VGND sg13cmos5l_fill_2
XFILLER_12_19 VPWR VGND sg13cmos5l_decap_8
XFILLER_8_157 VPWR VGND sg13cmos5l_decap_8
XFILLER_5_105 VPWR VGND sg13cmos5l_decap_8
XANTENNA__67__A FrameData[10] VPWR VGND sg13cmos5l_antennanp
XFILLER_4_20 VPWR VGND sg13cmos5l_decap_8
XFILLER_4_97 VPWR VGND sg13cmos5l_decap_8
XFILLER_4_64 VPWR VGND sg13cmos5l_decap_4
XFILLER_13_95 VPWR VGND sg13cmos5l_decap_8
X_40_ FrameStrobe_O[15] FrameStrobe[15] VPWR VGND sg13cmos5l_buf_1
XFILLER_8_0 VPWR VGND sg13cmos5l_decap_4
XFILLER_1_163 VPWR VGND sg13cmos5l_fill_2
XANTENNA__84__X FrameData_O[27] VPWR VGND sg13cmos5l_antennanp
XANTENNA__79__X FrameData_O[22] VPWR VGND sg13cmos5l_antennanp
XANTENNA__80__A FrameData[23] VPWR VGND sg13cmos5l_antennanp
X_23_ S2BEGb[6] N2END[1] VPWR VGND sg13cmos5l_buf_1
Xclkbuf_1_1__f_UserCLK _00_/A clkbuf_0_UserCLK/X VPWR VGND sg13cmos5l_buf_16
XANTENNA__75__A FrameData[18] VPWR VGND sg13cmos5l_antennanp
XFILLER_10_30 VPWR VGND sg13cmos5l_decap_8
X_06_ S4BEG[5] N4END[10] VPWR VGND sg13cmos5l_buf_1
XFILLER_7_53 VPWR VGND sg13cmos5l_fill_1
XANTENNA__87__X FrameData_O[30] VPWR VGND sg13cmos5l_antennanp
XFILLER_12_110 VPWR VGND sg13cmos5l_decap_8
XFILLER_8_169 VPWR VGND sg13cmos5l_fill_2
XFILLER_8_136 VPWR VGND sg13cmos5l_decap_8
XFILLER_16_40 VPWR VGND sg13cmos5l_fill_1
XANTENNA__83__A FrameData[26] VPWR VGND sg13cmos5l_antennanp
XFILLER_4_76 VPWR VGND sg13cmos5l_decap_8
XFILLER_4_32 VPWR VGND sg13cmos5l_fill_1
XANTENNA__78__A FrameData[21] VPWR VGND sg13cmos5l_antennanp
XFILLER_13_74 VPWR VGND sg13cmos5l_decap_8
X_22_ S2BEGb[5] N2END[2] VPWR VGND sg13cmos5l_buf_1
XFILLER_1_33 VPWR VGND sg13cmos5l_decap_8
XFILLER_10_86 VPWR VGND sg13cmos5l_decap_8
X_05_ S4BEG[4] N4END[11] VPWR VGND sg13cmos5l_buf_1
XANTENNA__86__A FrameData[29] VPWR VGND sg13cmos5l_antennanp
XFILLER_7_98 VPWR VGND sg13cmos5l_decap_8
XFILLER_7_87 VPWR VGND sg13cmos5l_fill_1
XFILLER_16_0 VPWR VGND sg13cmos5l_decap_4
XFILLER_12_177 VPWR VGND sg13cmos5l_fill_2
XFILLER_8_115 VPWR VGND sg13cmos5l_decap_8
XFILLER_16_85 VPWR VGND sg13cmos5l_decap_4
XFILLER_16_63 VPWR VGND sg13cmos5l_fill_2
XFILLER_16_52 VPWR VGND sg13cmos5l_decap_4
XFILLER_13_53 VPWR VGND sg13cmos5l_decap_8
XFILLER_1_121 VPWR VGND sg13cmos5l_decap_4
X_21_ S2BEGb[4] N2END[3] VPWR VGND sg13cmos5l_buf_1
XFILLER_1_78 VPWR VGND sg13cmos5l_decap_8
XFILLER_10_65 VPWR VGND sg13cmos5l_decap_8
X_04_ S4BEG[3] N4END[12] VPWR VGND sg13cmos5l_buf_1
XFILLER_16_109 VPWR VGND sg13cmos5l_decap_4
XFILLER_12_145 VPWR VGND sg13cmos5l_decap_8
XFILLER_16_97 VPWR VGND sg13cmos5l_fill_1
XFILLER_5_119 VPWR VGND sg13cmos5l_decap_8
XFILLER_4_141 VPWR VGND sg13cmos5l_decap_8
XFILLER_13_32 VPWR VGND sg13cmos5l_decap_8
X_20_ S2BEGb[3] N2END[4] VPWR VGND sg13cmos5l_buf_1
XFILLER_10_44 VPWR VGND sg13cmos5l_decap_8
X_03_ S4BEG[2] N4END[13] VPWR VGND sg13cmos5l_buf_1
XANTENNA__00__X UserCLKo VPWR VGND sg13cmos5l_antennanp
Xclkbuf_1_0__f_UserCLK clkload0/A clkbuf_0_UserCLK/X VPWR VGND sg13cmos5l_buf_16
XFILLER_15_143 VPWR VGND sg13cmos5l_fill_1
XFILLER_7_78 VPWR VGND sg13cmos5l_decap_8
XFILLER_7_34 VPWR VGND sg13cmos5l_fill_1
XFILLER_7_23 VPWR VGND sg13cmos5l_decap_8
XFILLER_12_124 VPWR VGND sg13cmos5l_decap_8
XFILLER_12_179 VPWR VGND sg13cmos5l_fill_1
XFILLER_16_21 VPWR VGND sg13cmos5l_decap_4
XFILLER_4_57 VPWR VGND sg13cmos5l_decap_8
XFILLER_4_46 VPWR VGND sg13cmos5l_decap_8
XFILLER_13_88 VPWR VGND sg13cmos5l_decap_8
XFILLER_8_4 VPWR VGND sg13cmos5l_fill_2
XFILLER_1_178 VPWR VGND sg13cmos5l_fill_2
XANTENNA__03__X S4BEG[2] VPWR VGND sg13cmos5l_antennanp
XFILLER_10_23 VPWR VGND sg13cmos5l_decap_8
X_79_ FrameData_O[22] FrameData[22] VPWR VGND sg13cmos5l_buf_1
X_02_ S4BEG[1] N4END[14] VPWR VGND sg13cmos5l_buf_1
XFILLER_7_57 VPWR VGND sg13cmos5l_fill_2
XFILLER_15_122 VPWR VGND sg13cmos5l_fill_2
XFILLER_12_103 VPWR VGND sg13cmos5l_decap_8
XFILLER_12_169 VPWR VGND sg13cmos5l_fill_2
XFILLER_16_77 VPWR VGND sg13cmos5l_decap_4
XFILLER_16_44 VPWR VGND sg13cmos5l_decap_4
XANTENNA__11__X S4BEG[10] VPWR VGND sg13cmos5l_antennanp
XFILLER_8_129 VPWR VGND sg13cmos5l_decap_8
XFILLER_7_140 VPWR VGND sg13cmos5l_decap_8
XFILLER_14_0 VPWR VGND sg13cmos5l_fill_1
XANTENNA__06__X S4BEG[5] VPWR VGND sg13cmos5l_antennanp
XFILLER_4_14 VPWR VGND sg13cmos5l_fill_2
XANTENNA__02__A N4END[14] VPWR VGND sg13cmos5l_antennanp
XFILLER_13_67 VPWR VGND sg13cmos5l_decap_8
XFILLER_1_113 VPWR VGND sg13cmos5l_fill_1
XFILLER_1_26 VPWR VGND sg13cmos5l_decap_8
X_78_ FrameData_O[21] FrameData[21] VPWR VGND sg13cmos5l_buf_1
XANTENNA__14__X S4BEG[13] VPWR VGND sg13cmos5l_antennanp
XFILLER_10_79 VPWR VGND sg13cmos5l_decap_8
X_01_ S4BEG[0] N4END[15] VPWR VGND sg13cmos5l_buf_1
XANTENNA__10__A N4END[6] VPWR VGND sg13cmos5l_antennanp
XANTENNA__09__X S4BEG[8] VPWR VGND sg13cmos5l_antennanp
XFILLER_15_101 VPWR VGND sg13cmos5l_decap_8
XFILLER_16_4 VPWR VGND sg13cmos5l_fill_2
XANTENNA__05__A N4END[11] VPWR VGND sg13cmos5l_antennanp
XFILLER_12_159 VPWR VGND sg13cmos5l_fill_2
XFILLER_8_108 VPWR VGND sg13cmos5l_decap_8
XFILLER_16_89 VPWR VGND sg13cmos5l_fill_1
XFILLER_11_170 VPWR VGND sg13cmos5l_fill_1
XANTENNA__22__X S2BEGb[5] VPWR VGND sg13cmos5l_antennanp
XFILLER_4_155 VPWR VGND sg13cmos5l_decap_8
XFILLER_13_46 VPWR VGND sg13cmos5l_decap_8
XANTENNA__17__X S2BEGb[0] VPWR VGND sg13cmos5l_antennanp
XFILLER_5_91 VPWR VGND sg13cmos5l_decap_8
XANTENNA__13__A N4END[3] VPWR VGND sg13cmos5l_antennanp
X_77_ FrameData_O[20] FrameData[20] VPWR VGND sg13cmos5l_buf_1
XANTENNA__08__A N4END[8] VPWR VGND sg13cmos5l_antennanp
XFILLER_10_58 VPWR VGND sg13cmos5l_decap_8
XANTENNA__30__X FrameStrobe_O[5] VPWR VGND sg13cmos5l_antennanp
X_00_ UserCLKo _00_/A VPWR VGND sg13cmos5l_buf_1
XFILLER_4_0 VPWR VGND sg13cmos5l_fill_2
XANTENNA__25__X FrameStrobe_O[0] VPWR VGND sg13cmos5l_antennanp
XFILLER_15_179 VPWR VGND sg13cmos5l_fill_1
XFILLER_15_124 VPWR VGND sg13cmos5l_fill_1
XANTENNA__21__A N2END[3] VPWR VGND sg13cmos5l_antennanp
XFILLER_12_138 VPWR VGND sg13cmos5l_decap_8
XFILLER_16_68 VPWR VGND sg13cmos5l_decap_4
XANTENNA__16__A N4END[0] VPWR VGND sg13cmos5l_antennanp
XFILLER_8_80 VPWR VGND sg13cmos5l_decap_8
XFILLER_4_27 VPWR VGND sg13cmos5l_fill_2
XFILLER_4_16 VPWR VGND sg13cmos5l_fill_1
XFILLER_4_134 VPWR VGND sg13cmos5l_decap_8
XFILLER_13_25 VPWR VGND sg13cmos5l_decap_8
XANTENNA__33__X FrameStrobe_O[8] VPWR VGND sg13cmos5l_antennanp
XFILLER_1_159 VPWR VGND sg13cmos5l_decap_4
XFILLER_5_70 VPWR VGND sg13cmos5l_decap_8
XANTENNA__28__X FrameStrobe_O[3] VPWR VGND sg13cmos5l_antennanp
X_76_ FrameData_O[19] FrameData[19] VPWR VGND sg13cmos5l_buf_1
XFILLER_10_37 VPWR VGND sg13cmos5l_decap_8
XANTENNA__24__A N2END[0] VPWR VGND sg13cmos5l_antennanp
X_59_ FrameData_O[2] FrameData[2] VPWR VGND sg13cmos5l_buf_1
XFILLER_2_93 VPWR VGND sg13cmos5l_decap_8
XANTENNA__19__A N2END[5] VPWR VGND sg13cmos5l_antennanp
XANTENNA__41__X FrameStrobe_O[16] VPWR VGND sg13cmos5l_antennanp
XFILLER_7_49 VPWR VGND sg13cmos5l_decap_4
XFILLER_7_16 VPWR VGND sg13cmos5l_decap_8
XFILLER_12_117 VPWR VGND sg13cmos5l_decap_8
XFILLER_16_36 VPWR VGND sg13cmos5l_decap_4
XFILLER_16_25 VPWR VGND sg13cmos5l_fill_1
XANTENNA__36__X FrameStrobe_O[11] VPWR VGND sg13cmos5l_antennanp
XFILLER_7_154 VPWR VGND sg13cmos5l_decap_8
XANTENNA__32__A FrameStrobe[7] VPWR VGND sg13cmos5l_antennanp
XFILLER_4_39 VPWR VGND sg13cmos5l_decap_8
XFILLER_4_124 VPWR VGND sg13cmos5l_fill_2
XFILLER_4_113 VPWR VGND sg13cmos5l_fill_1
XFILLER_12_0 VPWR VGND sg13cmos5l_fill_2
XANTENNA__27__A FrameStrobe[2] VPWR VGND sg13cmos5l_antennanp
XFILLER_0_160 VPWR VGND sg13cmos5l_decap_4
XANTENNA__44__X FrameStrobe_O[19] VPWR VGND sg13cmos5l_antennanp
XFILLER_14_91 VPWR VGND sg13cmos5l_decap_8
XFILLER_10_16 VPWR VGND sg13cmos5l_decap_4
X_75_ FrameData_O[18] FrameData[18] VPWR VGND sg13cmos5l_buf_1
XANTENNA__39__X FrameStrobe_O[14] VPWR VGND sg13cmos5l_antennanp
XANTENNA__40__A FrameStrobe[15] VPWR VGND sg13cmos5l_antennanp
XFILLER_4_2 VPWR VGND sg13cmos5l_fill_1
X_58_ FrameData_O[1] FrameData[1] VPWR VGND sg13cmos5l_buf_1
XANTENNA__35__A FrameStrobe[10] VPWR VGND sg13cmos5l_antennanp
XFILLER_15_115 VPWR VGND sg13cmos5l_fill_2
XFILLER_15_137 VPWR VGND sg13cmos5l_fill_2
XFILLER_16_59 VPWR VGND sg13cmos5l_decap_4
XFILLER_16_48 VPWR VGND sg13cmos5l_fill_1
XFILLER_16_15 VPWR VGND sg13cmos5l_fill_2
XANTENNA__52__X S2BEG[7] VPWR VGND sg13cmos5l_antennanp
XFILLER_7_133 VPWR VGND sg13cmos5l_decap_8
XANTENNA__47__X S2BEG[2] VPWR VGND sg13cmos5l_antennanp
XFILLER_8_9 VPWR VGND sg13cmos5l_decap_8
XANTENNA__43__A FrameStrobe[18] VPWR VGND sg13cmos5l_antennanp
XFILLER_5_50 VPWR VGND sg13cmos5l_decap_8
XANTENNA__38__A FrameStrobe[13] VPWR VGND sg13cmos5l_antennanp
XANTENNA__60__X FrameData_O[3] VPWR VGND sg13cmos5l_antennanp
XFILLER_14_70 VPWR VGND sg13cmos5l_decap_8
XFILLER_1_19 VPWR VGND sg13cmos5l_decap_8
X_74_ FrameData_O[17] FrameData[17] VPWR VGND sg13cmos5l_buf_1
XANTENNA__55__X S1BEG[2] VPWR VGND sg13cmos5l_antennanp
XFILLER_2_73 VPWR VGND sg13cmos5l_fill_2
XFILLER_2_40 VPWR VGND sg13cmos5l_decap_4
X_57_ FrameData_O[0] FrameData[0] VPWR VGND sg13cmos5l_buf_1
XANTENNA__51__A N2MID[1] VPWR VGND sg13cmos5l_antennanp
XFILLER_11_82 VPWR VGND sg13cmos5l_decap_8
XFILLER_2_0 VPWR VGND sg13cmos5l_fill_2
XANTENNA__46__A N2MID[6] VPWR VGND sg13cmos5l_antennanp
XFILLER_11_152 VPWR VGND sg13cmos5l_decap_8
XFILLER_11_174 VPWR VGND sg13cmos5l_decap_4
XFILLER_7_112 VPWR VGND sg13cmos5l_decap_8
XFILLER_8_94 VPWR VGND sg13cmos5l_decap_8
XFILLER_4_148 VPWR VGND sg13cmos5l_decap_8
XFILLER_4_126 VPWR VGND sg13cmos5l_fill_1
XFILLER_4_104 VPWR VGND sg13cmos5l_fill_2
XANTENNA__63__X FrameData_O[6] VPWR VGND sg13cmos5l_antennanp
XFILLER_3_170 VPWR VGND sg13cmos5l_fill_1
XFILLER_12_2 VPWR VGND sg13cmos5l_fill_1
XFILLER_13_39 VPWR VGND sg13cmos5l_decap_8
XANTENNA__58__X FrameData_O[1] VPWR VGND sg13cmos5l_antennanp
XFILLER_0_140 VPWR VGND sg13cmos5l_fill_2
XFILLER_5_84 VPWR VGND sg13cmos5l_decap_8
XANTENNA__54__A N1END[2] VPWR VGND sg13cmos5l_antennanp
X_73_ FrameData_O[16] FrameData[16] VPWR VGND sg13cmos5l_buf_1
XANTENNA__49__A N2MID[3] VPWR VGND sg13cmos5l_antennanp
XANTENNA__71__X FrameData_O[14] VPWR VGND sg13cmos5l_antennanp
X_56_ S1BEG[3] N1END[0] VPWR VGND sg13cmos5l_buf_1
XFILLER_2_52 VPWR VGND sg13cmos5l_fill_1
XANTENNA__66__X FrameData_O[9] VPWR VGND sg13cmos5l_antennanp
XFILLER_11_61 VPWR VGND sg13cmos5l_decap_8
XFILLER_15_117 VPWR VGND sg13cmos5l_fill_1
XFILLER_16_9 VPWR VGND sg13cmos5l_fill_2
X_39_ FrameStrobe_O[14] FrameStrobe[14] VPWR VGND sg13cmos5l_buf_1
XFILLER_16_17 VPWR VGND sg13cmos5l_fill_1
XANTENNA__62__A FrameData[5] VPWR VGND sg13cmos5l_antennanp
XFILLER_11_131 VPWR VGND sg13cmos5l_decap_8
XFILLER_7_179 VPWR VGND sg13cmos5l_fill_1
XFILLER_8_73 VPWR VGND sg13cmos5l_decap_8
XANTENNA__57__A FrameData[0] VPWR VGND sg13cmos5l_antennanp
XFILLER_13_18 VPWR VGND sg13cmos5l_decap_8
XANTENNA__74__X FrameData_O[17] VPWR VGND sg13cmos5l_antennanp
XFILLER_10_0 VPWR VGND sg13cmos5l_fill_2
XFILLER_5_30 VPWR VGND sg13cmos5l_decap_8
XANTENNA__69__X FrameData_O[12] VPWR VGND sg13cmos5l_antennanp
XANTENNA__70__A FrameData[13] VPWR VGND sg13cmos5l_antennanp
X_72_ FrameData_O[15] FrameData[15] VPWR VGND sg13cmos5l_buf_1
XANTENNA__65__A FrameData[8] VPWR VGND sg13cmos5l_antennanp
X_55_ S1BEG[2] N1END[1] VPWR VGND sg13cmos5l_buf_1
XFILLER_2_86 VPWR VGND sg13cmos5l_decap_8
XFILLER_2_75 VPWR VGND sg13cmos5l_fill_1
XFILLER_2_20 VPWR VGND sg13cmos5l_decap_4
XFILLER_11_40 VPWR VGND sg13cmos5l_decap_8
XFILLER_2_2 VPWR VGND sg13cmos5l_fill_1
XFILLER_15_129 VPWR VGND sg13cmos5l_decap_4
XANTENNA__82__X FrameData_O[25] VPWR VGND sg13cmos5l_antennanp
X_38_ FrameStrobe_O[13] FrameStrobe[13] VPWR VGND sg13cmos5l_buf_1
XFILLER_16_29 VPWR VGND sg13cmos5l_decap_4
XANTENNA__77__X FrameData_O[20] VPWR VGND sg13cmos5l_antennanp
XFILLER_11_110 VPWR VGND sg13cmos5l_decap_8
XFILLER_7_147 VPWR VGND sg13cmos5l_decap_8
XFILLER_8_52 VPWR VGND sg13cmos5l_decap_8
XFILLER_8_41 VPWR VGND sg13cmos5l_fill_1
XANTENNA__73__A FrameData[16] VPWR VGND sg13cmos5l_antennanp
XFILLER_4_117 VPWR VGND sg13cmos5l_decap_8
XFILLER_3_161 VPWR VGND sg13cmos5l_fill_1
XANTENNA__68__A FrameData[11] VPWR VGND sg13cmos5l_antennanp
XFILLER_0_131 VPWR VGND sg13cmos5l_fill_1
XFILLER_0_164 VPWR VGND sg13cmos5l_fill_1
XFILLER_5_64 VPWR VGND sg13cmos5l_fill_2
XFILLER_5_42 VPWR VGND sg13cmos5l_decap_4
XFILLER_6_9 VPWR VGND sg13cmos5l_fill_2
XANTENNA__85__X FrameData_O[28] VPWR VGND sg13cmos5l_antennanp
XFILLER_14_84 VPWR VGND sg13cmos5l_decap_8
X_71_ FrameData_O[14] FrameData[14] VPWR VGND sg13cmos5l_buf_1
XANTENNA__81__A FrameData[24] VPWR VGND sg13cmos5l_antennanp
X_54_ S1BEG[1] N1END[2] VPWR VGND sg13cmos5l_buf_1
XFILLER_15_108 VPWR VGND sg13cmos5l_decap_8
XANTENNA__76__A FrameData[19] VPWR VGND sg13cmos5l_antennanp
XFILLER_11_96 VPWR VGND sg13cmos5l_decap_8
X_37_ FrameStrobe_O[12] FrameStrobe[12] VPWR VGND sg13cmos5l_buf_1
XFILLER_0_0 VPWR VGND sg13cmos5l_fill_1
XFILLER_11_166 VPWR VGND sg13cmos5l_decap_4
XFILLER_7_126 VPWR VGND sg13cmos5l_decap_8
XANTENNA__88__X FrameData_O[31] VPWR VGND sg13cmos5l_antennanp
XANTENNA__84__A FrameData[27] VPWR VGND sg13cmos5l_antennanp
XFILLER_0_176 VPWR VGND sg13cmos5l_decap_4
XFILLER_5_98 VPWR VGND sg13cmos5l_decap_8
XANTENNA__79__A FrameData[22] VPWR VGND sg13cmos5l_antennanp
XFILLER_14_63 VPWR VGND sg13cmos5l_decap_8
X_70_ FrameData_O[13] FrameData[13] VPWR VGND sg13cmos5l_buf_1
X_53_ S1BEG[0] N1END[3] VPWR VGND sg13cmos5l_buf_1
XFILLER_2_66 VPWR VGND sg13cmos5l_decap_8
XFILLER_11_75 VPWR VGND sg13cmos5l_decap_8
XFILLER_14_131 VPWR VGND sg13cmos5l_fill_1
X_36_ FrameStrobe_O[11] FrameStrobe[11] VPWR VGND sg13cmos5l_buf_1
XFILLER_11_145 VPWR VGND sg13cmos5l_decap_8
XFILLER_11_178 VPWR VGND sg13cmos5l_fill_2
XFILLER_7_105 VPWR VGND sg13cmos5l_decap_8
XANTENNA__87__A FrameData[30] VPWR VGND sg13cmos5l_antennanp
XFILLER_8_87 VPWR VGND sg13cmos5l_decap_8
X_19_ S2BEGb[2] N2END[5] VPWR VGND sg13cmos5l_buf_1
XFILLER_3_152 VPWR VGND sg13cmos5l_decap_8
XFILLER_5_77 VPWR VGND sg13cmos5l_decap_8
XFILLER_5_66 VPWR VGND sg13cmos5l_fill_1
XFILLER_14_42 VPWR VGND sg13cmos5l_decap_8
X_52_ S2BEG[7] N2MID[0] VPWR VGND sg13cmos5l_buf_1
XFILLER_2_56 VPWR VGND sg13cmos5l_decap_8
XFILLER_2_12 VPWR VGND sg13cmos5l_decap_4
XFILLER_11_54 VPWR VGND sg13cmos5l_decap_8
X_35_ FrameStrobe_O[10] FrameStrobe[10] VPWR VGND sg13cmos5l_buf_1
XFILLER_11_124 VPWR VGND sg13cmos5l_decap_8
XFILLER_8_66 VPWR VGND sg13cmos5l_decap_8
XFILLER_8_33 VPWR VGND sg13cmos5l_fill_2
X_18_ S2BEGb[1] N2END[6] VPWR VGND sg13cmos5l_buf_1
XFILLER_4_109 VPWR VGND sg13cmos5l_decap_4
XFILLER_0_101 VPWR VGND sg13cmos5l_fill_2
XFILLER_5_23 VPWR VGND sg13cmos5l_decap_8
XFILLER_14_98 VPWR VGND sg13cmos5l_decap_8
XFILLER_4_9 VPWR VGND sg13cmos5l_fill_1
X_51_ S2BEG[6] N2MID[1] VPWR VGND sg13cmos5l_buf_1
XFILLER_2_79 VPWR VGND sg13cmos5l_decap_8
XFILLER_2_24 VPWR VGND sg13cmos5l_fill_2
XFILLER_11_33 VPWR VGND sg13cmos5l_decap_8
X_34_ FrameStrobe_O[9] FrameStrobe[9] VPWR VGND sg13cmos5l_buf_1
XFILLER_11_103 VPWR VGND sg13cmos5l_decap_8
XANTENNA__01__X S4BEG[0] VPWR VGND sg13cmos5l_antennanp
XFILLER_8_45 VPWR VGND sg13cmos5l_decap_8
XFILLER_8_23 VPWR VGND sg13cmos5l_decap_8
X_17_ S2BEGb[0] N2END[7] VPWR VGND sg13cmos5l_buf_1
XFILLER_6_162 VPWR VGND sg13cmos5l_fill_2
XFILLER_0_135 VPWR VGND sg13cmos5l_fill_1
XFILLER_5_57 VPWR VGND sg13cmos5l_decap_8
XFILLER_5_46 VPWR VGND sg13cmos5l_fill_1
XFILLER_14_22 VPWR VGND sg13cmos5l_decap_8
XFILLER_14_33 VPWR VGND sg13cmos5l_decap_4
XFILLER_14_77 VPWR VGND sg13cmos5l_decap_8
XANTENNA__04__X S4BEG[3] VPWR VGND sg13cmos5l_antennanp
X_50_ S2BEG[5] N2MID[2] VPWR VGND sg13cmos5l_buf_1
XFILLER_9_0 VPWR VGND sg13cmos5l_fill_1
XFILLER_2_36 VPWR VGND sg13cmos5l_fill_1
XANTENNA__00__A clkload0/A VPWR VGND sg13cmos5l_antennanp
XFILLER_11_89 VPWR VGND sg13cmos5l_decap_8
XFILLER_14_112 VPWR VGND sg13cmos5l_decap_8
XFILLER_14_123 VPWR VGND sg13cmos5l_fill_1
X_33_ FrameStrobe_O[8] FrameStrobe[8] VPWR VGND sg13cmos5l_buf_1
XFILLER_3_90 VPWR VGND sg13cmos5l_fill_2
XFILLER_11_159 VPWR VGND sg13cmos5l_decap_8
XFILLER_7_119 VPWR VGND sg13cmos5l_decap_8
XFILLER_10_170 VPWR VGND sg13cmos5l_fill_1
X_16_ S4BEG[15] N4END[0] VPWR VGND sg13cmos5l_buf_1
XFILLER_6_141 VPWR VGND sg13cmos5l_decap_8
XANTENNA__12__X S4BEG[11] VPWR VGND sg13cmos5l_antennanp
XFILLER_3_177 VPWR VGND sg13cmos5l_fill_2
XFILLER_3_133 VPWR VGND sg13cmos5l_fill_2
XANTENNA__07__X S4BEG[6] VPWR VGND sg13cmos5l_antennanp
XFILLER_0_114 VPWR VGND sg13cmos5l_fill_2
XANTENNA__03__A N4END[13] VPWR VGND sg13cmos5l_antennanp
XFILLER_14_56 VPWR VGND sg13cmos5l_decap_8
XFILLER_6_90 VPWR VGND sg13cmos5l_fill_1
XANTENNA__20__X S2BEGb[3] VPWR VGND sg13cmos5l_antennanp
XFILLER_2_48 VPWR VGND sg13cmos5l_decap_4
XANTENNA__15__X S4BEG[14] VPWR VGND sg13cmos5l_antennanp
XFILLER_11_68 VPWR VGND sg13cmos5l_decap_8
XFILLER_14_135 VPWR VGND sg13cmos5l_fill_2
XFILLER_14_146 VPWR VGND sg13cmos5l_fill_2
XFILLER_14_179 VPWR VGND sg13cmos5l_fill_1
X_32_ FrameStrobe_O[7] FrameStrobe[7] VPWR VGND sg13cmos5l_buf_1
XFILLER_9_161 VPWR VGND sg13cmos5l_decap_8
XANTENNA__11__A N4END[5] VPWR VGND sg13cmos5l_antennanp
XFILLER_11_138 VPWR VGND sg13cmos5l_decap_8
X_15_ S4BEG[14] N4END[1] VPWR VGND sg13cmos5l_buf_1
XFILLER_6_164 VPWR VGND sg13cmos5l_fill_1
XFILLER_6_120 VPWR VGND sg13cmos5l_decap_8
XANTENNA__06__A N4END[10] VPWR VGND sg13cmos5l_antennanp
XANTENNA__23__X S2BEGb[6] VPWR VGND sg13cmos5l_antennanp
XFILLER_5_37 VPWR VGND sg13cmos5l_fill_1
XANTENNA__18__X S2BEGb[1] VPWR VGND sg13cmos5l_antennanp
XANTENNA__14__A N4END[2] VPWR VGND sg13cmos5l_antennanp
XFILLER_2_16 VPWR VGND sg13cmos5l_fill_1
XANTENNA__09__A N4END[7] VPWR VGND sg13cmos5l_antennanp
XFILLER_11_47 VPWR VGND sg13cmos5l_decap_8
XANTENNA__31__X FrameStrobe_O[6] VPWR VGND sg13cmos5l_antennanp
X_31_ FrameStrobe_O[6] FrameStrobe[6] VPWR VGND sg13cmos5l_buf_1
XFILLER_9_140 VPWR VGND sg13cmos5l_decap_8
XFILLER_11_117 VPWR VGND sg13cmos5l_decap_8
XANTENNA__26__X FrameStrobe_O[1] VPWR VGND sg13cmos5l_antennanp
XFILLER_8_59 VPWR VGND sg13cmos5l_decap_8
X_14_ S4BEG[13] N4END[2] VPWR VGND sg13cmos5l_buf_1
XANTENNA__22__A N2END[2] VPWR VGND sg13cmos5l_antennanp
XFILLER_3_179 VPWR VGND sg13cmos5l_fill_1
XFILLER_0_82 VPWR VGND sg13cmos5l_fill_2
XANTENNA__17__A N2END[7] VPWR VGND sg13cmos5l_antennanp
XFILLER_0_116 VPWR VGND sg13cmos5l_fill_1
XFILLER_9_91 VPWR VGND sg13cmos5l_decap_8
XFILLER_5_16 VPWR VGND sg13cmos5l_decap_8
XANTENNA__34__X FrameStrobe_O[9] VPWR VGND sg13cmos5l_antennanp
XANTENNA__29__X FrameStrobe_O[4] VPWR VGND sg13cmos5l_antennanp
XANTENNA__30__A FrameStrobe[5] VPWR VGND sg13cmos5l_antennanp
XANTENNA__25__A FrameStrobe[0] VPWR VGND sg13cmos5l_antennanp
XFILLER_11_15 VPWR VGND sg13cmos5l_fill_1
XFILLER_11_26 VPWR VGND sg13cmos5l_decap_8
X_30_ FrameStrobe_O[5] FrameStrobe[5] VPWR VGND sg13cmos5l_buf_1
XFILLER_7_0 VPWR VGND sg13cmos5l_fill_2
XANTENNA__42__X FrameStrobe_O[17] VPWR VGND sg13cmos5l_antennanp
XFILLER_8_16 VPWR VGND sg13cmos5l_decap_8
XFILLER_6_155 VPWR VGND sg13cmos5l_decap_8
X_13_ S4BEG[12] N4END[3] VPWR VGND sg13cmos5l_buf_1
XFILLER_3_103 VPWR VGND sg13cmos5l_decap_4
XANTENNA__37__X FrameStrobe_O[12] VPWR VGND sg13cmos5l_antennanp
XFILLER_9_70 VPWR VGND sg13cmos5l_decap_8
XANTENNA__33__A FrameStrobe[8] VPWR VGND sg13cmos5l_antennanp
XFILLER_14_15 VPWR VGND sg13cmos5l_decap_8
XFILLER_14_37 VPWR VGND sg13cmos5l_fill_2
XANTENNA__28__A FrameStrobe[3] VPWR VGND sg13cmos5l_antennanp
XANTENNA__50__X S2BEG[5] VPWR VGND sg13cmos5l_antennanp
XANTENNA__45__X S2BEG[0] VPWR VGND sg13cmos5l_antennanp
XFILLER_2_29 VPWR VGND sg13cmos5l_decap_8
XFILLER_15_80 VPWR VGND sg13cmos5l_decap_8
XANTENNA__41__A FrameStrobe[16] VPWR VGND sg13cmos5l_antennanp
XFILLER_14_105 VPWR VGND sg13cmos5l_decap_8
XFILLER_14_127 VPWR VGND sg13cmos5l_decap_4
XFILLER_13_160 VPWR VGND sg13cmos5l_decap_4
XFILLER_9_175 VPWR VGND sg13cmos5l_decap_4
XFILLER_3_83 VPWR VGND sg13cmos5l_decap_8
XFILLER_3_61 VPWR VGND sg13cmos5l_decap_8
XANTENNA__36__A FrameStrobe[11] VPWR VGND sg13cmos5l_antennanp
XFILLER_8_39 VPWR VGND sg13cmos5l_fill_2
XFILLER_10_163 VPWR VGND sg13cmos5l_decap_8
XFILLER_10_174 VPWR VGND sg13cmos5l_decap_4
X_12_ S4BEG[11] N4END[4] VPWR VGND sg13cmos5l_buf_1
XFILLER_6_134 VPWR VGND sg13cmos5l_decap_8
XFILLER_3_159 VPWR VGND sg13cmos5l_fill_2
XFILLER_3_126 VPWR VGND sg13cmos5l_decap_8
XANTENNA__53__X S1BEG[0] VPWR VGND sg13cmos5l_antennanp
XFILLER_2_170 VPWR VGND sg13cmos5l_fill_1
XFILLER_0_107 VPWR VGND sg13cmos5l_decap_4
XFILLER_0_51 VPWR VGND sg13cmos5l_fill_2
XFILLER_0_62 VPWR VGND sg13cmos5l_fill_2
XANTENNA__48__X S2BEG[3] VPWR VGND sg13cmos5l_antennanp
XFILLER_15_0 VPWR VGND sg13cmos5l_fill_1
XANTENNA__44__A FrameStrobe[19] VPWR VGND sg13cmos5l_antennanp
XFILLER_14_49 VPWR VGND sg13cmos5l_decap_8
XFILLER_6_83 VPWR VGND sg13cmos5l_decap_8
XANTENNA__39__A FrameStrobe[14] VPWR VGND sg13cmos5l_antennanp
XANTENNA__61__X FrameData_O[4] VPWR VGND sg13cmos5l_antennanp
XFILLER_7_2 VPWR VGND sg13cmos5l_fill_1
XANTENNA__56__X S1BEG[3] VPWR VGND sg13cmos5l_antennanp
X_88_ FrameData_O[31] FrameData[31] VPWR VGND sg13cmos5l_buf_1
XFILLER_9_154 VPWR VGND sg13cmos5l_decap_8
XFILLER_3_40 VPWR VGND sg13cmos5l_decap_8
XANTENNA__52__A N2MID[0] VPWR VGND sg13cmos5l_antennanp
XFILLER_10_142 VPWR VGND sg13cmos5l_decap_8
XFILLER_12_82 VPWR VGND sg13cmos5l_decap_8
X_11_ S4BEG[10] N4END[5] VPWR VGND sg13cmos5l_buf_1
XANTENNA__47__A N2MID[5] VPWR VGND sg13cmos5l_antennanp
XFILLER_3_138 VPWR VGND sg13cmos5l_decap_4
XFILLER_0_41 VPWR VGND sg13cmos5l_fill_2
XFILLER_0_74 VPWR VGND sg13cmos5l_decap_4
XANTENNA__64__X FrameData_O[7] VPWR VGND sg13cmos5l_antennanp
XANTENNA__59__X FrameData_O[2] VPWR VGND sg13cmos5l_antennanp
XANTENNA__60__A FrameData[3] VPWR VGND sg13cmos5l_antennanp
XFILLER_6_95 VPWR VGND sg13cmos5l_decap_4
XFILLER_6_62 VPWR VGND sg13cmos5l_decap_8
XANTENNA__55__A N1END[1] VPWR VGND sg13cmos5l_antennanp
XFILLER_15_60 VPWR VGND sg13cmos5l_fill_1
XANTENNA__72__X FrameData_O[15] VPWR VGND sg13cmos5l_antennanp
XFILLER_9_133 VPWR VGND sg13cmos5l_decap_8
X_87_ FrameData_O[30] FrameData[30] VPWR VGND sg13cmos5l_buf_1
XFILLER_3_96 VPWR VGND sg13cmos5l_decap_8
XANTENNA__67__X FrameData_O[10] VPWR VGND sg13cmos5l_antennanp
XFILLER_10_121 VPWR VGND sg13cmos5l_decap_8
XFILLER_12_61 VPWR VGND sg13cmos5l_decap_8
X_10_ S4BEG[9] N4END[6] VPWR VGND sg13cmos5l_buf_1
XFILLER_6_169 VPWR VGND sg13cmos5l_fill_2
XFILLER_5_0 VPWR VGND sg13cmos5l_fill_2
XANTENNA__63__A FrameData[6] VPWR VGND sg13cmos5l_antennanp
XFILLER_0_97 VPWR VGND sg13cmos5l_fill_1
XFILLER_9_84 VPWR VGND sg13cmos5l_decap_8
XANTENNA__58__A FrameData[1] VPWR VGND sg13cmos5l_antennanp
XANTENNA__80__X FrameData_O[23] VPWR VGND sg13cmos5l_antennanp
XFILLER_14_29 VPWR VGND sg13cmos5l_fill_1
XANTENNA__75__X FrameData_O[18] VPWR VGND sg13cmos5l_antennanp
XFILLER_6_41 VPWR VGND sg13cmos5l_decap_8
XFILLER_6_30 VPWR VGND sg13cmos5l_fill_1
XFILLER_15_50 VPWR VGND sg13cmos5l_decap_4
XANTENNA__71__A FrameData[14] VPWR VGND sg13cmos5l_antennanp
XFILLER_15_94 VPWR VGND sg13cmos5l_decap_8
XFILLER_11_19 VPWR VGND sg13cmos5l_decap_8
XFILLER_14_119 VPWR VGND sg13cmos5l_decap_4
XANTENNA__66__A FrameData[9] VPWR VGND sg13cmos5l_antennanp
XFILLER_9_112 VPWR VGND sg13cmos5l_decap_8
X_86_ FrameData_O[29] FrameData[29] VPWR VGND sg13cmos5l_buf_1
XFILLER_3_75 VPWR VGND sg13cmos5l_decap_4
XFILLER_10_100 VPWR VGND sg13cmos5l_decap_8
XFILLER_12_40 VPWR VGND sg13cmos5l_decap_8
XFILLER_6_148 VPWR VGND sg13cmos5l_decap_8
XFILLER_6_104 VPWR VGND sg13cmos5l_decap_4
XANTENNA__83__X FrameData_O[26] VPWR VGND sg13cmos5l_antennanp
X_69_ FrameData_O[12] FrameData[12] VPWR VGND sg13cmos5l_buf_1
XFILLER_3_107 VPWR VGND sg13cmos5l_fill_2
XANTENNA__78__X FrameData_O[21] VPWR VGND sg13cmos5l_antennanp
XFILLER_0_87 VPWR VGND sg13cmos5l_decap_8
XFILLER_2_151 VPWR VGND sg13cmos5l_decap_8
Xclkbuf_0_UserCLK clkbuf_0_UserCLK/X UserCLK VPWR VGND sg13cmos5l_buf_16
XFILLER_9_63 VPWR VGND sg13cmos5l_decap_8
XANTENNA__74__A FrameData[17] VPWR VGND sg13cmos5l_antennanp
XANTENNA__69__A FrameData[12] VPWR VGND sg13cmos5l_antennanp
XFILLER_13_0 VPWR VGND sg13cmos5l_fill_1
XANTENNA__86__X FrameData_O[29] VPWR VGND sg13cmos5l_antennanp
XFILLER_15_73 VPWR VGND sg13cmos5l_decap_8
XANTENNA__82__A FrameData[25] VPWR VGND sg13cmos5l_antennanp
XFILLER_13_142 VPWR VGND sg13cmos5l_decap_8
XFILLER_13_153 VPWR VGND sg13cmos5l_decap_8
XFILLER_13_164 VPWR VGND sg13cmos5l_fill_1
X_85_ FrameData_O[28] FrameData[28] VPWR VGND sg13cmos5l_buf_1
XFILLER_9_179 VPWR VGND sg13cmos5l_fill_1
XFILLER_9_168 VPWR VGND sg13cmos5l_decap_8
XFILLER_3_54 VPWR VGND sg13cmos5l_decap_8
XFILLER_10_156 VPWR VGND sg13cmos5l_decap_8
XFILLER_10_178 VPWR VGND sg13cmos5l_fill_2
XFILLER_12_96 VPWR VGND sg13cmos5l_decap_8
XFILLER_6_127 VPWR VGND sg13cmos5l_decap_8
XANTENNA__77__A FrameData[20] VPWR VGND sg13cmos5l_antennanp
XFILLER_5_2 VPWR VGND sg13cmos5l_fill_1
X_68_ FrameData_O[11] FrameData[11] VPWR VGND sg13cmos5l_buf_1
XFILLER_3_119 VPWR VGND sg13cmos5l_decap_8
XFILLER_9_42 VPWR VGND sg13cmos5l_decap_8
XANTENNA__85__A FrameData[28] VPWR VGND sg13cmos5l_antennanp
XFILLER_6_76 VPWR VGND sg13cmos5l_decap_8
XFILLER_15_41 VPWR VGND sg13cmos5l_decap_4
XFILLER_13_121 VPWR VGND sg13cmos5l_decap_8
X_84_ FrameData_O[27] FrameData[27] VPWR VGND sg13cmos5l_buf_1
XFILLER_9_147 VPWR VGND sg13cmos5l_decap_8
XFILLER_3_33 VPWR VGND sg13cmos5l_decap_8
XFILLER_10_135 VPWR VGND sg13cmos5l_decap_8
XFILLER_12_75 VPWR VGND sg13cmos5l_decap_8
X_67_ FrameData_O[10] FrameData[10] VPWR VGND sg13cmos5l_buf_1
XANTENNA__88__A FrameData[31] VPWR VGND sg13cmos5l_antennanp
XFILLER_3_0 VPWR VGND sg13cmos5l_fill_2
XFILLER_0_56 VPWR VGND sg13cmos5l_fill_2
XFILLER_0_67 VPWR VGND sg13cmos5l_fill_2
XFILLER_0_78 VPWR VGND sg13cmos5l_fill_1
XFILLER_9_98 VPWR VGND sg13cmos5l_decap_8
XFILLER_6_99 VPWR VGND sg13cmos5l_fill_2
XFILLER_6_55 VPWR VGND sg13cmos5l_decap_8
XFILLER_16_163 VPWR VGND sg13cmos5l_fill_2
.ends
