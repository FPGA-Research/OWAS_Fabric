* NGSPICE file created from S_term_IO_W.ext - technology: ihp-sg13cmos5l

* Black-box entry subcircuit for sg13cmos5l_decap_8 abstract view
.subckt sg13cmos5l_decap_8 VDD VSS
.ends

* Black-box entry subcircuit for sg13cmos5l_buf_1 abstract view
.subckt sg13cmos5l_buf_1 X A VDD VSS
.ends

* Black-box entry subcircuit for sg13cmos5l_fill_1 abstract view
.subckt sg13cmos5l_fill_1 VDD VSS
.ends

* Black-box entry subcircuit for sg13cmos5l_fill_2 abstract view
.subckt sg13cmos5l_fill_2 VDD VSS
.ends

* Black-box entry subcircuit for sg13cmos5l_decap_4 abstract view
.subckt sg13cmos5l_decap_4 VDD VSS
.ends

* Black-box entry subcircuit for sg13cmos5l_antennanp abstract view
.subckt sg13cmos5l_antennanp A VDD VSS
.ends

* Black-box entry subcircuit for sg13cmos5l_inv_1 abstract view
.subckt sg13cmos5l_inv_1 Y A VDD VSS
.ends

* Black-box entry subcircuit for sg13cmos5l_buf_16 abstract view
.subckt sg13cmos5l_buf_16 X A VDD VSS
.ends

.subckt S_term_IO_W FrameData[0] FrameData[10] FrameData[11] FrameData[12] FrameData[13]
+ FrameData[14] FrameData[15] FrameData[16] FrameData[17] FrameData[18] FrameData[19]
+ FrameData[1] FrameData[20] FrameData[21] FrameData[22] FrameData[23] FrameData[24]
+ FrameData[25] FrameData[26] FrameData[27] FrameData[28] FrameData[29] FrameData[2]
+ FrameData[30] FrameData[31] FrameData[3] FrameData[4] FrameData[5] FrameData[6]
+ FrameData[7] FrameData[8] FrameData[9] FrameData_O[0] FrameData_O[10] FrameData_O[11]
+ FrameData_O[12] FrameData_O[13] FrameData_O[14] FrameData_O[15] FrameData_O[16]
+ FrameData_O[17] FrameData_O[18] FrameData_O[19] FrameData_O[1] FrameData_O[20] FrameData_O[21]
+ FrameData_O[22] FrameData_O[23] FrameData_O[24] FrameData_O[25] FrameData_O[26]
+ FrameData_O[27] FrameData_O[28] FrameData_O[29] FrameData_O[2] FrameData_O[30] FrameData_O[31]
+ FrameData_O[3] FrameData_O[4] FrameData_O[5] FrameData_O[6] FrameData_O[7] FrameData_O[8]
+ FrameData_O[9] FrameStrobe[0] FrameStrobe[10] FrameStrobe[11] FrameStrobe[12] FrameStrobe[13]
+ FrameStrobe[14] FrameStrobe[15] FrameStrobe[16] FrameStrobe[17] FrameStrobe[18]
+ FrameStrobe[19] FrameStrobe[1] FrameStrobe[2] FrameStrobe[3] FrameStrobe[4] FrameStrobe[5]
+ FrameStrobe[6] FrameStrobe[7] FrameStrobe[8] FrameStrobe[9] FrameStrobe_O[0] FrameStrobe_O[10]
+ FrameStrobe_O[11] FrameStrobe_O[12] FrameStrobe_O[13] FrameStrobe_O[14] FrameStrobe_O[15]
+ FrameStrobe_O[16] FrameStrobe_O[17] FrameStrobe_O[18] FrameStrobe_O[19] FrameStrobe_O[1]
+ FrameStrobe_O[2] FrameStrobe_O[3] FrameStrobe_O[4] FrameStrobe_O[5] FrameStrobe_O[6]
+ FrameStrobe_O[7] FrameStrobe_O[8] FrameStrobe_O[9] N1BEG[0] N1BEG[1] N1BEG[2] N1BEG[3]
+ N2BEG[0] N2BEG[1] N2BEG[2] N2BEG[3] N2BEG[4] N2BEG[5] N2BEG[6] N2BEG[7] N2BEGb[0]
+ N2BEGb[1] N2BEGb[2] N2BEGb[3] N2BEGb[4] N2BEGb[5] N2BEGb[6] N2BEGb[7] N4BEG[0] N4BEG[10]
+ N4BEG[11] N4BEG[12] N4BEG[13] N4BEG[14] N4BEG[15] N4BEG[1] N4BEG[2] N4BEG[3] N4BEG[4]
+ N4BEG[5] N4BEG[6] N4BEG[7] N4BEG[8] N4BEG[9] S1END[0] S1END[1] S1END[2] S1END[3]
+ S2END[0] S2END[1] S2END[2] S2END[3] S2END[4] S2END[5] S2END[6] S2END[7] S2MID[0]
+ S2MID[1] S2MID[2] S2MID[3] S2MID[4] S2MID[5] S2MID[6] S2MID[7] S4END[0] S4END[10]
+ S4END[11] S4END[12] S4END[13] S4END[14] S4END[15] S4END[1] S4END[2] S4END[3] S4END[4]
+ S4END[5] S4END[6] S4END[7] S4END[8] S4END[9] UserCLK UserCLKo VGND VPWR
XFILLER_13_122 VPWR VGND sg13cmos5l_decap_8
XFILLER_13_155 VPWR VGND sg13cmos5l_decap_8
X_83_ FrameData_O[26] FrameData[26] VPWR VGND sg13cmos5l_buf_1
XFILLER_9_126 VPWR VGND sg13cmos5l_decap_8
XFILLER_9_115 VPWR VGND sg13cmos5l_fill_1
XFILLER_9_104 VPWR VGND sg13cmos5l_decap_8
XFILLER_3_34 VPWR VGND sg13cmos5l_decap_8
XFILLER_10_103 VPWR VGND sg13cmos5l_fill_2
XFILLER_12_65 VPWR VGND sg13cmos5l_decap_8
XFILLER_12_76 VPWR VGND sg13cmos5l_fill_2
XFILLER_6_129 VPWR VGND sg13cmos5l_decap_8
X_66_ FrameData_O[9] FrameData[9] VPWR VGND sg13cmos5l_buf_1
XFILLER_9_55 VPWR VGND sg13cmos5l_decap_8
XFILLER_2_154 VPWR VGND sg13cmos5l_decap_8
X_49_ FrameStrobe_O[12] FrameStrobe[12] VPWR VGND sg13cmos5l_buf_1
XFILLER_7_213 VPWR VGND sg13cmos5l_decap_8
XFILLER_6_89 VPWR VGND sg13cmos5l_decap_4
XFILLER_6_23 VPWR VGND sg13cmos5l_decap_8
XFILLER_13_101 VPWR VGND sg13cmos5l_decap_8
XFILLER_13_134 VPWR VGND sg13cmos5l_decap_8
XFILLER_3_13 VPWR VGND sg13cmos5l_decap_8
X_82_ FrameData_O[25] FrameData[25] VPWR VGND sg13cmos5l_buf_1
XFILLER_12_44 VPWR VGND sg13cmos5l_decap_8
X_65_ FrameData_O[8] FrameData[8] VPWR VGND sg13cmos5l_buf_1
XFILLER_5_185 VPWR VGND sg13cmos5l_decap_8
XANTENNA__02__X N4BEG[2] VPWR VGND sg13cmos5l_antennanp
XFILLER_0_36 VPWR VGND sg13cmos5l_fill_2
XFILLER_9_34 VPWR VGND sg13cmos5l_decap_8
XFILLER_2_133 VPWR VGND sg13cmos5l_decap_8
X_48_ FrameStrobe_O[11] FrameStrobe[11] VPWR VGND sg13cmos5l_buf_1
XFILLER_11_221 VPWR VGND sg13cmos5l_fill_2
XFILLER_6_79 VPWR VGND sg13cmos5l_fill_2
XFILLER_15_66 VPWR VGND sg13cmos5l_fill_2
XANTENNA__10__X N4BEG[10] VPWR VGND sg13cmos5l_antennanp
XFILLER_15_77 VPWR VGND sg13cmos5l_fill_1
XFILLER_16_110 VPWR VGND sg13cmos5l_fill_1
XANTENNA__05__X N4BEG[5] VPWR VGND sg13cmos5l_antennanp
X_81_ FrameData_O[24] FrameData[24] VPWR VGND sg13cmos5l_buf_1
XFILLER_8_194 VPWR VGND sg13cmos5l_decap_8
XFILLER_3_69 VPWR VGND sg13cmos5l_decap_8
XANTENNA__01__A S4END[14] VPWR VGND sg13cmos5l_antennanp
XFILLER_10_149 VPWR VGND sg13cmos5l_decap_8
XFILLER_12_23 VPWR VGND sg13cmos5l_decap_8
XFILLER_5_6 VPWR VGND sg13cmos5l_decap_8
X_64_ FrameData_O[7] FrameData[7] VPWR VGND sg13cmos5l_buf_1
XFILLER_5_164 VPWR VGND sg13cmos5l_decap_8
XFILLER_9_13 VPWR VGND sg13cmos5l_decap_8
XFILLER_2_189 VPWR VGND sg13cmos5l_decap_8
XFILLER_2_112 VPWR VGND sg13cmos5l_decap_8
X_47_ FrameStrobe_O[10] FrameStrobe[10] VPWR VGND sg13cmos5l_buf_1
XANTENNA__13__X N4BEG[13] VPWR VGND sg13cmos5l_antennanp
XFILLER_11_200 VPWR VGND sg13cmos5l_decap_8
XFILLER_15_8 VPWR VGND sg13cmos5l_fill_1
XFILLER_1_0 VPWR VGND sg13cmos5l_fill_1
XANTENNA__08__X N4BEG[8] VPWR VGND sg13cmos5l_antennanp
XFILLER_6_58 VPWR VGND sg13cmos5l_decap_8
XANTENNA__04__A S4END[11] VPWR VGND sg13cmos5l_antennanp
XFILLER_15_45 VPWR VGND sg13cmos5l_fill_1
XFILLER_16_188 VPWR VGND sg13cmos5l_decap_8
XFILLER_13_169 VPWR VGND sg13cmos5l_decap_8
XFILLER_7_90 VPWR VGND sg13cmos5l_decap_8
XANTENNA__21__X N2BEGb[5] VPWR VGND sg13cmos5l_antennanp
X_80_ FrameData_O[23] FrameData[23] VPWR VGND sg13cmos5l_buf_1
XFILLER_8_173 VPWR VGND sg13cmos5l_decap_8
XFILLER_3_48 VPWR VGND sg13cmos5l_decap_8
XFILLER_10_128 VPWR VGND sg13cmos5l_decap_8
XANTENNA__16__X N2BEGb[0] VPWR VGND sg13cmos5l_antennanp
XFILLER_5_143 VPWR VGND sg13cmos5l_decap_8
X_63_ FrameData_O[6] FrameData[6] VPWR VGND sg13cmos5l_buf_1
XANTENNA__12__A S4END[3] VPWR VGND sg13cmos5l_antennanp
XFILLER_15_209 VPWR VGND sg13cmos5l_fill_2
XFILLER_2_168 VPWR VGND sg13cmos5l_decap_8
X_46_ FrameStrobe_O[9] FrameStrobe[9] VPWR VGND sg13cmos5l_buf_1
XFILLER_9_69 VPWR VGND sg13cmos5l_decap_8
XANTENNA__07__A S4END[8] VPWR VGND sg13cmos5l_antennanp
XFILLER_11_223 VPWR VGND sg13cmos5l_fill_1
X_29_ N2BEG[5] S2MID[2] VPWR VGND sg13cmos5l_buf_1
XFILLER_4_208 VPWR VGND sg13cmos5l_decap_8
XANTENNA__24__X N2BEG[0] VPWR VGND sg13cmos5l_antennanp
XFILLER_6_37 VPWR VGND sg13cmos5l_decap_8
XANTENNA__19__X N2BEGb[3] VPWR VGND sg13cmos5l_antennanp
XANTENNA__20__A S2END[3] VPWR VGND sg13cmos5l_antennanp
XFILLER_15_13 VPWR VGND sg13cmos5l_fill_1
XFILLER_16_101 VPWR VGND sg13cmos5l_fill_1
XFILLER_13_115 VPWR VGND sg13cmos5l_decap_8
XANTENNA__15__A S4END[0] VPWR VGND sg13cmos5l_antennanp
XFILLER_13_148 VPWR VGND sg13cmos5l_decap_8
XFILLER_3_27 VPWR VGND sg13cmos5l_decap_8
XFILLER_8_152 VPWR VGND sg13cmos5l_decap_8
XANTENNA__32__X N1BEG[0] VPWR VGND sg13cmos5l_antennanp
XFILLER_12_58 VPWR VGND sg13cmos5l_decap_8
XFILLER_5_122 VPWR VGND sg13cmos5l_decap_8
X_62_ FrameData_O[5] FrameData[5] VPWR VGND sg13cmos5l_buf_1
XFILLER_5_199 VPWR VGND sg13cmos5l_decap_8
XFILLER_2_147 VPWR VGND sg13cmos5l_decap_8
XANTENNA__27__X N2BEG[3] VPWR VGND sg13cmos5l_antennanp
XFILLER_9_48 VPWR VGND sg13cmos5l_decap_8
XFILLER_1_180 VPWR VGND sg13cmos5l_fill_2
X_45_ FrameStrobe_O[8] FrameStrobe[8] VPWR VGND sg13cmos5l_buf_1
XANTENNA__23__A S2END[0] VPWR VGND sg13cmos5l_antennanp
Xclkload0 clkload0/Y clkload0/A VPWR VGND sg13cmos5l_inv_1
XFILLER_7_206 VPWR VGND sg13cmos5l_decap_8
X_28_ N2BEG[4] S2MID[3] VPWR VGND sg13cmos5l_buf_1
XANTENNA__18__A S2END[5] VPWR VGND sg13cmos5l_antennanp
XFILLER_6_16 VPWR VGND sg13cmos5l_decap_8
XANTENNA__40__X FrameStrobe_O[3] VPWR VGND sg13cmos5l_antennanp
XANTENNA__35__X N1BEG[3] VPWR VGND sg13cmos5l_antennanp
XFILLER_0_223 VPWR VGND sg13cmos5l_fill_1
XFILLER_16_124 VPWR VGND sg13cmos5l_fill_1
XANTENNA__31__A S2MID[0] VPWR VGND sg13cmos5l_antennanp
XFILLER_12_193 VPWR VGND sg13cmos5l_decap_8
XFILLER_8_131 VPWR VGND sg13cmos5l_decap_8
XANTENNA__26__A S2MID[5] VPWR VGND sg13cmos5l_antennanp
XFILLER_12_37 VPWR VGND sg13cmos5l_decap_8
X_61_ FrameData_O[4] FrameData[4] VPWR VGND sg13cmos5l_buf_1
XFILLER_5_178 VPWR VGND sg13cmos5l_decap_8
XANTENNA__43__X FrameStrobe_O[6] VPWR VGND sg13cmos5l_antennanp
XFILLER_13_80 VPWR VGND sg13cmos5l_decap_8
XFILLER_9_27 VPWR VGND sg13cmos5l_decap_8
XFILLER_3_6 VPWR VGND sg13cmos5l_decap_8
XFILLER_2_126 VPWR VGND sg13cmos5l_decap_8
X_44_ FrameStrobe_O[7] FrameStrobe[7] VPWR VGND sg13cmos5l_buf_1
XANTENNA__38__X FrameStrobe_O[1] VPWR VGND sg13cmos5l_antennanp
XFILLER_11_214 VPWR VGND sg13cmos5l_decap_8
X_27_ N2BEG[3] S2MID[4] VPWR VGND sg13cmos5l_buf_1
XANTENNA__34__A S1END[1] VPWR VGND sg13cmos5l_antennanp
XFILLER_15_26 VPWR VGND sg13cmos5l_fill_1
XANTENNA__29__A S2MID[2] VPWR VGND sg13cmos5l_antennanp
XANTENNA__51__X FrameStrobe_O[14] VPWR VGND sg13cmos5l_antennanp
XFILLER_16_169 VPWR VGND sg13cmos5l_fill_2
XFILLER_16_136 VPWR VGND sg13cmos5l_fill_2
XANTENNA__46__X FrameStrobe_O[9] VPWR VGND sg13cmos5l_antennanp
XFILLER_12_172 VPWR VGND sg13cmos5l_decap_8
XFILLER_8_187 VPWR VGND sg13cmos5l_decap_8
XFILLER_8_110 VPWR VGND sg13cmos5l_decap_8
XFILLER_10_109 VPWR VGND sg13cmos5l_fill_2
XFILLER_12_16 VPWR VGND sg13cmos5l_decap_8
XANTENNA__42__A FrameStrobe[5] VPWR VGND sg13cmos5l_antennanp
X_60_ FrameData_O[3] FrameData[3] VPWR VGND sg13cmos5l_buf_1
XFILLER_5_157 VPWR VGND sg13cmos5l_decap_8
XFILLER_5_102 VPWR VGND sg13cmos5l_decap_4
XFILLER_4_94 VPWR VGND sg13cmos5l_decap_8
XFILLER_4_83 VPWR VGND sg13cmos5l_decap_4
XANTENNA__37__A FrameStrobe[0] VPWR VGND sg13cmos5l_antennanp
XFILLER_2_105 VPWR VGND sg13cmos5l_decap_8
X_43_ FrameStrobe_O[6] FrameStrobe[6] VPWR VGND sg13cmos5l_buf_1
XANTENNA__54__X FrameStrobe_O[17] VPWR VGND sg13cmos5l_antennanp
X_26_ N2BEG[2] S2MID[5] VPWR VGND sg13cmos5l_buf_1
XANTENNA__49__X FrameStrobe_O[12] VPWR VGND sg13cmos5l_antennanp
XANTENNA__50__A FrameStrobe[13] VPWR VGND sg13cmos5l_antennanp
XFILLER_3_222 VPWR VGND sg13cmos5l_fill_2
X_09_ N4BEG[9] S4END[6] VPWR VGND sg13cmos5l_buf_1
XANTENNA__45__A FrameStrobe[8] VPWR VGND sg13cmos5l_antennanp
XFILLER_11_6 VPWR VGND sg13cmos5l_decap_8
XFILLER_15_181 VPWR VGND sg13cmos5l_decap_8
XFILLER_13_129 VPWR VGND sg13cmos5l_fill_1
XFILLER_7_83 VPWR VGND sg13cmos5l_decap_8
XANTENNA__62__X FrameData_O[5] VPWR VGND sg13cmos5l_antennanp
XFILLER_12_151 VPWR VGND sg13cmos5l_decap_8
XFILLER_8_166 VPWR VGND sg13cmos5l_decap_8
XANTENNA__57__X FrameData_O[0] VPWR VGND sg13cmos5l_antennanp
XFILLER_5_136 VPWR VGND sg13cmos5l_decap_8
XFILLER_4_62 VPWR VGND sg13cmos5l_decap_8
XFILLER_4_180 VPWR VGND sg13cmos5l_decap_8
XANTENNA__53__A FrameStrobe[16] VPWR VGND sg13cmos5l_antennanp
X_42_ FrameStrobe_O[5] FrameStrobe[5] VPWR VGND sg13cmos5l_buf_1
XFILLER_1_161 VPWR VGND sg13cmos5l_fill_1
XANTENNA__48__A FrameStrobe[11] VPWR VGND sg13cmos5l_antennanp
XANTENNA__70__X FrameData_O[13] VPWR VGND sg13cmos5l_antennanp
XFILLER_6_220 VPWR VGND sg13cmos5l_decap_4
X_25_ N2BEG[1] S2MID[6] VPWR VGND sg13cmos5l_buf_1
XFILLER_10_72 VPWR VGND sg13cmos5l_decap_8
XFILLER_3_201 VPWR VGND sg13cmos5l_decap_8
XANTENNA__65__X FrameData_O[8] VPWR VGND sg13cmos5l_antennanp
X_08_ N4BEG[8] S4END[7] VPWR VGND sg13cmos5l_buf_1
XANTENNA__61__A FrameData[4] VPWR VGND sg13cmos5l_antennanp
XFILLER_13_108 VPWR VGND sg13cmos5l_decap_8
XFILLER_7_62 VPWR VGND sg13cmos5l_decap_8
XANTENNA__56__A FrameStrobe[19] VPWR VGND sg13cmos5l_antennanp
XFILLER_8_145 VPWR VGND sg13cmos5l_decap_8
XFILLER_8_101 VPWR VGND sg13cmos5l_fill_1
XFILLER_16_93 VPWR VGND sg13cmos5l_fill_1
XFILLER_5_115 VPWR VGND sg13cmos5l_decap_8
XANTENNA__73__X FrameData_O[16] VPWR VGND sg13cmos5l_antennanp
XFILLER_4_41 VPWR VGND sg13cmos5l_decap_8
XANTENNA__68__X FrameData_O[11] VPWR VGND sg13cmos5l_antennanp
XFILLER_13_94 VPWR VGND sg13cmos5l_decap_8
XFILLER_14_203 VPWR VGND sg13cmos5l_decap_4
X_41_ FrameStrobe_O[4] FrameStrobe[4] VPWR VGND sg13cmos5l_buf_1
XFILLER_1_195 VPWR VGND sg13cmos5l_fill_1
XFILLER_1_173 VPWR VGND sg13cmos5l_fill_1
XANTENNA__64__A FrameData[7] VPWR VGND sg13cmos5l_antennanp
X_24_ N2BEG[0] S2MID[7] VPWR VGND sg13cmos5l_buf_1
XFILLER_10_51 VPWR VGND sg13cmos5l_decap_8
XANTENNA__59__A FrameData[2] VPWR VGND sg13cmos5l_antennanp
XANTENNA__81__X FrameData_O[24] VPWR VGND sg13cmos5l_antennanp
XFILLER_0_205 VPWR VGND sg13cmos5l_decap_4
XFILLER_0_216 VPWR VGND sg13cmos5l_decap_8
X_07_ N4BEG[7] S4END[8] VPWR VGND sg13cmos5l_buf_1
XANTENNA__76__X FrameData_O[19] VPWR VGND sg13cmos5l_antennanp
XFILLER_7_41 VPWR VGND sg13cmos5l_decap_8
XANTENNA__72__A FrameData[15] VPWR VGND sg13cmos5l_antennanp
XFILLER_12_120 VPWR VGND sg13cmos5l_decap_8
XFILLER_12_186 VPWR VGND sg13cmos5l_decap_8
XFILLER_8_124 VPWR VGND sg13cmos5l_decap_8
XANTENNA__67__A FrameData[10] VPWR VGND sg13cmos5l_antennanp
XFILLER_4_20 VPWR VGND sg13cmos5l_decap_8
XFILLER_2_119 VPWR VGND sg13cmos5l_decap_8
XFILLER_13_73 VPWR VGND sg13cmos5l_decap_8
X_40_ FrameStrobe_O[3] FrameStrobe[3] VPWR VGND sg13cmos5l_buf_1
XANTENNA__84__X FrameData_O[27] VPWR VGND sg13cmos5l_antennanp
XFILLER_11_207 VPWR VGND sg13cmos5l_decap_8
XFILLER_1_7 VPWR VGND sg13cmos5l_decap_8
XANTENNA__79__X FrameData_O[22] VPWR VGND sg13cmos5l_antennanp
XANTENNA__80__A FrameData[23] VPWR VGND sg13cmos5l_antennanp
X_23_ N2BEGb[7] S2END[0] VPWR VGND sg13cmos5l_buf_1
XFILLER_1_65 VPWR VGND sg13cmos5l_fill_1
XFILLER_1_21 VPWR VGND sg13cmos5l_decap_8
Xclkbuf_1_1__f_UserCLK _36_/A clkbuf_0_UserCLK/X VPWR VGND sg13cmos5l_buf_16
XANTENNA__75__A FrameData[18] VPWR VGND sg13cmos5l_antennanp
XFILLER_10_30 VPWR VGND sg13cmos5l_decap_8
XFILLER_10_96 VPWR VGND sg13cmos5l_decap_8
X_06_ N4BEG[6] S4END[9] VPWR VGND sg13cmos5l_buf_1
XFILLER_15_195 VPWR VGND sg13cmos5l_decap_8
XFILLER_7_97 VPWR VGND sg13cmos5l_decap_4
XFILLER_7_20 VPWR VGND sg13cmos5l_decap_8
XANTENNA__87__X FrameData_O[30] VPWR VGND sg13cmos5l_antennanp
XFILLER_12_165 VPWR VGND sg13cmos5l_decap_8
XANTENNA__83__A FrameData[26] VPWR VGND sg13cmos5l_antennanp
XFILLER_5_106 VPWR VGND sg13cmos5l_fill_2
XFILLER_4_76 VPWR VGND sg13cmos5l_decap_8
XFILLER_4_194 VPWR VGND sg13cmos5l_decap_8
XANTENNA__78__A FrameData[21] VPWR VGND sg13cmos5l_antennanp
XFILLER_13_52 VPWR VGND sg13cmos5l_decap_8
XFILLER_1_153 VPWR VGND sg13cmos5l_fill_2
X_22_ N2BEGb[6] S2END[1] VPWR VGND sg13cmos5l_buf_1
XFILLER_10_86 VPWR VGND sg13cmos5l_fill_2
XFILLER_3_215 VPWR VGND sg13cmos5l_decap_8
X_05_ N4BEG[5] S4END[10] VPWR VGND sg13cmos5l_buf_1
XFILLER_16_119 VPWR VGND sg13cmos5l_fill_1
XANTENNA__86__A FrameData[29] VPWR VGND sg13cmos5l_antennanp
XFILLER_15_174 VPWR VGND sg13cmos5l_decap_8
XFILLER_7_76 VPWR VGND sg13cmos5l_decap_8
XFILLER_12_144 VPWR VGND sg13cmos5l_decap_8
XFILLER_8_159 VPWR VGND sg13cmos5l_decap_8
XFILLER_16_30 VPWR VGND sg13cmos5l_fill_2
XFILLER_7_192 VPWR VGND sg13cmos5l_decap_8
XFILLER_5_129 VPWR VGND sg13cmos5l_decap_8
XFILLER_4_55 VPWR VGND sg13cmos5l_decap_8
XFILLER_4_173 VPWR VGND sg13cmos5l_decap_8
XFILLER_13_31 VPWR VGND sg13cmos5l_decap_8
XFILLER_14_217 VPWR VGND sg13cmos5l_fill_1
XFILLER_9_210 VPWR VGND sg13cmos5l_decap_8
X_21_ N2BEGb[5] S2END[2] VPWR VGND sg13cmos5l_buf_1
XFILLER_6_213 VPWR VGND sg13cmos5l_decap_8
XFILLER_10_65 VPWR VGND sg13cmos5l_decap_8
X_04_ N4BEG[4] S4END[11] VPWR VGND sg13cmos5l_buf_1
XFILLER_15_120 VPWR VGND sg13cmos5l_fill_2
XFILLER_7_55 VPWR VGND sg13cmos5l_decap_8
XFILLER_8_138 VPWR VGND sg13cmos5l_decap_8
XFILLER_7_171 VPWR VGND sg13cmos5l_decap_8
XFILLER_4_34 VPWR VGND sg13cmos5l_decap_8
XFILLER_4_152 VPWR VGND sg13cmos5l_decap_8
XFILLER_14_207 VPWR VGND sg13cmos5l_fill_2
XFILLER_13_10 VPWR VGND sg13cmos5l_fill_1
XFILLER_13_87 VPWR VGND sg13cmos5l_decap_8
XFILLER_1_166 VPWR VGND sg13cmos5l_decap_8
XFILLER_1_155 VPWR VGND sg13cmos5l_fill_1
XFILLER_1_133 VPWR VGND sg13cmos5l_decap_4
X_20_ N2BEGb[4] S2END[3] VPWR VGND sg13cmos5l_buf_1
XFILLER_1_35 VPWR VGND sg13cmos5l_decap_4
XFILLER_10_44 VPWR VGND sg13cmos5l_decap_8
XFILLER_10_88 VPWR VGND sg13cmos5l_fill_1
X_03_ N4BEG[3] S4END[12] VPWR VGND sg13cmos5l_buf_1
XANTENNA__00__X N4BEG[0] VPWR VGND sg13cmos5l_antennanp
Xclkbuf_1_0__f_UserCLK clkload0/A clkbuf_0_UserCLK/X VPWR VGND sg13cmos5l_buf_16
XFILLER_7_34 VPWR VGND sg13cmos5l_decap_8
XFILLER_12_113 VPWR VGND sg13cmos5l_decap_8
XFILLER_12_179 VPWR VGND sg13cmos5l_decap_8
XFILLER_8_117 VPWR VGND sg13cmos5l_decap_8
XFILLER_8_106 VPWR VGND sg13cmos5l_fill_1
XFILLER_7_150 VPWR VGND sg13cmos5l_decap_8
XFILLER_4_131 VPWR VGND sg13cmos5l_decap_8
XFILLER_4_13 VPWR VGND sg13cmos5l_decap_8
XFILLER_13_66 VPWR VGND sg13cmos5l_decap_8
XFILLER_1_189 VPWR VGND sg13cmos5l_fill_2
XANTENNA__03__X N4BEG[3] VPWR VGND sg13cmos5l_antennanp
XFILLER_1_69 VPWR VGND sg13cmos5l_decap_4
XFILLER_1_14 VPWR VGND sg13cmos5l_decap_8
XFILLER_10_23 VPWR VGND sg13cmos5l_decap_8
X_79_ FrameData_O[22] FrameData[22] VPWR VGND sg13cmos5l_buf_1
X_02_ N4BEG[2] S4END[13] VPWR VGND sg13cmos5l_buf_1
XFILLER_15_188 VPWR VGND sg13cmos5l_decap_8
XFILLER_7_13 VPWR VGND sg13cmos5l_decap_8
XFILLER_12_158 VPWR VGND sg13cmos5l_decap_8
XFILLER_16_11 VPWR VGND sg13cmos5l_fill_2
XANTENNA__11__X N4BEG[11] VPWR VGND sg13cmos5l_antennanp
XANTENNA__06__X N4BEG[6] VPWR VGND sg13cmos5l_antennanp
XFILLER_4_187 VPWR VGND sg13cmos5l_decap_8
XFILLER_4_69 VPWR VGND sg13cmos5l_decap_8
XANTENNA__02__A S4END[13] VPWR VGND sg13cmos5l_antennanp
XFILLER_13_45 VPWR VGND sg13cmos5l_decap_8
XFILLER_1_146 VPWR VGND sg13cmos5l_decap_8
XFILLER_10_212 VPWR VGND sg13cmos5l_decap_8
XFILLER_10_223 VPWR VGND sg13cmos5l_fill_1
X_78_ FrameData_O[21] FrameData[21] VPWR VGND sg13cmos5l_buf_1
XANTENNA__14__X N4BEG[14] VPWR VGND sg13cmos5l_antennanp
XFILLER_10_79 VPWR VGND sg13cmos5l_decap_8
XFILLER_3_208 VPWR VGND sg13cmos5l_decap_8
X_01_ N4BEG[1] S4END[14] VPWR VGND sg13cmos5l_buf_1
XANTENNA__10__A S4END[5] VPWR VGND sg13cmos5l_antennanp
XFILLER_2_91 VPWR VGND sg13cmos5l_decap_8
XANTENNA__09__X N4BEG[9] VPWR VGND sg13cmos5l_antennanp
XFILLER_15_101 VPWR VGND sg13cmos5l_fill_1
XFILLER_15_167 VPWR VGND sg13cmos5l_decap_8
XANTENNA__05__A S4END[10] VPWR VGND sg13cmos5l_antennanp
XFILLER_12_137 VPWR VGND sg13cmos5l_decap_8
XFILLER_16_67 VPWR VGND sg13cmos5l_fill_1
XFILLER_7_185 VPWR VGND sg13cmos5l_decap_8
XANTENNA__22__X N2BEGb[6] VPWR VGND sg13cmos5l_antennanp
XFILLER_4_48 VPWR VGND sg13cmos5l_decap_8
XFILLER_4_166 VPWR VGND sg13cmos5l_decap_8
XFILLER_13_24 VPWR VGND sg13cmos5l_decap_8
XFILLER_8_6 VPWR VGND sg13cmos5l_decap_8
XANTENNA__17__X N2BEGb[1] VPWR VGND sg13cmos5l_antennanp
XFILLER_13_221 VPWR VGND sg13cmos5l_fill_2
XFILLER_9_203 VPWR VGND sg13cmos5l_decap_8
XFILLER_0_191 VPWR VGND sg13cmos5l_decap_8
XANTENNA__13__A S4END[2] VPWR VGND sg13cmos5l_antennanp
XFILLER_6_206 VPWR VGND sg13cmos5l_decap_8
X_77_ FrameData_O[20] FrameData[20] VPWR VGND sg13cmos5l_buf_1
XANTENNA__08__A S4END[7] VPWR VGND sg13cmos5l_antennanp
XFILLER_10_58 VPWR VGND sg13cmos5l_decap_8
XANTENNA__30__X N2BEG[6] VPWR VGND sg13cmos5l_antennanp
X_00_ N4BEG[0] S4END[15] VPWR VGND sg13cmos5l_buf_1
XANTENNA__25__X N2BEG[1] VPWR VGND sg13cmos5l_antennanp
XFILLER_11_90 VPWR VGND sg13cmos5l_decap_8
XFILLER_7_48 VPWR VGND sg13cmos5l_decap_8
XANTENNA__21__A S2END[2] VPWR VGND sg13cmos5l_antennanp
XFILLER_12_127 VPWR VGND sg13cmos5l_decap_8
XFILLER_11_193 VPWR VGND sg13cmos5l_decap_8
XFILLER_7_164 VPWR VGND sg13cmos5l_decap_8
XANTENNA__16__A S2END[7] VPWR VGND sg13cmos5l_antennanp
XFILLER_4_27 VPWR VGND sg13cmos5l_decap_8
XFILLER_4_145 VPWR VGND sg13cmos5l_decap_8
XFILLER_4_101 VPWR VGND sg13cmos5l_decap_8
XANTENNA__33__X N1BEG[1] VPWR VGND sg13cmos5l_antennanp
XFILLER_13_211 VPWR VGND sg13cmos5l_fill_2
XFILLER_1_159 VPWR VGND sg13cmos5l_fill_2
XFILLER_1_137 VPWR VGND sg13cmos5l_fill_2
XFILLER_1_104 VPWR VGND sg13cmos5l_fill_2
XFILLER_5_81 VPWR VGND sg13cmos5l_decap_8
XFILLER_1_28 VPWR VGND sg13cmos5l_decap_8
XANTENNA__28__X N2BEG[4] VPWR VGND sg13cmos5l_antennanp
XFILLER_14_90 VPWR VGND sg13cmos5l_decap_4
X_76_ FrameData_O[19] FrameData[19] VPWR VGND sg13cmos5l_buf_1
XFILLER_1_39 VPWR VGND sg13cmos5l_fill_1
XFILLER_10_37 VPWR VGND sg13cmos5l_decap_8
XANTENNA__24__A S2MID[7] VPWR VGND sg13cmos5l_antennanp
XFILLER_2_210 VPWR VGND sg13cmos5l_decap_8
X_59_ FrameData_O[2] FrameData[2] VPWR VGND sg13cmos5l_buf_1
XFILLER_2_82 VPWR VGND sg13cmos5l_fill_2
XANTENNA__19__A S2END[4] VPWR VGND sg13cmos5l_antennanp
XANTENNA__41__X FrameStrobe_O[4] VPWR VGND sg13cmos5l_antennanp
XFILLER_7_27 VPWR VGND sg13cmos5l_decap_8
XFILLER_12_106 VPWR VGND sg13cmos5l_decap_8
XANTENNA__36__X UserCLKo VPWR VGND sg13cmos5l_antennanp
XFILLER_11_172 VPWR VGND sg13cmos5l_decap_8
XFILLER_7_143 VPWR VGND sg13cmos5l_decap_8
XFILLER_8_92 VPWR VGND sg13cmos5l_decap_8
XANTENNA__32__A S1END[3] VPWR VGND sg13cmos5l_antennanp
XFILLER_4_124 VPWR VGND sg13cmos5l_decap_8
XANTENNA__27__A S2MID[4] VPWR VGND sg13cmos5l_antennanp
XFILLER_13_223 VPWR VGND sg13cmos5l_fill_1
XFILLER_13_59 VPWR VGND sg13cmos5l_decap_8
XANTENNA__44__X FrameStrobe_O[7] VPWR VGND sg13cmos5l_antennanp
XFILLER_10_16 VPWR VGND sg13cmos5l_decap_8
X_75_ FrameData_O[18] FrameData[18] VPWR VGND sg13cmos5l_buf_1
XANTENNA__39__X FrameStrobe_O[2] VPWR VGND sg13cmos5l_antennanp
XANTENNA__40__A FrameStrobe[3] VPWR VGND sg13cmos5l_antennanp
X_58_ FrameData_O[1] FrameData[1] VPWR VGND sg13cmos5l_buf_1
XANTENNA__35__A S1END[0] VPWR VGND sg13cmos5l_antennanp
XFILLER_16_48 VPWR VGND sg13cmos5l_fill_1
XANTENNA__52__X FrameStrobe_O[15] VPWR VGND sg13cmos5l_antennanp
XFILLER_11_151 VPWR VGND sg13cmos5l_decap_8
XFILLER_7_199 VPWR VGND sg13cmos5l_decap_8
XFILLER_7_122 VPWR VGND sg13cmos5l_decap_8
XANTENNA__47__X FrameStrobe_O[10] VPWR VGND sg13cmos5l_antennanp
XFILLER_3_180 VPWR VGND sg13cmos5l_decap_8
XFILLER_13_38 VPWR VGND sg13cmos5l_decap_8
XANTENNA__43__A FrameStrobe[6] VPWR VGND sg13cmos5l_antennanp
XFILLER_9_217 VPWR VGND sg13cmos5l_decap_8
XFILLER_10_205 VPWR VGND sg13cmos5l_decap_8
XANTENNA__38__A FrameStrobe[1] VPWR VGND sg13cmos5l_antennanp
XANTENNA__60__X FrameData_O[3] VPWR VGND sg13cmos5l_antennanp
XFILLER_5_220 VPWR VGND sg13cmos5l_decap_4
X_74_ FrameData_O[17] FrameData[17] VPWR VGND sg13cmos5l_buf_1
XANTENNA__55__X FrameStrobe_O[18] VPWR VGND sg13cmos5l_antennanp
XFILLER_2_62 VPWR VGND sg13cmos5l_decap_8
X_57_ FrameData_O[0] FrameData[0] VPWR VGND sg13cmos5l_buf_1
XANTENNA__51__A FrameStrobe[14] VPWR VGND sg13cmos5l_antennanp
XFILLER_14_182 VPWR VGND sg13cmos5l_decap_8
XANTENNA__46__A FrameStrobe[9] VPWR VGND sg13cmos5l_antennanp
XFILLER_11_130 VPWR VGND sg13cmos5l_decap_8
XFILLER_8_83 VPWR VGND sg13cmos5l_fill_1
XFILLER_7_178 VPWR VGND sg13cmos5l_decap_8
XFILLER_4_159 VPWR VGND sg13cmos5l_decap_8
XFILLER_4_115 VPWR VGND sg13cmos5l_fill_2
XANTENNA__63__X FrameData_O[6] VPWR VGND sg13cmos5l_antennanp
XFILLER_13_17 VPWR VGND sg13cmos5l_decap_8
XFILLER_1_129 VPWR VGND sg13cmos5l_fill_1
XANTENNA__58__X FrameData_O[1] VPWR VGND sg13cmos5l_antennanp
XFILLER_0_140 VPWR VGND sg13cmos5l_decap_8
XFILLER_0_162 VPWR VGND sg13cmos5l_decap_4
XFILLER_5_95 VPWR VGND sg13cmos5l_decap_8
XFILLER_5_73 VPWR VGND sg13cmos5l_fill_1
XFILLER_5_62 VPWR VGND sg13cmos5l_decap_8
XANTENNA__54__A FrameStrobe[17] VPWR VGND sg13cmos5l_antennanp
X_73_ FrameData_O[16] FrameData[16] VPWR VGND sg13cmos5l_buf_1
XANTENNA__49__A FrameStrobe[12] VPWR VGND sg13cmos5l_antennanp
XANTENNA__71__X FrameData_O[14] VPWR VGND sg13cmos5l_antennanp
X_56_ FrameStrobe_O[19] FrameStrobe[19] VPWR VGND sg13cmos5l_buf_1
XFILLER_2_74 VPWR VGND sg13cmos5l_fill_1
XFILLER_2_41 VPWR VGND sg13cmos5l_decap_8
XANTENNA__66__X FrameData_O[9] VPWR VGND sg13cmos5l_antennanp
XFILLER_11_83 VPWR VGND sg13cmos5l_decap_8
XFILLER_14_161 VPWR VGND sg13cmos5l_decap_8
X_39_ FrameStrobe_O[2] FrameStrobe[2] VPWR VGND sg13cmos5l_buf_1
XANTENNA__62__A FrameData[5] VPWR VGND sg13cmos5l_antennanp
XFILLER_11_186 VPWR VGND sg13cmos5l_decap_8
XFILLER_7_157 VPWR VGND sg13cmos5l_decap_8
XFILLER_8_62 VPWR VGND sg13cmos5l_decap_8
XANTENNA__57__A FrameData[0] VPWR VGND sg13cmos5l_antennanp
XFILLER_4_138 VPWR VGND sg13cmos5l_decap_8
XFILLER_1_119 VPWR VGND sg13cmos5l_decap_8
XFILLER_13_204 VPWR VGND sg13cmos5l_decap_8
XANTENNA__74__X FrameData_O[17] VPWR VGND sg13cmos5l_antennanp
XFILLER_5_41 VPWR VGND sg13cmos5l_decap_8
XANTENNA__69__X FrameData_O[12] VPWR VGND sg13cmos5l_antennanp
XANTENNA__70__A FrameData[13] VPWR VGND sg13cmos5l_antennanp
XFILLER_14_83 VPWR VGND sg13cmos5l_decap_8
XFILLER_14_94 VPWR VGND sg13cmos5l_fill_1
X_72_ FrameData_O[15] FrameData[15] VPWR VGND sg13cmos5l_buf_1
XANTENNA__65__A FrameData[8] VPWR VGND sg13cmos5l_antennanp
XFILLER_2_203 VPWR VGND sg13cmos5l_decap_8
X_55_ FrameStrobe_O[18] FrameStrobe[18] VPWR VGND sg13cmos5l_buf_1
XFILLER_2_20 VPWR VGND sg13cmos5l_decap_8
XFILLER_11_62 VPWR VGND sg13cmos5l_decap_8
XANTENNA__82__X FrameData_O[25] VPWR VGND sg13cmos5l_antennanp
XFILLER_14_140 VPWR VGND sg13cmos5l_decap_8
X_38_ FrameStrobe_O[1] FrameStrobe[1] VPWR VGND sg13cmos5l_buf_1
XANTENNA__77__X FrameData_O[20] VPWR VGND sg13cmos5l_antennanp
XFILLER_11_110 VPWR VGND sg13cmos5l_decap_4
XFILLER_11_165 VPWR VGND sg13cmos5l_decap_8
XFILLER_7_136 VPWR VGND sg13cmos5l_decap_8
XFILLER_8_41 VPWR VGND sg13cmos5l_decap_8
XANTENNA__73__A FrameData[16] VPWR VGND sg13cmos5l_antennanp
XFILLER_16_202 VPWR VGND sg13cmos5l_decap_8
XFILLER_3_194 VPWR VGND sg13cmos5l_decap_8
XFILLER_1_109 VPWR VGND sg13cmos5l_decap_8
XANTENNA__68__A FrameData[11] VPWR VGND sg13cmos5l_antennanp
XFILLER_0_186 VPWR VGND sg13cmos5l_fill_2
XFILLER_5_20 VPWR VGND sg13cmos5l_decap_8
XFILLER_10_219 VPWR VGND sg13cmos5l_decap_4
XFILLER_6_9 VPWR VGND sg13cmos5l_decap_8
XANTENNA__85__X FrameData_O[28] VPWR VGND sg13cmos5l_antennanp
X_71_ FrameData_O[14] FrameData[14] VPWR VGND sg13cmos5l_buf_1
XANTENNA__81__A FrameData[24] VPWR VGND sg13cmos5l_antennanp
XFILLER_4_6 VPWR VGND sg13cmos5l_decap_8
X_54_ FrameStrobe_O[17] FrameStrobe[17] VPWR VGND sg13cmos5l_buf_1
XFILLER_2_98 VPWR VGND sg13cmos5l_decap_8
XFILLER_11_41 VPWR VGND sg13cmos5l_decap_8
XANTENNA__76__A FrameData[19] VPWR VGND sg13cmos5l_antennanp
XFILLER_14_196 VPWR VGND sg13cmos5l_decap_8
X_37_ FrameStrobe_O[0] FrameStrobe[0] VPWR VGND sg13cmos5l_buf_1
XFILLER_0_0 VPWR VGND sg13cmos5l_fill_1
XFILLER_11_144 VPWR VGND sg13cmos5l_decap_8
XFILLER_7_115 VPWR VGND sg13cmos5l_decap_8
XFILLER_8_20 VPWR VGND sg13cmos5l_decap_8
XFILLER_6_192 VPWR VGND sg13cmos5l_decap_8
XANTENNA__88__X FrameData_O[31] VPWR VGND sg13cmos5l_antennanp
XFILLER_3_173 VPWR VGND sg13cmos5l_decap_8
XFILLER_13_217 VPWR VGND sg13cmos5l_fill_1
XANTENNA__84__A FrameData[27] VPWR VGND sg13cmos5l_antennanp
XANTENNA__79__A FrameData[22] VPWR VGND sg13cmos5l_antennanp
XFILLER_14_63 VPWR VGND sg13cmos5l_decap_8
XFILLER_5_213 VPWR VGND sg13cmos5l_decap_8
X_70_ FrameData_O[13] FrameData[13] VPWR VGND sg13cmos5l_buf_1
X_53_ FrameStrobe_O[16] FrameStrobe[16] VPWR VGND sg13cmos5l_buf_1
XFILLER_2_55 VPWR VGND sg13cmos5l_decap_8
XFILLER_15_109 VPWR VGND sg13cmos5l_fill_1
XFILLER_11_20 VPWR VGND sg13cmos5l_decap_8
XFILLER_11_97 VPWR VGND sg13cmos5l_decap_4
XFILLER_14_120 VPWR VGND sg13cmos5l_fill_2
XFILLER_14_175 VPWR VGND sg13cmos5l_decap_8
X_36_ UserCLKo _36_/A VPWR VGND sg13cmos5l_buf_1
XFILLER_11_101 VPWR VGND sg13cmos5l_fill_1
XFILLER_11_123 VPWR VGND sg13cmos5l_decap_8
XANTENNA__87__A FrameData[30] VPWR VGND sg13cmos5l_antennanp
XFILLER_8_76 VPWR VGND sg13cmos5l_decap_8
XFILLER_6_171 VPWR VGND sg13cmos5l_decap_8
X_19_ N2BEGb[3] S2END[4] VPWR VGND sg13cmos5l_buf_1
XFILLER_4_108 VPWR VGND sg13cmos5l_decap_8
XFILLER_3_152 VPWR VGND sg13cmos5l_decap_8
XFILLER_0_133 VPWR VGND sg13cmos5l_decap_8
XFILLER_0_155 VPWR VGND sg13cmos5l_decap_4
XFILLER_0_166 VPWR VGND sg13cmos5l_fill_2
XFILLER_8_222 VPWR VGND sg13cmos5l_fill_2
XFILLER_5_88 VPWR VGND sg13cmos5l_decap_8
XFILLER_5_55 VPWR VGND sg13cmos5l_decap_8
XFILLER_14_31 VPWR VGND sg13cmos5l_decap_4
XFILLER_14_42 VPWR VGND sg13cmos5l_decap_8
XFILLER_2_217 VPWR VGND sg13cmos5l_decap_8
X_52_ FrameStrobe_O[15] FrameStrobe[15] VPWR VGND sg13cmos5l_buf_1
XFILLER_2_78 VPWR VGND sg13cmos5l_decap_4
XFILLER_2_34 VPWR VGND sg13cmos5l_decap_8
XFILLER_11_76 VPWR VGND sg13cmos5l_decap_8
XFILLER_14_154 VPWR VGND sg13cmos5l_decap_8
X_35_ N1BEG[3] S1END[0] VPWR VGND sg13cmos5l_buf_1
XFILLER_11_179 VPWR VGND sg13cmos5l_decap_8
XFILLER_8_99 VPWR VGND sg13cmos5l_fill_2
XFILLER_8_88 VPWR VGND sg13cmos5l_fill_1
XFILLER_8_55 VPWR VGND sg13cmos5l_decap_8
XFILLER_6_150 VPWR VGND sg13cmos5l_decap_8
X_18_ N2BEGb[2] S2END[5] VPWR VGND sg13cmos5l_buf_1
XFILLER_3_131 VPWR VGND sg13cmos5l_decap_8
XFILLER_8_201 VPWR VGND sg13cmos5l_decap_8
XFILLER_5_34 VPWR VGND sg13cmos5l_decap_8
XFILLER_14_76 VPWR VGND sg13cmos5l_decap_8
XFILLER_14_98 VPWR VGND sg13cmos5l_fill_2
X_51_ FrameStrobe_O[14] FrameStrobe[14] VPWR VGND sg13cmos5l_buf_1
XFILLER_2_13 VPWR VGND sg13cmos5l_decap_8
XFILLER_11_55 VPWR VGND sg13cmos5l_decap_8
XFILLER_2_6 VPWR VGND sg13cmos5l_decap_8
XFILLER_14_122 VPWR VGND sg13cmos5l_fill_1
XFILLER_14_133 VPWR VGND sg13cmos5l_decap_8
X_34_ N1BEG[2] S1END[1] VPWR VGND sg13cmos5l_buf_1
XFILLER_11_114 VPWR VGND sg13cmos5l_fill_2
XANTENNA__01__X N4BEG[1] VPWR VGND sg13cmos5l_antennanp
XFILLER_11_158 VPWR VGND sg13cmos5l_decap_8
XFILLER_8_34 VPWR VGND sg13cmos5l_decap_8
XFILLER_7_129 VPWR VGND sg13cmos5l_decap_8
XFILLER_10_191 VPWR VGND sg13cmos5l_decap_8
X_17_ N2BEGb[1] S2END[6] VPWR VGND sg13cmos5l_buf_1
XFILLER_3_110 VPWR VGND sg13cmos5l_decap_8
XFILLER_16_217 VPWR VGND sg13cmos5l_fill_1
XFILLER_3_187 VPWR VGND sg13cmos5l_decap_8
XFILLER_5_13 VPWR VGND sg13cmos5l_decap_8
XANTENNA__04__X N4BEG[4] VPWR VGND sg13cmos5l_antennanp
X_50_ FrameStrobe_O[13] FrameStrobe[13] VPWR VGND sg13cmos5l_buf_1
XFILLER_2_69 VPWR VGND sg13cmos5l_fill_1
XANTENNA__00__A S4END[15] VPWR VGND sg13cmos5l_antennanp
XFILLER_11_34 VPWR VGND sg13cmos5l_decap_8
XFILLER_14_189 VPWR VGND sg13cmos5l_decap_8
X_33_ N1BEG[1] S1END[2] VPWR VGND sg13cmos5l_buf_1
XFILLER_9_182 VPWR VGND sg13cmos5l_decap_8
XFILLER_3_90 VPWR VGND sg13cmos5l_decap_4
XFILLER_11_137 VPWR VGND sg13cmos5l_decap_8
XFILLER_7_108 VPWR VGND sg13cmos5l_decap_8
XFILLER_10_170 VPWR VGND sg13cmos5l_decap_8
X_16_ N2BEGb[0] S2END[7] VPWR VGND sg13cmos5l_buf_1
XFILLER_8_13 VPWR VGND sg13cmos5l_decap_8
XFILLER_6_185 VPWR VGND sg13cmos5l_decap_8
XANTENNA__12__X N4BEG[12] VPWR VGND sg13cmos5l_antennanp
XFILLER_12_9 VPWR VGND sg13cmos5l_decap_8
XFILLER_3_166 VPWR VGND sg13cmos5l_decap_8
XANTENNA__07__X N4BEG[7] VPWR VGND sg13cmos5l_antennanp
XFILLER_0_147 VPWR VGND sg13cmos5l_fill_1
XFILLER_12_221 VPWR VGND sg13cmos5l_fill_2
XFILLER_5_69 VPWR VGND sg13cmos5l_decap_4
XANTENNA__03__A S4END[12] VPWR VGND sg13cmos5l_antennanp
XFILLER_14_12 VPWR VGND sg13cmos5l_fill_1
XFILLER_14_56 VPWR VGND sg13cmos5l_fill_1
XFILLER_5_206 VPWR VGND sg13cmos5l_decap_8
XANTENNA__20__X N2BEGb[4] VPWR VGND sg13cmos5l_antennanp
XFILLER_2_48 VPWR VGND sg13cmos5l_decap_8
XFILLER_11_13 VPWR VGND sg13cmos5l_decap_8
XANTENNA__15__X N4BEG[15] VPWR VGND sg13cmos5l_antennanp
XFILLER_14_113 VPWR VGND sg13cmos5l_decap_8
XFILLER_14_168 VPWR VGND sg13cmos5l_decap_8
XFILLER_13_190 VPWR VGND sg13cmos5l_decap_8
X_32_ N1BEG[0] S1END[3] VPWR VGND sg13cmos5l_buf_1
XFILLER_9_161 VPWR VGND sg13cmos5l_decap_8
XANTENNA__11__A S4END[4] VPWR VGND sg13cmos5l_antennanp
X_15_ N4BEG[15] S4END[0] VPWR VGND sg13cmos5l_buf_1
XFILLER_8_69 VPWR VGND sg13cmos5l_decap_8
XFILLER_6_164 VPWR VGND sg13cmos5l_decap_8
XANTENNA__06__A S4END[9] VPWR VGND sg13cmos5l_antennanp
XFILLER_3_145 VPWR VGND sg13cmos5l_decap_8
XFILLER_9_90 VPWR VGND sg13cmos5l_decap_8
XANTENNA__23__X N2BEGb[7] VPWR VGND sg13cmos5l_antennanp
XFILLER_0_126 VPWR VGND sg13cmos5l_decap_8
XFILLER_12_200 VPWR VGND sg13cmos5l_decap_8
XFILLER_8_215 VPWR VGND sg13cmos5l_decap_8
XFILLER_5_48 VPWR VGND sg13cmos5l_decap_8
XFILLER_14_24 VPWR VGND sg13cmos5l_decap_8
XANTENNA__18__X N2BEGb[2] VPWR VGND sg13cmos5l_antennanp
XANTENNA__14__A S4END[1] VPWR VGND sg13cmos5l_antennanp
XFILLER_2_27 VPWR VGND sg13cmos5l_decap_8
XFILLER_1_221 VPWR VGND sg13cmos5l_fill_2
XANTENNA__09__A S4END[6] VPWR VGND sg13cmos5l_antennanp
XFILLER_11_69 VPWR VGND sg13cmos5l_decap_8
XFILLER_14_147 VPWR VGND sg13cmos5l_decap_8
XANTENNA__31__X N2BEG[7] VPWR VGND sg13cmos5l_antennanp
X_31_ N2BEG[7] S2MID[0] VPWR VGND sg13cmos5l_buf_1
XFILLER_9_140 VPWR VGND sg13cmos5l_decap_8
XFILLER_11_106 VPWR VGND sg13cmos5l_fill_1
XANTENNA__26__X N2BEG[2] VPWR VGND sg13cmos5l_antennanp
XFILLER_8_48 VPWR VGND sg13cmos5l_decap_8
XFILLER_6_143 VPWR VGND sg13cmos5l_decap_8
X_14_ N4BEG[14] S4END[1] VPWR VGND sg13cmos5l_buf_1
XANTENNA__22__A S2END[1] VPWR VGND sg13cmos5l_antennanp
XFILLER_3_124 VPWR VGND sg13cmos5l_decap_8
XFILLER_16_209 VPWR VGND sg13cmos5l_decap_4
XANTENNA__17__A S2END[6] VPWR VGND sg13cmos5l_antennanp
XFILLER_0_116 VPWR VGND sg13cmos5l_fill_2
XFILLER_12_223 VPWR VGND sg13cmos5l_fill_1
XFILLER_5_27 VPWR VGND sg13cmos5l_decap_8
XANTENNA__34__X N1BEG[2] VPWR VGND sg13cmos5l_antennanp
XANTENNA__29__X N2BEG[5] VPWR VGND sg13cmos5l_antennanp
XANTENNA__30__A S2MID[1] VPWR VGND sg13cmos5l_antennanp
XANTENNA__25__A S2MID[6] VPWR VGND sg13cmos5l_antennanp
XFILLER_11_48 VPWR VGND sg13cmos5l_decap_8
XFILLER_14_126 VPWR VGND sg13cmos5l_decap_8
X_30_ N2BEG[6] S2MID[1] VPWR VGND sg13cmos5l_buf_1
XFILLER_9_196 VPWR VGND sg13cmos5l_decap_8
XANTENNA__42__X FrameStrobe_O[5] VPWR VGND sg13cmos5l_antennanp
XFILLER_10_184 VPWR VGND sg13cmos5l_decap_8
XFILLER_8_27 VPWR VGND sg13cmos5l_decap_8
XFILLER_6_199 VPWR VGND sg13cmos5l_decap_8
XFILLER_6_122 VPWR VGND sg13cmos5l_decap_8
XFILLER_6_111 VPWR VGND sg13cmos5l_fill_1
XFILLER_6_100 VPWR VGND sg13cmos5l_decap_8
X_13_ N4BEG[13] S4END[2] VPWR VGND sg13cmos5l_buf_1
XANTENNA__37__X FrameStrobe_O[0] VPWR VGND sg13cmos5l_antennanp
XANTENNA__33__A S1END[2] VPWR VGND sg13cmos5l_antennanp
XFILLER_10_9 VPWR VGND sg13cmos5l_decap_8
XANTENNA__28__A S2MID[3] VPWR VGND sg13cmos5l_antennanp
XANTENNA__50__X FrameStrobe_O[13] VPWR VGND sg13cmos5l_antennanp
XFILLER_1_223 VPWR VGND sg13cmos5l_fill_1
XANTENNA__45__X FrameStrobe_O[8] VPWR VGND sg13cmos5l_antennanp
XFILLER_11_27 VPWR VGND sg13cmos5l_decap_8
XANTENNA__41__A FrameStrobe[4] VPWR VGND sg13cmos5l_antennanp
XFILLER_9_175 VPWR VGND sg13cmos5l_decap_8
XFILLER_3_94 VPWR VGND sg13cmos5l_fill_2
XFILLER_3_83 VPWR VGND sg13cmos5l_decap_8
XANTENNA__36__A clkload0/A VPWR VGND sg13cmos5l_antennanp
XFILLER_10_163 VPWR VGND sg13cmos5l_decap_8
X_12_ N4BEG[12] S4END[3] VPWR VGND sg13cmos5l_buf_1
XFILLER_6_178 VPWR VGND sg13cmos5l_decap_8
XFILLER_3_159 VPWR VGND sg13cmos5l_decap_8
XANTENNA__53__X FrameStrobe_O[16] VPWR VGND sg13cmos5l_antennanp
XFILLER_15_222 VPWR VGND sg13cmos5l_fill_2
XFILLER_0_118 VPWR VGND sg13cmos5l_fill_1
XFILLER_0_95 VPWR VGND sg13cmos5l_fill_1
XANTENNA__48__X FrameStrobe_O[11] VPWR VGND sg13cmos5l_antennanp
XFILLER_12_214 VPWR VGND sg13cmos5l_decap_8
XFILLER_15_0 VPWR VGND sg13cmos5l_fill_2
XANTENNA__44__A FrameStrobe[7] VPWR VGND sg13cmos5l_antennanp
XFILLER_14_38 VPWR VGND sg13cmos5l_fill_1
XFILLER_14_49 VPWR VGND sg13cmos5l_decap_8
XFILLER_6_72 VPWR VGND sg13cmos5l_decap_8
XANTENNA__39__A FrameStrobe[2] VPWR VGND sg13cmos5l_antennanp
XANTENNA__61__X FrameData_O[4] VPWR VGND sg13cmos5l_antennanp
XFILLER_14_106 VPWR VGND sg13cmos5l_decap_4
XANTENNA__56__X FrameStrobe_O[19] VPWR VGND sg13cmos5l_antennanp
XFILLER_13_183 VPWR VGND sg13cmos5l_decap_8
X_88_ FrameData_O[31] FrameData[31] VPWR VGND sg13cmos5l_buf_1
XFILLER_9_154 VPWR VGND sg13cmos5l_decap_8
XFILLER_3_62 VPWR VGND sg13cmos5l_decap_8
XANTENNA__52__A FrameStrobe[15] VPWR VGND sg13cmos5l_antennanp
XFILLER_10_142 VPWR VGND sg13cmos5l_decap_8
XFILLER_12_82 VPWR VGND sg13cmos5l_fill_1
XFILLER_12_93 VPWR VGND sg13cmos5l_decap_4
X_11_ N4BEG[11] S4END[4] VPWR VGND sg13cmos5l_buf_1
XFILLER_6_157 VPWR VGND sg13cmos5l_decap_8
XANTENNA__47__A FrameStrobe[10] VPWR VGND sg13cmos5l_antennanp
XFILLER_3_138 VPWR VGND sg13cmos5l_decap_8
XFILLER_0_108 VPWR VGND sg13cmos5l_fill_1
XFILLER_9_83 VPWR VGND sg13cmos5l_decap_8
XFILLER_2_182 VPWR VGND sg13cmos5l_decap_8
XFILLER_8_208 VPWR VGND sg13cmos5l_decap_8
XANTENNA__64__X FrameData_O[7] VPWR VGND sg13cmos5l_antennanp
XANTENNA__59__X FrameData_O[2] VPWR VGND sg13cmos5l_antennanp
XANTENNA__60__A FrameData[3] VPWR VGND sg13cmos5l_antennanp
XFILLER_4_222 VPWR VGND sg13cmos5l_fill_2
XFILLER_6_51 VPWR VGND sg13cmos5l_decap_8
XANTENNA__55__A FrameStrobe[18] VPWR VGND sg13cmos5l_antennanp
XFILLER_15_71 VPWR VGND sg13cmos5l_fill_2
XFILLER_9_6 VPWR VGND sg13cmos5l_decap_8
XFILLER_16_181 VPWR VGND sg13cmos5l_decap_8
XANTENNA__72__X FrameData_O[15] VPWR VGND sg13cmos5l_antennanp
XFILLER_13_162 VPWR VGND sg13cmos5l_decap_8
XFILLER_9_133 VPWR VGND sg13cmos5l_decap_8
XFILLER_3_41 VPWR VGND sg13cmos5l_decap_8
X_87_ FrameData_O[30] FrameData[30] VPWR VGND sg13cmos5l_buf_1
XANTENNA__67__X FrameData_O[10] VPWR VGND sg13cmos5l_antennanp
XFILLER_10_121 VPWR VGND sg13cmos5l_decap_8
XFILLER_10_198 VPWR VGND sg13cmos5l_decap_8
XFILLER_12_72 VPWR VGND sg13cmos5l_decap_4
X_10_ N4BEG[10] S4END[5] VPWR VGND sg13cmos5l_buf_1
XFILLER_6_136 VPWR VGND sg13cmos5l_decap_8
XANTENNA__63__A FrameData[6] VPWR VGND sg13cmos5l_antennanp
XFILLER_15_202 VPWR VGND sg13cmos5l_decap_8
XFILLER_3_117 VPWR VGND sg13cmos5l_decap_8
XFILLER_9_62 VPWR VGND sg13cmos5l_decap_8
XFILLER_2_161 VPWR VGND sg13cmos5l_decap_8
XANTENNA__58__A FrameData[1] VPWR VGND sg13cmos5l_antennanp
XANTENNA__80__X FrameData_O[23] VPWR VGND sg13cmos5l_antennanp
XFILLER_7_220 VPWR VGND sg13cmos5l_decap_4
XANTENNA__75__X FrameData_O[18] VPWR VGND sg13cmos5l_antennanp
XFILLER_4_201 VPWR VGND sg13cmos5l_decap_8
XFILLER_6_85 VPWR VGND sg13cmos5l_fill_1
XFILLER_6_30 VPWR VGND sg13cmos5l_decap_8
XANTENNA__71__A FrameData[14] VPWR VGND sg13cmos5l_antennanp
XANTENNA__66__A FrameData[9] VPWR VGND sg13cmos5l_antennanp
XFILLER_13_141 VPWR VGND sg13cmos5l_decap_8
XFILLER_9_189 VPWR VGND sg13cmos5l_decap_8
X_86_ FrameData_O[29] FrameData[29] VPWR VGND sg13cmos5l_buf_1
XFILLER_3_20 VPWR VGND sg13cmos5l_decap_8
XFILLER_10_177 VPWR VGND sg13cmos5l_decap_8
XFILLER_12_51 VPWR VGND sg13cmos5l_decap_8
XFILLER_6_115 VPWR VGND sg13cmos5l_decap_8
XANTENNA__83__X FrameData_O[26] VPWR VGND sg13cmos5l_antennanp
XFILLER_5_192 VPWR VGND sg13cmos5l_decap_8
X_69_ FrameData_O[12] FrameData[12] VPWR VGND sg13cmos5l_buf_1
XANTENNA__78__X FrameData_O[21] VPWR VGND sg13cmos5l_antennanp
XFILLER_0_32 VPWR VGND sg13cmos5l_decap_4
XFILLER_2_140 VPWR VGND sg13cmos5l_decap_8
Xclkbuf_0_UserCLK clkbuf_0_UserCLK/X UserCLK VPWR VGND sg13cmos5l_buf_16
XFILLER_9_41 VPWR VGND sg13cmos5l_decap_8
XANTENNA__74__A FrameData[17] VPWR VGND sg13cmos5l_antennanp
XFILLER_14_19 VPWR VGND sg13cmos5l_fill_2
XANTENNA__69__A FrameData[12] VPWR VGND sg13cmos5l_antennanp
XANTENNA__86__X FrameData_O[29] VPWR VGND sg13cmos5l_antennanp
XANTENNA__82__A FrameData[25] VPWR VGND sg13cmos5l_antennanp
XFILLER_13_197 VPWR VGND sg13cmos5l_decap_8
X_85_ FrameData_O[28] FrameData[28] VPWR VGND sg13cmos5l_buf_1
XFILLER_9_168 VPWR VGND sg13cmos5l_decap_8
XFILLER_3_76 VPWR VGND sg13cmos5l_decap_8
XFILLER_10_156 VPWR VGND sg13cmos5l_decap_8
XFILLER_12_30 VPWR VGND sg13cmos5l_decap_8
XANTENNA__77__A FrameData[20] VPWR VGND sg13cmos5l_antennanp
XFILLER_5_171 VPWR VGND sg13cmos5l_decap_8
X_68_ FrameData_O[11] FrameData[11] VPWR VGND sg13cmos5l_buf_1
XFILLER_2_196 VPWR VGND sg13cmos5l_decap_8
XFILLER_0_99 VPWR VGND sg13cmos5l_fill_2
XFILLER_9_97 VPWR VGND sg13cmos5l_decap_8
XFILLER_9_20 VPWR VGND sg13cmos5l_decap_8
XFILLER_12_207 VPWR VGND sg13cmos5l_decap_8
XANTENNA__85__A FrameData[28] VPWR VGND sg13cmos5l_antennanp
XFILLER_6_65 VPWR VGND sg13cmos5l_decap_8
XFILLER_16_195 VPWR VGND sg13cmos5l_decap_8
XFILLER_7_6 VPWR VGND sg13cmos5l_decap_8
XFILLER_13_176 VPWR VGND sg13cmos5l_decap_8
X_84_ FrameData_O[27] FrameData[27] VPWR VGND sg13cmos5l_buf_1
XFILLER_9_147 VPWR VGND sg13cmos5l_decap_8
XFILLER_3_55 VPWR VGND sg13cmos5l_decap_8
XFILLER_10_135 VPWR VGND sg13cmos5l_decap_8
XFILLER_8_180 VPWR VGND sg13cmos5l_decap_8
XFILLER_12_86 VPWR VGND sg13cmos5l_decap_8
XFILLER_12_97 VPWR VGND sg13cmos5l_fill_2
X_67_ FrameData_O[10] FrameData[10] VPWR VGND sg13cmos5l_buf_1
XFILLER_5_150 VPWR VGND sg13cmos5l_decap_8
XANTENNA__88__A FrameData[31] VPWR VGND sg13cmos5l_antennanp
XFILLER_2_175 VPWR VGND sg13cmos5l_decap_8
XFILLER_0_89 VPWR VGND sg13cmos5l_fill_2
XFILLER_9_76 VPWR VGND sg13cmos5l_decap_8
XFILLER_4_215 VPWR VGND sg13cmos5l_decap_8
XFILLER_6_44 VPWR VGND sg13cmos5l_decap_8
.ends
